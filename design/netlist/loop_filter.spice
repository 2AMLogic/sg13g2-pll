* sg13g2-pll :: loop_filter -- generated by design/netlist.sh from loop_filter.sch
* xschem XSCHEM V3.4.7; do not edit by hand.
** sch_path: design/loop_filter.sch
.subckt loop_filter VCTRL VSS
*.iopin VCTRL
*.iopin VSS
XR1 VCTRL NZ sub! rppd w=4u l=120u m=1 b=0
XC1 NZ VSS cap_cmim w=40u l=40u m=1
XC2 VCTRL VSS cap_cmim w=8u l=8u m=1
.ends
