* extracted by klt extract --deck sg13g2

* cell loop_filter_resrppd_w4_l120
* pin vsubs
.SUBCKT loop_filter_resrppd_w4_l120 vsubs
* device instance $1 r0 *1 60.42,2 rppd
X$1 \$1 \$2 vsubs rppd r=7805.81752371 L=120U W=4U
.ENDS loop_filter_resrppd_w4_l120
