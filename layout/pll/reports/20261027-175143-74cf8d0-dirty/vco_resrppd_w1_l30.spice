* extracted by klt extract --deck sg13g2

* cell vco_resrppd_w1_l30
* pin vsubs
.SUBCKT vco_resrppd_w1_l30 vsubs
* device instance $1 r0 *1 15.42,0.5 rppd
X$1 \$1 \$2 vsubs rppd r=7823.47912525 L=30U W=1U
* device instance $2 r0 *1 46.76,0.5 rppd
X$2 \$3 \$4 vsubs rppd r=7823.47912525 L=30U W=1U
.ENDS vco_resrppd_w1_l30
