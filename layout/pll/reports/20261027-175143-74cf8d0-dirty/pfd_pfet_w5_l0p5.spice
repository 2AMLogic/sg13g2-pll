* extracted by klt extract --deck sg13g2

* cell pfd_pfet_w5_l0p5
.SUBCKT pfd_pfet_w5_l0p5
* device instance $1 r0 *1 0.67,2.5 pfet
M$1 \$11 \$1 \$9 \$97 pfet L=0.5U W=5U AS=2.1P AD=2.1P PS=10.84U PD=10.84U
* device instance $2 r0 *1 2.41,2.5 pfet
M$2 \$14 \$2 \$12 \$97 pfet L=0.5U W=5U AS=2.1P AD=2.1P PS=10.84U PD=10.84U
* device instance $3 r0 *1 4.15,2.5 pfet
M$3 \$17 \$3 \$15 \$97 pfet L=0.5U W=5U AS=2.1P AD=2.1P PS=10.84U PD=10.84U
* device instance $4 r0 *1 5.89,2.5 pfet
M$4 \$20 \$4 \$18 \$97 pfet L=0.5U W=5U AS=2.1P AD=2.1P PS=10.84U PD=10.84U
* device instance $5 r0 *1 7.63,2.5 pfet
M$5 \$23 \$5 \$21 \$97 pfet L=0.5U W=5U AS=2.1P AD=2.1P PS=10.84U PD=10.84U
* device instance $6 r0 *1 9.37,2.5 pfet
M$6 \$26 \$6 \$24 \$97 pfet L=0.5U W=5U AS=2.1P AD=2.1P PS=10.84U PD=10.84U
* device instance $7 r0 *1 11.11,2.5 pfet
M$7 \$29 \$7 \$27 \$97 pfet L=0.5U W=5U AS=2.1P AD=2.1P PS=10.84U PD=10.84U
* device instance $8 r0 *1 12.85,2.5 pfet
M$8 \$32 \$8 \$30 \$97 pfet L=0.5U W=5U AS=2.1P AD=2.1P PS=10.84U PD=10.84U
* device instance $9 r0 *1 0.67,8.82 pfet
M$9 \$35 \$10 \$33 \$97 pfet L=0.5U W=5U AS=2.1P AD=2.1P PS=10.84U PD=10.84U
* device instance $10 r0 *1 2.41,8.82 pfet
M$10 \$38 \$13 \$36 \$97 pfet L=0.5U W=5U AS=2.1P AD=2.1P PS=10.84U PD=10.84U
* device instance $11 r0 *1 4.15,8.82 pfet
M$11 \$41 \$16 \$39 \$97 pfet L=0.5U W=5U AS=2.1P AD=2.1P PS=10.84U PD=10.84U
* device instance $12 r0 *1 5.89,8.82 pfet
M$12 \$44 \$19 \$42 \$97 pfet L=0.5U W=5U AS=2.1P AD=2.1P PS=10.84U PD=10.84U
* device instance $13 r0 *1 7.63,8.82 pfet
M$13 \$47 \$22 \$45 \$97 pfet L=0.5U W=5U AS=2.1P AD=2.1P PS=10.84U PD=10.84U
* device instance $14 r0 *1 9.37,8.82 pfet
M$14 \$50 \$25 \$48 \$97 pfet L=0.5U W=5U AS=2.1P AD=2.1P PS=10.84U PD=10.84U
* device instance $15 r0 *1 11.11,8.82 pfet
M$15 \$53 \$28 \$51 \$97 pfet L=0.5U W=5U AS=2.1P AD=2.1P PS=10.84U PD=10.84U
* device instance $16 r0 *1 12.85,8.82 pfet
M$16 \$56 \$31 \$54 \$97 pfet L=0.5U W=5U AS=2.1P AD=2.1P PS=10.84U PD=10.84U
* device instance $17 r0 *1 0.67,15.14 pfet
M$17 \$59 \$34 \$57 \$97 pfet L=0.5U W=5U AS=2.1P AD=2.1P PS=10.84U PD=10.84U
* device instance $18 r0 *1 2.41,15.14 pfet
M$18 \$62 \$37 \$60 \$97 pfet L=0.5U W=5U AS=2.1P AD=2.1P PS=10.84U PD=10.84U
* device instance $19 r0 *1 4.15,15.14 pfet
M$19 \$65 \$40 \$63 \$97 pfet L=0.5U W=5U AS=2.1P AD=2.1P PS=10.84U PD=10.84U
* device instance $20 r0 *1 5.89,15.14 pfet
M$20 \$68 \$43 \$66 \$97 pfet L=0.5U W=5U AS=2.1P AD=2.1P PS=10.84U PD=10.84U
* device instance $21 r0 *1 7.63,15.14 pfet
M$21 \$71 \$46 \$69 \$97 pfet L=0.5U W=5U AS=2.1P AD=2.1P PS=10.84U PD=10.84U
* device instance $22 r0 *1 9.37,15.14 pfet
M$22 \$74 \$49 \$72 \$97 pfet L=0.5U W=5U AS=2.1P AD=2.1P PS=10.84U PD=10.84U
* device instance $23 r0 *1 11.11,15.14 pfet
M$23 \$77 \$52 \$75 \$97 pfet L=0.5U W=5U AS=2.1P AD=2.1P PS=10.84U PD=10.84U
* device instance $24 r0 *1 12.85,15.14 pfet
M$24 \$80 \$55 \$78 \$97 pfet L=0.5U W=5U AS=2.1P AD=2.1P PS=10.84U PD=10.84U
* device instance $25 r0 *1 0.67,21.46 pfet
M$25 \$82 \$58 \$81 \$97 pfet L=0.5U W=5U AS=2.1P AD=2.1P PS=10.84U PD=10.84U
* device instance $26 r0 *1 2.41,21.46 pfet
M$26 \$84 \$61 \$83 \$97 pfet L=0.5U W=5U AS=2.1P AD=2.1P PS=10.84U PD=10.84U
* device instance $27 r0 *1 4.15,21.46 pfet
M$27 \$86 \$64 \$85 \$97 pfet L=0.5U W=5U AS=2.1P AD=2.1P PS=10.84U PD=10.84U
* device instance $28 r0 *1 5.89,21.46 pfet
M$28 \$88 \$67 \$87 \$97 pfet L=0.5U W=5U AS=2.1P AD=2.1P PS=10.84U PD=10.84U
* device instance $29 r0 *1 7.63,21.46 pfet
M$29 \$90 \$70 \$89 \$97 pfet L=0.5U W=5U AS=2.1P AD=2.1P PS=10.84U PD=10.84U
* device instance $30 r0 *1 9.37,21.46 pfet
M$30 \$92 \$73 \$91 \$97 pfet L=0.5U W=5U AS=2.1P AD=2.1P PS=10.84U PD=10.84U
* device instance $31 r0 *1 11.11,21.46 pfet
M$31 \$94 \$76 \$93 \$97 pfet L=0.5U W=5U AS=2.1P AD=2.1P PS=10.84U PD=10.84U
* device instance $32 r0 *1 12.85,21.46 pfet
M$32 \$96 \$79 \$95 \$97 pfet L=0.5U W=5U AS=2.1P AD=2.1P PS=10.84U PD=10.84U
.ENDS pfd_pfet_w5_l0p5
