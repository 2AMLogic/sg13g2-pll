* extracted by klt extract --deck sg13g2

* cell lock_detector_resrhigh_w0p5_l500
* pin vsubs
.SUBCKT lock_detector_resrhigh_w0p5_l500 vsubs
* device instance $1 r0 *1 250.42,0.25 rhigh
X$1 \$1 \$2 vsubs rhigh r=1478580.86957 L=500U W=0.5U
.ENDS lock_detector_resrhigh_w0p5_l500
