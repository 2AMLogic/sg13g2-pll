* extracted by klt extract --deck sg13g2

* cell pll_divider_chain
* pin vsubs
.SUBCKT pll_divider_chain vsubs
* device instance $1 r0 *1 0.67,1 nfet
M$1 \$199 \$1 \$198 vsubs nfet L=0.5U W=2U AS=0.84P AD=0.84P PS=4.84U PD=4.84U
* device instance $2 r0 *1 2.41,1 nfet
M$2 \$201 \$2 \$200 vsubs nfet L=0.5U W=2U AS=0.84P AD=0.84P PS=4.84U PD=4.84U
* device instance $3 r0 *1 4.15,1 nfet
M$3 \$203 \$3 \$202 vsubs nfet L=0.5U W=2U AS=0.84P AD=0.84P PS=4.84U PD=4.84U
* device instance $4 r0 *1 5.89,1 nfet
M$4 \$205 \$4 \$204 vsubs nfet L=0.5U W=2U AS=0.84P AD=0.84P PS=4.84U PD=4.84U
* device instance $5 r0 *1 7.63,1 nfet
M$5 \$207 \$5 \$206 vsubs nfet L=0.5U W=2U AS=0.84P AD=0.84P PS=4.84U PD=4.84U
* device instance $6 r0 *1 9.37,1 nfet
M$6 \$209 \$6 \$208 vsubs nfet L=0.5U W=2U AS=0.84P AD=0.84P PS=4.84U PD=4.84U
* device instance $7 r0 *1 11.11,1 nfet
M$7 \$211 \$7 \$210 vsubs nfet L=0.5U W=2U AS=0.84P AD=0.84P PS=4.84U PD=4.84U
* device instance $8 r0 *1 12.85,1 nfet
M$8 \$213 \$8 \$212 vsubs nfet L=0.5U W=2U AS=0.84P AD=0.84P PS=4.84U PD=4.84U
* device instance $9 r0 *1 14.59,1 nfet
M$9 \$215 \$9 \$214 vsubs nfet L=0.5U W=2U AS=0.84P AD=0.84P PS=4.84U PD=4.84U
* device instance $10 r0 *1 16.33,1 nfet
M$10 \$217 \$10 \$216 vsubs nfet L=0.5U W=2U AS=0.84P AD=0.84P PS=4.84U PD=4.84U
* device instance $11 r0 *1 18.07,1 nfet
M$11 \$219 \$11 \$218 vsubs nfet L=0.5U W=2U AS=0.84P AD=0.84P PS=4.84U PD=4.84U
* device instance $12 r0 *1 19.81,1 nfet
M$12 \$221 \$12 \$220 vsubs nfet L=0.5U W=2U AS=0.84P AD=0.84P PS=4.84U PD=4.84U
* device instance $13 r0 *1 21.55,1 nfet
M$13 \$223 \$13 \$222 vsubs nfet L=0.5U W=2U AS=0.84P AD=0.84P PS=4.84U PD=4.84U
* device instance $14 r0 *1 23.29,1 nfet
M$14 \$225 \$14 \$224 vsubs nfet L=0.5U W=2U AS=0.84P AD=0.84P PS=4.84U PD=4.84U
* device instance $15 r0 *1 25.03,1 nfet
M$15 \$227 \$15 \$226 vsubs nfet L=0.5U W=2U AS=0.84P AD=0.84P PS=4.84U PD=4.84U
* device instance $16 r0 *1 26.77,1 nfet
M$16 \$229 \$16 \$228 vsubs nfet L=0.5U W=2U AS=0.84P AD=0.84P PS=4.84U PD=4.84U
* device instance $17 r0 *1 28.51,1 nfet
M$17 \$231 \$17 \$230 vsubs nfet L=0.5U W=2U AS=0.84P AD=0.84P PS=4.84U PD=4.84U
* device instance $18 r0 *1 30.25,1 nfet
M$18 \$233 \$18 \$232 vsubs nfet L=0.5U W=2U AS=0.84P AD=0.84P PS=4.84U PD=4.84U
* device instance $19 r0 *1 31.99,1 nfet
M$19 \$235 \$19 \$234 vsubs nfet L=0.5U W=2U AS=0.84P AD=0.84P PS=4.84U PD=4.84U
* device instance $20 r0 *1 33.73,1 nfet
M$20 \$237 \$20 \$236 vsubs nfet L=0.5U W=2U AS=0.84P AD=0.84P PS=4.84U PD=4.84U
* device instance $21 r0 *1 35.47,1 nfet
M$21 \$239 \$21 \$238 vsubs nfet L=0.5U W=2U AS=0.84P AD=0.84P PS=4.84U PD=4.84U
* device instance $22 r0 *1 37.21,1 nfet
M$22 \$241 \$22 \$240 vsubs nfet L=0.5U W=2U AS=0.84P AD=0.84P PS=4.84U PD=4.84U
* device instance $23 r0 *1 38.95,1 nfet
M$23 \$243 \$23 \$242 vsubs nfet L=0.5U W=2U AS=0.84P AD=0.84P PS=4.84U PD=4.84U
* device instance $24 r0 *1 40.69,1 nfet
M$24 \$245 \$24 \$244 vsubs nfet L=0.5U W=2U AS=0.84P AD=0.84P PS=4.84U PD=4.84U
* device instance $25 r0 *1 42.43,1 nfet
M$25 \$247 \$25 \$246 vsubs nfet L=0.5U W=2U AS=0.84P AD=0.84P PS=4.84U PD=4.84U
* device instance $26 r0 *1 44.17,1 nfet
M$26 \$249 \$26 \$248 vsubs nfet L=0.5U W=2U AS=0.84P AD=0.84P PS=4.84U PD=4.84U
* device instance $27 r0 *1 45.91,1 nfet
M$27 \$251 \$27 \$250 vsubs nfet L=0.5U W=2U AS=0.84P AD=0.84P PS=4.84U PD=4.84U
* device instance $28 r0 *1 47.65,1 nfet
M$28 \$253 \$28 \$252 vsubs nfet L=0.5U W=2U AS=0.84P AD=0.84P PS=4.84U PD=4.84U
* device instance $29 r0 *1 49.39,1 nfet
M$29 \$255 \$29 \$254 vsubs nfet L=0.5U W=2U AS=0.84P AD=0.84P PS=4.84U PD=4.84U
* device instance $30 r0 *1 51.13,1 nfet
M$30 \$257 \$30 \$256 vsubs nfet L=0.5U W=2U AS=0.84P AD=0.84P PS=4.84U PD=4.84U
* device instance $31 r0 *1 52.87,1 nfet
M$31 \$259 \$31 \$258 vsubs nfet L=0.5U W=2U AS=0.84P AD=0.84P PS=4.84U PD=4.84U
* device instance $32 r0 *1 54.61,1 nfet
M$32 \$261 \$32 \$260 vsubs nfet L=0.5U W=2U AS=0.84P AD=0.84P PS=4.84U PD=4.84U
* device instance $33 r0 *1 56.35,1 nfet
M$33 \$263 \$33 \$262 vsubs nfet L=0.5U W=2U AS=0.84P AD=0.84P PS=4.84U PD=4.84U
* device instance $34 r0 *1 58.09,1 nfet
M$34 \$265 \$34 \$264 vsubs nfet L=0.5U W=2U AS=0.84P AD=0.84P PS=4.84U PD=4.84U
* device instance $35 r0 *1 59.83,1 nfet
M$35 \$267 \$35 \$266 vsubs nfet L=0.5U W=2U AS=0.84P AD=0.84P PS=4.84U PD=4.84U
* device instance $36 r0 *1 61.57,1 nfet
M$36 \$269 \$36 \$268 vsubs nfet L=0.5U W=2U AS=0.84P AD=0.84P PS=4.84U PD=4.84U
* device instance $37 r0 *1 63.31,1 nfet
M$37 \$271 \$37 \$270 vsubs nfet L=0.5U W=2U AS=0.84P AD=0.84P PS=4.84U PD=4.84U
* device instance $38 r0 *1 65.05,1 nfet
M$38 \$273 \$38 \$272 vsubs nfet L=0.5U W=2U AS=0.84P AD=0.84P PS=4.84U PD=4.84U
* device instance $39 r0 *1 66.79,1 nfet
M$39 \$275 \$39 \$274 vsubs nfet L=0.5U W=2U AS=0.84P AD=0.84P PS=4.84U PD=4.84U
* device instance $40 r0 *1 68.53,1 nfet
M$40 \$277 \$40 \$276 vsubs nfet L=0.5U W=2U AS=0.84P AD=0.84P PS=4.84U PD=4.84U
* device instance $41 r0 *1 70.27,1 nfet
M$41 \$279 \$41 \$278 vsubs nfet L=0.5U W=2U AS=0.84P AD=0.84P PS=4.84U PD=4.84U
* device instance $42 r0 *1 72.01,1 nfet
M$42 \$281 \$42 \$280 vsubs nfet L=0.5U W=2U AS=0.84P AD=0.84P PS=4.84U PD=4.84U
* device instance $43 r0 *1 73.75,1 nfet
M$43 \$283 \$43 \$282 vsubs nfet L=0.5U W=2U AS=0.84P AD=0.84P PS=4.84U PD=4.84U
* device instance $44 r0 *1 75.49,1 nfet
M$44 \$285 \$44 \$284 vsubs nfet L=0.5U W=2U AS=0.84P AD=0.84P PS=4.84U PD=4.84U
* device instance $45 r0 *1 77.23,1 nfet
M$45 \$287 \$45 \$286 vsubs nfet L=0.5U W=2U AS=0.84P AD=0.84P PS=4.84U PD=4.84U
* device instance $46 r0 *1 78.97,1 nfet
M$46 \$289 \$46 \$288 vsubs nfet L=0.5U W=2U AS=0.84P AD=0.84P PS=4.84U PD=4.84U
* device instance $47 r0 *1 80.71,1 nfet
M$47 \$291 \$47 \$290 vsubs nfet L=0.5U W=2U AS=0.84P AD=0.84P PS=4.84U PD=4.84U
* device instance $48 r0 *1 82.45,1 nfet
M$48 \$293 \$48 \$292 vsubs nfet L=0.5U W=2U AS=0.84P AD=0.84P PS=4.84U PD=4.84U
* device instance $49 r0 *1 84.19,1 nfet
M$49 \$295 \$49 \$294 vsubs nfet L=0.5U W=2U AS=0.84P AD=0.84P PS=4.84U PD=4.84U
* device instance $50 r0 *1 85.93,1 nfet
M$50 \$297 \$50 \$296 vsubs nfet L=0.5U W=2U AS=0.84P AD=0.84P PS=4.84U PD=4.84U
* device instance $51 r0 *1 87.67,1 nfet
M$51 \$299 \$51 \$298 vsubs nfet L=0.5U W=2U AS=0.84P AD=0.84P PS=4.84U PD=4.84U
* device instance $52 r0 *1 89.41,1 nfet
M$52 \$301 \$52 \$300 vsubs nfet L=0.5U W=2U AS=0.84P AD=0.84P PS=4.84U PD=4.84U
* device instance $53 r0 *1 91.15,1 nfet
M$53 \$303 \$53 \$302 vsubs nfet L=0.5U W=2U AS=0.84P AD=0.84P PS=4.84U PD=4.84U
* device instance $54 r0 *1 92.89,1 nfet
M$54 \$305 \$54 \$304 vsubs nfet L=0.5U W=2U AS=0.84P AD=0.84P PS=4.84U PD=4.84U
* device instance $55 r0 *1 94.63,1 nfet
M$55 \$307 \$55 \$306 vsubs nfet L=0.5U W=2U AS=0.84P AD=0.84P PS=4.84U PD=4.84U
* device instance $56 r0 *1 96.37,1 nfet
M$56 \$309 \$56 \$308 vsubs nfet L=0.5U W=2U AS=0.84P AD=0.84P PS=4.84U PD=4.84U
* device instance $57 r0 *1 98.11,1 nfet
M$57 \$311 \$57 \$310 vsubs nfet L=0.5U W=2U AS=0.84P AD=0.84P PS=4.84U PD=4.84U
* device instance $58 r0 *1 99.85,1 nfet
M$58 \$313 \$58 \$312 vsubs nfet L=0.5U W=2U AS=0.84P AD=0.84P PS=4.84U PD=4.84U
* device instance $59 r0 *1 101.59,1 nfet
M$59 \$315 \$59 \$314 vsubs nfet L=0.5U W=2U AS=0.84P AD=0.84P PS=4.84U PD=4.84U
* device instance $60 r0 *1 103.33,1 nfet
M$60 \$317 \$60 \$316 vsubs nfet L=0.5U W=2U AS=0.84P AD=0.84P PS=4.84U PD=4.84U
* device instance $61 r0 *1 105.07,1 nfet
M$61 \$319 \$61 \$318 vsubs nfet L=0.5U W=2U AS=0.84P AD=0.84P PS=4.84U PD=4.84U
* device instance $62 r0 *1 106.81,1 nfet
M$62 \$321 \$62 \$320 vsubs nfet L=0.5U W=2U AS=0.84P AD=0.84P PS=4.84U PD=4.84U
* device instance $63 r0 *1 108.55,1 nfet
M$63 \$323 \$63 \$322 vsubs nfet L=0.5U W=2U AS=0.84P AD=0.84P PS=4.84U PD=4.84U
* device instance $64 r0 *1 110.29,1 nfet
M$64 \$325 \$64 \$324 vsubs nfet L=0.5U W=2U AS=0.84P AD=0.84P PS=4.84U PD=4.84U
* device instance $65 r0 *1 112.03,1 nfet
M$65 \$327 \$65 \$326 vsubs nfet L=0.5U W=2U AS=0.84P AD=0.84P PS=4.84U PD=4.84U
* device instance $66 r0 *1 113.77,1 nfet
M$66 \$329 \$66 \$328 vsubs nfet L=0.5U W=2U AS=0.84P AD=0.84P PS=4.84U PD=4.84U
* device instance $67 r0 *1 115.51,1 nfet
M$67 \$331 \$67 \$330 vsubs nfet L=0.5U W=2U AS=0.84P AD=0.84P PS=4.84U PD=4.84U
* device instance $68 r0 *1 117.25,1 nfet
M$68 \$333 \$68 \$332 vsubs nfet L=0.5U W=2U AS=0.84P AD=0.84P PS=4.84U PD=4.84U
* device instance $69 r0 *1 118.99,1 nfet
M$69 \$335 \$69 \$334 vsubs nfet L=0.5U W=2U AS=0.84P AD=0.84P PS=4.84U PD=4.84U
* device instance $70 r0 *1 120.73,1 nfet
M$70 \$337 \$70 \$336 vsubs nfet L=0.5U W=2U AS=0.84P AD=0.84P PS=4.84U PD=4.84U
* device instance $71 r0 *1 122.47,1 nfet
M$71 \$339 \$71 \$338 vsubs nfet L=0.5U W=2U AS=0.84P AD=0.84P PS=4.84U PD=4.84U
* device instance $72 r0 *1 124.21,1 nfet
M$72 \$341 \$72 \$340 vsubs nfet L=0.5U W=2U AS=0.84P AD=0.84P PS=4.84U PD=4.84U
* device instance $73 r0 *1 125.95,1 nfet
M$73 \$343 \$73 \$342 vsubs nfet L=0.5U W=2U AS=0.84P AD=0.84P PS=4.84U PD=4.84U
* device instance $74 r0 *1 127.69,1 nfet
M$74 \$345 \$74 \$344 vsubs nfet L=0.5U W=2U AS=0.84P AD=0.84P PS=4.84U PD=4.84U
* device instance $75 r0 *1 129.43,1 nfet
M$75 \$347 \$75 \$346 vsubs nfet L=0.5U W=2U AS=0.84P AD=0.84P PS=4.84U PD=4.84U
* device instance $76 r0 *1 131.17,1 nfet
M$76 \$349 \$76 \$348 vsubs nfet L=0.5U W=2U AS=0.84P AD=0.84P PS=4.84U PD=4.84U
* device instance $77 r0 *1 132.91,1 nfet
M$77 \$351 \$77 \$350 vsubs nfet L=0.5U W=2U AS=0.84P AD=0.84P PS=4.84U PD=4.84U
* device instance $78 r0 *1 134.65,1 nfet
M$78 \$353 \$78 \$352 vsubs nfet L=0.5U W=2U AS=0.84P AD=0.84P PS=4.84U PD=4.84U
* device instance $79 r0 *1 136.39,1 nfet
M$79 \$355 \$79 \$354 vsubs nfet L=0.5U W=2U AS=0.84P AD=0.84P PS=4.84U PD=4.84U
* device instance $80 r0 *1 138.13,1 nfet
M$80 \$357 \$80 \$356 vsubs nfet L=0.5U W=2U AS=0.84P AD=0.84P PS=4.84U PD=4.84U
* device instance $81 r0 *1 139.87,1 nfet
M$81 \$359 \$81 \$358 vsubs nfet L=0.5U W=2U AS=0.84P AD=0.84P PS=4.84U PD=4.84U
* device instance $82 r0 *1 141.61,1 nfet
M$82 \$361 \$82 \$360 vsubs nfet L=0.5U W=2U AS=0.84P AD=0.84P PS=4.84U PD=4.84U
* device instance $83 r0 *1 143.35,1 nfet
M$83 \$363 \$83 \$362 vsubs nfet L=0.5U W=2U AS=0.84P AD=0.84P PS=4.84U PD=4.84U
* device instance $84 r0 *1 145.09,1 nfet
M$84 \$365 \$84 \$364 vsubs nfet L=0.5U W=2U AS=0.84P AD=0.84P PS=4.84U PD=4.84U
* device instance $85 r0 *1 146.83,1 nfet
M$85 \$367 \$85 \$366 vsubs nfet L=0.5U W=2U AS=0.84P AD=0.84P PS=4.84U PD=4.84U
* device instance $86 r0 *1 148.57,1 nfet
M$86 \$369 \$86 \$368 vsubs nfet L=0.5U W=2U AS=0.84P AD=0.84P PS=4.84U PD=4.84U
* device instance $87 r0 *1 150.31,1 nfet
M$87 \$371 \$87 \$370 vsubs nfet L=0.5U W=2U AS=0.84P AD=0.84P PS=4.84U PD=4.84U
* device instance $88 r0 *1 152.05,1 nfet
M$88 \$373 \$88 \$372 vsubs nfet L=0.5U W=2U AS=0.84P AD=0.84P PS=4.84U PD=4.84U
* device instance $89 r0 *1 153.79,1 nfet
M$89 \$375 \$89 \$374 vsubs nfet L=0.5U W=2U AS=0.84P AD=0.84P PS=4.84U PD=4.84U
* device instance $90 r0 *1 155.53,1 nfet
M$90 \$377 \$90 \$376 vsubs nfet L=0.5U W=2U AS=0.84P AD=0.84P PS=4.84U PD=4.84U
* device instance $91 r0 *1 157.27,1 nfet
M$91 \$379 \$91 \$378 vsubs nfet L=0.5U W=2U AS=0.84P AD=0.84P PS=4.84U PD=4.84U
* device instance $92 r0 *1 159.01,1 nfet
M$92 \$381 \$92 \$380 vsubs nfet L=0.5U W=2U AS=0.84P AD=0.84P PS=4.84U PD=4.84U
* device instance $93 r0 *1 160.75,1 nfet
M$93 \$383 \$93 \$382 vsubs nfet L=0.5U W=2U AS=0.84P AD=0.84P PS=4.84U PD=4.84U
* device instance $94 r0 *1 162.49,1 nfet
M$94 \$385 \$94 \$384 vsubs nfet L=0.5U W=2U AS=0.84P AD=0.84P PS=4.84U PD=4.84U
* device instance $95 r0 *1 164.23,1 nfet
M$95 \$387 \$95 \$386 vsubs nfet L=0.5U W=2U AS=0.84P AD=0.84P PS=4.84U PD=4.84U
* device instance $96 r0 *1 165.97,1 nfet
M$96 \$389 \$96 \$388 vsubs nfet L=0.5U W=2U AS=0.84P AD=0.84P PS=4.84U PD=4.84U
* device instance $97 r0 *1 167.71,1 nfet
M$97 \$391 \$97 \$390 vsubs nfet L=0.5U W=2U AS=0.84P AD=0.84P PS=4.84U PD=4.84U
* device instance $98 r0 *1 169.45,1 nfet
M$98 \$393 \$98 \$392 vsubs nfet L=0.5U W=2U AS=0.84P AD=0.84P PS=4.84U PD=4.84U
* device instance $99 r0 *1 171.19,1 nfet
M$99 \$395 \$99 \$394 vsubs nfet L=0.5U W=2U AS=0.84P AD=0.84P PS=4.84U PD=4.84U
* device instance $100 r0 *1 172.93,1 nfet
M$100 \$397 \$100 \$396 vsubs nfet L=0.5U W=2U AS=0.84P AD=0.84P PS=4.84U
+ PD=4.84U
* device instance $101 r0 *1 174.67,1 nfet
M$101 \$399 \$101 \$398 vsubs nfet L=0.5U W=2U AS=0.84P AD=0.84P PS=4.84U
+ PD=4.84U
* device instance $102 r0 *1 176.41,1 nfet
M$102 \$401 \$102 \$400 vsubs nfet L=0.5U W=2U AS=0.84P AD=0.84P PS=4.84U
+ PD=4.84U
* device instance $103 r0 *1 178.15,1 nfet
M$103 \$403 \$103 \$402 vsubs nfet L=0.5U W=2U AS=0.84P AD=0.84P PS=4.84U
+ PD=4.84U
* device instance $104 r0 *1 179.89,1 nfet
M$104 \$405 \$104 \$404 vsubs nfet L=0.5U W=2U AS=0.84P AD=0.84P PS=4.84U
+ PD=4.84U
* device instance $105 r0 *1 181.63,1 nfet
M$105 \$407 \$105 \$406 vsubs nfet L=0.5U W=2U AS=0.84P AD=0.84P PS=4.84U
+ PD=4.84U
* device instance $106 r0 *1 183.37,1 nfet
M$106 \$409 \$106 \$408 vsubs nfet L=0.5U W=2U AS=0.84P AD=0.84P PS=4.84U
+ PD=4.84U
* device instance $107 r0 *1 185.11,1 nfet
M$107 \$411 \$107 \$410 vsubs nfet L=0.5U W=2U AS=0.84P AD=0.84P PS=4.84U
+ PD=4.84U
* device instance $108 r0 *1 186.85,1 nfet
M$108 \$413 \$108 \$412 vsubs nfet L=0.5U W=2U AS=0.84P AD=0.84P PS=4.84U
+ PD=4.84U
* device instance $109 r0 *1 188.59,1 nfet
M$109 \$415 \$109 \$414 vsubs nfet L=0.5U W=2U AS=0.84P AD=0.84P PS=4.84U
+ PD=4.84U
* device instance $110 r0 *1 190.33,1 nfet
M$110 \$417 \$110 \$416 vsubs nfet L=0.5U W=2U AS=0.84P AD=0.84P PS=4.84U
+ PD=4.84U
* device instance $111 r0 *1 192.07,1 nfet
M$111 \$419 \$111 \$418 vsubs nfet L=0.5U W=2U AS=0.84P AD=0.84P PS=4.84U
+ PD=4.84U
* device instance $112 r0 *1 193.81,1 nfet
M$112 \$421 \$112 \$420 vsubs nfet L=0.5U W=2U AS=0.84P AD=0.84P PS=4.84U
+ PD=4.84U
* device instance $113 r0 *1 195.55,1 nfet
M$113 \$423 \$113 \$422 vsubs nfet L=0.5U W=2U AS=0.84P AD=0.84P PS=4.84U
+ PD=4.84U
* device instance $114 r0 *1 197.29,1 nfet
M$114 \$425 \$114 \$424 vsubs nfet L=0.5U W=2U AS=0.84P AD=0.84P PS=4.84U
+ PD=4.84U
* device instance $115 r0 *1 199.03,1 nfet
M$115 \$427 \$115 \$426 vsubs nfet L=0.5U W=2U AS=0.84P AD=0.84P PS=4.84U
+ PD=4.84U
* device instance $116 r0 *1 200.77,1 nfet
M$116 \$429 \$116 \$428 vsubs nfet L=0.5U W=2U AS=0.84P AD=0.84P PS=4.84U
+ PD=4.84U
* device instance $117 r0 *1 202.51,1 nfet
M$117 \$431 \$117 \$430 vsubs nfet L=0.5U W=2U AS=0.84P AD=0.84P PS=4.84U
+ PD=4.84U
* device instance $118 r0 *1 204.25,1 nfet
M$118 \$433 \$118 \$432 vsubs nfet L=0.5U W=2U AS=0.84P AD=0.84P PS=4.84U
+ PD=4.84U
* device instance $119 r0 *1 205.99,1 nfet
M$119 \$435 \$119 \$434 vsubs nfet L=0.5U W=2U AS=0.84P AD=0.84P PS=4.84U
+ PD=4.84U
* device instance $120 r0 *1 207.73,1 nfet
M$120 \$437 \$120 \$436 vsubs nfet L=0.5U W=2U AS=0.84P AD=0.84P PS=4.84U
+ PD=4.84U
* device instance $121 r0 *1 209.47,1 nfet
M$121 \$439 \$121 \$438 vsubs nfet L=0.5U W=2U AS=0.84P AD=0.84P PS=4.84U
+ PD=4.84U
* device instance $122 r0 *1 211.21,1 nfet
M$122 \$441 \$122 \$440 vsubs nfet L=0.5U W=2U AS=0.84P AD=0.84P PS=4.84U
+ PD=4.84U
* device instance $123 r0 *1 212.95,1 nfet
M$123 \$443 \$123 \$442 vsubs nfet L=0.5U W=2U AS=0.84P AD=0.84P PS=4.84U
+ PD=4.84U
* device instance $124 r0 *1 214.69,1 nfet
M$124 \$445 \$124 \$444 vsubs nfet L=0.5U W=2U AS=0.84P AD=0.84P PS=4.84U
+ PD=4.84U
* device instance $125 r0 *1 216.43,1 nfet
M$125 \$447 \$125 \$446 vsubs nfet L=0.5U W=2U AS=0.84P AD=0.84P PS=4.84U
+ PD=4.84U
* device instance $126 r0 *1 218.17,1 nfet
M$126 \$449 \$126 \$448 vsubs nfet L=0.5U W=2U AS=0.84P AD=0.84P PS=4.84U
+ PD=4.84U
* device instance $127 r0 *1 219.91,1 nfet
M$127 \$451 \$127 \$450 vsubs nfet L=0.5U W=2U AS=0.84P AD=0.84P PS=4.84U
+ PD=4.84U
* device instance $128 r0 *1 221.65,1 nfet
M$128 \$453 \$128 \$452 vsubs nfet L=0.5U W=2U AS=0.84P AD=0.84P PS=4.84U
+ PD=4.84U
* device instance $129 r0 *1 223.39,1 nfet
M$129 \$455 \$129 \$454 vsubs nfet L=0.5U W=2U AS=0.84P AD=0.84P PS=4.84U
+ PD=4.84U
* device instance $130 r0 *1 225.13,1 nfet
M$130 \$457 \$130 \$456 vsubs nfet L=0.5U W=2U AS=0.84P AD=0.84P PS=4.84U
+ PD=4.84U
* device instance $131 r0 *1 226.87,1 nfet
M$131 \$459 \$131 \$458 vsubs nfet L=0.5U W=2U AS=0.84P AD=0.84P PS=4.84U
+ PD=4.84U
* device instance $132 r0 *1 228.61,1 nfet
M$132 \$461 \$132 \$460 vsubs nfet L=0.5U W=2U AS=0.84P AD=0.84P PS=4.84U
+ PD=4.84U
* device instance $133 r0 *1 230.35,1 nfet
M$133 \$463 \$133 \$462 vsubs nfet L=0.5U W=2U AS=0.84P AD=0.84P PS=4.84U
+ PD=4.84U
* device instance $134 r0 *1 232.09,1 nfet
M$134 \$465 \$134 \$464 vsubs nfet L=0.5U W=2U AS=0.84P AD=0.84P PS=4.84U
+ PD=4.84U
* device instance $135 r0 *1 233.83,1 nfet
M$135 \$467 \$135 \$466 vsubs nfet L=0.5U W=2U AS=0.84P AD=0.84P PS=4.84U
+ PD=4.84U
* device instance $136 r0 *1 235.57,1 nfet
M$136 \$469 \$136 \$468 vsubs nfet L=0.5U W=2U AS=0.84P AD=0.84P PS=4.84U
+ PD=4.84U
* device instance $137 r0 *1 237.31,1 nfet
M$137 \$471 \$137 \$470 vsubs nfet L=0.5U W=2U AS=0.84P AD=0.84P PS=4.84U
+ PD=4.84U
* device instance $138 r0 *1 239.05,1 nfet
M$138 \$473 \$138 \$472 vsubs nfet L=0.5U W=2U AS=0.84P AD=0.84P PS=4.84U
+ PD=4.84U
* device instance $139 r0 *1 240.79,1 nfet
M$139 \$475 \$139 \$474 vsubs nfet L=0.5U W=2U AS=0.84P AD=0.84P PS=4.84U
+ PD=4.84U
* device instance $140 r0 *1 242.53,1 nfet
M$140 \$477 \$140 \$476 vsubs nfet L=0.5U W=2U AS=0.84P AD=0.84P PS=4.84U
+ PD=4.84U
* device instance $141 r0 *1 244.27,1 nfet
M$141 \$479 \$141 \$478 vsubs nfet L=0.5U W=2U AS=0.84P AD=0.84P PS=4.84U
+ PD=4.84U
* device instance $142 r0 *1 246.01,1 nfet
M$142 \$481 \$142 \$480 vsubs nfet L=0.5U W=2U AS=0.84P AD=0.84P PS=4.84U
+ PD=4.84U
* device instance $143 r0 *1 247.75,1 nfet
M$143 \$483 \$143 \$482 vsubs nfet L=0.5U W=2U AS=0.84P AD=0.84P PS=4.84U
+ PD=4.84U
* device instance $144 r0 *1 249.49,1 nfet
M$144 \$485 \$144 \$484 vsubs nfet L=0.5U W=2U AS=0.84P AD=0.84P PS=4.84U
+ PD=4.84U
* device instance $145 r0 *1 251.23,1 nfet
M$145 \$487 \$145 \$486 vsubs nfet L=0.5U W=2U AS=0.84P AD=0.84P PS=4.84U
+ PD=4.84U
* device instance $146 r0 *1 252.97,1 nfet
M$146 \$489 \$146 \$488 vsubs nfet L=0.5U W=2U AS=0.84P AD=0.84P PS=4.84U
+ PD=4.84U
* device instance $147 r0 *1 254.71,1 nfet
M$147 \$491 \$147 \$490 vsubs nfet L=0.5U W=2U AS=0.84P AD=0.84P PS=4.84U
+ PD=4.84U
* device instance $148 r0 *1 256.45,1 nfet
M$148 \$493 \$148 \$492 vsubs nfet L=0.5U W=2U AS=0.84P AD=0.84P PS=4.84U
+ PD=4.84U
* device instance $149 r0 *1 258.19,1 nfet
M$149 \$495 \$149 \$494 vsubs nfet L=0.5U W=2U AS=0.84P AD=0.84P PS=4.84U
+ PD=4.84U
* device instance $150 r0 *1 259.93,1 nfet
M$150 \$497 \$150 \$496 vsubs nfet L=0.5U W=2U AS=0.84P AD=0.84P PS=4.84U
+ PD=4.84U
* device instance $151 r0 *1 261.67,1 nfet
M$151 \$499 \$151 \$498 vsubs nfet L=0.5U W=2U AS=0.84P AD=0.84P PS=4.84U
+ PD=4.84U
* device instance $152 r0 *1 263.41,1 nfet
M$152 \$501 \$152 \$500 vsubs nfet L=0.5U W=2U AS=0.84P AD=0.84P PS=4.84U
+ PD=4.84U
* device instance $153 r0 *1 265.15,1 nfet
M$153 \$503 \$153 \$502 vsubs nfet L=0.5U W=2U AS=0.84P AD=0.84P PS=4.84U
+ PD=4.84U
* device instance $154 r0 *1 266.89,1 nfet
M$154 \$505 \$154 \$504 vsubs nfet L=0.5U W=2U AS=0.84P AD=0.84P PS=4.84U
+ PD=4.84U
* device instance $155 r0 *1 268.63,1 nfet
M$155 \$507 \$155 \$506 vsubs nfet L=0.5U W=2U AS=0.84P AD=0.84P PS=4.84U
+ PD=4.84U
* device instance $156 r0 *1 270.37,1 nfet
M$156 \$509 \$156 \$508 vsubs nfet L=0.5U W=2U AS=0.84P AD=0.84P PS=4.84U
+ PD=4.84U
* device instance $157 r0 *1 272.11,1 nfet
M$157 \$511 \$157 \$510 vsubs nfet L=0.5U W=2U AS=0.84P AD=0.84P PS=4.84U
+ PD=4.84U
* device instance $158 r0 *1 273.85,1 nfet
M$158 \$513 \$158 \$512 vsubs nfet L=0.5U W=2U AS=0.84P AD=0.84P PS=4.84U
+ PD=4.84U
* device instance $159 r0 *1 275.59,1 nfet
M$159 \$515 \$159 \$514 vsubs nfet L=0.5U W=2U AS=0.84P AD=0.84P PS=4.84U
+ PD=4.84U
* device instance $160 r0 *1 277.33,1 nfet
M$160 \$517 \$160 \$516 vsubs nfet L=0.5U W=2U AS=0.84P AD=0.84P PS=4.84U
+ PD=4.84U
* device instance $161 r0 *1 279.07,1 nfet
M$161 \$519 \$161 \$518 vsubs nfet L=0.5U W=2U AS=0.84P AD=0.84P PS=4.84U
+ PD=4.84U
* device instance $162 r0 *1 280.81,1 nfet
M$162 \$521 \$162 \$520 vsubs nfet L=0.5U W=2U AS=0.84P AD=0.84P PS=4.84U
+ PD=4.84U
* device instance $163 r0 *1 282.55,1 nfet
M$163 \$523 \$163 \$522 vsubs nfet L=0.5U W=2U AS=0.84P AD=0.84P PS=4.84U
+ PD=4.84U
* device instance $164 r0 *1 284.29,1 nfet
M$164 \$525 \$164 \$524 vsubs nfet L=0.5U W=2U AS=0.84P AD=0.84P PS=4.84U
+ PD=4.84U
* device instance $165 r0 *1 286.03,1 nfet
M$165 \$527 \$165 \$526 vsubs nfet L=0.5U W=2U AS=0.84P AD=0.84P PS=4.84U
+ PD=4.84U
* device instance $166 r0 *1 287.77,1 nfet
M$166 \$529 \$166 \$528 vsubs nfet L=0.5U W=2U AS=0.84P AD=0.84P PS=4.84U
+ PD=4.84U
* device instance $167 r0 *1 289.51,1 nfet
M$167 \$531 \$167 \$530 vsubs nfet L=0.5U W=2U AS=0.84P AD=0.84P PS=4.84U
+ PD=4.84U
* device instance $168 r0 *1 291.25,1 nfet
M$168 \$533 \$168 \$532 vsubs nfet L=0.5U W=2U AS=0.84P AD=0.84P PS=4.84U
+ PD=4.84U
* device instance $169 r0 *1 292.99,1 nfet
M$169 \$535 \$169 \$534 vsubs nfet L=0.5U W=2U AS=0.84P AD=0.84P PS=4.84U
+ PD=4.84U
* device instance $170 r0 *1 294.73,1 nfet
M$170 \$537 \$170 \$536 vsubs nfet L=0.5U W=2U AS=0.84P AD=0.84P PS=4.84U
+ PD=4.84U
* device instance $171 r0 *1 296.47,1 nfet
M$171 \$539 \$171 \$538 vsubs nfet L=0.5U W=2U AS=0.84P AD=0.84P PS=4.84U
+ PD=4.84U
* device instance $172 r0 *1 298.21,1 nfet
M$172 \$541 \$172 \$540 vsubs nfet L=0.5U W=2U AS=0.84P AD=0.84P PS=4.84U
+ PD=4.84U
* device instance $173 r0 *1 299.95,1 nfet
M$173 \$543 \$173 \$542 vsubs nfet L=0.5U W=2U AS=0.84P AD=0.84P PS=4.84U
+ PD=4.84U
* device instance $174 r0 *1 301.69,1 nfet
M$174 \$545 \$174 \$544 vsubs nfet L=0.5U W=2U AS=0.84P AD=0.84P PS=4.84U
+ PD=4.84U
* device instance $175 r0 *1 303.43,1 nfet
M$175 \$547 \$175 \$546 vsubs nfet L=0.5U W=2U AS=0.84P AD=0.84P PS=4.84U
+ PD=4.84U
* device instance $176 r0 *1 305.17,1 nfet
M$176 \$549 \$176 \$548 vsubs nfet L=0.5U W=2U AS=0.84P AD=0.84P PS=4.84U
+ PD=4.84U
* device instance $177 r0 *1 306.91,1 nfet
M$177 \$551 \$177 \$550 vsubs nfet L=0.5U W=2U AS=0.84P AD=0.84P PS=4.84U
+ PD=4.84U
* device instance $178 r0 *1 308.65,1 nfet
M$178 \$553 \$178 \$552 vsubs nfet L=0.5U W=2U AS=0.84P AD=0.84P PS=4.84U
+ PD=4.84U
* device instance $179 r0 *1 310.39,1 nfet
M$179 \$555 \$179 \$554 vsubs nfet L=0.5U W=2U AS=0.84P AD=0.84P PS=4.84U
+ PD=4.84U
* device instance $180 r0 *1 312.13,1 nfet
M$180 \$557 \$180 \$556 vsubs nfet L=0.5U W=2U AS=0.84P AD=0.84P PS=4.84U
+ PD=4.84U
* device instance $181 r0 *1 313.87,1 nfet
M$181 \$559 \$181 \$558 vsubs nfet L=0.5U W=2U AS=0.84P AD=0.84P PS=4.84U
+ PD=4.84U
* device instance $182 r0 *1 315.61,1 nfet
M$182 \$561 \$182 \$560 vsubs nfet L=0.5U W=2U AS=0.84P AD=0.84P PS=4.84U
+ PD=4.84U
* device instance $183 r0 *1 317.35,1 nfet
M$183 \$563 \$183 \$562 vsubs nfet L=0.5U W=2U AS=0.84P AD=0.84P PS=4.84U
+ PD=4.84U
* device instance $184 r0 *1 319.09,1 nfet
M$184 \$565 \$184 \$564 vsubs nfet L=0.5U W=2U AS=0.84P AD=0.84P PS=4.84U
+ PD=4.84U
* device instance $185 r0 *1 320.83,1 nfet
M$185 \$567 \$185 \$566 vsubs nfet L=0.5U W=2U AS=0.84P AD=0.84P PS=4.84U
+ PD=4.84U
* device instance $186 r0 *1 322.57,1 nfet
M$186 \$569 \$186 \$568 vsubs nfet L=0.5U W=2U AS=0.84P AD=0.84P PS=4.84U
+ PD=4.84U
* device instance $187 r0 *1 324.31,1 nfet
M$187 \$571 \$187 \$570 vsubs nfet L=0.5U W=2U AS=0.84P AD=0.84P PS=4.84U
+ PD=4.84U
* device instance $188 r0 *1 326.05,1 nfet
M$188 \$573 \$188 \$572 vsubs nfet L=0.5U W=2U AS=0.84P AD=0.84P PS=4.84U
+ PD=4.84U
* device instance $189 r0 *1 327.79,1 nfet
M$189 \$575 \$189 \$574 vsubs nfet L=0.5U W=2U AS=0.84P AD=0.84P PS=4.84U
+ PD=4.84U
* device instance $190 r0 *1 329.53,1 nfet
M$190 \$577 \$190 \$576 vsubs nfet L=0.5U W=2U AS=0.84P AD=0.84P PS=4.84U
+ PD=4.84U
* device instance $191 r0 *1 331.27,1 nfet
M$191 \$579 \$191 \$578 vsubs nfet L=0.5U W=2U AS=0.84P AD=0.84P PS=4.84U
+ PD=4.84U
* device instance $192 r0 *1 333.01,1 nfet
M$192 \$581 \$192 \$580 vsubs nfet L=0.5U W=2U AS=0.84P AD=0.84P PS=4.84U
+ PD=4.84U
* device instance $193 r0 *1 334.75,1 nfet
M$193 \$583 \$193 \$582 vsubs nfet L=0.5U W=2U AS=0.84P AD=0.84P PS=4.84U
+ PD=4.84U
* device instance $194 r0 *1 336.49,1 nfet
M$194 \$585 \$194 \$584 vsubs nfet L=0.5U W=2U AS=0.84P AD=0.84P PS=4.84U
+ PD=4.84U
* device instance $195 r0 *1 338.23,1 nfet
M$195 \$587 \$195 \$586 vsubs nfet L=0.5U W=2U AS=0.84P AD=0.84P PS=4.84U
+ PD=4.84U
* device instance $196 r0 *1 339.97,1 nfet
M$196 \$589 \$196 \$588 vsubs nfet L=0.5U W=2U AS=0.84P AD=0.84P PS=4.84U
+ PD=4.84U
* device instance $197 r0 *1 341.71,1 nfet
M$197 \$591 \$197 \$590 vsubs nfet L=0.5U W=2U AS=0.84P AD=0.84P PS=4.84U
+ PD=4.84U
* device instance $198 r0 *1 0.67,9.42 pfet
M$198 \$790 \$592 \$789 \$1183 pfet L=0.5U W=5U AS=2.1P AD=2.1P PS=10.84U
+ PD=10.84U
* device instance $199 r0 *1 2.41,9.42 pfet
M$199 \$792 \$593 \$791 \$1183 pfet L=0.5U W=5U AS=2.1P AD=2.1P PS=10.84U
+ PD=10.84U
* device instance $200 r0 *1 4.15,9.42 pfet
M$200 \$794 \$594 \$793 \$1183 pfet L=0.5U W=5U AS=2.1P AD=2.1P PS=10.84U
+ PD=10.84U
* device instance $201 r0 *1 5.89,9.42 pfet
M$201 \$796 \$595 \$795 \$1183 pfet L=0.5U W=5U AS=2.1P AD=2.1P PS=10.84U
+ PD=10.84U
* device instance $202 r0 *1 7.63,9.42 pfet
M$202 \$798 \$596 \$797 \$1183 pfet L=0.5U W=5U AS=2.1P AD=2.1P PS=10.84U
+ PD=10.84U
* device instance $203 r0 *1 9.37,9.42 pfet
M$203 \$800 \$597 \$799 \$1183 pfet L=0.5U W=5U AS=2.1P AD=2.1P PS=10.84U
+ PD=10.84U
* device instance $204 r0 *1 11.11,9.42 pfet
M$204 \$802 \$598 \$801 \$1183 pfet L=0.5U W=5U AS=2.1P AD=2.1P PS=10.84U
+ PD=10.84U
* device instance $205 r0 *1 12.85,9.42 pfet
M$205 \$804 \$599 \$803 \$1183 pfet L=0.5U W=5U AS=2.1P AD=2.1P PS=10.84U
+ PD=10.84U
* device instance $206 r0 *1 14.59,9.42 pfet
M$206 \$806 \$600 \$805 \$1183 pfet L=0.5U W=5U AS=2.1P AD=2.1P PS=10.84U
+ PD=10.84U
* device instance $207 r0 *1 16.33,9.42 pfet
M$207 \$808 \$601 \$807 \$1183 pfet L=0.5U W=5U AS=2.1P AD=2.1P PS=10.84U
+ PD=10.84U
* device instance $208 r0 *1 18.07,9.42 pfet
M$208 \$810 \$602 \$809 \$1183 pfet L=0.5U W=5U AS=2.1P AD=2.1P PS=10.84U
+ PD=10.84U
* device instance $209 r0 *1 19.81,9.42 pfet
M$209 \$812 \$603 \$811 \$1183 pfet L=0.5U W=5U AS=2.1P AD=2.1P PS=10.84U
+ PD=10.84U
* device instance $210 r0 *1 21.55,9.42 pfet
M$210 \$814 \$604 \$813 \$1183 pfet L=0.5U W=5U AS=2.1P AD=2.1P PS=10.84U
+ PD=10.84U
* device instance $211 r0 *1 23.29,9.42 pfet
M$211 \$816 \$605 \$815 \$1183 pfet L=0.5U W=5U AS=2.1P AD=2.1P PS=10.84U
+ PD=10.84U
* device instance $212 r0 *1 25.03,9.42 pfet
M$212 \$818 \$606 \$817 \$1183 pfet L=0.5U W=5U AS=2.1P AD=2.1P PS=10.84U
+ PD=10.84U
* device instance $213 r0 *1 26.77,9.42 pfet
M$213 \$820 \$607 \$819 \$1183 pfet L=0.5U W=5U AS=2.1P AD=2.1P PS=10.84U
+ PD=10.84U
* device instance $214 r0 *1 28.51,9.42 pfet
M$214 \$822 \$608 \$821 \$1183 pfet L=0.5U W=5U AS=2.1P AD=2.1P PS=10.84U
+ PD=10.84U
* device instance $215 r0 *1 30.25,9.42 pfet
M$215 \$824 \$609 \$823 \$1183 pfet L=0.5U W=5U AS=2.1P AD=2.1P PS=10.84U
+ PD=10.84U
* device instance $216 r0 *1 31.99,9.42 pfet
M$216 \$826 \$610 \$825 \$1183 pfet L=0.5U W=5U AS=2.1P AD=2.1P PS=10.84U
+ PD=10.84U
* device instance $217 r0 *1 33.73,9.42 pfet
M$217 \$828 \$611 \$827 \$1183 pfet L=0.5U W=5U AS=2.1P AD=2.1P PS=10.84U
+ PD=10.84U
* device instance $218 r0 *1 35.47,9.42 pfet
M$218 \$830 \$612 \$829 \$1183 pfet L=0.5U W=5U AS=2.1P AD=2.1P PS=10.84U
+ PD=10.84U
* device instance $219 r0 *1 37.21,9.42 pfet
M$219 \$832 \$613 \$831 \$1183 pfet L=0.5U W=5U AS=2.1P AD=2.1P PS=10.84U
+ PD=10.84U
* device instance $220 r0 *1 38.95,9.42 pfet
M$220 \$834 \$614 \$833 \$1183 pfet L=0.5U W=5U AS=2.1P AD=2.1P PS=10.84U
+ PD=10.84U
* device instance $221 r0 *1 40.69,9.42 pfet
M$221 \$836 \$615 \$835 \$1183 pfet L=0.5U W=5U AS=2.1P AD=2.1P PS=10.84U
+ PD=10.84U
* device instance $222 r0 *1 42.43,9.42 pfet
M$222 \$838 \$616 \$837 \$1183 pfet L=0.5U W=5U AS=2.1P AD=2.1P PS=10.84U
+ PD=10.84U
* device instance $223 r0 *1 44.17,9.42 pfet
M$223 \$840 \$617 \$839 \$1183 pfet L=0.5U W=5U AS=2.1P AD=2.1P PS=10.84U
+ PD=10.84U
* device instance $224 r0 *1 45.91,9.42 pfet
M$224 \$842 \$618 \$841 \$1183 pfet L=0.5U W=5U AS=2.1P AD=2.1P PS=10.84U
+ PD=10.84U
* device instance $225 r0 *1 47.65,9.42 pfet
M$225 \$844 \$619 \$843 \$1183 pfet L=0.5U W=5U AS=2.1P AD=2.1P PS=10.84U
+ PD=10.84U
* device instance $226 r0 *1 49.39,9.42 pfet
M$226 \$846 \$620 \$845 \$1183 pfet L=0.5U W=5U AS=2.1P AD=2.1P PS=10.84U
+ PD=10.84U
* device instance $227 r0 *1 51.13,9.42 pfet
M$227 \$848 \$621 \$847 \$1183 pfet L=0.5U W=5U AS=2.1P AD=2.1P PS=10.84U
+ PD=10.84U
* device instance $228 r0 *1 52.87,9.42 pfet
M$228 \$850 \$622 \$849 \$1183 pfet L=0.5U W=5U AS=2.1P AD=2.1P PS=10.84U
+ PD=10.84U
* device instance $229 r0 *1 54.61,9.42 pfet
M$229 \$852 \$623 \$851 \$1183 pfet L=0.5U W=5U AS=2.1P AD=2.1P PS=10.84U
+ PD=10.84U
* device instance $230 r0 *1 56.35,9.42 pfet
M$230 \$854 \$624 \$853 \$1183 pfet L=0.5U W=5U AS=2.1P AD=2.1P PS=10.84U
+ PD=10.84U
* device instance $231 r0 *1 58.09,9.42 pfet
M$231 \$856 \$625 \$855 \$1183 pfet L=0.5U W=5U AS=2.1P AD=2.1P PS=10.84U
+ PD=10.84U
* device instance $232 r0 *1 59.83,9.42 pfet
M$232 \$858 \$626 \$857 \$1183 pfet L=0.5U W=5U AS=2.1P AD=2.1P PS=10.84U
+ PD=10.84U
* device instance $233 r0 *1 61.57,9.42 pfet
M$233 \$860 \$627 \$859 \$1183 pfet L=0.5U W=5U AS=2.1P AD=2.1P PS=10.84U
+ PD=10.84U
* device instance $234 r0 *1 63.31,9.42 pfet
M$234 \$862 \$628 \$861 \$1183 pfet L=0.5U W=5U AS=2.1P AD=2.1P PS=10.84U
+ PD=10.84U
* device instance $235 r0 *1 65.05,9.42 pfet
M$235 \$864 \$629 \$863 \$1183 pfet L=0.5U W=5U AS=2.1P AD=2.1P PS=10.84U
+ PD=10.84U
* device instance $236 r0 *1 66.79,9.42 pfet
M$236 \$866 \$630 \$865 \$1183 pfet L=0.5U W=5U AS=2.1P AD=2.1P PS=10.84U
+ PD=10.84U
* device instance $237 r0 *1 68.53,9.42 pfet
M$237 \$868 \$631 \$867 \$1183 pfet L=0.5U W=5U AS=2.1P AD=2.1P PS=10.84U
+ PD=10.84U
* device instance $238 r0 *1 70.27,9.42 pfet
M$238 \$870 \$632 \$869 \$1183 pfet L=0.5U W=5U AS=2.1P AD=2.1P PS=10.84U
+ PD=10.84U
* device instance $239 r0 *1 72.01,9.42 pfet
M$239 \$872 \$633 \$871 \$1183 pfet L=0.5U W=5U AS=2.1P AD=2.1P PS=10.84U
+ PD=10.84U
* device instance $240 r0 *1 73.75,9.42 pfet
M$240 \$874 \$634 \$873 \$1183 pfet L=0.5U W=5U AS=2.1P AD=2.1P PS=10.84U
+ PD=10.84U
* device instance $241 r0 *1 75.49,9.42 pfet
M$241 \$876 \$635 \$875 \$1183 pfet L=0.5U W=5U AS=2.1P AD=2.1P PS=10.84U
+ PD=10.84U
* device instance $242 r0 *1 77.23,9.42 pfet
M$242 \$878 \$636 \$877 \$1183 pfet L=0.5U W=5U AS=2.1P AD=2.1P PS=10.84U
+ PD=10.84U
* device instance $243 r0 *1 78.97,9.42 pfet
M$243 \$880 \$637 \$879 \$1183 pfet L=0.5U W=5U AS=2.1P AD=2.1P PS=10.84U
+ PD=10.84U
* device instance $244 r0 *1 80.71,9.42 pfet
M$244 \$882 \$638 \$881 \$1183 pfet L=0.5U W=5U AS=2.1P AD=2.1P PS=10.84U
+ PD=10.84U
* device instance $245 r0 *1 82.45,9.42 pfet
M$245 \$884 \$639 \$883 \$1183 pfet L=0.5U W=5U AS=2.1P AD=2.1P PS=10.84U
+ PD=10.84U
* device instance $246 r0 *1 84.19,9.42 pfet
M$246 \$886 \$640 \$885 \$1183 pfet L=0.5U W=5U AS=2.1P AD=2.1P PS=10.84U
+ PD=10.84U
* device instance $247 r0 *1 85.93,9.42 pfet
M$247 \$888 \$641 \$887 \$1183 pfet L=0.5U W=5U AS=2.1P AD=2.1P PS=10.84U
+ PD=10.84U
* device instance $248 r0 *1 87.67,9.42 pfet
M$248 \$890 \$642 \$889 \$1183 pfet L=0.5U W=5U AS=2.1P AD=2.1P PS=10.84U
+ PD=10.84U
* device instance $249 r0 *1 89.41,9.42 pfet
M$249 \$892 \$643 \$891 \$1183 pfet L=0.5U W=5U AS=2.1P AD=2.1P PS=10.84U
+ PD=10.84U
* device instance $250 r0 *1 91.15,9.42 pfet
M$250 \$894 \$644 \$893 \$1183 pfet L=0.5U W=5U AS=2.1P AD=2.1P PS=10.84U
+ PD=10.84U
* device instance $251 r0 *1 92.89,9.42 pfet
M$251 \$896 \$645 \$895 \$1183 pfet L=0.5U W=5U AS=2.1P AD=2.1P PS=10.84U
+ PD=10.84U
* device instance $252 r0 *1 94.63,9.42 pfet
M$252 \$898 \$646 \$897 \$1183 pfet L=0.5U W=5U AS=2.1P AD=2.1P PS=10.84U
+ PD=10.84U
* device instance $253 r0 *1 96.37,9.42 pfet
M$253 \$900 \$647 \$899 \$1183 pfet L=0.5U W=5U AS=2.1P AD=2.1P PS=10.84U
+ PD=10.84U
* device instance $254 r0 *1 98.11,9.42 pfet
M$254 \$902 \$648 \$901 \$1183 pfet L=0.5U W=5U AS=2.1P AD=2.1P PS=10.84U
+ PD=10.84U
* device instance $255 r0 *1 99.85,9.42 pfet
M$255 \$904 \$649 \$903 \$1183 pfet L=0.5U W=5U AS=2.1P AD=2.1P PS=10.84U
+ PD=10.84U
* device instance $256 r0 *1 101.59,9.42 pfet
M$256 \$906 \$650 \$905 \$1183 pfet L=0.5U W=5U AS=2.1P AD=2.1P PS=10.84U
+ PD=10.84U
* device instance $257 r0 *1 103.33,9.42 pfet
M$257 \$908 \$651 \$907 \$1183 pfet L=0.5U W=5U AS=2.1P AD=2.1P PS=10.84U
+ PD=10.84U
* device instance $258 r0 *1 105.07,9.42 pfet
M$258 \$910 \$652 \$909 \$1183 pfet L=0.5U W=5U AS=2.1P AD=2.1P PS=10.84U
+ PD=10.84U
* device instance $259 r0 *1 106.81,9.42 pfet
M$259 \$912 \$653 \$911 \$1183 pfet L=0.5U W=5U AS=2.1P AD=2.1P PS=10.84U
+ PD=10.84U
* device instance $260 r0 *1 108.55,9.42 pfet
M$260 \$914 \$654 \$913 \$1183 pfet L=0.5U W=5U AS=2.1P AD=2.1P PS=10.84U
+ PD=10.84U
* device instance $261 r0 *1 110.29,9.42 pfet
M$261 \$916 \$655 \$915 \$1183 pfet L=0.5U W=5U AS=2.1P AD=2.1P PS=10.84U
+ PD=10.84U
* device instance $262 r0 *1 112.03,9.42 pfet
M$262 \$918 \$656 \$917 \$1183 pfet L=0.5U W=5U AS=2.1P AD=2.1P PS=10.84U
+ PD=10.84U
* device instance $263 r0 *1 113.77,9.42 pfet
M$263 \$920 \$657 \$919 \$1183 pfet L=0.5U W=5U AS=2.1P AD=2.1P PS=10.84U
+ PD=10.84U
* device instance $264 r0 *1 115.51,9.42 pfet
M$264 \$922 \$658 \$921 \$1183 pfet L=0.5U W=5U AS=2.1P AD=2.1P PS=10.84U
+ PD=10.84U
* device instance $265 r0 *1 117.25,9.42 pfet
M$265 \$924 \$659 \$923 \$1183 pfet L=0.5U W=5U AS=2.1P AD=2.1P PS=10.84U
+ PD=10.84U
* device instance $266 r0 *1 118.99,9.42 pfet
M$266 \$926 \$660 \$925 \$1183 pfet L=0.5U W=5U AS=2.1P AD=2.1P PS=10.84U
+ PD=10.84U
* device instance $267 r0 *1 120.73,9.42 pfet
M$267 \$928 \$661 \$927 \$1183 pfet L=0.5U W=5U AS=2.1P AD=2.1P PS=10.84U
+ PD=10.84U
* device instance $268 r0 *1 122.47,9.42 pfet
M$268 \$930 \$662 \$929 \$1183 pfet L=0.5U W=5U AS=2.1P AD=2.1P PS=10.84U
+ PD=10.84U
* device instance $269 r0 *1 124.21,9.42 pfet
M$269 \$932 \$663 \$931 \$1183 pfet L=0.5U W=5U AS=2.1P AD=2.1P PS=10.84U
+ PD=10.84U
* device instance $270 r0 *1 125.95,9.42 pfet
M$270 \$934 \$664 \$933 \$1183 pfet L=0.5U W=5U AS=2.1P AD=2.1P PS=10.84U
+ PD=10.84U
* device instance $271 r0 *1 127.69,9.42 pfet
M$271 \$936 \$665 \$935 \$1183 pfet L=0.5U W=5U AS=2.1P AD=2.1P PS=10.84U
+ PD=10.84U
* device instance $272 r0 *1 129.43,9.42 pfet
M$272 \$938 \$666 \$937 \$1183 pfet L=0.5U W=5U AS=2.1P AD=2.1P PS=10.84U
+ PD=10.84U
* device instance $273 r0 *1 131.17,9.42 pfet
M$273 \$940 \$667 \$939 \$1183 pfet L=0.5U W=5U AS=2.1P AD=2.1P PS=10.84U
+ PD=10.84U
* device instance $274 r0 *1 132.91,9.42 pfet
M$274 \$942 \$668 \$941 \$1183 pfet L=0.5U W=5U AS=2.1P AD=2.1P PS=10.84U
+ PD=10.84U
* device instance $275 r0 *1 134.65,9.42 pfet
M$275 \$944 \$669 \$943 \$1183 pfet L=0.5U W=5U AS=2.1P AD=2.1P PS=10.84U
+ PD=10.84U
* device instance $276 r0 *1 136.39,9.42 pfet
M$276 \$946 \$670 \$945 \$1183 pfet L=0.5U W=5U AS=2.1P AD=2.1P PS=10.84U
+ PD=10.84U
* device instance $277 r0 *1 138.13,9.42 pfet
M$277 \$948 \$671 \$947 \$1183 pfet L=0.5U W=5U AS=2.1P AD=2.1P PS=10.84U
+ PD=10.84U
* device instance $278 r0 *1 139.87,9.42 pfet
M$278 \$950 \$672 \$949 \$1183 pfet L=0.5U W=5U AS=2.1P AD=2.1P PS=10.84U
+ PD=10.84U
* device instance $279 r0 *1 141.61,9.42 pfet
M$279 \$952 \$673 \$951 \$1183 pfet L=0.5U W=5U AS=2.1P AD=2.1P PS=10.84U
+ PD=10.84U
* device instance $280 r0 *1 143.35,9.42 pfet
M$280 \$954 \$674 \$953 \$1183 pfet L=0.5U W=5U AS=2.1P AD=2.1P PS=10.84U
+ PD=10.84U
* device instance $281 r0 *1 145.09,9.42 pfet
M$281 \$956 \$675 \$955 \$1183 pfet L=0.5U W=5U AS=2.1P AD=2.1P PS=10.84U
+ PD=10.84U
* device instance $282 r0 *1 146.83,9.42 pfet
M$282 \$958 \$676 \$957 \$1183 pfet L=0.5U W=5U AS=2.1P AD=2.1P PS=10.84U
+ PD=10.84U
* device instance $283 r0 *1 148.57,9.42 pfet
M$283 \$960 \$677 \$959 \$1183 pfet L=0.5U W=5U AS=2.1P AD=2.1P PS=10.84U
+ PD=10.84U
* device instance $284 r0 *1 150.31,9.42 pfet
M$284 \$962 \$678 \$961 \$1183 pfet L=0.5U W=5U AS=2.1P AD=2.1P PS=10.84U
+ PD=10.84U
* device instance $285 r0 *1 152.05,9.42 pfet
M$285 \$964 \$679 \$963 \$1183 pfet L=0.5U W=5U AS=2.1P AD=2.1P PS=10.84U
+ PD=10.84U
* device instance $286 r0 *1 153.79,9.42 pfet
M$286 \$966 \$680 \$965 \$1183 pfet L=0.5U W=5U AS=2.1P AD=2.1P PS=10.84U
+ PD=10.84U
* device instance $287 r0 *1 155.53,9.42 pfet
M$287 \$968 \$681 \$967 \$1183 pfet L=0.5U W=5U AS=2.1P AD=2.1P PS=10.84U
+ PD=10.84U
* device instance $288 r0 *1 157.27,9.42 pfet
M$288 \$970 \$682 \$969 \$1183 pfet L=0.5U W=5U AS=2.1P AD=2.1P PS=10.84U
+ PD=10.84U
* device instance $289 r0 *1 159.01,9.42 pfet
M$289 \$972 \$683 \$971 \$1183 pfet L=0.5U W=5U AS=2.1P AD=2.1P PS=10.84U
+ PD=10.84U
* device instance $290 r0 *1 160.75,9.42 pfet
M$290 \$974 \$684 \$973 \$1183 pfet L=0.5U W=5U AS=2.1P AD=2.1P PS=10.84U
+ PD=10.84U
* device instance $291 r0 *1 162.49,9.42 pfet
M$291 \$976 \$685 \$975 \$1183 pfet L=0.5U W=5U AS=2.1P AD=2.1P PS=10.84U
+ PD=10.84U
* device instance $292 r0 *1 164.23,9.42 pfet
M$292 \$978 \$686 \$977 \$1183 pfet L=0.5U W=5U AS=2.1P AD=2.1P PS=10.84U
+ PD=10.84U
* device instance $293 r0 *1 165.97,9.42 pfet
M$293 \$980 \$687 \$979 \$1183 pfet L=0.5U W=5U AS=2.1P AD=2.1P PS=10.84U
+ PD=10.84U
* device instance $294 r0 *1 167.71,9.42 pfet
M$294 \$982 \$688 \$981 \$1183 pfet L=0.5U W=5U AS=2.1P AD=2.1P PS=10.84U
+ PD=10.84U
* device instance $295 r0 *1 169.45,9.42 pfet
M$295 \$984 \$689 \$983 \$1183 pfet L=0.5U W=5U AS=2.1P AD=2.1P PS=10.84U
+ PD=10.84U
* device instance $296 r0 *1 171.19,9.42 pfet
M$296 \$986 \$690 \$985 \$1183 pfet L=0.5U W=5U AS=2.1P AD=2.1P PS=10.84U
+ PD=10.84U
* device instance $297 r0 *1 172.93,9.42 pfet
M$297 \$988 \$691 \$987 \$1183 pfet L=0.5U W=5U AS=2.1P AD=2.1P PS=10.84U
+ PD=10.84U
* device instance $298 r0 *1 174.67,9.42 pfet
M$298 \$990 \$692 \$989 \$1183 pfet L=0.5U W=5U AS=2.1P AD=2.1P PS=10.84U
+ PD=10.84U
* device instance $299 r0 *1 176.41,9.42 pfet
M$299 \$992 \$693 \$991 \$1183 pfet L=0.5U W=5U AS=2.1P AD=2.1P PS=10.84U
+ PD=10.84U
* device instance $300 r0 *1 178.15,9.42 pfet
M$300 \$994 \$694 \$993 \$1183 pfet L=0.5U W=5U AS=2.1P AD=2.1P PS=10.84U
+ PD=10.84U
* device instance $301 r0 *1 179.89,9.42 pfet
M$301 \$996 \$695 \$995 \$1183 pfet L=0.5U W=5U AS=2.1P AD=2.1P PS=10.84U
+ PD=10.84U
* device instance $302 r0 *1 181.63,9.42 pfet
M$302 \$998 \$696 \$997 \$1183 pfet L=0.5U W=5U AS=2.1P AD=2.1P PS=10.84U
+ PD=10.84U
* device instance $303 r0 *1 183.37,9.42 pfet
M$303 \$1000 \$697 \$999 \$1183 pfet L=0.5U W=5U AS=2.1P AD=2.1P PS=10.84U
+ PD=10.84U
* device instance $304 r0 *1 185.11,9.42 pfet
M$304 \$1002 \$698 \$1001 \$1183 pfet L=0.5U W=5U AS=2.1P AD=2.1P PS=10.84U
+ PD=10.84U
* device instance $305 r0 *1 186.85,9.42 pfet
M$305 \$1004 \$699 \$1003 \$1183 pfet L=0.5U W=5U AS=2.1P AD=2.1P PS=10.84U
+ PD=10.84U
* device instance $306 r0 *1 188.59,9.42 pfet
M$306 \$1006 \$700 \$1005 \$1183 pfet L=0.5U W=5U AS=2.1P AD=2.1P PS=10.84U
+ PD=10.84U
* device instance $307 r0 *1 190.33,9.42 pfet
M$307 \$1008 \$701 \$1007 \$1183 pfet L=0.5U W=5U AS=2.1P AD=2.1P PS=10.84U
+ PD=10.84U
* device instance $308 r0 *1 192.07,9.42 pfet
M$308 \$1010 \$702 \$1009 \$1183 pfet L=0.5U W=5U AS=2.1P AD=2.1P PS=10.84U
+ PD=10.84U
* device instance $309 r0 *1 193.81,9.42 pfet
M$309 \$1012 \$703 \$1011 \$1183 pfet L=0.5U W=5U AS=2.1P AD=2.1P PS=10.84U
+ PD=10.84U
* device instance $310 r0 *1 195.55,9.42 pfet
M$310 \$1014 \$704 \$1013 \$1183 pfet L=0.5U W=5U AS=2.1P AD=2.1P PS=10.84U
+ PD=10.84U
* device instance $311 r0 *1 197.29,9.42 pfet
M$311 \$1016 \$705 \$1015 \$1183 pfet L=0.5U W=5U AS=2.1P AD=2.1P PS=10.84U
+ PD=10.84U
* device instance $312 r0 *1 199.03,9.42 pfet
M$312 \$1018 \$706 \$1017 \$1183 pfet L=0.5U W=5U AS=2.1P AD=2.1P PS=10.84U
+ PD=10.84U
* device instance $313 r0 *1 200.77,9.42 pfet
M$313 \$1020 \$707 \$1019 \$1183 pfet L=0.5U W=5U AS=2.1P AD=2.1P PS=10.84U
+ PD=10.84U
* device instance $314 r0 *1 202.51,9.42 pfet
M$314 \$1022 \$708 \$1021 \$1183 pfet L=0.5U W=5U AS=2.1P AD=2.1P PS=10.84U
+ PD=10.84U
* device instance $315 r0 *1 204.25,9.42 pfet
M$315 \$1024 \$709 \$1023 \$1183 pfet L=0.5U W=5U AS=2.1P AD=2.1P PS=10.84U
+ PD=10.84U
* device instance $316 r0 *1 205.99,9.42 pfet
M$316 \$1026 \$710 \$1025 \$1183 pfet L=0.5U W=5U AS=2.1P AD=2.1P PS=10.84U
+ PD=10.84U
* device instance $317 r0 *1 207.73,9.42 pfet
M$317 \$1028 \$711 \$1027 \$1183 pfet L=0.5U W=5U AS=2.1P AD=2.1P PS=10.84U
+ PD=10.84U
* device instance $318 r0 *1 209.47,9.42 pfet
M$318 \$1030 \$712 \$1029 \$1183 pfet L=0.5U W=5U AS=2.1P AD=2.1P PS=10.84U
+ PD=10.84U
* device instance $319 r0 *1 211.21,9.42 pfet
M$319 \$1032 \$713 \$1031 \$1183 pfet L=0.5U W=5U AS=2.1P AD=2.1P PS=10.84U
+ PD=10.84U
* device instance $320 r0 *1 212.95,9.42 pfet
M$320 \$1034 \$714 \$1033 \$1183 pfet L=0.5U W=5U AS=2.1P AD=2.1P PS=10.84U
+ PD=10.84U
* device instance $321 r0 *1 214.69,9.42 pfet
M$321 \$1036 \$715 \$1035 \$1183 pfet L=0.5U W=5U AS=2.1P AD=2.1P PS=10.84U
+ PD=10.84U
* device instance $322 r0 *1 216.43,9.42 pfet
M$322 \$1038 \$716 \$1037 \$1183 pfet L=0.5U W=5U AS=2.1P AD=2.1P PS=10.84U
+ PD=10.84U
* device instance $323 r0 *1 218.17,9.42 pfet
M$323 \$1040 \$717 \$1039 \$1183 pfet L=0.5U W=5U AS=2.1P AD=2.1P PS=10.84U
+ PD=10.84U
* device instance $324 r0 *1 219.91,9.42 pfet
M$324 \$1042 \$718 \$1041 \$1183 pfet L=0.5U W=5U AS=2.1P AD=2.1P PS=10.84U
+ PD=10.84U
* device instance $325 r0 *1 221.65,9.42 pfet
M$325 \$1044 \$719 \$1043 \$1183 pfet L=0.5U W=5U AS=2.1P AD=2.1P PS=10.84U
+ PD=10.84U
* device instance $326 r0 *1 223.39,9.42 pfet
M$326 \$1046 \$720 \$1045 \$1183 pfet L=0.5U W=5U AS=2.1P AD=2.1P PS=10.84U
+ PD=10.84U
* device instance $327 r0 *1 225.13,9.42 pfet
M$327 \$1048 \$721 \$1047 \$1183 pfet L=0.5U W=5U AS=2.1P AD=2.1P PS=10.84U
+ PD=10.84U
* device instance $328 r0 *1 226.87,9.42 pfet
M$328 \$1050 \$722 \$1049 \$1183 pfet L=0.5U W=5U AS=2.1P AD=2.1P PS=10.84U
+ PD=10.84U
* device instance $329 r0 *1 228.61,9.42 pfet
M$329 \$1052 \$723 \$1051 \$1183 pfet L=0.5U W=5U AS=2.1P AD=2.1P PS=10.84U
+ PD=10.84U
* device instance $330 r0 *1 230.35,9.42 pfet
M$330 \$1054 \$724 \$1053 \$1183 pfet L=0.5U W=5U AS=2.1P AD=2.1P PS=10.84U
+ PD=10.84U
* device instance $331 r0 *1 232.09,9.42 pfet
M$331 \$1056 \$725 \$1055 \$1183 pfet L=0.5U W=5U AS=2.1P AD=2.1P PS=10.84U
+ PD=10.84U
* device instance $332 r0 *1 233.83,9.42 pfet
M$332 \$1058 \$726 \$1057 \$1183 pfet L=0.5U W=5U AS=2.1P AD=2.1P PS=10.84U
+ PD=10.84U
* device instance $333 r0 *1 235.57,9.42 pfet
M$333 \$1060 \$727 \$1059 \$1183 pfet L=0.5U W=5U AS=2.1P AD=2.1P PS=10.84U
+ PD=10.84U
* device instance $334 r0 *1 237.31,9.42 pfet
M$334 \$1062 \$728 \$1061 \$1183 pfet L=0.5U W=5U AS=2.1P AD=2.1P PS=10.84U
+ PD=10.84U
* device instance $335 r0 *1 239.05,9.42 pfet
M$335 \$1064 \$729 \$1063 \$1183 pfet L=0.5U W=5U AS=2.1P AD=2.1P PS=10.84U
+ PD=10.84U
* device instance $336 r0 *1 240.79,9.42 pfet
M$336 \$1066 \$730 \$1065 \$1183 pfet L=0.5U W=5U AS=2.1P AD=2.1P PS=10.84U
+ PD=10.84U
* device instance $337 r0 *1 242.53,9.42 pfet
M$337 \$1068 \$731 \$1067 \$1183 pfet L=0.5U W=5U AS=2.1P AD=2.1P PS=10.84U
+ PD=10.84U
* device instance $338 r0 *1 244.27,9.42 pfet
M$338 \$1070 \$732 \$1069 \$1183 pfet L=0.5U W=5U AS=2.1P AD=2.1P PS=10.84U
+ PD=10.84U
* device instance $339 r0 *1 246.01,9.42 pfet
M$339 \$1072 \$733 \$1071 \$1183 pfet L=0.5U W=5U AS=2.1P AD=2.1P PS=10.84U
+ PD=10.84U
* device instance $340 r0 *1 247.75,9.42 pfet
M$340 \$1074 \$734 \$1073 \$1183 pfet L=0.5U W=5U AS=2.1P AD=2.1P PS=10.84U
+ PD=10.84U
* device instance $341 r0 *1 249.49,9.42 pfet
M$341 \$1076 \$735 \$1075 \$1183 pfet L=0.5U W=5U AS=2.1P AD=2.1P PS=10.84U
+ PD=10.84U
* device instance $342 r0 *1 251.23,9.42 pfet
M$342 \$1078 \$736 \$1077 \$1183 pfet L=0.5U W=5U AS=2.1P AD=2.1P PS=10.84U
+ PD=10.84U
* device instance $343 r0 *1 252.97,9.42 pfet
M$343 \$1080 \$737 \$1079 \$1183 pfet L=0.5U W=5U AS=2.1P AD=2.1P PS=10.84U
+ PD=10.84U
* device instance $344 r0 *1 254.71,9.42 pfet
M$344 \$1082 \$738 \$1081 \$1183 pfet L=0.5U W=5U AS=2.1P AD=2.1P PS=10.84U
+ PD=10.84U
* device instance $345 r0 *1 256.45,9.42 pfet
M$345 \$1084 \$739 \$1083 \$1183 pfet L=0.5U W=5U AS=2.1P AD=2.1P PS=10.84U
+ PD=10.84U
* device instance $346 r0 *1 258.19,9.42 pfet
M$346 \$1086 \$740 \$1085 \$1183 pfet L=0.5U W=5U AS=2.1P AD=2.1P PS=10.84U
+ PD=10.84U
* device instance $347 r0 *1 259.93,9.42 pfet
M$347 \$1088 \$741 \$1087 \$1183 pfet L=0.5U W=5U AS=2.1P AD=2.1P PS=10.84U
+ PD=10.84U
* device instance $348 r0 *1 261.67,9.42 pfet
M$348 \$1090 \$742 \$1089 \$1183 pfet L=0.5U W=5U AS=2.1P AD=2.1P PS=10.84U
+ PD=10.84U
* device instance $349 r0 *1 263.41,9.42 pfet
M$349 \$1092 \$743 \$1091 \$1183 pfet L=0.5U W=5U AS=2.1P AD=2.1P PS=10.84U
+ PD=10.84U
* device instance $350 r0 *1 265.15,9.42 pfet
M$350 \$1094 \$744 \$1093 \$1183 pfet L=0.5U W=5U AS=2.1P AD=2.1P PS=10.84U
+ PD=10.84U
* device instance $351 r0 *1 266.89,9.42 pfet
M$351 \$1096 \$745 \$1095 \$1183 pfet L=0.5U W=5U AS=2.1P AD=2.1P PS=10.84U
+ PD=10.84U
* device instance $352 r0 *1 268.63,9.42 pfet
M$352 \$1098 \$746 \$1097 \$1183 pfet L=0.5U W=5U AS=2.1P AD=2.1P PS=10.84U
+ PD=10.84U
* device instance $353 r0 *1 270.37,9.42 pfet
M$353 \$1100 \$747 \$1099 \$1183 pfet L=0.5U W=5U AS=2.1P AD=2.1P PS=10.84U
+ PD=10.84U
* device instance $354 r0 *1 272.11,9.42 pfet
M$354 \$1102 \$748 \$1101 \$1183 pfet L=0.5U W=5U AS=2.1P AD=2.1P PS=10.84U
+ PD=10.84U
* device instance $355 r0 *1 273.85,9.42 pfet
M$355 \$1104 \$749 \$1103 \$1183 pfet L=0.5U W=5U AS=2.1P AD=2.1P PS=10.84U
+ PD=10.84U
* device instance $356 r0 *1 275.59,9.42 pfet
M$356 \$1106 \$750 \$1105 \$1183 pfet L=0.5U W=5U AS=2.1P AD=2.1P PS=10.84U
+ PD=10.84U
* device instance $357 r0 *1 277.33,9.42 pfet
M$357 \$1108 \$751 \$1107 \$1183 pfet L=0.5U W=5U AS=2.1P AD=2.1P PS=10.84U
+ PD=10.84U
* device instance $358 r0 *1 279.07,9.42 pfet
M$358 \$1110 \$752 \$1109 \$1183 pfet L=0.5U W=5U AS=2.1P AD=2.1P PS=10.84U
+ PD=10.84U
* device instance $359 r0 *1 280.81,9.42 pfet
M$359 \$1112 \$753 \$1111 \$1183 pfet L=0.5U W=5U AS=2.1P AD=2.1P PS=10.84U
+ PD=10.84U
* device instance $360 r0 *1 282.55,9.42 pfet
M$360 \$1114 \$754 \$1113 \$1183 pfet L=0.5U W=5U AS=2.1P AD=2.1P PS=10.84U
+ PD=10.84U
* device instance $361 r0 *1 284.29,9.42 pfet
M$361 \$1116 \$755 \$1115 \$1183 pfet L=0.5U W=5U AS=2.1P AD=2.1P PS=10.84U
+ PD=10.84U
* device instance $362 r0 *1 286.03,9.42 pfet
M$362 \$1118 \$756 \$1117 \$1183 pfet L=0.5U W=5U AS=2.1P AD=2.1P PS=10.84U
+ PD=10.84U
* device instance $363 r0 *1 287.77,9.42 pfet
M$363 \$1120 \$757 \$1119 \$1183 pfet L=0.5U W=5U AS=2.1P AD=2.1P PS=10.84U
+ PD=10.84U
* device instance $364 r0 *1 289.51,9.42 pfet
M$364 \$1122 \$758 \$1121 \$1183 pfet L=0.5U W=5U AS=2.1P AD=2.1P PS=10.84U
+ PD=10.84U
* device instance $365 r0 *1 291.25,9.42 pfet
M$365 \$1124 \$759 \$1123 \$1183 pfet L=0.5U W=5U AS=2.1P AD=2.1P PS=10.84U
+ PD=10.84U
* device instance $366 r0 *1 292.99,9.42 pfet
M$366 \$1126 \$760 \$1125 \$1183 pfet L=0.5U W=5U AS=2.1P AD=2.1P PS=10.84U
+ PD=10.84U
* device instance $367 r0 *1 294.73,9.42 pfet
M$367 \$1128 \$761 \$1127 \$1183 pfet L=0.5U W=5U AS=2.1P AD=2.1P PS=10.84U
+ PD=10.84U
* device instance $368 r0 *1 296.47,9.42 pfet
M$368 \$1130 \$762 \$1129 \$1183 pfet L=0.5U W=5U AS=2.1P AD=2.1P PS=10.84U
+ PD=10.84U
* device instance $369 r0 *1 298.21,9.42 pfet
M$369 \$1132 \$763 \$1131 \$1183 pfet L=0.5U W=5U AS=2.1P AD=2.1P PS=10.84U
+ PD=10.84U
* device instance $370 r0 *1 299.95,9.42 pfet
M$370 \$1134 \$764 \$1133 \$1183 pfet L=0.5U W=5U AS=2.1P AD=2.1P PS=10.84U
+ PD=10.84U
* device instance $371 r0 *1 301.69,9.42 pfet
M$371 \$1136 \$765 \$1135 \$1183 pfet L=0.5U W=5U AS=2.1P AD=2.1P PS=10.84U
+ PD=10.84U
* device instance $372 r0 *1 303.43,9.42 pfet
M$372 \$1138 \$766 \$1137 \$1183 pfet L=0.5U W=5U AS=2.1P AD=2.1P PS=10.84U
+ PD=10.84U
* device instance $373 r0 *1 305.17,9.42 pfet
M$373 \$1140 \$767 \$1139 \$1183 pfet L=0.5U W=5U AS=2.1P AD=2.1P PS=10.84U
+ PD=10.84U
* device instance $374 r0 *1 306.91,9.42 pfet
M$374 \$1142 \$768 \$1141 \$1183 pfet L=0.5U W=5U AS=2.1P AD=2.1P PS=10.84U
+ PD=10.84U
* device instance $375 r0 *1 308.65,9.42 pfet
M$375 \$1144 \$769 \$1143 \$1183 pfet L=0.5U W=5U AS=2.1P AD=2.1P PS=10.84U
+ PD=10.84U
* device instance $376 r0 *1 310.39,9.42 pfet
M$376 \$1146 \$770 \$1145 \$1183 pfet L=0.5U W=5U AS=2.1P AD=2.1P PS=10.84U
+ PD=10.84U
* device instance $377 r0 *1 312.13,9.42 pfet
M$377 \$1148 \$771 \$1147 \$1183 pfet L=0.5U W=5U AS=2.1P AD=2.1P PS=10.84U
+ PD=10.84U
* device instance $378 r0 *1 313.87,9.42 pfet
M$378 \$1150 \$772 \$1149 \$1183 pfet L=0.5U W=5U AS=2.1P AD=2.1P PS=10.84U
+ PD=10.84U
* device instance $379 r0 *1 315.61,9.42 pfet
M$379 \$1152 \$773 \$1151 \$1183 pfet L=0.5U W=5U AS=2.1P AD=2.1P PS=10.84U
+ PD=10.84U
* device instance $380 r0 *1 317.35,9.42 pfet
M$380 \$1154 \$774 \$1153 \$1183 pfet L=0.5U W=5U AS=2.1P AD=2.1P PS=10.84U
+ PD=10.84U
* device instance $381 r0 *1 319.09,9.42 pfet
M$381 \$1156 \$775 \$1155 \$1183 pfet L=0.5U W=5U AS=2.1P AD=2.1P PS=10.84U
+ PD=10.84U
* device instance $382 r0 *1 320.83,9.42 pfet
M$382 \$1158 \$776 \$1157 \$1183 pfet L=0.5U W=5U AS=2.1P AD=2.1P PS=10.84U
+ PD=10.84U
* device instance $383 r0 *1 322.57,9.42 pfet
M$383 \$1160 \$777 \$1159 \$1183 pfet L=0.5U W=5U AS=2.1P AD=2.1P PS=10.84U
+ PD=10.84U
* device instance $384 r0 *1 324.31,9.42 pfet
M$384 \$1162 \$778 \$1161 \$1183 pfet L=0.5U W=5U AS=2.1P AD=2.1P PS=10.84U
+ PD=10.84U
* device instance $385 r0 *1 326.05,9.42 pfet
M$385 \$1164 \$779 \$1163 \$1183 pfet L=0.5U W=5U AS=2.1P AD=2.1P PS=10.84U
+ PD=10.84U
* device instance $386 r0 *1 327.79,9.42 pfet
M$386 \$1166 \$780 \$1165 \$1183 pfet L=0.5U W=5U AS=2.1P AD=2.1P PS=10.84U
+ PD=10.84U
* device instance $387 r0 *1 329.53,9.42 pfet
M$387 \$1168 \$781 \$1167 \$1183 pfet L=0.5U W=5U AS=2.1P AD=2.1P PS=10.84U
+ PD=10.84U
* device instance $388 r0 *1 331.27,9.42 pfet
M$388 \$1170 \$782 \$1169 \$1183 pfet L=0.5U W=5U AS=2.1P AD=2.1P PS=10.84U
+ PD=10.84U
* device instance $389 r0 *1 333.01,9.42 pfet
M$389 \$1172 \$783 \$1171 \$1183 pfet L=0.5U W=5U AS=2.1P AD=2.1P PS=10.84U
+ PD=10.84U
* device instance $390 r0 *1 334.75,9.42 pfet
M$390 \$1174 \$784 \$1173 \$1183 pfet L=0.5U W=5U AS=2.1P AD=2.1P PS=10.84U
+ PD=10.84U
* device instance $391 r0 *1 336.49,9.42 pfet
M$391 \$1176 \$785 \$1175 \$1183 pfet L=0.5U W=5U AS=2.1P AD=2.1P PS=10.84U
+ PD=10.84U
* device instance $392 r0 *1 338.23,9.42 pfet
M$392 \$1178 \$786 \$1177 \$1183 pfet L=0.5U W=5U AS=2.1P AD=2.1P PS=10.84U
+ PD=10.84U
* device instance $393 r0 *1 339.97,9.42 pfet
M$393 \$1180 \$787 \$1179 \$1183 pfet L=0.5U W=5U AS=2.1P AD=2.1P PS=10.84U
+ PD=10.84U
* device instance $394 r0 *1 341.71,9.42 pfet
M$394 \$1182 \$788 \$1181 \$1183 pfet L=0.5U W=5U AS=2.1P AD=2.1P PS=10.84U
+ PD=10.84U
.ENDS pll_divider_chain
