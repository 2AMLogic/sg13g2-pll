* extracted by klt extract --deck sg13g2

* cell pfd_pfet_w10_l0p5
.SUBCKT pfd_pfet_w10_l0p5
* device instance $1 r0 *1 0.67,5 pfet
M$1 \$2 \$3 \$1 \$4 pfet L=0.5U W=10U AS=4.2P AD=4.2P PS=20.84U PD=20.84U
.ENDS pfd_pfet_w10_l0p5
