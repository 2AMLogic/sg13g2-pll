* extracted by klt extract --deck sg13g2

* cell pfd_nfet_w2_l0p5
* pin vsubs
.SUBCKT pfd_nfet_w2_l0p5 vsubs
* device instance $1 r0 *1 0.67,1 nfet
M$1 \$10 \$1 \$9 vsubs nfet L=0.5U W=2U AS=0.84P AD=0.84P PS=4.84U PD=4.84U
* device instance $2 r0 *1 2.41,1 nfet
M$2 \$12 \$2 \$11 vsubs nfet L=0.5U W=2U AS=0.84P AD=0.84P PS=4.84U PD=4.84U
* device instance $3 r0 *1 4.15,1 nfet
M$3 \$14 \$3 \$13 vsubs nfet L=0.5U W=2U AS=0.84P AD=0.84P PS=4.84U PD=4.84U
* device instance $4 r0 *1 5.89,1 nfet
M$4 \$16 \$4 \$15 vsubs nfet L=0.5U W=2U AS=0.84P AD=0.84P PS=4.84U PD=4.84U
* device instance $5 r0 *1 7.63,1 nfet
M$5 \$18 \$5 \$17 vsubs nfet L=0.5U W=2U AS=0.84P AD=0.84P PS=4.84U PD=4.84U
* device instance $6 r0 *1 9.37,1 nfet
M$6 \$20 \$6 \$19 vsubs nfet L=0.5U W=2U AS=0.84P AD=0.84P PS=4.84U PD=4.84U
* device instance $7 r0 *1 11.11,1 nfet
M$7 \$22 \$7 \$21 vsubs nfet L=0.5U W=2U AS=0.84P AD=0.84P PS=4.84U PD=4.84U
* device instance $8 r0 *1 12.85,1 nfet
M$8 \$24 \$8 \$23 vsubs nfet L=0.5U W=2U AS=0.84P AD=0.84P PS=4.84U PD=4.84U
* device instance $9 r0 *1 0.67,4.32 nfet
M$9 \$34 \$25 \$33 vsubs nfet L=0.5U W=2U AS=0.84P AD=0.84P PS=4.84U PD=4.84U
* device instance $10 r0 *1 2.41,4.32 nfet
M$10 \$36 \$26 \$35 vsubs nfet L=0.5U W=2U AS=0.84P AD=0.84P PS=4.84U PD=4.84U
* device instance $11 r0 *1 4.15,4.32 nfet
M$11 \$38 \$27 \$37 vsubs nfet L=0.5U W=2U AS=0.84P AD=0.84P PS=4.84U PD=4.84U
* device instance $12 r0 *1 5.89,4.32 nfet
M$12 \$40 \$28 \$39 vsubs nfet L=0.5U W=2U AS=0.84P AD=0.84P PS=4.84U PD=4.84U
* device instance $13 r0 *1 7.63,4.32 nfet
M$13 \$42 \$29 \$41 vsubs nfet L=0.5U W=2U AS=0.84P AD=0.84P PS=4.84U PD=4.84U
* device instance $14 r0 *1 9.37,4.32 nfet
M$14 \$44 \$30 \$43 vsubs nfet L=0.5U W=2U AS=0.84P AD=0.84P PS=4.84U PD=4.84U
* device instance $15 r0 *1 11.11,4.32 nfet
M$15 \$46 \$31 \$45 vsubs nfet L=0.5U W=2U AS=0.84P AD=0.84P PS=4.84U PD=4.84U
* device instance $16 r0 *1 12.85,4.32 nfet
M$16 \$48 \$32 \$47 vsubs nfet L=0.5U W=2U AS=0.84P AD=0.84P PS=4.84U PD=4.84U
* device instance $17 r0 *1 0.67,7.64 nfet
M$17 \$58 \$49 \$57 vsubs nfet L=0.5U W=2U AS=0.84P AD=0.84P PS=4.84U PD=4.84U
* device instance $18 r0 *1 2.41,7.64 nfet
M$18 \$60 \$50 \$59 vsubs nfet L=0.5U W=2U AS=0.84P AD=0.84P PS=4.84U PD=4.84U
* device instance $19 r0 *1 4.15,7.64 nfet
M$19 \$62 \$51 \$61 vsubs nfet L=0.5U W=2U AS=0.84P AD=0.84P PS=4.84U PD=4.84U
* device instance $20 r0 *1 5.89,7.64 nfet
M$20 \$64 \$52 \$63 vsubs nfet L=0.5U W=2U AS=0.84P AD=0.84P PS=4.84U PD=4.84U
* device instance $21 r0 *1 7.63,7.64 nfet
M$21 \$66 \$53 \$65 vsubs nfet L=0.5U W=2U AS=0.84P AD=0.84P PS=4.84U PD=4.84U
* device instance $22 r0 *1 9.37,7.64 nfet
M$22 \$68 \$54 \$67 vsubs nfet L=0.5U W=2U AS=0.84P AD=0.84P PS=4.84U PD=4.84U
* device instance $23 r0 *1 11.11,7.64 nfet
M$23 \$70 \$55 \$69 vsubs nfet L=0.5U W=2U AS=0.84P AD=0.84P PS=4.84U PD=4.84U
* device instance $24 r0 *1 12.85,7.64 nfet
M$24 \$72 \$56 \$71 vsubs nfet L=0.5U W=2U AS=0.84P AD=0.84P PS=4.84U PD=4.84U
* device instance $25 r0 *1 0.67,10.96 nfet
M$25 \$82 \$73 \$81 vsubs nfet L=0.5U W=2U AS=0.84P AD=0.84P PS=4.84U PD=4.84U
* device instance $26 r0 *1 2.41,10.96 nfet
M$26 \$84 \$74 \$83 vsubs nfet L=0.5U W=2U AS=0.84P AD=0.84P PS=4.84U PD=4.84U
* device instance $27 r0 *1 4.15,10.96 nfet
M$27 \$86 \$75 \$85 vsubs nfet L=0.5U W=2U AS=0.84P AD=0.84P PS=4.84U PD=4.84U
* device instance $28 r0 *1 5.89,10.96 nfet
M$28 \$88 \$76 \$87 vsubs nfet L=0.5U W=2U AS=0.84P AD=0.84P PS=4.84U PD=4.84U
* device instance $29 r0 *1 7.63,10.96 nfet
M$29 \$90 \$77 \$89 vsubs nfet L=0.5U W=2U AS=0.84P AD=0.84P PS=4.84U PD=4.84U
* device instance $30 r0 *1 9.37,10.96 nfet
M$30 \$92 \$78 \$91 vsubs nfet L=0.5U W=2U AS=0.84P AD=0.84P PS=4.84U PD=4.84U
* device instance $31 r0 *1 11.11,10.96 nfet
M$31 \$94 \$79 \$93 vsubs nfet L=0.5U W=2U AS=0.84P AD=0.84P PS=4.84U PD=4.84U
* device instance $32 r0 *1 12.85,10.96 nfet
M$32 \$96 \$80 \$95 vsubs nfet L=0.5U W=2U AS=0.84P AD=0.84P PS=4.84U PD=4.84U
.ENDS pfd_nfet_w2_l0p5
