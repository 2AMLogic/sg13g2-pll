* extracted by klt extract --deck sg13g2

* cell divider_chain_pfet_w5_l0p5
.SUBCKT divider_chain_pfet_w5_l0p5
* device instance $1 r0 *1 0.67,2.5 pfet
M$1 \$199 \$1 \$198 \$592 pfet L=0.5U W=5U AS=2.1P AD=2.1P PS=10.84U PD=10.84U
* device instance $2 r0 *1 2.41,2.5 pfet
M$2 \$201 \$2 \$200 \$592 pfet L=0.5U W=5U AS=2.1P AD=2.1P PS=10.84U PD=10.84U
* device instance $3 r0 *1 4.15,2.5 pfet
M$3 \$203 \$3 \$202 \$592 pfet L=0.5U W=5U AS=2.1P AD=2.1P PS=10.84U PD=10.84U
* device instance $4 r0 *1 5.89,2.5 pfet
M$4 \$205 \$4 \$204 \$592 pfet L=0.5U W=5U AS=2.1P AD=2.1P PS=10.84U PD=10.84U
* device instance $5 r0 *1 7.63,2.5 pfet
M$5 \$207 \$5 \$206 \$592 pfet L=0.5U W=5U AS=2.1P AD=2.1P PS=10.84U PD=10.84U
* device instance $6 r0 *1 9.37,2.5 pfet
M$6 \$209 \$6 \$208 \$592 pfet L=0.5U W=5U AS=2.1P AD=2.1P PS=10.84U PD=10.84U
* device instance $7 r0 *1 11.11,2.5 pfet
M$7 \$211 \$7 \$210 \$592 pfet L=0.5U W=5U AS=2.1P AD=2.1P PS=10.84U PD=10.84U
* device instance $8 r0 *1 12.85,2.5 pfet
M$8 \$213 \$8 \$212 \$592 pfet L=0.5U W=5U AS=2.1P AD=2.1P PS=10.84U PD=10.84U
* device instance $9 r0 *1 14.59,2.5 pfet
M$9 \$215 \$9 \$214 \$592 pfet L=0.5U W=5U AS=2.1P AD=2.1P PS=10.84U PD=10.84U
* device instance $10 r0 *1 16.33,2.5 pfet
M$10 \$217 \$10 \$216 \$592 pfet L=0.5U W=5U AS=2.1P AD=2.1P PS=10.84U PD=10.84U
* device instance $11 r0 *1 18.07,2.5 pfet
M$11 \$219 \$11 \$218 \$592 pfet L=0.5U W=5U AS=2.1P AD=2.1P PS=10.84U PD=10.84U
* device instance $12 r0 *1 19.81,2.5 pfet
M$12 \$221 \$12 \$220 \$592 pfet L=0.5U W=5U AS=2.1P AD=2.1P PS=10.84U PD=10.84U
* device instance $13 r0 *1 21.55,2.5 pfet
M$13 \$223 \$13 \$222 \$592 pfet L=0.5U W=5U AS=2.1P AD=2.1P PS=10.84U PD=10.84U
* device instance $14 r0 *1 23.29,2.5 pfet
M$14 \$225 \$14 \$224 \$592 pfet L=0.5U W=5U AS=2.1P AD=2.1P PS=10.84U PD=10.84U
* device instance $15 r0 *1 25.03,2.5 pfet
M$15 \$227 \$15 \$226 \$592 pfet L=0.5U W=5U AS=2.1P AD=2.1P PS=10.84U PD=10.84U
* device instance $16 r0 *1 26.77,2.5 pfet
M$16 \$229 \$16 \$228 \$592 pfet L=0.5U W=5U AS=2.1P AD=2.1P PS=10.84U PD=10.84U
* device instance $17 r0 *1 28.51,2.5 pfet
M$17 \$231 \$17 \$230 \$592 pfet L=0.5U W=5U AS=2.1P AD=2.1P PS=10.84U PD=10.84U
* device instance $18 r0 *1 30.25,2.5 pfet
M$18 \$233 \$18 \$232 \$592 pfet L=0.5U W=5U AS=2.1P AD=2.1P PS=10.84U PD=10.84U
* device instance $19 r0 *1 31.99,2.5 pfet
M$19 \$235 \$19 \$234 \$592 pfet L=0.5U W=5U AS=2.1P AD=2.1P PS=10.84U PD=10.84U
* device instance $20 r0 *1 33.73,2.5 pfet
M$20 \$237 \$20 \$236 \$592 pfet L=0.5U W=5U AS=2.1P AD=2.1P PS=10.84U PD=10.84U
* device instance $21 r0 *1 35.47,2.5 pfet
M$21 \$239 \$21 \$238 \$592 pfet L=0.5U W=5U AS=2.1P AD=2.1P PS=10.84U PD=10.84U
* device instance $22 r0 *1 37.21,2.5 pfet
M$22 \$241 \$22 \$240 \$592 pfet L=0.5U W=5U AS=2.1P AD=2.1P PS=10.84U PD=10.84U
* device instance $23 r0 *1 38.95,2.5 pfet
M$23 \$243 \$23 \$242 \$592 pfet L=0.5U W=5U AS=2.1P AD=2.1P PS=10.84U PD=10.84U
* device instance $24 r0 *1 40.69,2.5 pfet
M$24 \$245 \$24 \$244 \$592 pfet L=0.5U W=5U AS=2.1P AD=2.1P PS=10.84U PD=10.84U
* device instance $25 r0 *1 42.43,2.5 pfet
M$25 \$247 \$25 \$246 \$592 pfet L=0.5U W=5U AS=2.1P AD=2.1P PS=10.84U PD=10.84U
* device instance $26 r0 *1 44.17,2.5 pfet
M$26 \$249 \$26 \$248 \$592 pfet L=0.5U W=5U AS=2.1P AD=2.1P PS=10.84U PD=10.84U
* device instance $27 r0 *1 45.91,2.5 pfet
M$27 \$251 \$27 \$250 \$592 pfet L=0.5U W=5U AS=2.1P AD=2.1P PS=10.84U PD=10.84U
* device instance $28 r0 *1 47.65,2.5 pfet
M$28 \$253 \$28 \$252 \$592 pfet L=0.5U W=5U AS=2.1P AD=2.1P PS=10.84U PD=10.84U
* device instance $29 r0 *1 49.39,2.5 pfet
M$29 \$255 \$29 \$254 \$592 pfet L=0.5U W=5U AS=2.1P AD=2.1P PS=10.84U PD=10.84U
* device instance $30 r0 *1 51.13,2.5 pfet
M$30 \$257 \$30 \$256 \$592 pfet L=0.5U W=5U AS=2.1P AD=2.1P PS=10.84U PD=10.84U
* device instance $31 r0 *1 52.87,2.5 pfet
M$31 \$259 \$31 \$258 \$592 pfet L=0.5U W=5U AS=2.1P AD=2.1P PS=10.84U PD=10.84U
* device instance $32 r0 *1 54.61,2.5 pfet
M$32 \$261 \$32 \$260 \$592 pfet L=0.5U W=5U AS=2.1P AD=2.1P PS=10.84U PD=10.84U
* device instance $33 r0 *1 56.35,2.5 pfet
M$33 \$263 \$33 \$262 \$592 pfet L=0.5U W=5U AS=2.1P AD=2.1P PS=10.84U PD=10.84U
* device instance $34 r0 *1 58.09,2.5 pfet
M$34 \$265 \$34 \$264 \$592 pfet L=0.5U W=5U AS=2.1P AD=2.1P PS=10.84U PD=10.84U
* device instance $35 r0 *1 59.83,2.5 pfet
M$35 \$267 \$35 \$266 \$592 pfet L=0.5U W=5U AS=2.1P AD=2.1P PS=10.84U PD=10.84U
* device instance $36 r0 *1 61.57,2.5 pfet
M$36 \$269 \$36 \$268 \$592 pfet L=0.5U W=5U AS=2.1P AD=2.1P PS=10.84U PD=10.84U
* device instance $37 r0 *1 63.31,2.5 pfet
M$37 \$271 \$37 \$270 \$592 pfet L=0.5U W=5U AS=2.1P AD=2.1P PS=10.84U PD=10.84U
* device instance $38 r0 *1 65.05,2.5 pfet
M$38 \$273 \$38 \$272 \$592 pfet L=0.5U W=5U AS=2.1P AD=2.1P PS=10.84U PD=10.84U
* device instance $39 r0 *1 66.79,2.5 pfet
M$39 \$275 \$39 \$274 \$592 pfet L=0.5U W=5U AS=2.1P AD=2.1P PS=10.84U PD=10.84U
* device instance $40 r0 *1 68.53,2.5 pfet
M$40 \$277 \$40 \$276 \$592 pfet L=0.5U W=5U AS=2.1P AD=2.1P PS=10.84U PD=10.84U
* device instance $41 r0 *1 70.27,2.5 pfet
M$41 \$279 \$41 \$278 \$592 pfet L=0.5U W=5U AS=2.1P AD=2.1P PS=10.84U PD=10.84U
* device instance $42 r0 *1 72.01,2.5 pfet
M$42 \$281 \$42 \$280 \$592 pfet L=0.5U W=5U AS=2.1P AD=2.1P PS=10.84U PD=10.84U
* device instance $43 r0 *1 73.75,2.5 pfet
M$43 \$283 \$43 \$282 \$592 pfet L=0.5U W=5U AS=2.1P AD=2.1P PS=10.84U PD=10.84U
* device instance $44 r0 *1 75.49,2.5 pfet
M$44 \$285 \$44 \$284 \$592 pfet L=0.5U W=5U AS=2.1P AD=2.1P PS=10.84U PD=10.84U
* device instance $45 r0 *1 77.23,2.5 pfet
M$45 \$287 \$45 \$286 \$592 pfet L=0.5U W=5U AS=2.1P AD=2.1P PS=10.84U PD=10.84U
* device instance $46 r0 *1 78.97,2.5 pfet
M$46 \$289 \$46 \$288 \$592 pfet L=0.5U W=5U AS=2.1P AD=2.1P PS=10.84U PD=10.84U
* device instance $47 r0 *1 80.71,2.5 pfet
M$47 \$291 \$47 \$290 \$592 pfet L=0.5U W=5U AS=2.1P AD=2.1P PS=10.84U PD=10.84U
* device instance $48 r0 *1 82.45,2.5 pfet
M$48 \$293 \$48 \$292 \$592 pfet L=0.5U W=5U AS=2.1P AD=2.1P PS=10.84U PD=10.84U
* device instance $49 r0 *1 84.19,2.5 pfet
M$49 \$295 \$49 \$294 \$592 pfet L=0.5U W=5U AS=2.1P AD=2.1P PS=10.84U PD=10.84U
* device instance $50 r0 *1 85.93,2.5 pfet
M$50 \$297 \$50 \$296 \$592 pfet L=0.5U W=5U AS=2.1P AD=2.1P PS=10.84U PD=10.84U
* device instance $51 r0 *1 87.67,2.5 pfet
M$51 \$299 \$51 \$298 \$592 pfet L=0.5U W=5U AS=2.1P AD=2.1P PS=10.84U PD=10.84U
* device instance $52 r0 *1 89.41,2.5 pfet
M$52 \$301 \$52 \$300 \$592 pfet L=0.5U W=5U AS=2.1P AD=2.1P PS=10.84U PD=10.84U
* device instance $53 r0 *1 91.15,2.5 pfet
M$53 \$303 \$53 \$302 \$592 pfet L=0.5U W=5U AS=2.1P AD=2.1P PS=10.84U PD=10.84U
* device instance $54 r0 *1 92.89,2.5 pfet
M$54 \$305 \$54 \$304 \$592 pfet L=0.5U W=5U AS=2.1P AD=2.1P PS=10.84U PD=10.84U
* device instance $55 r0 *1 94.63,2.5 pfet
M$55 \$307 \$55 \$306 \$592 pfet L=0.5U W=5U AS=2.1P AD=2.1P PS=10.84U PD=10.84U
* device instance $56 r0 *1 96.37,2.5 pfet
M$56 \$309 \$56 \$308 \$592 pfet L=0.5U W=5U AS=2.1P AD=2.1P PS=10.84U PD=10.84U
* device instance $57 r0 *1 98.11,2.5 pfet
M$57 \$311 \$57 \$310 \$592 pfet L=0.5U W=5U AS=2.1P AD=2.1P PS=10.84U PD=10.84U
* device instance $58 r0 *1 99.85,2.5 pfet
M$58 \$313 \$58 \$312 \$592 pfet L=0.5U W=5U AS=2.1P AD=2.1P PS=10.84U PD=10.84U
* device instance $59 r0 *1 101.59,2.5 pfet
M$59 \$315 \$59 \$314 \$592 pfet L=0.5U W=5U AS=2.1P AD=2.1P PS=10.84U PD=10.84U
* device instance $60 r0 *1 103.33,2.5 pfet
M$60 \$317 \$60 \$316 \$592 pfet L=0.5U W=5U AS=2.1P AD=2.1P PS=10.84U PD=10.84U
* device instance $61 r0 *1 105.07,2.5 pfet
M$61 \$319 \$61 \$318 \$592 pfet L=0.5U W=5U AS=2.1P AD=2.1P PS=10.84U PD=10.84U
* device instance $62 r0 *1 106.81,2.5 pfet
M$62 \$321 \$62 \$320 \$592 pfet L=0.5U W=5U AS=2.1P AD=2.1P PS=10.84U PD=10.84U
* device instance $63 r0 *1 108.55,2.5 pfet
M$63 \$323 \$63 \$322 \$592 pfet L=0.5U W=5U AS=2.1P AD=2.1P PS=10.84U PD=10.84U
* device instance $64 r0 *1 110.29,2.5 pfet
M$64 \$325 \$64 \$324 \$592 pfet L=0.5U W=5U AS=2.1P AD=2.1P PS=10.84U PD=10.84U
* device instance $65 r0 *1 112.03,2.5 pfet
M$65 \$327 \$65 \$326 \$592 pfet L=0.5U W=5U AS=2.1P AD=2.1P PS=10.84U PD=10.84U
* device instance $66 r0 *1 113.77,2.5 pfet
M$66 \$329 \$66 \$328 \$592 pfet L=0.5U W=5U AS=2.1P AD=2.1P PS=10.84U PD=10.84U
* device instance $67 r0 *1 115.51,2.5 pfet
M$67 \$331 \$67 \$330 \$592 pfet L=0.5U W=5U AS=2.1P AD=2.1P PS=10.84U PD=10.84U
* device instance $68 r0 *1 117.25,2.5 pfet
M$68 \$333 \$68 \$332 \$592 pfet L=0.5U W=5U AS=2.1P AD=2.1P PS=10.84U PD=10.84U
* device instance $69 r0 *1 118.99,2.5 pfet
M$69 \$335 \$69 \$334 \$592 pfet L=0.5U W=5U AS=2.1P AD=2.1P PS=10.84U PD=10.84U
* device instance $70 r0 *1 120.73,2.5 pfet
M$70 \$337 \$70 \$336 \$592 pfet L=0.5U W=5U AS=2.1P AD=2.1P PS=10.84U PD=10.84U
* device instance $71 r0 *1 122.47,2.5 pfet
M$71 \$339 \$71 \$338 \$592 pfet L=0.5U W=5U AS=2.1P AD=2.1P PS=10.84U PD=10.84U
* device instance $72 r0 *1 124.21,2.5 pfet
M$72 \$341 \$72 \$340 \$592 pfet L=0.5U W=5U AS=2.1P AD=2.1P PS=10.84U PD=10.84U
* device instance $73 r0 *1 125.95,2.5 pfet
M$73 \$343 \$73 \$342 \$592 pfet L=0.5U W=5U AS=2.1P AD=2.1P PS=10.84U PD=10.84U
* device instance $74 r0 *1 127.69,2.5 pfet
M$74 \$345 \$74 \$344 \$592 pfet L=0.5U W=5U AS=2.1P AD=2.1P PS=10.84U PD=10.84U
* device instance $75 r0 *1 129.43,2.5 pfet
M$75 \$347 \$75 \$346 \$592 pfet L=0.5U W=5U AS=2.1P AD=2.1P PS=10.84U PD=10.84U
* device instance $76 r0 *1 131.17,2.5 pfet
M$76 \$349 \$76 \$348 \$592 pfet L=0.5U W=5U AS=2.1P AD=2.1P PS=10.84U PD=10.84U
* device instance $77 r0 *1 132.91,2.5 pfet
M$77 \$351 \$77 \$350 \$592 pfet L=0.5U W=5U AS=2.1P AD=2.1P PS=10.84U PD=10.84U
* device instance $78 r0 *1 134.65,2.5 pfet
M$78 \$353 \$78 \$352 \$592 pfet L=0.5U W=5U AS=2.1P AD=2.1P PS=10.84U PD=10.84U
* device instance $79 r0 *1 136.39,2.5 pfet
M$79 \$355 \$79 \$354 \$592 pfet L=0.5U W=5U AS=2.1P AD=2.1P PS=10.84U PD=10.84U
* device instance $80 r0 *1 138.13,2.5 pfet
M$80 \$357 \$80 \$356 \$592 pfet L=0.5U W=5U AS=2.1P AD=2.1P PS=10.84U PD=10.84U
* device instance $81 r0 *1 139.87,2.5 pfet
M$81 \$359 \$81 \$358 \$592 pfet L=0.5U W=5U AS=2.1P AD=2.1P PS=10.84U PD=10.84U
* device instance $82 r0 *1 141.61,2.5 pfet
M$82 \$361 \$82 \$360 \$592 pfet L=0.5U W=5U AS=2.1P AD=2.1P PS=10.84U PD=10.84U
* device instance $83 r0 *1 143.35,2.5 pfet
M$83 \$363 \$83 \$362 \$592 pfet L=0.5U W=5U AS=2.1P AD=2.1P PS=10.84U PD=10.84U
* device instance $84 r0 *1 145.09,2.5 pfet
M$84 \$365 \$84 \$364 \$592 pfet L=0.5U W=5U AS=2.1P AD=2.1P PS=10.84U PD=10.84U
* device instance $85 r0 *1 146.83,2.5 pfet
M$85 \$367 \$85 \$366 \$592 pfet L=0.5U W=5U AS=2.1P AD=2.1P PS=10.84U PD=10.84U
* device instance $86 r0 *1 148.57,2.5 pfet
M$86 \$369 \$86 \$368 \$592 pfet L=0.5U W=5U AS=2.1P AD=2.1P PS=10.84U PD=10.84U
* device instance $87 r0 *1 150.31,2.5 pfet
M$87 \$371 \$87 \$370 \$592 pfet L=0.5U W=5U AS=2.1P AD=2.1P PS=10.84U PD=10.84U
* device instance $88 r0 *1 152.05,2.5 pfet
M$88 \$373 \$88 \$372 \$592 pfet L=0.5U W=5U AS=2.1P AD=2.1P PS=10.84U PD=10.84U
* device instance $89 r0 *1 153.79,2.5 pfet
M$89 \$375 \$89 \$374 \$592 pfet L=0.5U W=5U AS=2.1P AD=2.1P PS=10.84U PD=10.84U
* device instance $90 r0 *1 155.53,2.5 pfet
M$90 \$377 \$90 \$376 \$592 pfet L=0.5U W=5U AS=2.1P AD=2.1P PS=10.84U PD=10.84U
* device instance $91 r0 *1 157.27,2.5 pfet
M$91 \$379 \$91 \$378 \$592 pfet L=0.5U W=5U AS=2.1P AD=2.1P PS=10.84U PD=10.84U
* device instance $92 r0 *1 159.01,2.5 pfet
M$92 \$381 \$92 \$380 \$592 pfet L=0.5U W=5U AS=2.1P AD=2.1P PS=10.84U PD=10.84U
* device instance $93 r0 *1 160.75,2.5 pfet
M$93 \$383 \$93 \$382 \$592 pfet L=0.5U W=5U AS=2.1P AD=2.1P PS=10.84U PD=10.84U
* device instance $94 r0 *1 162.49,2.5 pfet
M$94 \$385 \$94 \$384 \$592 pfet L=0.5U W=5U AS=2.1P AD=2.1P PS=10.84U PD=10.84U
* device instance $95 r0 *1 164.23,2.5 pfet
M$95 \$387 \$95 \$386 \$592 pfet L=0.5U W=5U AS=2.1P AD=2.1P PS=10.84U PD=10.84U
* device instance $96 r0 *1 165.97,2.5 pfet
M$96 \$389 \$96 \$388 \$592 pfet L=0.5U W=5U AS=2.1P AD=2.1P PS=10.84U PD=10.84U
* device instance $97 r0 *1 167.71,2.5 pfet
M$97 \$391 \$97 \$390 \$592 pfet L=0.5U W=5U AS=2.1P AD=2.1P PS=10.84U PD=10.84U
* device instance $98 r0 *1 169.45,2.5 pfet
M$98 \$393 \$98 \$392 \$592 pfet L=0.5U W=5U AS=2.1P AD=2.1P PS=10.84U PD=10.84U
* device instance $99 r0 *1 171.19,2.5 pfet
M$99 \$395 \$99 \$394 \$592 pfet L=0.5U W=5U AS=2.1P AD=2.1P PS=10.84U PD=10.84U
* device instance $100 r0 *1 172.93,2.5 pfet
M$100 \$397 \$100 \$396 \$592 pfet L=0.5U W=5U AS=2.1P AD=2.1P PS=10.84U
+ PD=10.84U
* device instance $101 r0 *1 174.67,2.5 pfet
M$101 \$399 \$101 \$398 \$592 pfet L=0.5U W=5U AS=2.1P AD=2.1P PS=10.84U
+ PD=10.84U
* device instance $102 r0 *1 176.41,2.5 pfet
M$102 \$401 \$102 \$400 \$592 pfet L=0.5U W=5U AS=2.1P AD=2.1P PS=10.84U
+ PD=10.84U
* device instance $103 r0 *1 178.15,2.5 pfet
M$103 \$403 \$103 \$402 \$592 pfet L=0.5U W=5U AS=2.1P AD=2.1P PS=10.84U
+ PD=10.84U
* device instance $104 r0 *1 179.89,2.5 pfet
M$104 \$405 \$104 \$404 \$592 pfet L=0.5U W=5U AS=2.1P AD=2.1P PS=10.84U
+ PD=10.84U
* device instance $105 r0 *1 181.63,2.5 pfet
M$105 \$407 \$105 \$406 \$592 pfet L=0.5U W=5U AS=2.1P AD=2.1P PS=10.84U
+ PD=10.84U
* device instance $106 r0 *1 183.37,2.5 pfet
M$106 \$409 \$106 \$408 \$592 pfet L=0.5U W=5U AS=2.1P AD=2.1P PS=10.84U
+ PD=10.84U
* device instance $107 r0 *1 185.11,2.5 pfet
M$107 \$411 \$107 \$410 \$592 pfet L=0.5U W=5U AS=2.1P AD=2.1P PS=10.84U
+ PD=10.84U
* device instance $108 r0 *1 186.85,2.5 pfet
M$108 \$413 \$108 \$412 \$592 pfet L=0.5U W=5U AS=2.1P AD=2.1P PS=10.84U
+ PD=10.84U
* device instance $109 r0 *1 188.59,2.5 pfet
M$109 \$415 \$109 \$414 \$592 pfet L=0.5U W=5U AS=2.1P AD=2.1P PS=10.84U
+ PD=10.84U
* device instance $110 r0 *1 190.33,2.5 pfet
M$110 \$417 \$110 \$416 \$592 pfet L=0.5U W=5U AS=2.1P AD=2.1P PS=10.84U
+ PD=10.84U
* device instance $111 r0 *1 192.07,2.5 pfet
M$111 \$419 \$111 \$418 \$592 pfet L=0.5U W=5U AS=2.1P AD=2.1P PS=10.84U
+ PD=10.84U
* device instance $112 r0 *1 193.81,2.5 pfet
M$112 \$421 \$112 \$420 \$592 pfet L=0.5U W=5U AS=2.1P AD=2.1P PS=10.84U
+ PD=10.84U
* device instance $113 r0 *1 195.55,2.5 pfet
M$113 \$423 \$113 \$422 \$592 pfet L=0.5U W=5U AS=2.1P AD=2.1P PS=10.84U
+ PD=10.84U
* device instance $114 r0 *1 197.29,2.5 pfet
M$114 \$425 \$114 \$424 \$592 pfet L=0.5U W=5U AS=2.1P AD=2.1P PS=10.84U
+ PD=10.84U
* device instance $115 r0 *1 199.03,2.5 pfet
M$115 \$427 \$115 \$426 \$592 pfet L=0.5U W=5U AS=2.1P AD=2.1P PS=10.84U
+ PD=10.84U
* device instance $116 r0 *1 200.77,2.5 pfet
M$116 \$429 \$116 \$428 \$592 pfet L=0.5U W=5U AS=2.1P AD=2.1P PS=10.84U
+ PD=10.84U
* device instance $117 r0 *1 202.51,2.5 pfet
M$117 \$431 \$117 \$430 \$592 pfet L=0.5U W=5U AS=2.1P AD=2.1P PS=10.84U
+ PD=10.84U
* device instance $118 r0 *1 204.25,2.5 pfet
M$118 \$433 \$118 \$432 \$592 pfet L=0.5U W=5U AS=2.1P AD=2.1P PS=10.84U
+ PD=10.84U
* device instance $119 r0 *1 205.99,2.5 pfet
M$119 \$435 \$119 \$434 \$592 pfet L=0.5U W=5U AS=2.1P AD=2.1P PS=10.84U
+ PD=10.84U
* device instance $120 r0 *1 207.73,2.5 pfet
M$120 \$437 \$120 \$436 \$592 pfet L=0.5U W=5U AS=2.1P AD=2.1P PS=10.84U
+ PD=10.84U
* device instance $121 r0 *1 209.47,2.5 pfet
M$121 \$439 \$121 \$438 \$592 pfet L=0.5U W=5U AS=2.1P AD=2.1P PS=10.84U
+ PD=10.84U
* device instance $122 r0 *1 211.21,2.5 pfet
M$122 \$441 \$122 \$440 \$592 pfet L=0.5U W=5U AS=2.1P AD=2.1P PS=10.84U
+ PD=10.84U
* device instance $123 r0 *1 212.95,2.5 pfet
M$123 \$443 \$123 \$442 \$592 pfet L=0.5U W=5U AS=2.1P AD=2.1P PS=10.84U
+ PD=10.84U
* device instance $124 r0 *1 214.69,2.5 pfet
M$124 \$445 \$124 \$444 \$592 pfet L=0.5U W=5U AS=2.1P AD=2.1P PS=10.84U
+ PD=10.84U
* device instance $125 r0 *1 216.43,2.5 pfet
M$125 \$447 \$125 \$446 \$592 pfet L=0.5U W=5U AS=2.1P AD=2.1P PS=10.84U
+ PD=10.84U
* device instance $126 r0 *1 218.17,2.5 pfet
M$126 \$449 \$126 \$448 \$592 pfet L=0.5U W=5U AS=2.1P AD=2.1P PS=10.84U
+ PD=10.84U
* device instance $127 r0 *1 219.91,2.5 pfet
M$127 \$451 \$127 \$450 \$592 pfet L=0.5U W=5U AS=2.1P AD=2.1P PS=10.84U
+ PD=10.84U
* device instance $128 r0 *1 221.65,2.5 pfet
M$128 \$453 \$128 \$452 \$592 pfet L=0.5U W=5U AS=2.1P AD=2.1P PS=10.84U
+ PD=10.84U
* device instance $129 r0 *1 223.39,2.5 pfet
M$129 \$455 \$129 \$454 \$592 pfet L=0.5U W=5U AS=2.1P AD=2.1P PS=10.84U
+ PD=10.84U
* device instance $130 r0 *1 225.13,2.5 pfet
M$130 \$457 \$130 \$456 \$592 pfet L=0.5U W=5U AS=2.1P AD=2.1P PS=10.84U
+ PD=10.84U
* device instance $131 r0 *1 226.87,2.5 pfet
M$131 \$459 \$131 \$458 \$592 pfet L=0.5U W=5U AS=2.1P AD=2.1P PS=10.84U
+ PD=10.84U
* device instance $132 r0 *1 228.61,2.5 pfet
M$132 \$461 \$132 \$460 \$592 pfet L=0.5U W=5U AS=2.1P AD=2.1P PS=10.84U
+ PD=10.84U
* device instance $133 r0 *1 230.35,2.5 pfet
M$133 \$463 \$133 \$462 \$592 pfet L=0.5U W=5U AS=2.1P AD=2.1P PS=10.84U
+ PD=10.84U
* device instance $134 r0 *1 232.09,2.5 pfet
M$134 \$465 \$134 \$464 \$592 pfet L=0.5U W=5U AS=2.1P AD=2.1P PS=10.84U
+ PD=10.84U
* device instance $135 r0 *1 233.83,2.5 pfet
M$135 \$467 \$135 \$466 \$592 pfet L=0.5U W=5U AS=2.1P AD=2.1P PS=10.84U
+ PD=10.84U
* device instance $136 r0 *1 235.57,2.5 pfet
M$136 \$469 \$136 \$468 \$592 pfet L=0.5U W=5U AS=2.1P AD=2.1P PS=10.84U
+ PD=10.84U
* device instance $137 r0 *1 237.31,2.5 pfet
M$137 \$471 \$137 \$470 \$592 pfet L=0.5U W=5U AS=2.1P AD=2.1P PS=10.84U
+ PD=10.84U
* device instance $138 r0 *1 239.05,2.5 pfet
M$138 \$473 \$138 \$472 \$592 pfet L=0.5U W=5U AS=2.1P AD=2.1P PS=10.84U
+ PD=10.84U
* device instance $139 r0 *1 240.79,2.5 pfet
M$139 \$475 \$139 \$474 \$592 pfet L=0.5U W=5U AS=2.1P AD=2.1P PS=10.84U
+ PD=10.84U
* device instance $140 r0 *1 242.53,2.5 pfet
M$140 \$477 \$140 \$476 \$592 pfet L=0.5U W=5U AS=2.1P AD=2.1P PS=10.84U
+ PD=10.84U
* device instance $141 r0 *1 244.27,2.5 pfet
M$141 \$479 \$141 \$478 \$592 pfet L=0.5U W=5U AS=2.1P AD=2.1P PS=10.84U
+ PD=10.84U
* device instance $142 r0 *1 246.01,2.5 pfet
M$142 \$481 \$142 \$480 \$592 pfet L=0.5U W=5U AS=2.1P AD=2.1P PS=10.84U
+ PD=10.84U
* device instance $143 r0 *1 247.75,2.5 pfet
M$143 \$483 \$143 \$482 \$592 pfet L=0.5U W=5U AS=2.1P AD=2.1P PS=10.84U
+ PD=10.84U
* device instance $144 r0 *1 249.49,2.5 pfet
M$144 \$485 \$144 \$484 \$592 pfet L=0.5U W=5U AS=2.1P AD=2.1P PS=10.84U
+ PD=10.84U
* device instance $145 r0 *1 251.23,2.5 pfet
M$145 \$487 \$145 \$486 \$592 pfet L=0.5U W=5U AS=2.1P AD=2.1P PS=10.84U
+ PD=10.84U
* device instance $146 r0 *1 252.97,2.5 pfet
M$146 \$489 \$146 \$488 \$592 pfet L=0.5U W=5U AS=2.1P AD=2.1P PS=10.84U
+ PD=10.84U
* device instance $147 r0 *1 254.71,2.5 pfet
M$147 \$491 \$147 \$490 \$592 pfet L=0.5U W=5U AS=2.1P AD=2.1P PS=10.84U
+ PD=10.84U
* device instance $148 r0 *1 256.45,2.5 pfet
M$148 \$493 \$148 \$492 \$592 pfet L=0.5U W=5U AS=2.1P AD=2.1P PS=10.84U
+ PD=10.84U
* device instance $149 r0 *1 258.19,2.5 pfet
M$149 \$495 \$149 \$494 \$592 pfet L=0.5U W=5U AS=2.1P AD=2.1P PS=10.84U
+ PD=10.84U
* device instance $150 r0 *1 259.93,2.5 pfet
M$150 \$497 \$150 \$496 \$592 pfet L=0.5U W=5U AS=2.1P AD=2.1P PS=10.84U
+ PD=10.84U
* device instance $151 r0 *1 261.67,2.5 pfet
M$151 \$499 \$151 \$498 \$592 pfet L=0.5U W=5U AS=2.1P AD=2.1P PS=10.84U
+ PD=10.84U
* device instance $152 r0 *1 263.41,2.5 pfet
M$152 \$501 \$152 \$500 \$592 pfet L=0.5U W=5U AS=2.1P AD=2.1P PS=10.84U
+ PD=10.84U
* device instance $153 r0 *1 265.15,2.5 pfet
M$153 \$503 \$153 \$502 \$592 pfet L=0.5U W=5U AS=2.1P AD=2.1P PS=10.84U
+ PD=10.84U
* device instance $154 r0 *1 266.89,2.5 pfet
M$154 \$505 \$154 \$504 \$592 pfet L=0.5U W=5U AS=2.1P AD=2.1P PS=10.84U
+ PD=10.84U
* device instance $155 r0 *1 268.63,2.5 pfet
M$155 \$507 \$155 \$506 \$592 pfet L=0.5U W=5U AS=2.1P AD=2.1P PS=10.84U
+ PD=10.84U
* device instance $156 r0 *1 270.37,2.5 pfet
M$156 \$509 \$156 \$508 \$592 pfet L=0.5U W=5U AS=2.1P AD=2.1P PS=10.84U
+ PD=10.84U
* device instance $157 r0 *1 272.11,2.5 pfet
M$157 \$511 \$157 \$510 \$592 pfet L=0.5U W=5U AS=2.1P AD=2.1P PS=10.84U
+ PD=10.84U
* device instance $158 r0 *1 273.85,2.5 pfet
M$158 \$513 \$158 \$512 \$592 pfet L=0.5U W=5U AS=2.1P AD=2.1P PS=10.84U
+ PD=10.84U
* device instance $159 r0 *1 275.59,2.5 pfet
M$159 \$515 \$159 \$514 \$592 pfet L=0.5U W=5U AS=2.1P AD=2.1P PS=10.84U
+ PD=10.84U
* device instance $160 r0 *1 277.33,2.5 pfet
M$160 \$517 \$160 \$516 \$592 pfet L=0.5U W=5U AS=2.1P AD=2.1P PS=10.84U
+ PD=10.84U
* device instance $161 r0 *1 279.07,2.5 pfet
M$161 \$519 \$161 \$518 \$592 pfet L=0.5U W=5U AS=2.1P AD=2.1P PS=10.84U
+ PD=10.84U
* device instance $162 r0 *1 280.81,2.5 pfet
M$162 \$521 \$162 \$520 \$592 pfet L=0.5U W=5U AS=2.1P AD=2.1P PS=10.84U
+ PD=10.84U
* device instance $163 r0 *1 282.55,2.5 pfet
M$163 \$523 \$163 \$522 \$592 pfet L=0.5U W=5U AS=2.1P AD=2.1P PS=10.84U
+ PD=10.84U
* device instance $164 r0 *1 284.29,2.5 pfet
M$164 \$525 \$164 \$524 \$592 pfet L=0.5U W=5U AS=2.1P AD=2.1P PS=10.84U
+ PD=10.84U
* device instance $165 r0 *1 286.03,2.5 pfet
M$165 \$527 \$165 \$526 \$592 pfet L=0.5U W=5U AS=2.1P AD=2.1P PS=10.84U
+ PD=10.84U
* device instance $166 r0 *1 287.77,2.5 pfet
M$166 \$529 \$166 \$528 \$592 pfet L=0.5U W=5U AS=2.1P AD=2.1P PS=10.84U
+ PD=10.84U
* device instance $167 r0 *1 289.51,2.5 pfet
M$167 \$531 \$167 \$530 \$592 pfet L=0.5U W=5U AS=2.1P AD=2.1P PS=10.84U
+ PD=10.84U
* device instance $168 r0 *1 291.25,2.5 pfet
M$168 \$533 \$168 \$532 \$592 pfet L=0.5U W=5U AS=2.1P AD=2.1P PS=10.84U
+ PD=10.84U
* device instance $169 r0 *1 292.99,2.5 pfet
M$169 \$535 \$169 \$534 \$592 pfet L=0.5U W=5U AS=2.1P AD=2.1P PS=10.84U
+ PD=10.84U
* device instance $170 r0 *1 294.73,2.5 pfet
M$170 \$537 \$170 \$536 \$592 pfet L=0.5U W=5U AS=2.1P AD=2.1P PS=10.84U
+ PD=10.84U
* device instance $171 r0 *1 296.47,2.5 pfet
M$171 \$539 \$171 \$538 \$592 pfet L=0.5U W=5U AS=2.1P AD=2.1P PS=10.84U
+ PD=10.84U
* device instance $172 r0 *1 298.21,2.5 pfet
M$172 \$541 \$172 \$540 \$592 pfet L=0.5U W=5U AS=2.1P AD=2.1P PS=10.84U
+ PD=10.84U
* device instance $173 r0 *1 299.95,2.5 pfet
M$173 \$543 \$173 \$542 \$592 pfet L=0.5U W=5U AS=2.1P AD=2.1P PS=10.84U
+ PD=10.84U
* device instance $174 r0 *1 301.69,2.5 pfet
M$174 \$545 \$174 \$544 \$592 pfet L=0.5U W=5U AS=2.1P AD=2.1P PS=10.84U
+ PD=10.84U
* device instance $175 r0 *1 303.43,2.5 pfet
M$175 \$547 \$175 \$546 \$592 pfet L=0.5U W=5U AS=2.1P AD=2.1P PS=10.84U
+ PD=10.84U
* device instance $176 r0 *1 305.17,2.5 pfet
M$176 \$549 \$176 \$548 \$592 pfet L=0.5U W=5U AS=2.1P AD=2.1P PS=10.84U
+ PD=10.84U
* device instance $177 r0 *1 306.91,2.5 pfet
M$177 \$551 \$177 \$550 \$592 pfet L=0.5U W=5U AS=2.1P AD=2.1P PS=10.84U
+ PD=10.84U
* device instance $178 r0 *1 308.65,2.5 pfet
M$178 \$553 \$178 \$552 \$592 pfet L=0.5U W=5U AS=2.1P AD=2.1P PS=10.84U
+ PD=10.84U
* device instance $179 r0 *1 310.39,2.5 pfet
M$179 \$555 \$179 \$554 \$592 pfet L=0.5U W=5U AS=2.1P AD=2.1P PS=10.84U
+ PD=10.84U
* device instance $180 r0 *1 312.13,2.5 pfet
M$180 \$557 \$180 \$556 \$592 pfet L=0.5U W=5U AS=2.1P AD=2.1P PS=10.84U
+ PD=10.84U
* device instance $181 r0 *1 313.87,2.5 pfet
M$181 \$559 \$181 \$558 \$592 pfet L=0.5U W=5U AS=2.1P AD=2.1P PS=10.84U
+ PD=10.84U
* device instance $182 r0 *1 315.61,2.5 pfet
M$182 \$561 \$182 \$560 \$592 pfet L=0.5U W=5U AS=2.1P AD=2.1P PS=10.84U
+ PD=10.84U
* device instance $183 r0 *1 317.35,2.5 pfet
M$183 \$563 \$183 \$562 \$592 pfet L=0.5U W=5U AS=2.1P AD=2.1P PS=10.84U
+ PD=10.84U
* device instance $184 r0 *1 319.09,2.5 pfet
M$184 \$565 \$184 \$564 \$592 pfet L=0.5U W=5U AS=2.1P AD=2.1P PS=10.84U
+ PD=10.84U
* device instance $185 r0 *1 320.83,2.5 pfet
M$185 \$567 \$185 \$566 \$592 pfet L=0.5U W=5U AS=2.1P AD=2.1P PS=10.84U
+ PD=10.84U
* device instance $186 r0 *1 322.57,2.5 pfet
M$186 \$569 \$186 \$568 \$592 pfet L=0.5U W=5U AS=2.1P AD=2.1P PS=10.84U
+ PD=10.84U
* device instance $187 r0 *1 324.31,2.5 pfet
M$187 \$571 \$187 \$570 \$592 pfet L=0.5U W=5U AS=2.1P AD=2.1P PS=10.84U
+ PD=10.84U
* device instance $188 r0 *1 326.05,2.5 pfet
M$188 \$573 \$188 \$572 \$592 pfet L=0.5U W=5U AS=2.1P AD=2.1P PS=10.84U
+ PD=10.84U
* device instance $189 r0 *1 327.79,2.5 pfet
M$189 \$575 \$189 \$574 \$592 pfet L=0.5U W=5U AS=2.1P AD=2.1P PS=10.84U
+ PD=10.84U
* device instance $190 r0 *1 329.53,2.5 pfet
M$190 \$577 \$190 \$576 \$592 pfet L=0.5U W=5U AS=2.1P AD=2.1P PS=10.84U
+ PD=10.84U
* device instance $191 r0 *1 331.27,2.5 pfet
M$191 \$579 \$191 \$578 \$592 pfet L=0.5U W=5U AS=2.1P AD=2.1P PS=10.84U
+ PD=10.84U
* device instance $192 r0 *1 333.01,2.5 pfet
M$192 \$581 \$192 \$580 \$592 pfet L=0.5U W=5U AS=2.1P AD=2.1P PS=10.84U
+ PD=10.84U
* device instance $193 r0 *1 334.75,2.5 pfet
M$193 \$583 \$193 \$582 \$592 pfet L=0.5U W=5U AS=2.1P AD=2.1P PS=10.84U
+ PD=10.84U
* device instance $194 r0 *1 336.49,2.5 pfet
M$194 \$585 \$194 \$584 \$592 pfet L=0.5U W=5U AS=2.1P AD=2.1P PS=10.84U
+ PD=10.84U
* device instance $195 r0 *1 338.23,2.5 pfet
M$195 \$587 \$195 \$586 \$592 pfet L=0.5U W=5U AS=2.1P AD=2.1P PS=10.84U
+ PD=10.84U
* device instance $196 r0 *1 339.97,2.5 pfet
M$196 \$589 \$196 \$588 \$592 pfet L=0.5U W=5U AS=2.1P AD=2.1P PS=10.84U
+ PD=10.84U
* device instance $197 r0 *1 341.71,2.5 pfet
M$197 \$591 \$197 \$590 \$592 pfet L=0.5U W=5U AS=2.1P AD=2.1P PS=10.84U
+ PD=10.84U
.ENDS divider_chain_pfet_w5_l0p5
