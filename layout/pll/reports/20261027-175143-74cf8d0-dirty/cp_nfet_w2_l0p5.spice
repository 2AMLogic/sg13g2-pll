* extracted by klt extract --deck sg13g2

* cell cp_nfet_w2_l0p5
* pin vsubs
.SUBCKT cp_nfet_w2_l0p5 vsubs
* device instance $1 r0 *1 0.67,1 nfet
M$1 \$2 \$5 \$1 vsubs nfet L=0.5U W=2U AS=0.84P AD=0.84P PS=4.84U PD=4.84U
* device instance $2 r0 *1 2.41,1 nfet
M$2 \$4 \$6 \$3 vsubs nfet L=0.5U W=2U AS=0.84P AD=0.84P PS=4.84U PD=4.84U
.ENDS cp_nfet_w2_l0p5
