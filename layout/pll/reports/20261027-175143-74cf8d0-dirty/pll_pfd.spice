* extracted by klt extract --deck sg13g2

* cell pll_pfd
* pin vsubs
.SUBCKT pll_pfd vsubs
* device instance $1 r0 *1 0.67,1 nfet
M$1 \$21 \$1 \$19 vsubs nfet L=0.5U W=2U AS=0.84P AD=0.84P PS=4.84U PD=4.84U
* device instance $2 r0 *1 2.41,1 nfet
M$2 \$24 \$2 \$22 vsubs nfet L=0.5U W=2U AS=0.84P AD=0.84P PS=4.84U PD=4.84U
* device instance $3 r0 *1 4.15,1 nfet
M$3 \$27 \$3 \$25 vsubs nfet L=0.5U W=2U AS=0.84P AD=0.84P PS=4.84U PD=4.84U
* device instance $4 r0 *1 5.89,1 nfet
M$4 \$30 \$4 \$28 vsubs nfet L=0.5U W=2U AS=0.84P AD=0.84P PS=4.84U PD=4.84U
* device instance $5 r0 *1 7.63,1 nfet
M$5 \$33 \$5 \$31 vsubs nfet L=0.5U W=2U AS=0.84P AD=0.84P PS=4.84U PD=4.84U
* device instance $6 r0 *1 9.37,1 nfet
M$6 \$36 \$6 \$34 vsubs nfet L=0.5U W=2U AS=0.84P AD=0.84P PS=4.84U PD=4.84U
* device instance $7 r0 *1 11.11,1 nfet
M$7 \$39 \$7 \$37 vsubs nfet L=0.5U W=2U AS=0.84P AD=0.84P PS=4.84U PD=4.84U
* device instance $8 r0 *1 12.85,1 nfet
M$8 \$42 \$8 \$40 vsubs nfet L=0.5U W=2U AS=0.84P AD=0.84P PS=4.84U PD=4.84U
* device instance $9 r0 *1 18.19,2 nfet
M$9 \$44 \$9 \$43 vsubs nfet L=0.5U W=4U AS=1.68P AD=1.68P PS=8.84U PD=8.84U
* device instance $10 r0 *1 0.67,4.32 nfet
M$10 \$62 \$20 \$61 vsubs nfet L=0.5U W=2U AS=0.84P AD=0.84P PS=4.84U PD=4.84U
* device instance $11 r0 *1 2.41,4.32 nfet
M$11 \$64 \$23 \$63 vsubs nfet L=0.5U W=2U AS=0.84P AD=0.84P PS=4.84U PD=4.84U
* device instance $12 r0 *1 4.15,4.32 nfet
M$12 \$66 \$26 \$65 vsubs nfet L=0.5U W=2U AS=0.84P AD=0.84P PS=4.84U PD=4.84U
* device instance $13 r0 *1 5.89,4.32 nfet
M$13 \$68 \$29 \$67 vsubs nfet L=0.5U W=2U AS=0.84P AD=0.84P PS=4.84U PD=4.84U
* device instance $14 r0 *1 7.63,4.32 nfet
M$14 \$70 \$32 \$69 vsubs nfet L=0.5U W=2U AS=0.84P AD=0.84P PS=4.84U PD=4.84U
* device instance $15 r0 *1 9.37,4.32 nfet
M$15 \$72 \$35 \$71 vsubs nfet L=0.5U W=2U AS=0.84P AD=0.84P PS=4.84U PD=4.84U
* device instance $16 r0 *1 11.11,4.32 nfet
M$16 \$74 \$38 \$73 vsubs nfet L=0.5U W=2U AS=0.84P AD=0.84P PS=4.84U PD=4.84U
* device instance $17 r0 *1 12.85,4.32 nfet
M$17 \$76 \$41 \$75 vsubs nfet L=0.5U W=2U AS=0.84P AD=0.84P PS=4.84U PD=4.84U
* device instance $18 r0 *1 0.67,7.64 nfet
M$18 \$89 \$88 \$87 vsubs nfet L=0.5U W=2U AS=0.84P AD=0.84P PS=4.84U PD=4.84U
* device instance $19 r0 *1 2.41,7.64 nfet
M$19 \$92 \$91 \$90 vsubs nfet L=0.5U W=2U AS=0.84P AD=0.84P PS=4.84U PD=4.84U
* device instance $20 r0 *1 4.15,7.64 nfet
M$20 \$95 \$94 \$93 vsubs nfet L=0.5U W=2U AS=0.84P AD=0.84P PS=4.84U PD=4.84U
* device instance $21 r0 *1 5.89,7.64 nfet
M$21 \$98 \$97 \$96 vsubs nfet L=0.5U W=2U AS=0.84P AD=0.84P PS=4.84U PD=4.84U
* device instance $22 r0 *1 7.63,7.64 nfet
M$22 \$101 \$100 \$99 vsubs nfet L=0.5U W=2U AS=0.84P AD=0.84P PS=4.84U PD=4.84U
* device instance $23 r0 *1 9.37,7.64 nfet
M$23 \$104 \$103 \$102 vsubs nfet L=0.5U W=2U AS=0.84P AD=0.84P PS=4.84U
+ PD=4.84U
* device instance $24 r0 *1 11.11,7.64 nfet
M$24 \$107 \$106 \$105 vsubs nfet L=0.5U W=2U AS=0.84P AD=0.84P PS=4.84U
+ PD=4.84U
* device instance $25 r0 *1 12.85,7.64 nfet
M$25 \$110 \$109 \$108 vsubs nfet L=0.5U W=2U AS=0.84P AD=0.84P PS=4.84U
+ PD=4.84U
* device instance $26 r0 *1 0.67,10.96 nfet
M$26 \$113 \$112 \$111 vsubs nfet L=0.5U W=2U AS=0.84P AD=0.84P PS=4.84U
+ PD=4.84U
* device instance $27 r0 *1 2.41,10.96 nfet
M$27 \$116 \$115 \$114 vsubs nfet L=0.5U W=2U AS=0.84P AD=0.84P PS=4.84U
+ PD=4.84U
* device instance $28 r0 *1 4.15,10.96 nfet
M$28 \$119 \$118 \$117 vsubs nfet L=0.5U W=2U AS=0.84P AD=0.84P PS=4.84U
+ PD=4.84U
* device instance $29 r0 *1 5.89,10.96 nfet
M$29 \$122 \$121 \$120 vsubs nfet L=0.5U W=2U AS=0.84P AD=0.84P PS=4.84U
+ PD=4.84U
* device instance $30 r0 *1 7.63,10.96 nfet
M$30 \$125 \$124 \$123 vsubs nfet L=0.5U W=2U AS=0.84P AD=0.84P PS=4.84U
+ PD=4.84U
* device instance $31 r0 *1 9.37,10.96 nfet
M$31 \$128 \$127 \$126 vsubs nfet L=0.5U W=2U AS=0.84P AD=0.84P PS=4.84U
+ PD=4.84U
* device instance $32 r0 *1 11.11,10.96 nfet
M$32 \$131 \$130 \$129 vsubs nfet L=0.5U W=2U AS=0.84P AD=0.84P PS=4.84U
+ PD=4.84U
* device instance $33 r0 *1 12.85,10.96 nfet
M$33 \$134 \$133 \$132 vsubs nfet L=0.5U W=2U AS=0.84P AD=0.84P PS=4.84U
+ PD=4.84U
* device instance $34 r0 *1 23.53,2.5 pfet
M$34 \$46 \$10 \$45 \$200 pfet L=0.5U W=5U AS=2.1P AD=2.1P PS=10.84U PD=10.84U
* device instance $35 r0 *1 25.27,2.5 pfet
M$35 \$48 \$11 \$47 \$200 pfet L=0.5U W=5U AS=2.1P AD=2.1P PS=10.84U PD=10.84U
* device instance $36 r0 *1 27.01,2.5 pfet
M$36 \$50 \$12 \$49 \$200 pfet L=0.5U W=5U AS=2.1P AD=2.1P PS=10.84U PD=10.84U
* device instance $37 r0 *1 28.75,2.5 pfet
M$37 \$52 \$13 \$51 \$200 pfet L=0.5U W=5U AS=2.1P AD=2.1P PS=10.84U PD=10.84U
* device instance $38 r0 *1 30.49,2.5 pfet
M$38 \$54 \$14 \$53 \$200 pfet L=0.5U W=5U AS=2.1P AD=2.1P PS=10.84U PD=10.84U
* device instance $39 r0 *1 32.23,2.5 pfet
M$39 \$56 \$15 \$55 \$200 pfet L=0.5U W=5U AS=2.1P AD=2.1P PS=10.84U PD=10.84U
* device instance $40 r0 *1 33.97,2.5 pfet
M$40 \$58 \$16 \$57 \$200 pfet L=0.5U W=5U AS=2.1P AD=2.1P PS=10.84U PD=10.84U
* device instance $41 r0 *1 35.71,2.5 pfet
M$41 \$60 \$17 \$59 \$200 pfet L=0.5U W=5U AS=2.1P AD=2.1P PS=10.84U PD=10.84U
* device instance $42 r0 *1 41.35,5 pfet
M$42 \$86 \$18 \$85 \$151 pfet L=0.5U W=10U AS=4.2P AD=4.2P PS=20.84U PD=20.84U
* device instance $43 r0 *1 23.53,8.82 pfet
M$43 \$136 \$77 \$135 \$200 pfet L=0.5U W=5U AS=2.1P AD=2.1P PS=10.84U PD=10.84U
* device instance $44 r0 *1 25.27,8.82 pfet
M$44 \$138 \$78 \$137 \$200 pfet L=0.5U W=5U AS=2.1P AD=2.1P PS=10.84U PD=10.84U
* device instance $45 r0 *1 27.01,8.82 pfet
M$45 \$140 \$79 \$139 \$200 pfet L=0.5U W=5U AS=2.1P AD=2.1P PS=10.84U PD=10.84U
* device instance $46 r0 *1 28.75,8.82 pfet
M$46 \$142 \$80 \$141 \$200 pfet L=0.5U W=5U AS=2.1P AD=2.1P PS=10.84U PD=10.84U
* device instance $47 r0 *1 30.49,8.82 pfet
M$47 \$144 \$81 \$143 \$200 pfet L=0.5U W=5U AS=2.1P AD=2.1P PS=10.84U PD=10.84U
* device instance $48 r0 *1 32.23,8.82 pfet
M$48 \$146 \$82 \$145 \$200 pfet L=0.5U W=5U AS=2.1P AD=2.1P PS=10.84U PD=10.84U
* device instance $49 r0 *1 33.97,8.82 pfet
M$49 \$148 \$83 \$147 \$200 pfet L=0.5U W=5U AS=2.1P AD=2.1P PS=10.84U PD=10.84U
* device instance $50 r0 *1 35.71,8.82 pfet
M$50 \$150 \$84 \$149 \$200 pfet L=0.5U W=5U AS=2.1P AD=2.1P PS=10.84U PD=10.84U
* device instance $51 r0 *1 23.53,15.14 pfet
M$51 \$154 \$153 \$152 \$200 pfet L=0.5U W=5U AS=2.1P AD=2.1P PS=10.84U
+ PD=10.84U
* device instance $52 r0 *1 25.27,15.14 pfet
M$52 \$157 \$156 \$155 \$200 pfet L=0.5U W=5U AS=2.1P AD=2.1P PS=10.84U
+ PD=10.84U
* device instance $53 r0 *1 27.01,15.14 pfet
M$53 \$160 \$159 \$158 \$200 pfet L=0.5U W=5U AS=2.1P AD=2.1P PS=10.84U
+ PD=10.84U
* device instance $54 r0 *1 28.75,15.14 pfet
M$54 \$163 \$162 \$161 \$200 pfet L=0.5U W=5U AS=2.1P AD=2.1P PS=10.84U
+ PD=10.84U
* device instance $55 r0 *1 30.49,15.14 pfet
M$55 \$166 \$165 \$164 \$200 pfet L=0.5U W=5U AS=2.1P AD=2.1P PS=10.84U
+ PD=10.84U
* device instance $56 r0 *1 32.23,15.14 pfet
M$56 \$169 \$168 \$167 \$200 pfet L=0.5U W=5U AS=2.1P AD=2.1P PS=10.84U
+ PD=10.84U
* device instance $57 r0 *1 33.97,15.14 pfet
M$57 \$172 \$171 \$170 \$200 pfet L=0.5U W=5U AS=2.1P AD=2.1P PS=10.84U
+ PD=10.84U
* device instance $58 r0 *1 35.71,15.14 pfet
M$58 \$175 \$174 \$173 \$200 pfet L=0.5U W=5U AS=2.1P AD=2.1P PS=10.84U
+ PD=10.84U
* device instance $59 r0 *1 23.53,21.46 pfet
M$59 \$185 \$176 \$184 \$200 pfet L=0.5U W=5U AS=2.1P AD=2.1P PS=10.84U
+ PD=10.84U
* device instance $60 r0 *1 25.27,21.46 pfet
M$60 \$187 \$177 \$186 \$200 pfet L=0.5U W=5U AS=2.1P AD=2.1P PS=10.84U
+ PD=10.84U
* device instance $61 r0 *1 27.01,21.46 pfet
M$61 \$189 \$178 \$188 \$200 pfet L=0.5U W=5U AS=2.1P AD=2.1P PS=10.84U
+ PD=10.84U
* device instance $62 r0 *1 28.75,21.46 pfet
M$62 \$191 \$179 \$190 \$200 pfet L=0.5U W=5U AS=2.1P AD=2.1P PS=10.84U
+ PD=10.84U
* device instance $63 r0 *1 30.49,21.46 pfet
M$63 \$193 \$180 \$192 \$200 pfet L=0.5U W=5U AS=2.1P AD=2.1P PS=10.84U
+ PD=10.84U
* device instance $64 r0 *1 32.23,21.46 pfet
M$64 \$195 \$181 \$194 \$200 pfet L=0.5U W=5U AS=2.1P AD=2.1P PS=10.84U
+ PD=10.84U
* device instance $65 r0 *1 33.97,21.46 pfet
M$65 \$197 \$182 \$196 \$200 pfet L=0.5U W=5U AS=2.1P AD=2.1P PS=10.84U
+ PD=10.84U
* device instance $66 r0 *1 35.71,21.46 pfet
M$66 \$199 \$183 \$198 \$200 pfet L=0.5U W=5U AS=2.1P AD=2.1P PS=10.84U
+ PD=10.84U
.ENDS pll_pfd
