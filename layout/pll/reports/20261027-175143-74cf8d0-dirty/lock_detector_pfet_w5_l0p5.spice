* extracted by klt extract --deck sg13g2

* cell lock_detector_pfet_w5_l0p5
.SUBCKT lock_detector_pfet_w5_l0p5
* device instance $1 r0 *1 0.67,2.5 pfet
M$1 \$8 \$1 \$6 \$46 pfet L=0.5U W=5U AS=2.1P AD=2.1P PS=10.84U PD=10.84U
* device instance $2 r0 *1 2.41,2.5 pfet
M$2 \$11 \$2 \$9 \$46 pfet L=0.5U W=5U AS=2.1P AD=2.1P PS=10.84U PD=10.84U
* device instance $3 r0 *1 4.15,2.5 pfet
M$3 \$14 \$3 \$12 \$46 pfet L=0.5U W=5U AS=2.1P AD=2.1P PS=10.84U PD=10.84U
* device instance $4 r0 *1 5.89,2.5 pfet
M$4 \$17 \$4 \$15 \$46 pfet L=0.5U W=5U AS=2.1P AD=2.1P PS=10.84U PD=10.84U
* device instance $5 r0 *1 7.63,2.5 pfet
M$5 \$20 \$5 \$18 \$46 pfet L=0.5U W=5U AS=2.1P AD=2.1P PS=10.84U PD=10.84U
* device instance $6 r0 *1 0.67,8.82 pfet
M$6 \$23 \$7 \$21 \$46 pfet L=0.5U W=5U AS=2.1P AD=2.1P PS=10.84U PD=10.84U
* device instance $7 r0 *1 2.41,8.82 pfet
M$7 \$26 \$10 \$24 \$46 pfet L=0.5U W=5U AS=2.1P AD=2.1P PS=10.84U PD=10.84U
* device instance $8 r0 *1 4.15,8.82 pfet
M$8 \$29 \$13 \$27 \$46 pfet L=0.5U W=5U AS=2.1P AD=2.1P PS=10.84U PD=10.84U
* device instance $9 r0 *1 5.89,8.82 pfet
M$9 \$32 \$16 \$30 \$46 pfet L=0.5U W=5U AS=2.1P AD=2.1P PS=10.84U PD=10.84U
* device instance $10 r0 *1 7.63,8.82 pfet
M$10 \$35 \$19 \$33 \$46 pfet L=0.5U W=5U AS=2.1P AD=2.1P PS=10.84U PD=10.84U
* device instance $11 r0 *1 0.67,15.14 pfet
M$11 \$37 \$22 \$36 \$46 pfet L=0.5U W=5U AS=2.1P AD=2.1P PS=10.84U PD=10.84U
* device instance $12 r0 *1 2.41,15.14 pfet
M$12 \$39 \$25 \$38 \$46 pfet L=0.5U W=5U AS=2.1P AD=2.1P PS=10.84U PD=10.84U
* device instance $13 r0 *1 4.15,15.14 pfet
M$13 \$41 \$28 \$40 \$46 pfet L=0.5U W=5U AS=2.1P AD=2.1P PS=10.84U PD=10.84U
* device instance $14 r0 *1 5.89,15.14 pfet
M$14 \$43 \$31 \$42 \$46 pfet L=0.5U W=5U AS=2.1P AD=2.1P PS=10.84U PD=10.84U
* device instance $15 r0 *1 7.63,15.14 pfet
M$15 \$45 \$34 \$44 \$46 pfet L=0.5U W=5U AS=2.1P AD=2.1P PS=10.84U PD=10.84U
.ENDS lock_detector_pfet_w5_l0p5
