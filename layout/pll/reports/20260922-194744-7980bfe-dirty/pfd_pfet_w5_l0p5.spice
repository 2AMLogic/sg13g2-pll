* extracted by klt extract --deck sg13g2

* cell pfd_pfet_w5_l0p5
.SUBCKT pfd_pfet_w5_l0p5
* device instance $1 r0 *1 0.67,2.5 pfet
M$1 \$33 \$1 \$32 \$94 pfet L=0.5U W=5U AS=2.1P AD=2.1P PS=10.84U PD=10.84U
* device instance $2 r0 *1 2.41,2.5 pfet
M$2 \$35 \$2 \$34 \$94 pfet L=0.5U W=5U AS=2.1P AD=2.1P PS=10.84U PD=10.84U
* device instance $3 r0 *1 4.15,2.5 pfet
M$3 \$37 \$3 \$36 \$94 pfet L=0.5U W=5U AS=2.1P AD=2.1P PS=10.84U PD=10.84U
* device instance $4 r0 *1 5.89,2.5 pfet
M$4 \$39 \$4 \$38 \$94 pfet L=0.5U W=5U AS=2.1P AD=2.1P PS=10.84U PD=10.84U
* device instance $5 r0 *1 7.63,2.5 pfet
M$5 \$41 \$5 \$40 \$94 pfet L=0.5U W=5U AS=2.1P AD=2.1P PS=10.84U PD=10.84U
* device instance $6 r0 *1 9.37,2.5 pfet
M$6 \$43 \$6 \$42 \$94 pfet L=0.5U W=5U AS=2.1P AD=2.1P PS=10.84U PD=10.84U
* device instance $7 r0 *1 11.11,2.5 pfet
M$7 \$45 \$7 \$44 \$94 pfet L=0.5U W=5U AS=2.1P AD=2.1P PS=10.84U PD=10.84U
* device instance $8 r0 *1 12.85,2.5 pfet
M$8 \$47 \$8 \$46 \$94 pfet L=0.5U W=5U AS=2.1P AD=2.1P PS=10.84U PD=10.84U
* device instance $9 r0 *1 14.59,2.5 pfet
M$9 \$49 \$9 \$48 \$94 pfet L=0.5U W=5U AS=2.1P AD=2.1P PS=10.84U PD=10.84U
* device instance $10 r0 *1 16.33,2.5 pfet
M$10 \$51 \$10 \$50 \$94 pfet L=0.5U W=5U AS=2.1P AD=2.1P PS=10.84U PD=10.84U
* device instance $11 r0 *1 18.07,2.5 pfet
M$11 \$53 \$11 \$52 \$94 pfet L=0.5U W=5U AS=2.1P AD=2.1P PS=10.84U PD=10.84U
* device instance $12 r0 *1 19.81,2.5 pfet
M$12 \$55 \$12 \$54 \$94 pfet L=0.5U W=5U AS=2.1P AD=2.1P PS=10.84U PD=10.84U
* device instance $13 r0 *1 21.55,2.5 pfet
M$13 \$57 \$13 \$56 \$94 pfet L=0.5U W=5U AS=2.1P AD=2.1P PS=10.84U PD=10.84U
* device instance $14 r0 *1 23.29,2.5 pfet
M$14 \$59 \$14 \$58 \$94 pfet L=0.5U W=5U AS=2.1P AD=2.1P PS=10.84U PD=10.84U
* device instance $15 r0 *1 25.03,2.5 pfet
M$15 \$61 \$15 \$60 \$94 pfet L=0.5U W=5U AS=2.1P AD=2.1P PS=10.84U PD=10.84U
* device instance $16 r0 *1 26.77,2.5 pfet
M$16 \$63 \$16 \$62 \$94 pfet L=0.5U W=5U AS=2.1P AD=2.1P PS=10.84U PD=10.84U
* device instance $17 r0 *1 28.51,2.5 pfet
M$17 \$65 \$17 \$64 \$94 pfet L=0.5U W=5U AS=2.1P AD=2.1P PS=10.84U PD=10.84U
* device instance $18 r0 *1 30.25,2.5 pfet
M$18 \$67 \$18 \$66 \$94 pfet L=0.5U W=5U AS=2.1P AD=2.1P PS=10.84U PD=10.84U
* device instance $19 r0 *1 31.99,2.5 pfet
M$19 \$69 \$19 \$68 \$94 pfet L=0.5U W=5U AS=2.1P AD=2.1P PS=10.84U PD=10.84U
* device instance $20 r0 *1 33.73,2.5 pfet
M$20 \$71 \$20 \$70 \$94 pfet L=0.5U W=5U AS=2.1P AD=2.1P PS=10.84U PD=10.84U
* device instance $21 r0 *1 35.47,2.5 pfet
M$21 \$73 \$21 \$72 \$94 pfet L=0.5U W=5U AS=2.1P AD=2.1P PS=10.84U PD=10.84U
* device instance $22 r0 *1 37.21,2.5 pfet
M$22 \$75 \$22 \$74 \$94 pfet L=0.5U W=5U AS=2.1P AD=2.1P PS=10.84U PD=10.84U
* device instance $23 r0 *1 38.95,2.5 pfet
M$23 \$77 \$23 \$76 \$94 pfet L=0.5U W=5U AS=2.1P AD=2.1P PS=10.84U PD=10.84U
* device instance $24 r0 *1 40.69,2.5 pfet
M$24 \$79 \$24 \$78 \$94 pfet L=0.5U W=5U AS=2.1P AD=2.1P PS=10.84U PD=10.84U
* device instance $25 r0 *1 42.43,2.5 pfet
M$25 \$81 \$25 \$80 \$94 pfet L=0.5U W=5U AS=2.1P AD=2.1P PS=10.84U PD=10.84U
* device instance $26 r0 *1 44.17,2.5 pfet
M$26 \$83 \$26 \$82 \$94 pfet L=0.5U W=5U AS=2.1P AD=2.1P PS=10.84U PD=10.84U
* device instance $27 r0 *1 45.91,2.5 pfet
M$27 \$85 \$27 \$84 \$94 pfet L=0.5U W=5U AS=2.1P AD=2.1P PS=10.84U PD=10.84U
* device instance $28 r0 *1 47.65,2.5 pfet
M$28 \$87 \$28 \$86 \$94 pfet L=0.5U W=5U AS=2.1P AD=2.1P PS=10.84U PD=10.84U
* device instance $29 r0 *1 49.39,2.5 pfet
M$29 \$89 \$29 \$88 \$94 pfet L=0.5U W=5U AS=2.1P AD=2.1P PS=10.84U PD=10.84U
* device instance $30 r0 *1 51.13,2.5 pfet
M$30 \$91 \$30 \$90 \$94 pfet L=0.5U W=5U AS=2.1P AD=2.1P PS=10.84U PD=10.84U
* device instance $31 r0 *1 52.87,2.5 pfet
M$31 \$93 \$31 \$92 \$94 pfet L=0.5U W=5U AS=2.1P AD=2.1P PS=10.84U PD=10.84U
.ENDS pfd_pfet_w5_l0p5
