* extracted by klt extract --deck sg13g2

* cell vco_nfet_w4_l1
* pin vsubs
.SUBCKT vco_nfet_w4_l1 vsubs
* device instance $1 r0 *1 0.92,2 nfet
M$1 \$2 \$7 \$1 vsubs nfet L=1U W=4U AS=1.68P AD=1.68P PS=8.84U PD=8.84U
* device instance $2 r0 *1 3.16,2 nfet
M$2 \$4 \$8 \$3 vsubs nfet L=1U W=4U AS=1.68P AD=1.68P PS=8.84U PD=8.84U
* device instance $3 r0 *1 5.4,2 nfet
M$3 \$6 \$9 \$5 vsubs nfet L=1U W=4U AS=1.68P AD=1.68P PS=8.84U PD=8.84U
.ENDS vco_nfet_w4_l1
