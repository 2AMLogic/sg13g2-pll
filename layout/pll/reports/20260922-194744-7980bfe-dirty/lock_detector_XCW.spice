* extracted by klt extract --deck sg13g2

* cell lock_detector_XCW
.SUBCKT lock_detector_XCW
* device instance $1 r0 *1 23,23 cap_cmim
C$1 \$1 \$2 3.0447e-12
.ENDS lock_detector_XCW
