* extracted by klt extract --deck sg13g2

* cell pll_pfd
* pin vsubs
.SUBCKT pll_pfd vsubs
* device instance $1 r0 *1 0.67,1 nfet
M$1 \$66 \$1 \$65 vsubs nfet L=0.5U W=2U AS=0.84P AD=0.84P PS=4.84U PD=4.84U
* device instance $2 r0 *1 2.41,1 nfet
M$2 \$68 \$2 \$67 vsubs nfet L=0.5U W=2U AS=0.84P AD=0.84P PS=4.84U PD=4.84U
* device instance $3 r0 *1 4.15,1 nfet
M$3 \$70 \$3 \$69 vsubs nfet L=0.5U W=2U AS=0.84P AD=0.84P PS=4.84U PD=4.84U
* device instance $4 r0 *1 5.89,1 nfet
M$4 \$72 \$4 \$71 vsubs nfet L=0.5U W=2U AS=0.84P AD=0.84P PS=4.84U PD=4.84U
* device instance $5 r0 *1 7.63,1 nfet
M$5 \$74 \$5 \$73 vsubs nfet L=0.5U W=2U AS=0.84P AD=0.84P PS=4.84U PD=4.84U
* device instance $6 r0 *1 9.37,1 nfet
M$6 \$76 \$6 \$75 vsubs nfet L=0.5U W=2U AS=0.84P AD=0.84P PS=4.84U PD=4.84U
* device instance $7 r0 *1 11.11,1 nfet
M$7 \$78 \$7 \$77 vsubs nfet L=0.5U W=2U AS=0.84P AD=0.84P PS=4.84U PD=4.84U
* device instance $8 r0 *1 12.85,1 nfet
M$8 \$80 \$8 \$79 vsubs nfet L=0.5U W=2U AS=0.84P AD=0.84P PS=4.84U PD=4.84U
* device instance $9 r0 *1 14.59,1 nfet
M$9 \$82 \$9 \$81 vsubs nfet L=0.5U W=2U AS=0.84P AD=0.84P PS=4.84U PD=4.84U
* device instance $10 r0 *1 16.33,1 nfet
M$10 \$84 \$10 \$83 vsubs nfet L=0.5U W=2U AS=0.84P AD=0.84P PS=4.84U PD=4.84U
* device instance $11 r0 *1 18.07,1 nfet
M$11 \$86 \$11 \$85 vsubs nfet L=0.5U W=2U AS=0.84P AD=0.84P PS=4.84U PD=4.84U
* device instance $12 r0 *1 19.81,1 nfet
M$12 \$88 \$12 \$87 vsubs nfet L=0.5U W=2U AS=0.84P AD=0.84P PS=4.84U PD=4.84U
* device instance $13 r0 *1 21.55,1 nfet
M$13 \$90 \$13 \$89 vsubs nfet L=0.5U W=2U AS=0.84P AD=0.84P PS=4.84U PD=4.84U
* device instance $14 r0 *1 23.29,1 nfet
M$14 \$92 \$14 \$91 vsubs nfet L=0.5U W=2U AS=0.84P AD=0.84P PS=4.84U PD=4.84U
* device instance $15 r0 *1 25.03,1 nfet
M$15 \$94 \$15 \$93 vsubs nfet L=0.5U W=2U AS=0.84P AD=0.84P PS=4.84U PD=4.84U
* device instance $16 r0 *1 26.77,1 nfet
M$16 \$96 \$16 \$95 vsubs nfet L=0.5U W=2U AS=0.84P AD=0.84P PS=4.84U PD=4.84U
* device instance $17 r0 *1 28.51,1 nfet
M$17 \$98 \$17 \$97 vsubs nfet L=0.5U W=2U AS=0.84P AD=0.84P PS=4.84U PD=4.84U
* device instance $18 r0 *1 30.25,1 nfet
M$18 \$100 \$18 \$99 vsubs nfet L=0.5U W=2U AS=0.84P AD=0.84P PS=4.84U PD=4.84U
* device instance $19 r0 *1 31.99,1 nfet
M$19 \$102 \$19 \$101 vsubs nfet L=0.5U W=2U AS=0.84P AD=0.84P PS=4.84U PD=4.84U
* device instance $20 r0 *1 33.73,1 nfet
M$20 \$104 \$20 \$103 vsubs nfet L=0.5U W=2U AS=0.84P AD=0.84P PS=4.84U PD=4.84U
* device instance $21 r0 *1 35.47,1 nfet
M$21 \$106 \$21 \$105 vsubs nfet L=0.5U W=2U AS=0.84P AD=0.84P PS=4.84U PD=4.84U
* device instance $22 r0 *1 37.21,1 nfet
M$22 \$108 \$22 \$107 vsubs nfet L=0.5U W=2U AS=0.84P AD=0.84P PS=4.84U PD=4.84U
* device instance $23 r0 *1 38.95,1 nfet
M$23 \$110 \$23 \$109 vsubs nfet L=0.5U W=2U AS=0.84P AD=0.84P PS=4.84U PD=4.84U
* device instance $24 r0 *1 40.69,1 nfet
M$24 \$112 \$24 \$111 vsubs nfet L=0.5U W=2U AS=0.84P AD=0.84P PS=4.84U PD=4.84U
* device instance $25 r0 *1 42.43,1 nfet
M$25 \$114 \$25 \$113 vsubs nfet L=0.5U W=2U AS=0.84P AD=0.84P PS=4.84U PD=4.84U
* device instance $26 r0 *1 44.17,1 nfet
M$26 \$116 \$26 \$115 vsubs nfet L=0.5U W=2U AS=0.84P AD=0.84P PS=4.84U PD=4.84U
* device instance $27 r0 *1 45.91,1 nfet
M$27 \$118 \$27 \$117 vsubs nfet L=0.5U W=2U AS=0.84P AD=0.84P PS=4.84U PD=4.84U
* device instance $28 r0 *1 47.65,1 nfet
M$28 \$120 \$28 \$119 vsubs nfet L=0.5U W=2U AS=0.84P AD=0.84P PS=4.84U PD=4.84U
* device instance $29 r0 *1 49.39,1 nfet
M$29 \$122 \$29 \$121 vsubs nfet L=0.5U W=2U AS=0.84P AD=0.84P PS=4.84U PD=4.84U
* device instance $30 r0 *1 51.13,1 nfet
M$30 \$124 \$30 \$123 vsubs nfet L=0.5U W=2U AS=0.84P AD=0.84P PS=4.84U PD=4.84U
* device instance $31 r0 *1 52.87,1 nfet
M$31 \$126 \$31 \$125 vsubs nfet L=0.5U W=2U AS=0.84P AD=0.84P PS=4.84U PD=4.84U
* device instance $32 r0 *1 58.21,2 nfet
M$32 \$128 \$32 \$127 vsubs nfet L=0.5U W=4U AS=1.68P AD=1.68P PS=8.84U PD=8.84U
* device instance $33 r0 *1 63.55,2.5 pfet
M$33 \$130 \$33 \$129 \$193 pfet L=0.5U W=5U AS=2.1P AD=2.1P PS=10.84U PD=10.84U
* device instance $34 r0 *1 65.29,2.5 pfet
M$34 \$132 \$34 \$131 \$193 pfet L=0.5U W=5U AS=2.1P AD=2.1P PS=10.84U PD=10.84U
* device instance $35 r0 *1 67.03,2.5 pfet
M$35 \$134 \$35 \$133 \$193 pfet L=0.5U W=5U AS=2.1P AD=2.1P PS=10.84U PD=10.84U
* device instance $36 r0 *1 68.77,2.5 pfet
M$36 \$136 \$36 \$135 \$193 pfet L=0.5U W=5U AS=2.1P AD=2.1P PS=10.84U PD=10.84U
* device instance $37 r0 *1 70.51,2.5 pfet
M$37 \$138 \$37 \$137 \$193 pfet L=0.5U W=5U AS=2.1P AD=2.1P PS=10.84U PD=10.84U
* device instance $38 r0 *1 72.25,2.5 pfet
M$38 \$140 \$38 \$139 \$193 pfet L=0.5U W=5U AS=2.1P AD=2.1P PS=10.84U PD=10.84U
* device instance $39 r0 *1 73.99,2.5 pfet
M$39 \$142 \$39 \$141 \$193 pfet L=0.5U W=5U AS=2.1P AD=2.1P PS=10.84U PD=10.84U
* device instance $40 r0 *1 75.73,2.5 pfet
M$40 \$144 \$40 \$143 \$193 pfet L=0.5U W=5U AS=2.1P AD=2.1P PS=10.84U PD=10.84U
* device instance $41 r0 *1 77.47,2.5 pfet
M$41 \$146 \$41 \$145 \$193 pfet L=0.5U W=5U AS=2.1P AD=2.1P PS=10.84U PD=10.84U
* device instance $42 r0 *1 79.21,2.5 pfet
M$42 \$148 \$42 \$147 \$193 pfet L=0.5U W=5U AS=2.1P AD=2.1P PS=10.84U PD=10.84U
* device instance $43 r0 *1 80.95,2.5 pfet
M$43 \$150 \$43 \$149 \$193 pfet L=0.5U W=5U AS=2.1P AD=2.1P PS=10.84U PD=10.84U
* device instance $44 r0 *1 82.69,2.5 pfet
M$44 \$152 \$44 \$151 \$193 pfet L=0.5U W=5U AS=2.1P AD=2.1P PS=10.84U PD=10.84U
* device instance $45 r0 *1 84.43,2.5 pfet
M$45 \$154 \$45 \$153 \$193 pfet L=0.5U W=5U AS=2.1P AD=2.1P PS=10.84U PD=10.84U
* device instance $46 r0 *1 86.17,2.5 pfet
M$46 \$156 \$46 \$155 \$193 pfet L=0.5U W=5U AS=2.1P AD=2.1P PS=10.84U PD=10.84U
* device instance $47 r0 *1 87.91,2.5 pfet
M$47 \$158 \$47 \$157 \$193 pfet L=0.5U W=5U AS=2.1P AD=2.1P PS=10.84U PD=10.84U
* device instance $48 r0 *1 89.65,2.5 pfet
M$48 \$160 \$48 \$159 \$193 pfet L=0.5U W=5U AS=2.1P AD=2.1P PS=10.84U PD=10.84U
* device instance $49 r0 *1 91.39,2.5 pfet
M$49 \$162 \$49 \$161 \$193 pfet L=0.5U W=5U AS=2.1P AD=2.1P PS=10.84U PD=10.84U
* device instance $50 r0 *1 93.13,2.5 pfet
M$50 \$164 \$50 \$163 \$193 pfet L=0.5U W=5U AS=2.1P AD=2.1P PS=10.84U PD=10.84U
* device instance $51 r0 *1 94.87,2.5 pfet
M$51 \$166 \$51 \$165 \$193 pfet L=0.5U W=5U AS=2.1P AD=2.1P PS=10.84U PD=10.84U
* device instance $52 r0 *1 96.61,2.5 pfet
M$52 \$168 \$52 \$167 \$193 pfet L=0.5U W=5U AS=2.1P AD=2.1P PS=10.84U PD=10.84U
* device instance $53 r0 *1 98.35,2.5 pfet
M$53 \$170 \$53 \$169 \$193 pfet L=0.5U W=5U AS=2.1P AD=2.1P PS=10.84U PD=10.84U
* device instance $54 r0 *1 100.09,2.5 pfet
M$54 \$172 \$54 \$171 \$193 pfet L=0.5U W=5U AS=2.1P AD=2.1P PS=10.84U PD=10.84U
* device instance $55 r0 *1 101.83,2.5 pfet
M$55 \$174 \$55 \$173 \$193 pfet L=0.5U W=5U AS=2.1P AD=2.1P PS=10.84U PD=10.84U
* device instance $56 r0 *1 103.57,2.5 pfet
M$56 \$176 \$56 \$175 \$193 pfet L=0.5U W=5U AS=2.1P AD=2.1P PS=10.84U PD=10.84U
* device instance $57 r0 *1 105.31,2.5 pfet
M$57 \$178 \$57 \$177 \$193 pfet L=0.5U W=5U AS=2.1P AD=2.1P PS=10.84U PD=10.84U
* device instance $58 r0 *1 107.05,2.5 pfet
M$58 \$180 \$58 \$179 \$193 pfet L=0.5U W=5U AS=2.1P AD=2.1P PS=10.84U PD=10.84U
* device instance $59 r0 *1 108.79,2.5 pfet
M$59 \$182 \$59 \$181 \$193 pfet L=0.5U W=5U AS=2.1P AD=2.1P PS=10.84U PD=10.84U
* device instance $60 r0 *1 110.53,2.5 pfet
M$60 \$184 \$60 \$183 \$193 pfet L=0.5U W=5U AS=2.1P AD=2.1P PS=10.84U PD=10.84U
* device instance $61 r0 *1 112.27,2.5 pfet
M$61 \$186 \$61 \$185 \$193 pfet L=0.5U W=5U AS=2.1P AD=2.1P PS=10.84U PD=10.84U
* device instance $62 r0 *1 114.01,2.5 pfet
M$62 \$188 \$62 \$187 \$193 pfet L=0.5U W=5U AS=2.1P AD=2.1P PS=10.84U PD=10.84U
* device instance $63 r0 *1 115.75,2.5 pfet
M$63 \$190 \$63 \$189 \$193 pfet L=0.5U W=5U AS=2.1P AD=2.1P PS=10.84U PD=10.84U
* device instance $64 r0 *1 121.39,5 pfet
M$64 \$192 \$64 \$191 \$194 pfet L=0.5U W=10U AS=4.2P AD=4.2P PS=20.84U
+ PD=20.84U
.ENDS pll_pfd
