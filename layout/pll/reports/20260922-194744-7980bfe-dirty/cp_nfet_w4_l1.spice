* extracted by klt extract --deck sg13g2

* cell cp_nfet_w4_l1
* pin vsubs
.SUBCKT cp_nfet_w4_l1 vsubs
* device instance $1 r0 *1 0.92,2 nfet
M$1 \$2 \$3 \$1 vsubs nfet L=1U W=4U AS=1.68P AD=1.68P PS=8.84U PD=8.84U
.ENDS cp_nfet_w4_l1
