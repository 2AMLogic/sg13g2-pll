* extracted by klt extract --deck sg13g2

* cell vco_nfet_w2_l0p28
* pin vsubs
.SUBCKT vco_nfet_w2_l0p28 vsubs
* device instance $1 r0 *1 0.56,1 nfet
M$1 \$2 \$11 \$1 vsubs nfet L=0.28U W=2U AS=0.84P AD=0.84P PS=4.84U PD=4.84U
* device instance $2 r0 *1 2.08,1 nfet
M$2 \$4 \$12 \$3 vsubs nfet L=0.28U W=2U AS=0.84P AD=0.84P PS=4.84U PD=4.84U
* device instance $3 r0 *1 3.6,1 nfet
M$3 \$6 \$13 \$5 vsubs nfet L=0.28U W=2U AS=0.84P AD=0.84P PS=4.84U PD=4.84U
* device instance $4 r0 *1 5.12,1 nfet
M$4 \$8 \$14 \$7 vsubs nfet L=0.28U W=2U AS=0.84P AD=0.84P PS=4.84U PD=4.84U
* device instance $5 r0 *1 6.64,1 nfet
M$5 \$10 \$15 \$9 vsubs nfet L=0.28U W=2U AS=0.84P AD=0.84P PS=4.84U PD=4.84U
.ENDS vco_nfet_w2_l0p28
