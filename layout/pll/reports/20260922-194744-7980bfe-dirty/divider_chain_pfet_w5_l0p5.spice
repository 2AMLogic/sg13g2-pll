* extracted by klt extract --deck sg13g2

* cell divider_chain_pfet_w5_l0p5
.SUBCKT divider_chain_pfet_w5_l0p5
* device instance $1 r0 *1 0.67,2.5 pfet
M$1 \$82 \$1 \$80 \$475 pfet L=0.5U W=5U AS=2.1P AD=2.1P PS=10.84U PD=10.84U
* device instance $2 r0 *1 2.41,2.5 pfet
M$2 \$85 \$2 \$83 \$475 pfet L=0.5U W=5U AS=2.1P AD=2.1P PS=10.84U PD=10.84U
* device instance $3 r0 *1 4.15,2.5 pfet
M$3 \$88 \$3 \$86 \$475 pfet L=0.5U W=5U AS=2.1P AD=2.1P PS=10.84U PD=10.84U
* device instance $4 r0 *1 5.89,2.5 pfet
M$4 \$91 \$4 \$89 \$475 pfet L=0.5U W=5U AS=2.1P AD=2.1P PS=10.84U PD=10.84U
* device instance $5 r0 *1 7.63,2.5 pfet
M$5 \$94 \$5 \$92 \$475 pfet L=0.5U W=5U AS=2.1P AD=2.1P PS=10.84U PD=10.84U
* device instance $6 r0 *1 9.37,2.5 pfet
M$6 \$97 \$6 \$95 \$475 pfet L=0.5U W=5U AS=2.1P AD=2.1P PS=10.84U PD=10.84U
* device instance $7 r0 *1 11.11,2.5 pfet
M$7 \$100 \$7 \$98 \$475 pfet L=0.5U W=5U AS=2.1P AD=2.1P PS=10.84U PD=10.84U
* device instance $8 r0 *1 12.85,2.5 pfet
M$8 \$103 \$8 \$101 \$475 pfet L=0.5U W=5U AS=2.1P AD=2.1P PS=10.84U PD=10.84U
* device instance $9 r0 *1 14.59,2.5 pfet
M$9 \$106 \$9 \$104 \$475 pfet L=0.5U W=5U AS=2.1P AD=2.1P PS=10.84U PD=10.84U
* device instance $10 r0 *1 16.33,2.5 pfet
M$10 \$109 \$10 \$107 \$475 pfet L=0.5U W=5U AS=2.1P AD=2.1P PS=10.84U PD=10.84U
* device instance $11 r0 *1 18.07,2.5 pfet
M$11 \$112 \$11 \$110 \$475 pfet L=0.5U W=5U AS=2.1P AD=2.1P PS=10.84U PD=10.84U
* device instance $12 r0 *1 19.81,2.5 pfet
M$12 \$115 \$12 \$113 \$475 pfet L=0.5U W=5U AS=2.1P AD=2.1P PS=10.84U PD=10.84U
* device instance $13 r0 *1 21.55,2.5 pfet
M$13 \$118 \$13 \$116 \$475 pfet L=0.5U W=5U AS=2.1P AD=2.1P PS=10.84U PD=10.84U
* device instance $14 r0 *1 23.29,2.5 pfet
M$14 \$121 \$14 \$119 \$475 pfet L=0.5U W=5U AS=2.1P AD=2.1P PS=10.84U PD=10.84U
* device instance $15 r0 *1 25.03,2.5 pfet
M$15 \$124 \$15 \$122 \$475 pfet L=0.5U W=5U AS=2.1P AD=2.1P PS=10.84U PD=10.84U
* device instance $16 r0 *1 26.77,2.5 pfet
M$16 \$127 \$16 \$125 \$475 pfet L=0.5U W=5U AS=2.1P AD=2.1P PS=10.84U PD=10.84U
* device instance $17 r0 *1 28.51,2.5 pfet
M$17 \$130 \$17 \$128 \$475 pfet L=0.5U W=5U AS=2.1P AD=2.1P PS=10.84U PD=10.84U
* device instance $18 r0 *1 30.25,2.5 pfet
M$18 \$133 \$18 \$131 \$475 pfet L=0.5U W=5U AS=2.1P AD=2.1P PS=10.84U PD=10.84U
* device instance $19 r0 *1 31.99,2.5 pfet
M$19 \$136 \$19 \$134 \$475 pfet L=0.5U W=5U AS=2.1P AD=2.1P PS=10.84U PD=10.84U
* device instance $20 r0 *1 33.73,2.5 pfet
M$20 \$139 \$20 \$137 \$475 pfet L=0.5U W=5U AS=2.1P AD=2.1P PS=10.84U PD=10.84U
* device instance $21 r0 *1 35.47,2.5 pfet
M$21 \$142 \$21 \$140 \$475 pfet L=0.5U W=5U AS=2.1P AD=2.1P PS=10.84U PD=10.84U
* device instance $22 r0 *1 37.21,2.5 pfet
M$22 \$145 \$22 \$143 \$475 pfet L=0.5U W=5U AS=2.1P AD=2.1P PS=10.84U PD=10.84U
* device instance $23 r0 *1 38.95,2.5 pfet
M$23 \$148 \$23 \$146 \$475 pfet L=0.5U W=5U AS=2.1P AD=2.1P PS=10.84U PD=10.84U
* device instance $24 r0 *1 40.69,2.5 pfet
M$24 \$151 \$24 \$149 \$475 pfet L=0.5U W=5U AS=2.1P AD=2.1P PS=10.84U PD=10.84U
* device instance $25 r0 *1 42.43,2.5 pfet
M$25 \$154 \$25 \$152 \$475 pfet L=0.5U W=5U AS=2.1P AD=2.1P PS=10.84U PD=10.84U
* device instance $26 r0 *1 44.17,2.5 pfet
M$26 \$157 \$26 \$155 \$475 pfet L=0.5U W=5U AS=2.1P AD=2.1P PS=10.84U PD=10.84U
* device instance $27 r0 *1 45.91,2.5 pfet
M$27 \$160 \$27 \$158 \$475 pfet L=0.5U W=5U AS=2.1P AD=2.1P PS=10.84U PD=10.84U
* device instance $28 r0 *1 47.65,2.5 pfet
M$28 \$163 \$28 \$161 \$475 pfet L=0.5U W=5U AS=2.1P AD=2.1P PS=10.84U PD=10.84U
* device instance $29 r0 *1 49.39,2.5 pfet
M$29 \$166 \$29 \$164 \$475 pfet L=0.5U W=5U AS=2.1P AD=2.1P PS=10.84U PD=10.84U
* device instance $30 r0 *1 51.13,2.5 pfet
M$30 \$169 \$30 \$167 \$475 pfet L=0.5U W=5U AS=2.1P AD=2.1P PS=10.84U PD=10.84U
* device instance $31 r0 *1 52.87,2.5 pfet
M$31 \$172 \$31 \$170 \$475 pfet L=0.5U W=5U AS=2.1P AD=2.1P PS=10.84U PD=10.84U
* device instance $32 r0 *1 54.61,2.5 pfet
M$32 \$175 \$32 \$173 \$475 pfet L=0.5U W=5U AS=2.1P AD=2.1P PS=10.84U PD=10.84U
* device instance $33 r0 *1 56.35,2.5 pfet
M$33 \$178 \$33 \$176 \$475 pfet L=0.5U W=5U AS=2.1P AD=2.1P PS=10.84U PD=10.84U
* device instance $34 r0 *1 58.09,2.5 pfet
M$34 \$181 \$34 \$179 \$475 pfet L=0.5U W=5U AS=2.1P AD=2.1P PS=10.84U PD=10.84U
* device instance $35 r0 *1 59.83,2.5 pfet
M$35 \$184 \$35 \$182 \$475 pfet L=0.5U W=5U AS=2.1P AD=2.1P PS=10.84U PD=10.84U
* device instance $36 r0 *1 61.57,2.5 pfet
M$36 \$187 \$36 \$185 \$475 pfet L=0.5U W=5U AS=2.1P AD=2.1P PS=10.84U PD=10.84U
* device instance $37 r0 *1 63.31,2.5 pfet
M$37 \$190 \$37 \$188 \$475 pfet L=0.5U W=5U AS=2.1P AD=2.1P PS=10.84U PD=10.84U
* device instance $38 r0 *1 65.05,2.5 pfet
M$38 \$193 \$38 \$191 \$475 pfet L=0.5U W=5U AS=2.1P AD=2.1P PS=10.84U PD=10.84U
* device instance $39 r0 *1 66.79,2.5 pfet
M$39 \$196 \$39 \$194 \$475 pfet L=0.5U W=5U AS=2.1P AD=2.1P PS=10.84U PD=10.84U
* device instance $40 r0 *1 68.53,2.5 pfet
M$40 \$199 \$40 \$197 \$475 pfet L=0.5U W=5U AS=2.1P AD=2.1P PS=10.84U PD=10.84U
* device instance $41 r0 *1 70.27,2.5 pfet
M$41 \$202 \$41 \$200 \$475 pfet L=0.5U W=5U AS=2.1P AD=2.1P PS=10.84U PD=10.84U
* device instance $42 r0 *1 72.01,2.5 pfet
M$42 \$205 \$42 \$203 \$475 pfet L=0.5U W=5U AS=2.1P AD=2.1P PS=10.84U PD=10.84U
* device instance $43 r0 *1 73.75,2.5 pfet
M$43 \$208 \$43 \$206 \$475 pfet L=0.5U W=5U AS=2.1P AD=2.1P PS=10.84U PD=10.84U
* device instance $44 r0 *1 75.49,2.5 pfet
M$44 \$211 \$44 \$209 \$475 pfet L=0.5U W=5U AS=2.1P AD=2.1P PS=10.84U PD=10.84U
* device instance $45 r0 *1 77.23,2.5 pfet
M$45 \$214 \$45 \$212 \$475 pfet L=0.5U W=5U AS=2.1P AD=2.1P PS=10.84U PD=10.84U
* device instance $46 r0 *1 78.97,2.5 pfet
M$46 \$217 \$46 \$215 \$475 pfet L=0.5U W=5U AS=2.1P AD=2.1P PS=10.84U PD=10.84U
* device instance $47 r0 *1 80.71,2.5 pfet
M$47 \$220 \$47 \$218 \$475 pfet L=0.5U W=5U AS=2.1P AD=2.1P PS=10.84U PD=10.84U
* device instance $48 r0 *1 82.45,2.5 pfet
M$48 \$223 \$48 \$221 \$475 pfet L=0.5U W=5U AS=2.1P AD=2.1P PS=10.84U PD=10.84U
* device instance $49 r0 *1 84.19,2.5 pfet
M$49 \$226 \$49 \$224 \$475 pfet L=0.5U W=5U AS=2.1P AD=2.1P PS=10.84U PD=10.84U
* device instance $50 r0 *1 85.93,2.5 pfet
M$50 \$229 \$50 \$227 \$475 pfet L=0.5U W=5U AS=2.1P AD=2.1P PS=10.84U PD=10.84U
* device instance $51 r0 *1 87.67,2.5 pfet
M$51 \$232 \$51 \$230 \$475 pfet L=0.5U W=5U AS=2.1P AD=2.1P PS=10.84U PD=10.84U
* device instance $52 r0 *1 89.41,2.5 pfet
M$52 \$235 \$52 \$233 \$475 pfet L=0.5U W=5U AS=2.1P AD=2.1P PS=10.84U PD=10.84U
* device instance $53 r0 *1 91.15,2.5 pfet
M$53 \$238 \$53 \$236 \$475 pfet L=0.5U W=5U AS=2.1P AD=2.1P PS=10.84U PD=10.84U
* device instance $54 r0 *1 92.89,2.5 pfet
M$54 \$241 \$54 \$239 \$475 pfet L=0.5U W=5U AS=2.1P AD=2.1P PS=10.84U PD=10.84U
* device instance $55 r0 *1 94.63,2.5 pfet
M$55 \$244 \$55 \$242 \$475 pfet L=0.5U W=5U AS=2.1P AD=2.1P PS=10.84U PD=10.84U
* device instance $56 r0 *1 96.37,2.5 pfet
M$56 \$247 \$56 \$245 \$475 pfet L=0.5U W=5U AS=2.1P AD=2.1P PS=10.84U PD=10.84U
* device instance $57 r0 *1 98.11,2.5 pfet
M$57 \$250 \$57 \$248 \$475 pfet L=0.5U W=5U AS=2.1P AD=2.1P PS=10.84U PD=10.84U
* device instance $58 r0 *1 99.85,2.5 pfet
M$58 \$253 \$58 \$251 \$475 pfet L=0.5U W=5U AS=2.1P AD=2.1P PS=10.84U PD=10.84U
* device instance $59 r0 *1 101.59,2.5 pfet
M$59 \$256 \$59 \$254 \$475 pfet L=0.5U W=5U AS=2.1P AD=2.1P PS=10.84U PD=10.84U
* device instance $60 r0 *1 103.33,2.5 pfet
M$60 \$259 \$60 \$257 \$475 pfet L=0.5U W=5U AS=2.1P AD=2.1P PS=10.84U PD=10.84U
* device instance $61 r0 *1 105.07,2.5 pfet
M$61 \$262 \$61 \$260 \$475 pfet L=0.5U W=5U AS=2.1P AD=2.1P PS=10.84U PD=10.84U
* device instance $62 r0 *1 106.81,2.5 pfet
M$62 \$265 \$62 \$263 \$475 pfet L=0.5U W=5U AS=2.1P AD=2.1P PS=10.84U PD=10.84U
* device instance $63 r0 *1 108.55,2.5 pfet
M$63 \$268 \$63 \$266 \$475 pfet L=0.5U W=5U AS=2.1P AD=2.1P PS=10.84U PD=10.84U
* device instance $64 r0 *1 110.29,2.5 pfet
M$64 \$271 \$64 \$269 \$475 pfet L=0.5U W=5U AS=2.1P AD=2.1P PS=10.84U PD=10.84U
* device instance $65 r0 *1 112.03,2.5 pfet
M$65 \$274 \$65 \$272 \$475 pfet L=0.5U W=5U AS=2.1P AD=2.1P PS=10.84U PD=10.84U
* device instance $66 r0 *1 113.77,2.5 pfet
M$66 \$277 \$66 \$275 \$475 pfet L=0.5U W=5U AS=2.1P AD=2.1P PS=10.84U PD=10.84U
* device instance $67 r0 *1 115.51,2.5 pfet
M$67 \$280 \$67 \$278 \$475 pfet L=0.5U W=5U AS=2.1P AD=2.1P PS=10.84U PD=10.84U
* device instance $68 r0 *1 117.25,2.5 pfet
M$68 \$283 \$68 \$281 \$475 pfet L=0.5U W=5U AS=2.1P AD=2.1P PS=10.84U PD=10.84U
* device instance $69 r0 *1 118.99,2.5 pfet
M$69 \$286 \$69 \$284 \$475 pfet L=0.5U W=5U AS=2.1P AD=2.1P PS=10.84U PD=10.84U
* device instance $70 r0 *1 120.73,2.5 pfet
M$70 \$289 \$70 \$287 \$475 pfet L=0.5U W=5U AS=2.1P AD=2.1P PS=10.84U PD=10.84U
* device instance $71 r0 *1 122.47,2.5 pfet
M$71 \$292 \$71 \$290 \$475 pfet L=0.5U W=5U AS=2.1P AD=2.1P PS=10.84U PD=10.84U
* device instance $72 r0 *1 124.21,2.5 pfet
M$72 \$295 \$72 \$293 \$475 pfet L=0.5U W=5U AS=2.1P AD=2.1P PS=10.84U PD=10.84U
* device instance $73 r0 *1 125.95,2.5 pfet
M$73 \$298 \$73 \$296 \$475 pfet L=0.5U W=5U AS=2.1P AD=2.1P PS=10.84U PD=10.84U
* device instance $74 r0 *1 127.69,2.5 pfet
M$74 \$301 \$74 \$299 \$475 pfet L=0.5U W=5U AS=2.1P AD=2.1P PS=10.84U PD=10.84U
* device instance $75 r0 *1 129.43,2.5 pfet
M$75 \$304 \$75 \$302 \$475 pfet L=0.5U W=5U AS=2.1P AD=2.1P PS=10.84U PD=10.84U
* device instance $76 r0 *1 131.17,2.5 pfet
M$76 \$307 \$76 \$305 \$475 pfet L=0.5U W=5U AS=2.1P AD=2.1P PS=10.84U PD=10.84U
* device instance $77 r0 *1 132.91,2.5 pfet
M$77 \$310 \$77 \$308 \$475 pfet L=0.5U W=5U AS=2.1P AD=2.1P PS=10.84U PD=10.84U
* device instance $78 r0 *1 134.65,2.5 pfet
M$78 \$313 \$78 \$311 \$475 pfet L=0.5U W=5U AS=2.1P AD=2.1P PS=10.84U PD=10.84U
* device instance $79 r0 *1 136.39,2.5 pfet
M$79 \$316 \$79 \$314 \$475 pfet L=0.5U W=5U AS=2.1P AD=2.1P PS=10.84U PD=10.84U
* device instance $80 r0 *1 0.67,8.82 pfet
M$80 \$318 \$81 \$317 \$475 pfet L=0.5U W=5U AS=2.1P AD=2.1P PS=10.84U PD=10.84U
* device instance $81 r0 *1 2.41,8.82 pfet
M$81 \$320 \$84 \$319 \$475 pfet L=0.5U W=5U AS=2.1P AD=2.1P PS=10.84U PD=10.84U
* device instance $82 r0 *1 4.15,8.82 pfet
M$82 \$322 \$87 \$321 \$475 pfet L=0.5U W=5U AS=2.1P AD=2.1P PS=10.84U PD=10.84U
* device instance $83 r0 *1 5.89,8.82 pfet
M$83 \$324 \$90 \$323 \$475 pfet L=0.5U W=5U AS=2.1P AD=2.1P PS=10.84U PD=10.84U
* device instance $84 r0 *1 7.63,8.82 pfet
M$84 \$326 \$93 \$325 \$475 pfet L=0.5U W=5U AS=2.1P AD=2.1P PS=10.84U PD=10.84U
* device instance $85 r0 *1 9.37,8.82 pfet
M$85 \$328 \$96 \$327 \$475 pfet L=0.5U W=5U AS=2.1P AD=2.1P PS=10.84U PD=10.84U
* device instance $86 r0 *1 11.11,8.82 pfet
M$86 \$330 \$99 \$329 \$475 pfet L=0.5U W=5U AS=2.1P AD=2.1P PS=10.84U PD=10.84U
* device instance $87 r0 *1 12.85,8.82 pfet
M$87 \$332 \$102 \$331 \$475 pfet L=0.5U W=5U AS=2.1P AD=2.1P PS=10.84U
+ PD=10.84U
* device instance $88 r0 *1 14.59,8.82 pfet
M$88 \$334 \$105 \$333 \$475 pfet L=0.5U W=5U AS=2.1P AD=2.1P PS=10.84U
+ PD=10.84U
* device instance $89 r0 *1 16.33,8.82 pfet
M$89 \$336 \$108 \$335 \$475 pfet L=0.5U W=5U AS=2.1P AD=2.1P PS=10.84U
+ PD=10.84U
* device instance $90 r0 *1 18.07,8.82 pfet
M$90 \$338 \$111 \$337 \$475 pfet L=0.5U W=5U AS=2.1P AD=2.1P PS=10.84U
+ PD=10.84U
* device instance $91 r0 *1 19.81,8.82 pfet
M$91 \$340 \$114 \$339 \$475 pfet L=0.5U W=5U AS=2.1P AD=2.1P PS=10.84U
+ PD=10.84U
* device instance $92 r0 *1 21.55,8.82 pfet
M$92 \$342 \$117 \$341 \$475 pfet L=0.5U W=5U AS=2.1P AD=2.1P PS=10.84U
+ PD=10.84U
* device instance $93 r0 *1 23.29,8.82 pfet
M$93 \$344 \$120 \$343 \$475 pfet L=0.5U W=5U AS=2.1P AD=2.1P PS=10.84U
+ PD=10.84U
* device instance $94 r0 *1 25.03,8.82 pfet
M$94 \$346 \$123 \$345 \$475 pfet L=0.5U W=5U AS=2.1P AD=2.1P PS=10.84U
+ PD=10.84U
* device instance $95 r0 *1 26.77,8.82 pfet
M$95 \$348 \$126 \$347 \$475 pfet L=0.5U W=5U AS=2.1P AD=2.1P PS=10.84U
+ PD=10.84U
* device instance $96 r0 *1 28.51,8.82 pfet
M$96 \$350 \$129 \$349 \$475 pfet L=0.5U W=5U AS=2.1P AD=2.1P PS=10.84U
+ PD=10.84U
* device instance $97 r0 *1 30.25,8.82 pfet
M$97 \$352 \$132 \$351 \$475 pfet L=0.5U W=5U AS=2.1P AD=2.1P PS=10.84U
+ PD=10.84U
* device instance $98 r0 *1 31.99,8.82 pfet
M$98 \$354 \$135 \$353 \$475 pfet L=0.5U W=5U AS=2.1P AD=2.1P PS=10.84U
+ PD=10.84U
* device instance $99 r0 *1 33.73,8.82 pfet
M$99 \$356 \$138 \$355 \$475 pfet L=0.5U W=5U AS=2.1P AD=2.1P PS=10.84U
+ PD=10.84U
* device instance $100 r0 *1 35.47,8.82 pfet
M$100 \$358 \$141 \$357 \$475 pfet L=0.5U W=5U AS=2.1P AD=2.1P PS=10.84U
+ PD=10.84U
* device instance $101 r0 *1 37.21,8.82 pfet
M$101 \$360 \$144 \$359 \$475 pfet L=0.5U W=5U AS=2.1P AD=2.1P PS=10.84U
+ PD=10.84U
* device instance $102 r0 *1 38.95,8.82 pfet
M$102 \$362 \$147 \$361 \$475 pfet L=0.5U W=5U AS=2.1P AD=2.1P PS=10.84U
+ PD=10.84U
* device instance $103 r0 *1 40.69,8.82 pfet
M$103 \$364 \$150 \$363 \$475 pfet L=0.5U W=5U AS=2.1P AD=2.1P PS=10.84U
+ PD=10.84U
* device instance $104 r0 *1 42.43,8.82 pfet
M$104 \$366 \$153 \$365 \$475 pfet L=0.5U W=5U AS=2.1P AD=2.1P PS=10.84U
+ PD=10.84U
* device instance $105 r0 *1 44.17,8.82 pfet
M$105 \$368 \$156 \$367 \$475 pfet L=0.5U W=5U AS=2.1P AD=2.1P PS=10.84U
+ PD=10.84U
* device instance $106 r0 *1 45.91,8.82 pfet
M$106 \$370 \$159 \$369 \$475 pfet L=0.5U W=5U AS=2.1P AD=2.1P PS=10.84U
+ PD=10.84U
* device instance $107 r0 *1 47.65,8.82 pfet
M$107 \$372 \$162 \$371 \$475 pfet L=0.5U W=5U AS=2.1P AD=2.1P PS=10.84U
+ PD=10.84U
* device instance $108 r0 *1 49.39,8.82 pfet
M$108 \$374 \$165 \$373 \$475 pfet L=0.5U W=5U AS=2.1P AD=2.1P PS=10.84U
+ PD=10.84U
* device instance $109 r0 *1 51.13,8.82 pfet
M$109 \$376 \$168 \$375 \$475 pfet L=0.5U W=5U AS=2.1P AD=2.1P PS=10.84U
+ PD=10.84U
* device instance $110 r0 *1 52.87,8.82 pfet
M$110 \$378 \$171 \$377 \$475 pfet L=0.5U W=5U AS=2.1P AD=2.1P PS=10.84U
+ PD=10.84U
* device instance $111 r0 *1 54.61,8.82 pfet
M$111 \$380 \$174 \$379 \$475 pfet L=0.5U W=5U AS=2.1P AD=2.1P PS=10.84U
+ PD=10.84U
* device instance $112 r0 *1 56.35,8.82 pfet
M$112 \$382 \$177 \$381 \$475 pfet L=0.5U W=5U AS=2.1P AD=2.1P PS=10.84U
+ PD=10.84U
* device instance $113 r0 *1 58.09,8.82 pfet
M$113 \$384 \$180 \$383 \$475 pfet L=0.5U W=5U AS=2.1P AD=2.1P PS=10.84U
+ PD=10.84U
* device instance $114 r0 *1 59.83,8.82 pfet
M$114 \$386 \$183 \$385 \$475 pfet L=0.5U W=5U AS=2.1P AD=2.1P PS=10.84U
+ PD=10.84U
* device instance $115 r0 *1 61.57,8.82 pfet
M$115 \$388 \$186 \$387 \$475 pfet L=0.5U W=5U AS=2.1P AD=2.1P PS=10.84U
+ PD=10.84U
* device instance $116 r0 *1 63.31,8.82 pfet
M$116 \$390 \$189 \$389 \$475 pfet L=0.5U W=5U AS=2.1P AD=2.1P PS=10.84U
+ PD=10.84U
* device instance $117 r0 *1 65.05,8.82 pfet
M$117 \$392 \$192 \$391 \$475 pfet L=0.5U W=5U AS=2.1P AD=2.1P PS=10.84U
+ PD=10.84U
* device instance $118 r0 *1 66.79,8.82 pfet
M$118 \$394 \$195 \$393 \$475 pfet L=0.5U W=5U AS=2.1P AD=2.1P PS=10.84U
+ PD=10.84U
* device instance $119 r0 *1 68.53,8.82 pfet
M$119 \$396 \$198 \$395 \$475 pfet L=0.5U W=5U AS=2.1P AD=2.1P PS=10.84U
+ PD=10.84U
* device instance $120 r0 *1 70.27,8.82 pfet
M$120 \$398 \$201 \$397 \$475 pfet L=0.5U W=5U AS=2.1P AD=2.1P PS=10.84U
+ PD=10.84U
* device instance $121 r0 *1 72.01,8.82 pfet
M$121 \$400 \$204 \$399 \$475 pfet L=0.5U W=5U AS=2.1P AD=2.1P PS=10.84U
+ PD=10.84U
* device instance $122 r0 *1 73.75,8.82 pfet
M$122 \$402 \$207 \$401 \$475 pfet L=0.5U W=5U AS=2.1P AD=2.1P PS=10.84U
+ PD=10.84U
* device instance $123 r0 *1 75.49,8.82 pfet
M$123 \$404 \$210 \$403 \$475 pfet L=0.5U W=5U AS=2.1P AD=2.1P PS=10.84U
+ PD=10.84U
* device instance $124 r0 *1 77.23,8.82 pfet
M$124 \$406 \$213 \$405 \$475 pfet L=0.5U W=5U AS=2.1P AD=2.1P PS=10.84U
+ PD=10.84U
* device instance $125 r0 *1 78.97,8.82 pfet
M$125 \$408 \$216 \$407 \$475 pfet L=0.5U W=5U AS=2.1P AD=2.1P PS=10.84U
+ PD=10.84U
* device instance $126 r0 *1 80.71,8.82 pfet
M$126 \$410 \$219 \$409 \$475 pfet L=0.5U W=5U AS=2.1P AD=2.1P PS=10.84U
+ PD=10.84U
* device instance $127 r0 *1 82.45,8.82 pfet
M$127 \$412 \$222 \$411 \$475 pfet L=0.5U W=5U AS=2.1P AD=2.1P PS=10.84U
+ PD=10.84U
* device instance $128 r0 *1 84.19,8.82 pfet
M$128 \$414 \$225 \$413 \$475 pfet L=0.5U W=5U AS=2.1P AD=2.1P PS=10.84U
+ PD=10.84U
* device instance $129 r0 *1 85.93,8.82 pfet
M$129 \$416 \$228 \$415 \$475 pfet L=0.5U W=5U AS=2.1P AD=2.1P PS=10.84U
+ PD=10.84U
* device instance $130 r0 *1 87.67,8.82 pfet
M$130 \$418 \$231 \$417 \$475 pfet L=0.5U W=5U AS=2.1P AD=2.1P PS=10.84U
+ PD=10.84U
* device instance $131 r0 *1 89.41,8.82 pfet
M$131 \$420 \$234 \$419 \$475 pfet L=0.5U W=5U AS=2.1P AD=2.1P PS=10.84U
+ PD=10.84U
* device instance $132 r0 *1 91.15,8.82 pfet
M$132 \$422 \$237 \$421 \$475 pfet L=0.5U W=5U AS=2.1P AD=2.1P PS=10.84U
+ PD=10.84U
* device instance $133 r0 *1 92.89,8.82 pfet
M$133 \$424 \$240 \$423 \$475 pfet L=0.5U W=5U AS=2.1P AD=2.1P PS=10.84U
+ PD=10.84U
* device instance $134 r0 *1 94.63,8.82 pfet
M$134 \$426 \$243 \$425 \$475 pfet L=0.5U W=5U AS=2.1P AD=2.1P PS=10.84U
+ PD=10.84U
* device instance $135 r0 *1 96.37,8.82 pfet
M$135 \$428 \$246 \$427 \$475 pfet L=0.5U W=5U AS=2.1P AD=2.1P PS=10.84U
+ PD=10.84U
* device instance $136 r0 *1 98.11,8.82 pfet
M$136 \$430 \$249 \$429 \$475 pfet L=0.5U W=5U AS=2.1P AD=2.1P PS=10.84U
+ PD=10.84U
* device instance $137 r0 *1 99.85,8.82 pfet
M$137 \$432 \$252 \$431 \$475 pfet L=0.5U W=5U AS=2.1P AD=2.1P PS=10.84U
+ PD=10.84U
* device instance $138 r0 *1 101.59,8.82 pfet
M$138 \$434 \$255 \$433 \$475 pfet L=0.5U W=5U AS=2.1P AD=2.1P PS=10.84U
+ PD=10.84U
* device instance $139 r0 *1 103.33,8.82 pfet
M$139 \$436 \$258 \$435 \$475 pfet L=0.5U W=5U AS=2.1P AD=2.1P PS=10.84U
+ PD=10.84U
* device instance $140 r0 *1 105.07,8.82 pfet
M$140 \$438 \$261 \$437 \$475 pfet L=0.5U W=5U AS=2.1P AD=2.1P PS=10.84U
+ PD=10.84U
* device instance $141 r0 *1 106.81,8.82 pfet
M$141 \$440 \$264 \$439 \$475 pfet L=0.5U W=5U AS=2.1P AD=2.1P PS=10.84U
+ PD=10.84U
* device instance $142 r0 *1 108.55,8.82 pfet
M$142 \$442 \$267 \$441 \$475 pfet L=0.5U W=5U AS=2.1P AD=2.1P PS=10.84U
+ PD=10.84U
* device instance $143 r0 *1 110.29,8.82 pfet
M$143 \$444 \$270 \$443 \$475 pfet L=0.5U W=5U AS=2.1P AD=2.1P PS=10.84U
+ PD=10.84U
* device instance $144 r0 *1 112.03,8.82 pfet
M$144 \$446 \$273 \$445 \$475 pfet L=0.5U W=5U AS=2.1P AD=2.1P PS=10.84U
+ PD=10.84U
* device instance $145 r0 *1 113.77,8.82 pfet
M$145 \$448 \$276 \$447 \$475 pfet L=0.5U W=5U AS=2.1P AD=2.1P PS=10.84U
+ PD=10.84U
* device instance $146 r0 *1 115.51,8.82 pfet
M$146 \$450 \$279 \$449 \$475 pfet L=0.5U W=5U AS=2.1P AD=2.1P PS=10.84U
+ PD=10.84U
* device instance $147 r0 *1 117.25,8.82 pfet
M$147 \$452 \$282 \$451 \$475 pfet L=0.5U W=5U AS=2.1P AD=2.1P PS=10.84U
+ PD=10.84U
* device instance $148 r0 *1 118.99,8.82 pfet
M$148 \$454 \$285 \$453 \$475 pfet L=0.5U W=5U AS=2.1P AD=2.1P PS=10.84U
+ PD=10.84U
* device instance $149 r0 *1 120.73,8.82 pfet
M$149 \$456 \$288 \$455 \$475 pfet L=0.5U W=5U AS=2.1P AD=2.1P PS=10.84U
+ PD=10.84U
* device instance $150 r0 *1 122.47,8.82 pfet
M$150 \$458 \$291 \$457 \$475 pfet L=0.5U W=5U AS=2.1P AD=2.1P PS=10.84U
+ PD=10.84U
* device instance $151 r0 *1 124.21,8.82 pfet
M$151 \$460 \$294 \$459 \$475 pfet L=0.5U W=5U AS=2.1P AD=2.1P PS=10.84U
+ PD=10.84U
* device instance $152 r0 *1 125.95,8.82 pfet
M$152 \$462 \$297 \$461 \$475 pfet L=0.5U W=5U AS=2.1P AD=2.1P PS=10.84U
+ PD=10.84U
* device instance $153 r0 *1 127.69,8.82 pfet
M$153 \$464 \$300 \$463 \$475 pfet L=0.5U W=5U AS=2.1P AD=2.1P PS=10.84U
+ PD=10.84U
* device instance $154 r0 *1 129.43,8.82 pfet
M$154 \$466 \$303 \$465 \$475 pfet L=0.5U W=5U AS=2.1P AD=2.1P PS=10.84U
+ PD=10.84U
* device instance $155 r0 *1 131.17,8.82 pfet
M$155 \$468 \$306 \$467 \$475 pfet L=0.5U W=5U AS=2.1P AD=2.1P PS=10.84U
+ PD=10.84U
* device instance $156 r0 *1 132.91,8.82 pfet
M$156 \$470 \$309 \$469 \$475 pfet L=0.5U W=5U AS=2.1P AD=2.1P PS=10.84U
+ PD=10.84U
* device instance $157 r0 *1 134.65,8.82 pfet
M$157 \$472 \$312 \$471 \$475 pfet L=0.5U W=5U AS=2.1P AD=2.1P PS=10.84U
+ PD=10.84U
* device instance $158 r0 *1 136.39,8.82 pfet
M$158 \$474 \$315 \$473 \$475 pfet L=0.5U W=5U AS=2.1P AD=2.1P PS=10.84U
+ PD=10.84U
.ENDS divider_chain_pfet_w5_l0p5
