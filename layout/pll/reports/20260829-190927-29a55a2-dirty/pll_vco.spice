* extracted by klt extract --deck sg13g2

* cell pll_vco
* pin vsubs
.SUBCKT pll_vco vsubs
* device instance $1 r0 *1 0.56,1 nfet
M$1 \$33 \$1 \$32 vsubs nfet L=0.28U W=2U AS=0.84P AD=0.84P PS=4.84U PD=4.84U
* device instance $2 r0 *1 2.08,1 nfet
M$2 \$35 \$2 \$34 vsubs nfet L=0.28U W=2U AS=0.84P AD=0.84P PS=4.84U PD=4.84U
* device instance $3 r0 *1 3.6,1 nfet
M$3 \$38 \$37 \$36 vsubs nfet L=0.28U W=2U AS=0.84P AD=0.84P PS=4.84U PD=4.84U
* device instance $4 r0 *1 5.12,1 nfet
M$4 \$41 \$40 \$39 vsubs nfet L=0.28U W=2U AS=0.84P AD=0.84P PS=4.84U PD=4.84U
* device instance $5 r0 *1 6.64,1 nfet
M$5 \$44 \$43 \$42 vsubs nfet L=0.28U W=2U AS=0.84P AD=0.84P PS=4.84U PD=4.84U
* device instance $6 r0 *1 12.12,1 nfet
M$6 \$46 \$3 \$45 vsubs nfet L=1U W=2U AS=0.84P AD=0.84P PS=4.84U PD=4.84U
* device instance $7 r0 *1 14.36,1 nfet
M$7 \$48 \$4 \$47 vsubs nfet L=1U W=2U AS=0.84P AD=0.84P PS=4.84U PD=4.84U
* device instance $8 r0 *1 16.6,1 nfet
M$8 \$50 \$5 \$49 vsubs nfet L=1U W=2U AS=0.84P AD=0.84P PS=4.84U PD=4.84U
* device instance $9 r0 *1 22.09,2 nfet
M$9 \$53 \$52 \$51 vsubs nfet L=0.3U W=4U AS=1.68P AD=1.68P PS=8.84U PD=8.84U
* device instance $10 r0 *1 23.63,2 nfet
M$10 \$55 \$6 \$54 vsubs nfet L=0.3U W=4U AS=1.68P AD=1.68P PS=8.84U PD=8.84U
* device instance $11 r0 *1 28.87,2 nfet
M$11 \$57 \$7 \$56 vsubs nfet L=0.5U W=4U AS=1.68P AD=1.68P PS=8.84U PD=8.84U
* device instance $12 r0 *1 30.61,2 nfet
M$12 \$59 \$8 \$58 vsubs nfet L=0.5U W=4U AS=1.68P AD=1.68P PS=8.84U PD=8.84U
* device instance $13 r0 *1 32.35,2 nfet
M$13 \$61 \$9 \$60 vsubs nfet L=0.5U W=4U AS=1.68P AD=1.68P PS=8.84U PD=8.84U
* device instance $14 r0 *1 34.09,2 nfet
M$14 \$63 \$10 \$62 vsubs nfet L=0.5U W=4U AS=1.68P AD=1.68P PS=8.84U PD=8.84U
* device instance $15 r0 *1 35.83,2 nfet
M$15 \$65 \$11 \$64 vsubs nfet L=0.5U W=4U AS=1.68P AD=1.68P PS=8.84U PD=8.84U
* device instance $16 r0 *1 37.57,2 nfet
M$16 \$67 \$12 \$66 vsubs nfet L=0.5U W=4U AS=1.68P AD=1.68P PS=8.84U PD=8.84U
* device instance $17 r0 *1 39.31,2 nfet
M$17 \$69 \$13 \$68 vsubs nfet L=0.5U W=4U AS=1.68P AD=1.68P PS=8.84U PD=8.84U
* device instance $18 r0 *1 44.9,2 nfet
M$18 \$71 \$14 \$70 vsubs nfet L=1U W=4U AS=1.68P AD=1.68P PS=8.84U PD=8.84U
* device instance $19 r0 *1 47.14,2 nfet
M$19 \$73 \$15 \$72 vsubs nfet L=1U W=4U AS=1.68P AD=1.68P PS=8.84U PD=8.84U
* device instance $20 r0 *1 49.38,2 nfet
M$20 \$75 \$16 \$74 vsubs nfet L=1U W=4U AS=1.68P AD=1.68P PS=8.84U PD=8.84U
* device instance $21 r0 *1 55.22,4 nfet
M$21 \$77 \$17 \$76 vsubs nfet L=1U W=8U AS=3.36P AD=3.36P PS=16.84U PD=16.84U
* device instance $22 r0 *1 61.06,1.5 pfet
M$22 \$81 \$18 \$78 \$127 pfet L=1U W=3U AS=1.26P AD=1.26P PS=6.84U PD=6.84U
* device instance $23 r0 *1 66.84,2.5 pfet
M$23 \$84 \$83 \$82 \$128 pfet L=0.28U W=5U AS=2.1P AD=2.1P PS=10.84U PD=10.84U
* device instance $24 r0 *1 68.36,2.5 pfet
M$24 \$87 \$86 \$85 \$128 pfet L=0.28U W=5U AS=2.1P AD=2.1P PS=10.84U PD=10.84U
* device instance $25 r0 *1 69.88,2.5 pfet
M$25 \$90 \$89 \$88 \$128 pfet L=0.28U W=5U AS=2.1P AD=2.1P PS=10.84U PD=10.84U
* device instance $26 r0 *1 71.4,2.5 pfet
M$26 \$93 \$92 \$91 \$128 pfet L=0.28U W=5U AS=2.1P AD=2.1P PS=10.84U PD=10.84U
* device instance $27 r0 *1 72.92,2.5 pfet
M$27 \$95 \$19 \$94 \$128 pfet L=0.28U W=5U AS=2.1P AD=2.1P PS=10.84U PD=10.84U
* device instance $28 r0 *1 78.7,3 pfet
M$28 \$97 \$20 \$96 \$129 pfet L=1U W=6U AS=2.52P AD=2.52P PS=12.84U PD=12.84U
* device instance $29 r0 *1 80.94,3 pfet
M$29 \$99 \$21 \$98 \$129 pfet L=1U W=6U AS=2.52P AD=2.52P PS=12.84U PD=12.84U
* device instance $30 r0 *1 86.83,5 pfet
M$30 \$101 \$22 \$100 \$130 pfet L=0.5U W=10U AS=4.2P AD=4.2P PS=20.84U
+ PD=20.84U
* device instance $31 r0 *1 88.57,5 pfet
M$31 \$103 \$23 \$102 \$130 pfet L=0.5U W=10U AS=4.2P AD=4.2P PS=20.84U
+ PD=20.84U
* device instance $32 r0 *1 90.31,5 pfet
M$32 \$105 \$24 \$104 \$130 pfet L=0.5U W=10U AS=4.2P AD=4.2P PS=20.84U
+ PD=20.84U
* device instance $33 r0 *1 92.05,5 pfet
M$33 \$107 \$25 \$106 \$130 pfet L=0.5U W=10U AS=4.2P AD=4.2P PS=20.84U
+ PD=20.84U
* device instance $34 r0 *1 93.79,5 pfet
M$34 \$109 \$26 \$108 \$130 pfet L=0.5U W=10U AS=4.2P AD=4.2P PS=20.84U
+ PD=20.84U
* device instance $35 r0 *1 95.53,5 pfet
M$35 \$111 \$27 \$110 \$130 pfet L=0.5U W=10U AS=4.2P AD=4.2P PS=20.84U
+ PD=20.84U
* device instance $36 r0 *1 97.27,5 pfet
M$36 \$113 \$28 \$112 \$130 pfet L=0.5U W=10U AS=4.2P AD=4.2P PS=20.84U
+ PD=20.84U
* device instance $37 r0 *1 103.16,5 pfet
M$37 \$115 \$29 \$114 \$131 pfet L=1U W=10U AS=4.2P AD=4.2P PS=20.84U PD=20.84U
* device instance $38 r0 *1 105.4,5 pfet
M$38 \$117 \$30 \$116 \$131 pfet L=1U W=10U AS=4.2P AD=4.2P PS=20.84U PD=20.84U
* device instance $39 r0 *1 138.88,0.5 rppd
R$39 \$122 \$123 vsubs 7800 rppd
* device instance $40 r0 *1 170.22,0.5 rppd
R$40 \$124 \$126 vsubs 7800 rppd
* device instance $41 r0 *1 30.42,15.72 rppd
R$41 \$31 \$79 vsubs 15600 rppd
* device instance $42 r0 *1 91.76,15.72 rppd
R$42 \$80 \$120 vsubs 15600 rppd
* device instance $43 r0 *1 153.1,15.72 rppd
R$43 \$121 \$125 vsubs 15600 rppd
* device instance $44 r0 *1 115.04,0.25 rhigh
R$44 \$118 \$119 vsubs 21760 rhigh
.ENDS pll_vco
