* extracted by klt extract --deck sg13g2

* cell vco_XCDECAP
.SUBCKT vco_XCDECAP
* device instance $1 r0 *1 30.5,30.5 cap_cmim
C$1 \$1 \$2 5.4096e-12 cap_cmim
.ENDS vco_XCDECAP
