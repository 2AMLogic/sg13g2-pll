* extracted by klt extract --deck sg13g2

* cell loop_filter_XC1
.SUBCKT loop_filter_XC1
* device instance $1 r0 *1 20.5,20.5 cap_cmim
C$1 \$1 \$2 2.4064e-12 cap_cmim
.ENDS loop_filter_XC1
