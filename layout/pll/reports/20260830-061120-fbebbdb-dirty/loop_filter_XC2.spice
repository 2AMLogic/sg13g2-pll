* extracted by klt extract --deck sg13g2

* cell loop_filter_XC2
.SUBCKT loop_filter_XC2
* device instance $1 r0 *1 4.5,4.5 cap_cmim
C$1 \$1 \$2 9.728e-14 cap_cmim
.ENDS loop_filter_XC2
