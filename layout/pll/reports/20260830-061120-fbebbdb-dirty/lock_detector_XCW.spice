* extracted by klt extract --deck sg13g2

* cell lock_detector_XCW
.SUBCKT lock_detector_XCW
* device instance $1 r0 *1 3.5,3.5 cap_cmim
C$1 \$1 \$2 5.496e-14 cap_cmim
.ENDS lock_detector_XCW
