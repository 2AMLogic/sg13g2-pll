* extracted by klt extract --deck sg13g2

* cell cp_pfet_w24_l1
.SUBCKT cp_pfet_w24_l1
* device instance $1 r0 *1 0.92,12 pfet
M$1 \$2 \$5 \$1 \$7 pfet L=1U W=24U AS=10.08P AD=10.08P PS=48.84U PD=48.84U
* device instance $2 r0 *1 3.16,12 pfet
M$2 \$4 \$6 \$3 \$7 pfet L=1U W=24U AS=10.08P AD=10.08P PS=48.84U PD=48.84U
.ENDS cp_pfet_w24_l1
