* extracted by klt extract --deck sg13g2

* cell lock_detector_pfet_w5_l0p5
.SUBCKT lock_detector_pfet_w5_l0p5
* device instance $1 r0 *1 0.67,2.5 pfet
M$1 \$9 \$1 \$7 \$55 pfet L=0.5U W=5U AS=2.1P AD=2.1P PS=10.84U PD=10.84U
* device instance $2 r0 *1 2.41,2.5 pfet
M$2 \$12 \$2 \$10 \$55 pfet L=0.5U W=5U AS=2.1P AD=2.1P PS=10.84U PD=10.84U
* device instance $3 r0 *1 4.15,2.5 pfet
M$3 \$15 \$3 \$13 \$55 pfet L=0.5U W=5U AS=2.1P AD=2.1P PS=10.84U PD=10.84U
* device instance $4 r0 *1 5.89,2.5 pfet
M$4 \$18 \$4 \$16 \$55 pfet L=0.5U W=5U AS=2.1P AD=2.1P PS=10.84U PD=10.84U
* device instance $5 r0 *1 7.63,2.5 pfet
M$5 \$21 \$5 \$19 \$55 pfet L=0.5U W=5U AS=2.1P AD=2.1P PS=10.84U PD=10.84U
* device instance $6 r0 *1 9.37,2.5 pfet
M$6 \$24 \$6 \$22 \$55 pfet L=0.5U W=5U AS=2.1P AD=2.1P PS=10.84U PD=10.84U
* device instance $7 r0 *1 0.67,8.82 pfet
M$7 \$27 \$8 \$25 \$55 pfet L=0.5U W=5U AS=2.1P AD=2.1P PS=10.84U PD=10.84U
* device instance $8 r0 *1 2.41,8.82 pfet
M$8 \$30 \$11 \$28 \$55 pfet L=0.5U W=5U AS=2.1P AD=2.1P PS=10.84U PD=10.84U
* device instance $9 r0 *1 4.15,8.82 pfet
M$9 \$33 \$14 \$31 \$55 pfet L=0.5U W=5U AS=2.1P AD=2.1P PS=10.84U PD=10.84U
* device instance $10 r0 *1 5.89,8.82 pfet
M$10 \$36 \$17 \$34 \$55 pfet L=0.5U W=5U AS=2.1P AD=2.1P PS=10.84U PD=10.84U
* device instance $11 r0 *1 7.63,8.82 pfet
M$11 \$39 \$20 \$37 \$55 pfet L=0.5U W=5U AS=2.1P AD=2.1P PS=10.84U PD=10.84U
* device instance $12 r0 *1 9.37,8.82 pfet
M$12 \$42 \$23 \$40 \$55 pfet L=0.5U W=5U AS=2.1P AD=2.1P PS=10.84U PD=10.84U
* device instance $13 r0 *1 0.67,15.14 pfet
M$13 \$44 \$26 \$43 \$55 pfet L=0.5U W=5U AS=2.1P AD=2.1P PS=10.84U PD=10.84U
* device instance $14 r0 *1 2.41,15.14 pfet
M$14 \$46 \$29 \$45 \$55 pfet L=0.5U W=5U AS=2.1P AD=2.1P PS=10.84U PD=10.84U
* device instance $15 r0 *1 4.15,15.14 pfet
M$15 \$48 \$32 \$47 \$55 pfet L=0.5U W=5U AS=2.1P AD=2.1P PS=10.84U PD=10.84U
* device instance $16 r0 *1 5.89,15.14 pfet
M$16 \$50 \$35 \$49 \$55 pfet L=0.5U W=5U AS=2.1P AD=2.1P PS=10.84U PD=10.84U
* device instance $17 r0 *1 7.63,15.14 pfet
M$17 \$52 \$38 \$51 \$55 pfet L=0.5U W=5U AS=2.1P AD=2.1P PS=10.84U PD=10.84U
* device instance $18 r0 *1 9.37,15.14 pfet
M$18 \$54 \$41 \$53 \$55 pfet L=0.5U W=5U AS=2.1P AD=2.1P PS=10.84U PD=10.84U
.ENDS lock_detector_pfet_w5_l0p5
