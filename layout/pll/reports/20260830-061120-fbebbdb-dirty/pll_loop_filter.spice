* extracted by klt extract --deck sg13g2

* cell pll_loop_filter
* pin vsubs
.SUBCKT pll_loop_filter vsubs
* device instance $1 r0 *1 145.34,20.5 cap_cmim
C$1 \$3 \$5 2.4064e-12 cap_cmim
* device instance $2 r0 *1 174.34,4.5 cap_cmim
C$2 \$4 \$6 9.728e-14 cap_cmim
* device instance $3 r0 *1 60.42,2 rppd
R$3 \$1 \$2 vsubs 7800 rppd
.ENDS pll_loop_filter
