* extracted by klt extract --deck sg13g2

* cell lock_detector_XDW.XC1
.SUBCKT lock_detector_XDW.XC1
* device instance $1 r0 *1 2.5,2.5 cap_cmim
C$1 \$1 \$2 2.464e-14 cap_cmim
.ENDS lock_detector_XDW.XC1
