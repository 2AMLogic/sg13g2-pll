* extracted by klt extract --deck sg13g2

* cell pfd_nfet_w2_l0p5
* pin vsubs
.SUBCKT pfd_nfet_w2_l0p5 vsubs
* device instance $1 r0 *1 0.67,1 nfet
M$1 \$33 \$1 \$32 vsubs nfet L=0.5U W=2U AS=0.84P AD=0.84P PS=4.84U PD=4.84U
* device instance $2 r0 *1 2.41,1 nfet
M$2 \$35 \$2 \$34 vsubs nfet L=0.5U W=2U AS=0.84P AD=0.84P PS=4.84U PD=4.84U
* device instance $3 r0 *1 4.15,1 nfet
M$3 \$37 \$3 \$36 vsubs nfet L=0.5U W=2U AS=0.84P AD=0.84P PS=4.84U PD=4.84U
* device instance $4 r0 *1 5.89,1 nfet
M$4 \$39 \$4 \$38 vsubs nfet L=0.5U W=2U AS=0.84P AD=0.84P PS=4.84U PD=4.84U
* device instance $5 r0 *1 7.63,1 nfet
M$5 \$41 \$5 \$40 vsubs nfet L=0.5U W=2U AS=0.84P AD=0.84P PS=4.84U PD=4.84U
* device instance $6 r0 *1 9.37,1 nfet
M$6 \$43 \$6 \$42 vsubs nfet L=0.5U W=2U AS=0.84P AD=0.84P PS=4.84U PD=4.84U
* device instance $7 r0 *1 11.11,1 nfet
M$7 \$45 \$7 \$44 vsubs nfet L=0.5U W=2U AS=0.84P AD=0.84P PS=4.84U PD=4.84U
* device instance $8 r0 *1 12.85,1 nfet
M$8 \$47 \$8 \$46 vsubs nfet L=0.5U W=2U AS=0.84P AD=0.84P PS=4.84U PD=4.84U
* device instance $9 r0 *1 14.59,1 nfet
M$9 \$49 \$9 \$48 vsubs nfet L=0.5U W=2U AS=0.84P AD=0.84P PS=4.84U PD=4.84U
* device instance $10 r0 *1 16.33,1 nfet
M$10 \$51 \$10 \$50 vsubs nfet L=0.5U W=2U AS=0.84P AD=0.84P PS=4.84U PD=4.84U
* device instance $11 r0 *1 18.07,1 nfet
M$11 \$53 \$11 \$52 vsubs nfet L=0.5U W=2U AS=0.84P AD=0.84P PS=4.84U PD=4.84U
* device instance $12 r0 *1 19.81,1 nfet
M$12 \$55 \$12 \$54 vsubs nfet L=0.5U W=2U AS=0.84P AD=0.84P PS=4.84U PD=4.84U
* device instance $13 r0 *1 21.55,1 nfet
M$13 \$57 \$13 \$56 vsubs nfet L=0.5U W=2U AS=0.84P AD=0.84P PS=4.84U PD=4.84U
* device instance $14 r0 *1 23.29,1 nfet
M$14 \$59 \$14 \$58 vsubs nfet L=0.5U W=2U AS=0.84P AD=0.84P PS=4.84U PD=4.84U
* device instance $15 r0 *1 25.03,1 nfet
M$15 \$61 \$15 \$60 vsubs nfet L=0.5U W=2U AS=0.84P AD=0.84P PS=4.84U PD=4.84U
* device instance $16 r0 *1 26.77,1 nfet
M$16 \$63 \$16 \$62 vsubs nfet L=0.5U W=2U AS=0.84P AD=0.84P PS=4.84U PD=4.84U
* device instance $17 r0 *1 28.51,1 nfet
M$17 \$65 \$17 \$64 vsubs nfet L=0.5U W=2U AS=0.84P AD=0.84P PS=4.84U PD=4.84U
* device instance $18 r0 *1 30.25,1 nfet
M$18 \$67 \$18 \$66 vsubs nfet L=0.5U W=2U AS=0.84P AD=0.84P PS=4.84U PD=4.84U
* device instance $19 r0 *1 31.99,1 nfet
M$19 \$69 \$19 \$68 vsubs nfet L=0.5U W=2U AS=0.84P AD=0.84P PS=4.84U PD=4.84U
* device instance $20 r0 *1 33.73,1 nfet
M$20 \$71 \$20 \$70 vsubs nfet L=0.5U W=2U AS=0.84P AD=0.84P PS=4.84U PD=4.84U
* device instance $21 r0 *1 35.47,1 nfet
M$21 \$73 \$21 \$72 vsubs nfet L=0.5U W=2U AS=0.84P AD=0.84P PS=4.84U PD=4.84U
* device instance $22 r0 *1 37.21,1 nfet
M$22 \$75 \$22 \$74 vsubs nfet L=0.5U W=2U AS=0.84P AD=0.84P PS=4.84U PD=4.84U
* device instance $23 r0 *1 38.95,1 nfet
M$23 \$77 \$23 \$76 vsubs nfet L=0.5U W=2U AS=0.84P AD=0.84P PS=4.84U PD=4.84U
* device instance $24 r0 *1 40.69,1 nfet
M$24 \$79 \$24 \$78 vsubs nfet L=0.5U W=2U AS=0.84P AD=0.84P PS=4.84U PD=4.84U
* device instance $25 r0 *1 42.43,1 nfet
M$25 \$81 \$25 \$80 vsubs nfet L=0.5U W=2U AS=0.84P AD=0.84P PS=4.84U PD=4.84U
* device instance $26 r0 *1 44.17,1 nfet
M$26 \$83 \$26 \$82 vsubs nfet L=0.5U W=2U AS=0.84P AD=0.84P PS=4.84U PD=4.84U
* device instance $27 r0 *1 45.91,1 nfet
M$27 \$85 \$27 \$84 vsubs nfet L=0.5U W=2U AS=0.84P AD=0.84P PS=4.84U PD=4.84U
* device instance $28 r0 *1 47.65,1 nfet
M$28 \$87 \$28 \$86 vsubs nfet L=0.5U W=2U AS=0.84P AD=0.84P PS=4.84U PD=4.84U
* device instance $29 r0 *1 49.39,1 nfet
M$29 \$89 \$29 \$88 vsubs nfet L=0.5U W=2U AS=0.84P AD=0.84P PS=4.84U PD=4.84U
* device instance $30 r0 *1 51.13,1 nfet
M$30 \$91 \$30 \$90 vsubs nfet L=0.5U W=2U AS=0.84P AD=0.84P PS=4.84U PD=4.84U
* device instance $31 r0 *1 52.87,1 nfet
M$31 \$93 \$31 \$92 vsubs nfet L=0.5U W=2U AS=0.84P AD=0.84P PS=4.84U PD=4.84U
.ENDS pfd_nfet_w2_l0p5
