* extracted by klt extract --deck sg13g2

* cell pll_divider_chain
* pin vsubs
.SUBCKT pll_divider_chain vsubs
* device instance $1 r0 *1 0.67,1 nfet
M$1 \$81 \$1 \$80 vsubs nfet L=0.5U W=2U AS=0.84P AD=0.84P PS=4.84U PD=4.84U
* device instance $2 r0 *1 2.41,1 nfet
M$2 \$83 \$2 \$82 vsubs nfet L=0.5U W=2U AS=0.84P AD=0.84P PS=4.84U PD=4.84U
* device instance $3 r0 *1 4.15,1 nfet
M$3 \$85 \$3 \$84 vsubs nfet L=0.5U W=2U AS=0.84P AD=0.84P PS=4.84U PD=4.84U
* device instance $4 r0 *1 5.89,1 nfet
M$4 \$87 \$4 \$86 vsubs nfet L=0.5U W=2U AS=0.84P AD=0.84P PS=4.84U PD=4.84U
* device instance $5 r0 *1 7.63,1 nfet
M$5 \$89 \$5 \$88 vsubs nfet L=0.5U W=2U AS=0.84P AD=0.84P PS=4.84U PD=4.84U
* device instance $6 r0 *1 9.37,1 nfet
M$6 \$91 \$6 \$90 vsubs nfet L=0.5U W=2U AS=0.84P AD=0.84P PS=4.84U PD=4.84U
* device instance $7 r0 *1 11.11,1 nfet
M$7 \$93 \$7 \$92 vsubs nfet L=0.5U W=2U AS=0.84P AD=0.84P PS=4.84U PD=4.84U
* device instance $8 r0 *1 12.85,1 nfet
M$8 \$95 \$8 \$94 vsubs nfet L=0.5U W=2U AS=0.84P AD=0.84P PS=4.84U PD=4.84U
* device instance $9 r0 *1 14.59,1 nfet
M$9 \$97 \$9 \$96 vsubs nfet L=0.5U W=2U AS=0.84P AD=0.84P PS=4.84U PD=4.84U
* device instance $10 r0 *1 16.33,1 nfet
M$10 \$99 \$10 \$98 vsubs nfet L=0.5U W=2U AS=0.84P AD=0.84P PS=4.84U PD=4.84U
* device instance $11 r0 *1 18.07,1 nfet
M$11 \$101 \$11 \$100 vsubs nfet L=0.5U W=2U AS=0.84P AD=0.84P PS=4.84U PD=4.84U
* device instance $12 r0 *1 19.81,1 nfet
M$12 \$103 \$12 \$102 vsubs nfet L=0.5U W=2U AS=0.84P AD=0.84P PS=4.84U PD=4.84U
* device instance $13 r0 *1 21.55,1 nfet
M$13 \$105 \$13 \$104 vsubs nfet L=0.5U W=2U AS=0.84P AD=0.84P PS=4.84U PD=4.84U
* device instance $14 r0 *1 23.29,1 nfet
M$14 \$107 \$14 \$106 vsubs nfet L=0.5U W=2U AS=0.84P AD=0.84P PS=4.84U PD=4.84U
* device instance $15 r0 *1 25.03,1 nfet
M$15 \$109 \$15 \$108 vsubs nfet L=0.5U W=2U AS=0.84P AD=0.84P PS=4.84U PD=4.84U
* device instance $16 r0 *1 26.77,1 nfet
M$16 \$111 \$16 \$110 vsubs nfet L=0.5U W=2U AS=0.84P AD=0.84P PS=4.84U PD=4.84U
* device instance $17 r0 *1 28.51,1 nfet
M$17 \$113 \$17 \$112 vsubs nfet L=0.5U W=2U AS=0.84P AD=0.84P PS=4.84U PD=4.84U
* device instance $18 r0 *1 30.25,1 nfet
M$18 \$115 \$18 \$114 vsubs nfet L=0.5U W=2U AS=0.84P AD=0.84P PS=4.84U PD=4.84U
* device instance $19 r0 *1 31.99,1 nfet
M$19 \$117 \$19 \$116 vsubs nfet L=0.5U W=2U AS=0.84P AD=0.84P PS=4.84U PD=4.84U
* device instance $20 r0 *1 33.73,1 nfet
M$20 \$119 \$20 \$118 vsubs nfet L=0.5U W=2U AS=0.84P AD=0.84P PS=4.84U PD=4.84U
* device instance $21 r0 *1 35.47,1 nfet
M$21 \$121 \$21 \$120 vsubs nfet L=0.5U W=2U AS=0.84P AD=0.84P PS=4.84U PD=4.84U
* device instance $22 r0 *1 37.21,1 nfet
M$22 \$123 \$22 \$122 vsubs nfet L=0.5U W=2U AS=0.84P AD=0.84P PS=4.84U PD=4.84U
* device instance $23 r0 *1 38.95,1 nfet
M$23 \$125 \$23 \$124 vsubs nfet L=0.5U W=2U AS=0.84P AD=0.84P PS=4.84U PD=4.84U
* device instance $24 r0 *1 40.69,1 nfet
M$24 \$127 \$24 \$126 vsubs nfet L=0.5U W=2U AS=0.84P AD=0.84P PS=4.84U PD=4.84U
* device instance $25 r0 *1 42.43,1 nfet
M$25 \$129 \$25 \$128 vsubs nfet L=0.5U W=2U AS=0.84P AD=0.84P PS=4.84U PD=4.84U
* device instance $26 r0 *1 44.17,1 nfet
M$26 \$131 \$26 \$130 vsubs nfet L=0.5U W=2U AS=0.84P AD=0.84P PS=4.84U PD=4.84U
* device instance $27 r0 *1 45.91,1 nfet
M$27 \$133 \$27 \$132 vsubs nfet L=0.5U W=2U AS=0.84P AD=0.84P PS=4.84U PD=4.84U
* device instance $28 r0 *1 47.65,1 nfet
M$28 \$135 \$28 \$134 vsubs nfet L=0.5U W=2U AS=0.84P AD=0.84P PS=4.84U PD=4.84U
* device instance $29 r0 *1 49.39,1 nfet
M$29 \$137 \$29 \$136 vsubs nfet L=0.5U W=2U AS=0.84P AD=0.84P PS=4.84U PD=4.84U
* device instance $30 r0 *1 51.13,1 nfet
M$30 \$139 \$30 \$138 vsubs nfet L=0.5U W=2U AS=0.84P AD=0.84P PS=4.84U PD=4.84U
* device instance $31 r0 *1 52.87,1 nfet
M$31 \$141 \$31 \$140 vsubs nfet L=0.5U W=2U AS=0.84P AD=0.84P PS=4.84U PD=4.84U
* device instance $32 r0 *1 54.61,1 nfet
M$32 \$143 \$32 \$142 vsubs nfet L=0.5U W=2U AS=0.84P AD=0.84P PS=4.84U PD=4.84U
* device instance $33 r0 *1 56.35,1 nfet
M$33 \$145 \$33 \$144 vsubs nfet L=0.5U W=2U AS=0.84P AD=0.84P PS=4.84U PD=4.84U
* device instance $34 r0 *1 58.09,1 nfet
M$34 \$147 \$34 \$146 vsubs nfet L=0.5U W=2U AS=0.84P AD=0.84P PS=4.84U PD=4.84U
* device instance $35 r0 *1 59.83,1 nfet
M$35 \$149 \$35 \$148 vsubs nfet L=0.5U W=2U AS=0.84P AD=0.84P PS=4.84U PD=4.84U
* device instance $36 r0 *1 61.57,1 nfet
M$36 \$151 \$36 \$150 vsubs nfet L=0.5U W=2U AS=0.84P AD=0.84P PS=4.84U PD=4.84U
* device instance $37 r0 *1 63.31,1 nfet
M$37 \$153 \$37 \$152 vsubs nfet L=0.5U W=2U AS=0.84P AD=0.84P PS=4.84U PD=4.84U
* device instance $38 r0 *1 65.05,1 nfet
M$38 \$155 \$38 \$154 vsubs nfet L=0.5U W=2U AS=0.84P AD=0.84P PS=4.84U PD=4.84U
* device instance $39 r0 *1 66.79,1 nfet
M$39 \$157 \$39 \$156 vsubs nfet L=0.5U W=2U AS=0.84P AD=0.84P PS=4.84U PD=4.84U
* device instance $40 r0 *1 68.53,1 nfet
M$40 \$159 \$40 \$158 vsubs nfet L=0.5U W=2U AS=0.84P AD=0.84P PS=4.84U PD=4.84U
* device instance $41 r0 *1 70.27,1 nfet
M$41 \$161 \$41 \$160 vsubs nfet L=0.5U W=2U AS=0.84P AD=0.84P PS=4.84U PD=4.84U
* device instance $42 r0 *1 72.01,1 nfet
M$42 \$163 \$42 \$162 vsubs nfet L=0.5U W=2U AS=0.84P AD=0.84P PS=4.84U PD=4.84U
* device instance $43 r0 *1 73.75,1 nfet
M$43 \$165 \$43 \$164 vsubs nfet L=0.5U W=2U AS=0.84P AD=0.84P PS=4.84U PD=4.84U
* device instance $44 r0 *1 75.49,1 nfet
M$44 \$167 \$44 \$166 vsubs nfet L=0.5U W=2U AS=0.84P AD=0.84P PS=4.84U PD=4.84U
* device instance $45 r0 *1 77.23,1 nfet
M$45 \$169 \$45 \$168 vsubs nfet L=0.5U W=2U AS=0.84P AD=0.84P PS=4.84U PD=4.84U
* device instance $46 r0 *1 78.97,1 nfet
M$46 \$171 \$46 \$170 vsubs nfet L=0.5U W=2U AS=0.84P AD=0.84P PS=4.84U PD=4.84U
* device instance $47 r0 *1 80.71,1 nfet
M$47 \$173 \$47 \$172 vsubs nfet L=0.5U W=2U AS=0.84P AD=0.84P PS=4.84U PD=4.84U
* device instance $48 r0 *1 82.45,1 nfet
M$48 \$175 \$48 \$174 vsubs nfet L=0.5U W=2U AS=0.84P AD=0.84P PS=4.84U PD=4.84U
* device instance $49 r0 *1 84.19,1 nfet
M$49 \$177 \$49 \$176 vsubs nfet L=0.5U W=2U AS=0.84P AD=0.84P PS=4.84U PD=4.84U
* device instance $50 r0 *1 85.93,1 nfet
M$50 \$179 \$50 \$178 vsubs nfet L=0.5U W=2U AS=0.84P AD=0.84P PS=4.84U PD=4.84U
* device instance $51 r0 *1 87.67,1 nfet
M$51 \$181 \$51 \$180 vsubs nfet L=0.5U W=2U AS=0.84P AD=0.84P PS=4.84U PD=4.84U
* device instance $52 r0 *1 89.41,1 nfet
M$52 \$183 \$52 \$182 vsubs nfet L=0.5U W=2U AS=0.84P AD=0.84P PS=4.84U PD=4.84U
* device instance $53 r0 *1 91.15,1 nfet
M$53 \$185 \$53 \$184 vsubs nfet L=0.5U W=2U AS=0.84P AD=0.84P PS=4.84U PD=4.84U
* device instance $54 r0 *1 92.89,1 nfet
M$54 \$187 \$54 \$186 vsubs nfet L=0.5U W=2U AS=0.84P AD=0.84P PS=4.84U PD=4.84U
* device instance $55 r0 *1 94.63,1 nfet
M$55 \$189 \$55 \$188 vsubs nfet L=0.5U W=2U AS=0.84P AD=0.84P PS=4.84U PD=4.84U
* device instance $56 r0 *1 96.37,1 nfet
M$56 \$191 \$56 \$190 vsubs nfet L=0.5U W=2U AS=0.84P AD=0.84P PS=4.84U PD=4.84U
* device instance $57 r0 *1 98.11,1 nfet
M$57 \$193 \$57 \$192 vsubs nfet L=0.5U W=2U AS=0.84P AD=0.84P PS=4.84U PD=4.84U
* device instance $58 r0 *1 99.85,1 nfet
M$58 \$195 \$58 \$194 vsubs nfet L=0.5U W=2U AS=0.84P AD=0.84P PS=4.84U PD=4.84U
* device instance $59 r0 *1 101.59,1 nfet
M$59 \$197 \$59 \$196 vsubs nfet L=0.5U W=2U AS=0.84P AD=0.84P PS=4.84U PD=4.84U
* device instance $60 r0 *1 103.33,1 nfet
M$60 \$199 \$60 \$198 vsubs nfet L=0.5U W=2U AS=0.84P AD=0.84P PS=4.84U PD=4.84U
* device instance $61 r0 *1 105.07,1 nfet
M$61 \$201 \$61 \$200 vsubs nfet L=0.5U W=2U AS=0.84P AD=0.84P PS=4.84U PD=4.84U
* device instance $62 r0 *1 106.81,1 nfet
M$62 \$203 \$62 \$202 vsubs nfet L=0.5U W=2U AS=0.84P AD=0.84P PS=4.84U PD=4.84U
* device instance $63 r0 *1 108.55,1 nfet
M$63 \$205 \$63 \$204 vsubs nfet L=0.5U W=2U AS=0.84P AD=0.84P PS=4.84U PD=4.84U
* device instance $64 r0 *1 110.29,1 nfet
M$64 \$207 \$64 \$206 vsubs nfet L=0.5U W=2U AS=0.84P AD=0.84P PS=4.84U PD=4.84U
* device instance $65 r0 *1 112.03,1 nfet
M$65 \$209 \$65 \$208 vsubs nfet L=0.5U W=2U AS=0.84P AD=0.84P PS=4.84U PD=4.84U
* device instance $66 r0 *1 113.77,1 nfet
M$66 \$211 \$66 \$210 vsubs nfet L=0.5U W=2U AS=0.84P AD=0.84P PS=4.84U PD=4.84U
* device instance $67 r0 *1 115.51,1 nfet
M$67 \$213 \$67 \$212 vsubs nfet L=0.5U W=2U AS=0.84P AD=0.84P PS=4.84U PD=4.84U
* device instance $68 r0 *1 117.25,1 nfet
M$68 \$215 \$68 \$214 vsubs nfet L=0.5U W=2U AS=0.84P AD=0.84P PS=4.84U PD=4.84U
* device instance $69 r0 *1 118.99,1 nfet
M$69 \$217 \$69 \$216 vsubs nfet L=0.5U W=2U AS=0.84P AD=0.84P PS=4.84U PD=4.84U
* device instance $70 r0 *1 120.73,1 nfet
M$70 \$219 \$70 \$218 vsubs nfet L=0.5U W=2U AS=0.84P AD=0.84P PS=4.84U PD=4.84U
* device instance $71 r0 *1 122.47,1 nfet
M$71 \$221 \$71 \$220 vsubs nfet L=0.5U W=2U AS=0.84P AD=0.84P PS=4.84U PD=4.84U
* device instance $72 r0 *1 124.21,1 nfet
M$72 \$223 \$72 \$222 vsubs nfet L=0.5U W=2U AS=0.84P AD=0.84P PS=4.84U PD=4.84U
* device instance $73 r0 *1 125.95,1 nfet
M$73 \$225 \$73 \$224 vsubs nfet L=0.5U W=2U AS=0.84P AD=0.84P PS=4.84U PD=4.84U
* device instance $74 r0 *1 127.69,1 nfet
M$74 \$227 \$74 \$226 vsubs nfet L=0.5U W=2U AS=0.84P AD=0.84P PS=4.84U PD=4.84U
* device instance $75 r0 *1 129.43,1 nfet
M$75 \$229 \$75 \$228 vsubs nfet L=0.5U W=2U AS=0.84P AD=0.84P PS=4.84U PD=4.84U
* device instance $76 r0 *1 131.17,1 nfet
M$76 \$231 \$76 \$230 vsubs nfet L=0.5U W=2U AS=0.84P AD=0.84P PS=4.84U PD=4.84U
* device instance $77 r0 *1 132.91,1 nfet
M$77 \$233 \$77 \$232 vsubs nfet L=0.5U W=2U AS=0.84P AD=0.84P PS=4.84U PD=4.84U
* device instance $78 r0 *1 134.65,1 nfet
M$78 \$235 \$78 \$234 vsubs nfet L=0.5U W=2U AS=0.84P AD=0.84P PS=4.84U PD=4.84U
* device instance $79 r0 *1 136.39,1 nfet
M$79 \$237 \$79 \$236 vsubs nfet L=0.5U W=2U AS=0.84P AD=0.84P PS=4.84U PD=4.84U
* device instance $80 r0 *1 0.67,4.32 nfet
M$80 \$318 \$238 \$317 vsubs nfet L=0.5U W=2U AS=0.84P AD=0.84P PS=4.84U
+ PD=4.84U
* device instance $81 r0 *1 2.41,4.32 nfet
M$81 \$320 \$239 \$319 vsubs nfet L=0.5U W=2U AS=0.84P AD=0.84P PS=4.84U
+ PD=4.84U
* device instance $82 r0 *1 4.15,4.32 nfet
M$82 \$322 \$240 \$321 vsubs nfet L=0.5U W=2U AS=0.84P AD=0.84P PS=4.84U
+ PD=4.84U
* device instance $83 r0 *1 5.89,4.32 nfet
M$83 \$324 \$241 \$323 vsubs nfet L=0.5U W=2U AS=0.84P AD=0.84P PS=4.84U
+ PD=4.84U
* device instance $84 r0 *1 7.63,4.32 nfet
M$84 \$326 \$242 \$325 vsubs nfet L=0.5U W=2U AS=0.84P AD=0.84P PS=4.84U
+ PD=4.84U
* device instance $85 r0 *1 9.37,4.32 nfet
M$85 \$328 \$243 \$327 vsubs nfet L=0.5U W=2U AS=0.84P AD=0.84P PS=4.84U
+ PD=4.84U
* device instance $86 r0 *1 11.11,4.32 nfet
M$86 \$330 \$244 \$329 vsubs nfet L=0.5U W=2U AS=0.84P AD=0.84P PS=4.84U
+ PD=4.84U
* device instance $87 r0 *1 12.85,4.32 nfet
M$87 \$332 \$245 \$331 vsubs nfet L=0.5U W=2U AS=0.84P AD=0.84P PS=4.84U
+ PD=4.84U
* device instance $88 r0 *1 14.59,4.32 nfet
M$88 \$334 \$246 \$333 vsubs nfet L=0.5U W=2U AS=0.84P AD=0.84P PS=4.84U
+ PD=4.84U
* device instance $89 r0 *1 16.33,4.32 nfet
M$89 \$336 \$247 \$335 vsubs nfet L=0.5U W=2U AS=0.84P AD=0.84P PS=4.84U
+ PD=4.84U
* device instance $90 r0 *1 18.07,4.32 nfet
M$90 \$338 \$248 \$337 vsubs nfet L=0.5U W=2U AS=0.84P AD=0.84P PS=4.84U
+ PD=4.84U
* device instance $91 r0 *1 19.81,4.32 nfet
M$91 \$340 \$249 \$339 vsubs nfet L=0.5U W=2U AS=0.84P AD=0.84P PS=4.84U
+ PD=4.84U
* device instance $92 r0 *1 21.55,4.32 nfet
M$92 \$342 \$250 \$341 vsubs nfet L=0.5U W=2U AS=0.84P AD=0.84P PS=4.84U
+ PD=4.84U
* device instance $93 r0 *1 23.29,4.32 nfet
M$93 \$344 \$251 \$343 vsubs nfet L=0.5U W=2U AS=0.84P AD=0.84P PS=4.84U
+ PD=4.84U
* device instance $94 r0 *1 25.03,4.32 nfet
M$94 \$346 \$252 \$345 vsubs nfet L=0.5U W=2U AS=0.84P AD=0.84P PS=4.84U
+ PD=4.84U
* device instance $95 r0 *1 26.77,4.32 nfet
M$95 \$348 \$253 \$347 vsubs nfet L=0.5U W=2U AS=0.84P AD=0.84P PS=4.84U
+ PD=4.84U
* device instance $96 r0 *1 28.51,4.32 nfet
M$96 \$350 \$254 \$349 vsubs nfet L=0.5U W=2U AS=0.84P AD=0.84P PS=4.84U
+ PD=4.84U
* device instance $97 r0 *1 30.25,4.32 nfet
M$97 \$352 \$255 \$351 vsubs nfet L=0.5U W=2U AS=0.84P AD=0.84P PS=4.84U
+ PD=4.84U
* device instance $98 r0 *1 31.99,4.32 nfet
M$98 \$354 \$256 \$353 vsubs nfet L=0.5U W=2U AS=0.84P AD=0.84P PS=4.84U
+ PD=4.84U
* device instance $99 r0 *1 33.73,4.32 nfet
M$99 \$356 \$257 \$355 vsubs nfet L=0.5U W=2U AS=0.84P AD=0.84P PS=4.84U
+ PD=4.84U
* device instance $100 r0 *1 35.47,4.32 nfet
M$100 \$358 \$258 \$357 vsubs nfet L=0.5U W=2U AS=0.84P AD=0.84P PS=4.84U
+ PD=4.84U
* device instance $101 r0 *1 37.21,4.32 nfet
M$101 \$360 \$259 \$359 vsubs nfet L=0.5U W=2U AS=0.84P AD=0.84P PS=4.84U
+ PD=4.84U
* device instance $102 r0 *1 38.95,4.32 nfet
M$102 \$362 \$260 \$361 vsubs nfet L=0.5U W=2U AS=0.84P AD=0.84P PS=4.84U
+ PD=4.84U
* device instance $103 r0 *1 40.69,4.32 nfet
M$103 \$364 \$261 \$363 vsubs nfet L=0.5U W=2U AS=0.84P AD=0.84P PS=4.84U
+ PD=4.84U
* device instance $104 r0 *1 42.43,4.32 nfet
M$104 \$366 \$262 \$365 vsubs nfet L=0.5U W=2U AS=0.84P AD=0.84P PS=4.84U
+ PD=4.84U
* device instance $105 r0 *1 44.17,4.32 nfet
M$105 \$368 \$263 \$367 vsubs nfet L=0.5U W=2U AS=0.84P AD=0.84P PS=4.84U
+ PD=4.84U
* device instance $106 r0 *1 45.91,4.32 nfet
M$106 \$370 \$264 \$369 vsubs nfet L=0.5U W=2U AS=0.84P AD=0.84P PS=4.84U
+ PD=4.84U
* device instance $107 r0 *1 47.65,4.32 nfet
M$107 \$372 \$265 \$371 vsubs nfet L=0.5U W=2U AS=0.84P AD=0.84P PS=4.84U
+ PD=4.84U
* device instance $108 r0 *1 49.39,4.32 nfet
M$108 \$374 \$266 \$373 vsubs nfet L=0.5U W=2U AS=0.84P AD=0.84P PS=4.84U
+ PD=4.84U
* device instance $109 r0 *1 51.13,4.32 nfet
M$109 \$376 \$267 \$375 vsubs nfet L=0.5U W=2U AS=0.84P AD=0.84P PS=4.84U
+ PD=4.84U
* device instance $110 r0 *1 52.87,4.32 nfet
M$110 \$378 \$268 \$377 vsubs nfet L=0.5U W=2U AS=0.84P AD=0.84P PS=4.84U
+ PD=4.84U
* device instance $111 r0 *1 54.61,4.32 nfet
M$111 \$380 \$269 \$379 vsubs nfet L=0.5U W=2U AS=0.84P AD=0.84P PS=4.84U
+ PD=4.84U
* device instance $112 r0 *1 56.35,4.32 nfet
M$112 \$382 \$270 \$381 vsubs nfet L=0.5U W=2U AS=0.84P AD=0.84P PS=4.84U
+ PD=4.84U
* device instance $113 r0 *1 58.09,4.32 nfet
M$113 \$384 \$271 \$383 vsubs nfet L=0.5U W=2U AS=0.84P AD=0.84P PS=4.84U
+ PD=4.84U
* device instance $114 r0 *1 59.83,4.32 nfet
M$114 \$386 \$272 \$385 vsubs nfet L=0.5U W=2U AS=0.84P AD=0.84P PS=4.84U
+ PD=4.84U
* device instance $115 r0 *1 61.57,4.32 nfet
M$115 \$388 \$273 \$387 vsubs nfet L=0.5U W=2U AS=0.84P AD=0.84P PS=4.84U
+ PD=4.84U
* device instance $116 r0 *1 63.31,4.32 nfet
M$116 \$390 \$274 \$389 vsubs nfet L=0.5U W=2U AS=0.84P AD=0.84P PS=4.84U
+ PD=4.84U
* device instance $117 r0 *1 65.05,4.32 nfet
M$117 \$392 \$275 \$391 vsubs nfet L=0.5U W=2U AS=0.84P AD=0.84P PS=4.84U
+ PD=4.84U
* device instance $118 r0 *1 66.79,4.32 nfet
M$118 \$394 \$276 \$393 vsubs nfet L=0.5U W=2U AS=0.84P AD=0.84P PS=4.84U
+ PD=4.84U
* device instance $119 r0 *1 68.53,4.32 nfet
M$119 \$396 \$277 \$395 vsubs nfet L=0.5U W=2U AS=0.84P AD=0.84P PS=4.84U
+ PD=4.84U
* device instance $120 r0 *1 70.27,4.32 nfet
M$120 \$398 \$278 \$397 vsubs nfet L=0.5U W=2U AS=0.84P AD=0.84P PS=4.84U
+ PD=4.84U
* device instance $121 r0 *1 72.01,4.32 nfet
M$121 \$400 \$279 \$399 vsubs nfet L=0.5U W=2U AS=0.84P AD=0.84P PS=4.84U
+ PD=4.84U
* device instance $122 r0 *1 73.75,4.32 nfet
M$122 \$402 \$280 \$401 vsubs nfet L=0.5U W=2U AS=0.84P AD=0.84P PS=4.84U
+ PD=4.84U
* device instance $123 r0 *1 75.49,4.32 nfet
M$123 \$404 \$281 \$403 vsubs nfet L=0.5U W=2U AS=0.84P AD=0.84P PS=4.84U
+ PD=4.84U
* device instance $124 r0 *1 77.23,4.32 nfet
M$124 \$406 \$282 \$405 vsubs nfet L=0.5U W=2U AS=0.84P AD=0.84P PS=4.84U
+ PD=4.84U
* device instance $125 r0 *1 78.97,4.32 nfet
M$125 \$408 \$283 \$407 vsubs nfet L=0.5U W=2U AS=0.84P AD=0.84P PS=4.84U
+ PD=4.84U
* device instance $126 r0 *1 80.71,4.32 nfet
M$126 \$410 \$284 \$409 vsubs nfet L=0.5U W=2U AS=0.84P AD=0.84P PS=4.84U
+ PD=4.84U
* device instance $127 r0 *1 82.45,4.32 nfet
M$127 \$412 \$285 \$411 vsubs nfet L=0.5U W=2U AS=0.84P AD=0.84P PS=4.84U
+ PD=4.84U
* device instance $128 r0 *1 84.19,4.32 nfet
M$128 \$414 \$286 \$413 vsubs nfet L=0.5U W=2U AS=0.84P AD=0.84P PS=4.84U
+ PD=4.84U
* device instance $129 r0 *1 85.93,4.32 nfet
M$129 \$416 \$287 \$415 vsubs nfet L=0.5U W=2U AS=0.84P AD=0.84P PS=4.84U
+ PD=4.84U
* device instance $130 r0 *1 87.67,4.32 nfet
M$130 \$418 \$288 \$417 vsubs nfet L=0.5U W=2U AS=0.84P AD=0.84P PS=4.84U
+ PD=4.84U
* device instance $131 r0 *1 89.41,4.32 nfet
M$131 \$420 \$289 \$419 vsubs nfet L=0.5U W=2U AS=0.84P AD=0.84P PS=4.84U
+ PD=4.84U
* device instance $132 r0 *1 91.15,4.32 nfet
M$132 \$422 \$290 \$421 vsubs nfet L=0.5U W=2U AS=0.84P AD=0.84P PS=4.84U
+ PD=4.84U
* device instance $133 r0 *1 92.89,4.32 nfet
M$133 \$424 \$291 \$423 vsubs nfet L=0.5U W=2U AS=0.84P AD=0.84P PS=4.84U
+ PD=4.84U
* device instance $134 r0 *1 94.63,4.32 nfet
M$134 \$426 \$292 \$425 vsubs nfet L=0.5U W=2U AS=0.84P AD=0.84P PS=4.84U
+ PD=4.84U
* device instance $135 r0 *1 96.37,4.32 nfet
M$135 \$428 \$293 \$427 vsubs nfet L=0.5U W=2U AS=0.84P AD=0.84P PS=4.84U
+ PD=4.84U
* device instance $136 r0 *1 98.11,4.32 nfet
M$136 \$430 \$294 \$429 vsubs nfet L=0.5U W=2U AS=0.84P AD=0.84P PS=4.84U
+ PD=4.84U
* device instance $137 r0 *1 99.85,4.32 nfet
M$137 \$432 \$295 \$431 vsubs nfet L=0.5U W=2U AS=0.84P AD=0.84P PS=4.84U
+ PD=4.84U
* device instance $138 r0 *1 101.59,4.32 nfet
M$138 \$434 \$296 \$433 vsubs nfet L=0.5U W=2U AS=0.84P AD=0.84P PS=4.84U
+ PD=4.84U
* device instance $139 r0 *1 103.33,4.32 nfet
M$139 \$436 \$297 \$435 vsubs nfet L=0.5U W=2U AS=0.84P AD=0.84P PS=4.84U
+ PD=4.84U
* device instance $140 r0 *1 105.07,4.32 nfet
M$140 \$438 \$298 \$437 vsubs nfet L=0.5U W=2U AS=0.84P AD=0.84P PS=4.84U
+ PD=4.84U
* device instance $141 r0 *1 106.81,4.32 nfet
M$141 \$440 \$299 \$439 vsubs nfet L=0.5U W=2U AS=0.84P AD=0.84P PS=4.84U
+ PD=4.84U
* device instance $142 r0 *1 108.55,4.32 nfet
M$142 \$442 \$300 \$441 vsubs nfet L=0.5U W=2U AS=0.84P AD=0.84P PS=4.84U
+ PD=4.84U
* device instance $143 r0 *1 110.29,4.32 nfet
M$143 \$444 \$301 \$443 vsubs nfet L=0.5U W=2U AS=0.84P AD=0.84P PS=4.84U
+ PD=4.84U
* device instance $144 r0 *1 112.03,4.32 nfet
M$144 \$446 \$302 \$445 vsubs nfet L=0.5U W=2U AS=0.84P AD=0.84P PS=4.84U
+ PD=4.84U
* device instance $145 r0 *1 113.77,4.32 nfet
M$145 \$448 \$303 \$447 vsubs nfet L=0.5U W=2U AS=0.84P AD=0.84P PS=4.84U
+ PD=4.84U
* device instance $146 r0 *1 115.51,4.32 nfet
M$146 \$450 \$304 \$449 vsubs nfet L=0.5U W=2U AS=0.84P AD=0.84P PS=4.84U
+ PD=4.84U
* device instance $147 r0 *1 117.25,4.32 nfet
M$147 \$452 \$305 \$451 vsubs nfet L=0.5U W=2U AS=0.84P AD=0.84P PS=4.84U
+ PD=4.84U
* device instance $148 r0 *1 118.99,4.32 nfet
M$148 \$454 \$306 \$453 vsubs nfet L=0.5U W=2U AS=0.84P AD=0.84P PS=4.84U
+ PD=4.84U
* device instance $149 r0 *1 120.73,4.32 nfet
M$149 \$456 \$307 \$455 vsubs nfet L=0.5U W=2U AS=0.84P AD=0.84P PS=4.84U
+ PD=4.84U
* device instance $150 r0 *1 122.47,4.32 nfet
M$150 \$458 \$308 \$457 vsubs nfet L=0.5U W=2U AS=0.84P AD=0.84P PS=4.84U
+ PD=4.84U
* device instance $151 r0 *1 124.21,4.32 nfet
M$151 \$460 \$309 \$459 vsubs nfet L=0.5U W=2U AS=0.84P AD=0.84P PS=4.84U
+ PD=4.84U
* device instance $152 r0 *1 125.95,4.32 nfet
M$152 \$462 \$310 \$461 vsubs nfet L=0.5U W=2U AS=0.84P AD=0.84P PS=4.84U
+ PD=4.84U
* device instance $153 r0 *1 127.69,4.32 nfet
M$153 \$464 \$311 \$463 vsubs nfet L=0.5U W=2U AS=0.84P AD=0.84P PS=4.84U
+ PD=4.84U
* device instance $154 r0 *1 129.43,4.32 nfet
M$154 \$466 \$312 \$465 vsubs nfet L=0.5U W=2U AS=0.84P AD=0.84P PS=4.84U
+ PD=4.84U
* device instance $155 r0 *1 131.17,4.32 nfet
M$155 \$468 \$313 \$467 vsubs nfet L=0.5U W=2U AS=0.84P AD=0.84P PS=4.84U
+ PD=4.84U
* device instance $156 r0 *1 132.91,4.32 nfet
M$156 \$470 \$314 \$469 vsubs nfet L=0.5U W=2U AS=0.84P AD=0.84P PS=4.84U
+ PD=4.84U
* device instance $157 r0 *1 134.65,4.32 nfet
M$157 \$472 \$315 \$471 vsubs nfet L=0.5U W=2U AS=0.84P AD=0.84P PS=4.84U
+ PD=4.84U
* device instance $158 r0 *1 136.39,4.32 nfet
M$158 \$474 \$316 \$473 vsubs nfet L=0.5U W=2U AS=0.84P AD=0.84P PS=4.84U
+ PD=4.84U
* device instance $159 r0 *1 0.67,12.74 pfet
M$159 \$556 \$475 \$554 \$949 pfet L=0.5U W=5U AS=2.1P AD=2.1P PS=10.84U
+ PD=10.84U
* device instance $160 r0 *1 2.41,12.74 pfet
M$160 \$559 \$476 \$557 \$949 pfet L=0.5U W=5U AS=2.1P AD=2.1P PS=10.84U
+ PD=10.84U
* device instance $161 r0 *1 4.15,12.74 pfet
M$161 \$562 \$477 \$560 \$949 pfet L=0.5U W=5U AS=2.1P AD=2.1P PS=10.84U
+ PD=10.84U
* device instance $162 r0 *1 5.89,12.74 pfet
M$162 \$565 \$478 \$563 \$949 pfet L=0.5U W=5U AS=2.1P AD=2.1P PS=10.84U
+ PD=10.84U
* device instance $163 r0 *1 7.63,12.74 pfet
M$163 \$568 \$479 \$566 \$949 pfet L=0.5U W=5U AS=2.1P AD=2.1P PS=10.84U
+ PD=10.84U
* device instance $164 r0 *1 9.37,12.74 pfet
M$164 \$571 \$480 \$569 \$949 pfet L=0.5U W=5U AS=2.1P AD=2.1P PS=10.84U
+ PD=10.84U
* device instance $165 r0 *1 11.11,12.74 pfet
M$165 \$574 \$481 \$572 \$949 pfet L=0.5U W=5U AS=2.1P AD=2.1P PS=10.84U
+ PD=10.84U
* device instance $166 r0 *1 12.85,12.74 pfet
M$166 \$577 \$482 \$575 \$949 pfet L=0.5U W=5U AS=2.1P AD=2.1P PS=10.84U
+ PD=10.84U
* device instance $167 r0 *1 14.59,12.74 pfet
M$167 \$580 \$483 \$578 \$949 pfet L=0.5U W=5U AS=2.1P AD=2.1P PS=10.84U
+ PD=10.84U
* device instance $168 r0 *1 16.33,12.74 pfet
M$168 \$583 \$484 \$581 \$949 pfet L=0.5U W=5U AS=2.1P AD=2.1P PS=10.84U
+ PD=10.84U
* device instance $169 r0 *1 18.07,12.74 pfet
M$169 \$586 \$485 \$584 \$949 pfet L=0.5U W=5U AS=2.1P AD=2.1P PS=10.84U
+ PD=10.84U
* device instance $170 r0 *1 19.81,12.74 pfet
M$170 \$589 \$486 \$587 \$949 pfet L=0.5U W=5U AS=2.1P AD=2.1P PS=10.84U
+ PD=10.84U
* device instance $171 r0 *1 21.55,12.74 pfet
M$171 \$592 \$487 \$590 \$949 pfet L=0.5U W=5U AS=2.1P AD=2.1P PS=10.84U
+ PD=10.84U
* device instance $172 r0 *1 23.29,12.74 pfet
M$172 \$595 \$488 \$593 \$949 pfet L=0.5U W=5U AS=2.1P AD=2.1P PS=10.84U
+ PD=10.84U
* device instance $173 r0 *1 25.03,12.74 pfet
M$173 \$598 \$489 \$596 \$949 pfet L=0.5U W=5U AS=2.1P AD=2.1P PS=10.84U
+ PD=10.84U
* device instance $174 r0 *1 26.77,12.74 pfet
M$174 \$601 \$490 \$599 \$949 pfet L=0.5U W=5U AS=2.1P AD=2.1P PS=10.84U
+ PD=10.84U
* device instance $175 r0 *1 28.51,12.74 pfet
M$175 \$604 \$491 \$602 \$949 pfet L=0.5U W=5U AS=2.1P AD=2.1P PS=10.84U
+ PD=10.84U
* device instance $176 r0 *1 30.25,12.74 pfet
M$176 \$607 \$492 \$605 \$949 pfet L=0.5U W=5U AS=2.1P AD=2.1P PS=10.84U
+ PD=10.84U
* device instance $177 r0 *1 31.99,12.74 pfet
M$177 \$610 \$493 \$608 \$949 pfet L=0.5U W=5U AS=2.1P AD=2.1P PS=10.84U
+ PD=10.84U
* device instance $178 r0 *1 33.73,12.74 pfet
M$178 \$613 \$494 \$611 \$949 pfet L=0.5U W=5U AS=2.1P AD=2.1P PS=10.84U
+ PD=10.84U
* device instance $179 r0 *1 35.47,12.74 pfet
M$179 \$616 \$495 \$614 \$949 pfet L=0.5U W=5U AS=2.1P AD=2.1P PS=10.84U
+ PD=10.84U
* device instance $180 r0 *1 37.21,12.74 pfet
M$180 \$619 \$496 \$617 \$949 pfet L=0.5U W=5U AS=2.1P AD=2.1P PS=10.84U
+ PD=10.84U
* device instance $181 r0 *1 38.95,12.74 pfet
M$181 \$622 \$497 \$620 \$949 pfet L=0.5U W=5U AS=2.1P AD=2.1P PS=10.84U
+ PD=10.84U
* device instance $182 r0 *1 40.69,12.74 pfet
M$182 \$625 \$498 \$623 \$949 pfet L=0.5U W=5U AS=2.1P AD=2.1P PS=10.84U
+ PD=10.84U
* device instance $183 r0 *1 42.43,12.74 pfet
M$183 \$628 \$499 \$626 \$949 pfet L=0.5U W=5U AS=2.1P AD=2.1P PS=10.84U
+ PD=10.84U
* device instance $184 r0 *1 44.17,12.74 pfet
M$184 \$631 \$500 \$629 \$949 pfet L=0.5U W=5U AS=2.1P AD=2.1P PS=10.84U
+ PD=10.84U
* device instance $185 r0 *1 45.91,12.74 pfet
M$185 \$634 \$501 \$632 \$949 pfet L=0.5U W=5U AS=2.1P AD=2.1P PS=10.84U
+ PD=10.84U
* device instance $186 r0 *1 47.65,12.74 pfet
M$186 \$637 \$502 \$635 \$949 pfet L=0.5U W=5U AS=2.1P AD=2.1P PS=10.84U
+ PD=10.84U
* device instance $187 r0 *1 49.39,12.74 pfet
M$187 \$640 \$503 \$638 \$949 pfet L=0.5U W=5U AS=2.1P AD=2.1P PS=10.84U
+ PD=10.84U
* device instance $188 r0 *1 51.13,12.74 pfet
M$188 \$643 \$504 \$641 \$949 pfet L=0.5U W=5U AS=2.1P AD=2.1P PS=10.84U
+ PD=10.84U
* device instance $189 r0 *1 52.87,12.74 pfet
M$189 \$646 \$505 \$644 \$949 pfet L=0.5U W=5U AS=2.1P AD=2.1P PS=10.84U
+ PD=10.84U
* device instance $190 r0 *1 54.61,12.74 pfet
M$190 \$649 \$506 \$647 \$949 pfet L=0.5U W=5U AS=2.1P AD=2.1P PS=10.84U
+ PD=10.84U
* device instance $191 r0 *1 56.35,12.74 pfet
M$191 \$652 \$507 \$650 \$949 pfet L=0.5U W=5U AS=2.1P AD=2.1P PS=10.84U
+ PD=10.84U
* device instance $192 r0 *1 58.09,12.74 pfet
M$192 \$655 \$508 \$653 \$949 pfet L=0.5U W=5U AS=2.1P AD=2.1P PS=10.84U
+ PD=10.84U
* device instance $193 r0 *1 59.83,12.74 pfet
M$193 \$658 \$509 \$656 \$949 pfet L=0.5U W=5U AS=2.1P AD=2.1P PS=10.84U
+ PD=10.84U
* device instance $194 r0 *1 61.57,12.74 pfet
M$194 \$661 \$510 \$659 \$949 pfet L=0.5U W=5U AS=2.1P AD=2.1P PS=10.84U
+ PD=10.84U
* device instance $195 r0 *1 63.31,12.74 pfet
M$195 \$664 \$511 \$662 \$949 pfet L=0.5U W=5U AS=2.1P AD=2.1P PS=10.84U
+ PD=10.84U
* device instance $196 r0 *1 65.05,12.74 pfet
M$196 \$667 \$512 \$665 \$949 pfet L=0.5U W=5U AS=2.1P AD=2.1P PS=10.84U
+ PD=10.84U
* device instance $197 r0 *1 66.79,12.74 pfet
M$197 \$670 \$513 \$668 \$949 pfet L=0.5U W=5U AS=2.1P AD=2.1P PS=10.84U
+ PD=10.84U
* device instance $198 r0 *1 68.53,12.74 pfet
M$198 \$673 \$514 \$671 \$949 pfet L=0.5U W=5U AS=2.1P AD=2.1P PS=10.84U
+ PD=10.84U
* device instance $199 r0 *1 70.27,12.74 pfet
M$199 \$676 \$515 \$674 \$949 pfet L=0.5U W=5U AS=2.1P AD=2.1P PS=10.84U
+ PD=10.84U
* device instance $200 r0 *1 72.01,12.74 pfet
M$200 \$679 \$516 \$677 \$949 pfet L=0.5U W=5U AS=2.1P AD=2.1P PS=10.84U
+ PD=10.84U
* device instance $201 r0 *1 73.75,12.74 pfet
M$201 \$682 \$517 \$680 \$949 pfet L=0.5U W=5U AS=2.1P AD=2.1P PS=10.84U
+ PD=10.84U
* device instance $202 r0 *1 75.49,12.74 pfet
M$202 \$685 \$518 \$683 \$949 pfet L=0.5U W=5U AS=2.1P AD=2.1P PS=10.84U
+ PD=10.84U
* device instance $203 r0 *1 77.23,12.74 pfet
M$203 \$688 \$519 \$686 \$949 pfet L=0.5U W=5U AS=2.1P AD=2.1P PS=10.84U
+ PD=10.84U
* device instance $204 r0 *1 78.97,12.74 pfet
M$204 \$691 \$520 \$689 \$949 pfet L=0.5U W=5U AS=2.1P AD=2.1P PS=10.84U
+ PD=10.84U
* device instance $205 r0 *1 80.71,12.74 pfet
M$205 \$694 \$521 \$692 \$949 pfet L=0.5U W=5U AS=2.1P AD=2.1P PS=10.84U
+ PD=10.84U
* device instance $206 r0 *1 82.45,12.74 pfet
M$206 \$697 \$522 \$695 \$949 pfet L=0.5U W=5U AS=2.1P AD=2.1P PS=10.84U
+ PD=10.84U
* device instance $207 r0 *1 84.19,12.74 pfet
M$207 \$700 \$523 \$698 \$949 pfet L=0.5U W=5U AS=2.1P AD=2.1P PS=10.84U
+ PD=10.84U
* device instance $208 r0 *1 85.93,12.74 pfet
M$208 \$703 \$524 \$701 \$949 pfet L=0.5U W=5U AS=2.1P AD=2.1P PS=10.84U
+ PD=10.84U
* device instance $209 r0 *1 87.67,12.74 pfet
M$209 \$706 \$525 \$704 \$949 pfet L=0.5U W=5U AS=2.1P AD=2.1P PS=10.84U
+ PD=10.84U
* device instance $210 r0 *1 89.41,12.74 pfet
M$210 \$709 \$526 \$707 \$949 pfet L=0.5U W=5U AS=2.1P AD=2.1P PS=10.84U
+ PD=10.84U
* device instance $211 r0 *1 91.15,12.74 pfet
M$211 \$712 \$527 \$710 \$949 pfet L=0.5U W=5U AS=2.1P AD=2.1P PS=10.84U
+ PD=10.84U
* device instance $212 r0 *1 92.89,12.74 pfet
M$212 \$715 \$528 \$713 \$949 pfet L=0.5U W=5U AS=2.1P AD=2.1P PS=10.84U
+ PD=10.84U
* device instance $213 r0 *1 94.63,12.74 pfet
M$213 \$718 \$529 \$716 \$949 pfet L=0.5U W=5U AS=2.1P AD=2.1P PS=10.84U
+ PD=10.84U
* device instance $214 r0 *1 96.37,12.74 pfet
M$214 \$721 \$530 \$719 \$949 pfet L=0.5U W=5U AS=2.1P AD=2.1P PS=10.84U
+ PD=10.84U
* device instance $215 r0 *1 98.11,12.74 pfet
M$215 \$724 \$531 \$722 \$949 pfet L=0.5U W=5U AS=2.1P AD=2.1P PS=10.84U
+ PD=10.84U
* device instance $216 r0 *1 99.85,12.74 pfet
M$216 \$727 \$532 \$725 \$949 pfet L=0.5U W=5U AS=2.1P AD=2.1P PS=10.84U
+ PD=10.84U
* device instance $217 r0 *1 101.59,12.74 pfet
M$217 \$730 \$533 \$728 \$949 pfet L=0.5U W=5U AS=2.1P AD=2.1P PS=10.84U
+ PD=10.84U
* device instance $218 r0 *1 103.33,12.74 pfet
M$218 \$733 \$534 \$731 \$949 pfet L=0.5U W=5U AS=2.1P AD=2.1P PS=10.84U
+ PD=10.84U
* device instance $219 r0 *1 105.07,12.74 pfet
M$219 \$736 \$535 \$734 \$949 pfet L=0.5U W=5U AS=2.1P AD=2.1P PS=10.84U
+ PD=10.84U
* device instance $220 r0 *1 106.81,12.74 pfet
M$220 \$739 \$536 \$737 \$949 pfet L=0.5U W=5U AS=2.1P AD=2.1P PS=10.84U
+ PD=10.84U
* device instance $221 r0 *1 108.55,12.74 pfet
M$221 \$742 \$537 \$740 \$949 pfet L=0.5U W=5U AS=2.1P AD=2.1P PS=10.84U
+ PD=10.84U
* device instance $222 r0 *1 110.29,12.74 pfet
M$222 \$745 \$538 \$743 \$949 pfet L=0.5U W=5U AS=2.1P AD=2.1P PS=10.84U
+ PD=10.84U
* device instance $223 r0 *1 112.03,12.74 pfet
M$223 \$748 \$539 \$746 \$949 pfet L=0.5U W=5U AS=2.1P AD=2.1P PS=10.84U
+ PD=10.84U
* device instance $224 r0 *1 113.77,12.74 pfet
M$224 \$751 \$540 \$749 \$949 pfet L=0.5U W=5U AS=2.1P AD=2.1P PS=10.84U
+ PD=10.84U
* device instance $225 r0 *1 115.51,12.74 pfet
M$225 \$754 \$541 \$752 \$949 pfet L=0.5U W=5U AS=2.1P AD=2.1P PS=10.84U
+ PD=10.84U
* device instance $226 r0 *1 117.25,12.74 pfet
M$226 \$757 \$542 \$755 \$949 pfet L=0.5U W=5U AS=2.1P AD=2.1P PS=10.84U
+ PD=10.84U
* device instance $227 r0 *1 118.99,12.74 pfet
M$227 \$760 \$543 \$758 \$949 pfet L=0.5U W=5U AS=2.1P AD=2.1P PS=10.84U
+ PD=10.84U
* device instance $228 r0 *1 120.73,12.74 pfet
M$228 \$763 \$544 \$761 \$949 pfet L=0.5U W=5U AS=2.1P AD=2.1P PS=10.84U
+ PD=10.84U
* device instance $229 r0 *1 122.47,12.74 pfet
M$229 \$766 \$545 \$764 \$949 pfet L=0.5U W=5U AS=2.1P AD=2.1P PS=10.84U
+ PD=10.84U
* device instance $230 r0 *1 124.21,12.74 pfet
M$230 \$769 \$546 \$767 \$949 pfet L=0.5U W=5U AS=2.1P AD=2.1P PS=10.84U
+ PD=10.84U
* device instance $231 r0 *1 125.95,12.74 pfet
M$231 \$772 \$547 \$770 \$949 pfet L=0.5U W=5U AS=2.1P AD=2.1P PS=10.84U
+ PD=10.84U
* device instance $232 r0 *1 127.69,12.74 pfet
M$232 \$775 \$548 \$773 \$949 pfet L=0.5U W=5U AS=2.1P AD=2.1P PS=10.84U
+ PD=10.84U
* device instance $233 r0 *1 129.43,12.74 pfet
M$233 \$778 \$549 \$776 \$949 pfet L=0.5U W=5U AS=2.1P AD=2.1P PS=10.84U
+ PD=10.84U
* device instance $234 r0 *1 131.17,12.74 pfet
M$234 \$781 \$550 \$779 \$949 pfet L=0.5U W=5U AS=2.1P AD=2.1P PS=10.84U
+ PD=10.84U
* device instance $235 r0 *1 132.91,12.74 pfet
M$235 \$784 \$551 \$782 \$949 pfet L=0.5U W=5U AS=2.1P AD=2.1P PS=10.84U
+ PD=10.84U
* device instance $236 r0 *1 134.65,12.74 pfet
M$236 \$787 \$552 \$785 \$949 pfet L=0.5U W=5U AS=2.1P AD=2.1P PS=10.84U
+ PD=10.84U
* device instance $237 r0 *1 136.39,12.74 pfet
M$237 \$790 \$553 \$788 \$949 pfet L=0.5U W=5U AS=2.1P AD=2.1P PS=10.84U
+ PD=10.84U
* device instance $238 r0 *1 0.67,19.06 pfet
M$238 \$792 \$555 \$791 \$949 pfet L=0.5U W=5U AS=2.1P AD=2.1P PS=10.84U
+ PD=10.84U
* device instance $239 r0 *1 2.41,19.06 pfet
M$239 \$794 \$558 \$793 \$949 pfet L=0.5U W=5U AS=2.1P AD=2.1P PS=10.84U
+ PD=10.84U
* device instance $240 r0 *1 4.15,19.06 pfet
M$240 \$796 \$561 \$795 \$949 pfet L=0.5U W=5U AS=2.1P AD=2.1P PS=10.84U
+ PD=10.84U
* device instance $241 r0 *1 5.89,19.06 pfet
M$241 \$798 \$564 \$797 \$949 pfet L=0.5U W=5U AS=2.1P AD=2.1P PS=10.84U
+ PD=10.84U
* device instance $242 r0 *1 7.63,19.06 pfet
M$242 \$800 \$567 \$799 \$949 pfet L=0.5U W=5U AS=2.1P AD=2.1P PS=10.84U
+ PD=10.84U
* device instance $243 r0 *1 9.37,19.06 pfet
M$243 \$802 \$570 \$801 \$949 pfet L=0.5U W=5U AS=2.1P AD=2.1P PS=10.84U
+ PD=10.84U
* device instance $244 r0 *1 11.11,19.06 pfet
M$244 \$804 \$573 \$803 \$949 pfet L=0.5U W=5U AS=2.1P AD=2.1P PS=10.84U
+ PD=10.84U
* device instance $245 r0 *1 12.85,19.06 pfet
M$245 \$806 \$576 \$805 \$949 pfet L=0.5U W=5U AS=2.1P AD=2.1P PS=10.84U
+ PD=10.84U
* device instance $246 r0 *1 14.59,19.06 pfet
M$246 \$808 \$579 \$807 \$949 pfet L=0.5U W=5U AS=2.1P AD=2.1P PS=10.84U
+ PD=10.84U
* device instance $247 r0 *1 16.33,19.06 pfet
M$247 \$810 \$582 \$809 \$949 pfet L=0.5U W=5U AS=2.1P AD=2.1P PS=10.84U
+ PD=10.84U
* device instance $248 r0 *1 18.07,19.06 pfet
M$248 \$812 \$585 \$811 \$949 pfet L=0.5U W=5U AS=2.1P AD=2.1P PS=10.84U
+ PD=10.84U
* device instance $249 r0 *1 19.81,19.06 pfet
M$249 \$814 \$588 \$813 \$949 pfet L=0.5U W=5U AS=2.1P AD=2.1P PS=10.84U
+ PD=10.84U
* device instance $250 r0 *1 21.55,19.06 pfet
M$250 \$816 \$591 \$815 \$949 pfet L=0.5U W=5U AS=2.1P AD=2.1P PS=10.84U
+ PD=10.84U
* device instance $251 r0 *1 23.29,19.06 pfet
M$251 \$818 \$594 \$817 \$949 pfet L=0.5U W=5U AS=2.1P AD=2.1P PS=10.84U
+ PD=10.84U
* device instance $252 r0 *1 25.03,19.06 pfet
M$252 \$820 \$597 \$819 \$949 pfet L=0.5U W=5U AS=2.1P AD=2.1P PS=10.84U
+ PD=10.84U
* device instance $253 r0 *1 26.77,19.06 pfet
M$253 \$822 \$600 \$821 \$949 pfet L=0.5U W=5U AS=2.1P AD=2.1P PS=10.84U
+ PD=10.84U
* device instance $254 r0 *1 28.51,19.06 pfet
M$254 \$824 \$603 \$823 \$949 pfet L=0.5U W=5U AS=2.1P AD=2.1P PS=10.84U
+ PD=10.84U
* device instance $255 r0 *1 30.25,19.06 pfet
M$255 \$826 \$606 \$825 \$949 pfet L=0.5U W=5U AS=2.1P AD=2.1P PS=10.84U
+ PD=10.84U
* device instance $256 r0 *1 31.99,19.06 pfet
M$256 \$828 \$609 \$827 \$949 pfet L=0.5U W=5U AS=2.1P AD=2.1P PS=10.84U
+ PD=10.84U
* device instance $257 r0 *1 33.73,19.06 pfet
M$257 \$830 \$612 \$829 \$949 pfet L=0.5U W=5U AS=2.1P AD=2.1P PS=10.84U
+ PD=10.84U
* device instance $258 r0 *1 35.47,19.06 pfet
M$258 \$832 \$615 \$831 \$949 pfet L=0.5U W=5U AS=2.1P AD=2.1P PS=10.84U
+ PD=10.84U
* device instance $259 r0 *1 37.21,19.06 pfet
M$259 \$834 \$618 \$833 \$949 pfet L=0.5U W=5U AS=2.1P AD=2.1P PS=10.84U
+ PD=10.84U
* device instance $260 r0 *1 38.95,19.06 pfet
M$260 \$836 \$621 \$835 \$949 pfet L=0.5U W=5U AS=2.1P AD=2.1P PS=10.84U
+ PD=10.84U
* device instance $261 r0 *1 40.69,19.06 pfet
M$261 \$838 \$624 \$837 \$949 pfet L=0.5U W=5U AS=2.1P AD=2.1P PS=10.84U
+ PD=10.84U
* device instance $262 r0 *1 42.43,19.06 pfet
M$262 \$840 \$627 \$839 \$949 pfet L=0.5U W=5U AS=2.1P AD=2.1P PS=10.84U
+ PD=10.84U
* device instance $263 r0 *1 44.17,19.06 pfet
M$263 \$842 \$630 \$841 \$949 pfet L=0.5U W=5U AS=2.1P AD=2.1P PS=10.84U
+ PD=10.84U
* device instance $264 r0 *1 45.91,19.06 pfet
M$264 \$844 \$633 \$843 \$949 pfet L=0.5U W=5U AS=2.1P AD=2.1P PS=10.84U
+ PD=10.84U
* device instance $265 r0 *1 47.65,19.06 pfet
M$265 \$846 \$636 \$845 \$949 pfet L=0.5U W=5U AS=2.1P AD=2.1P PS=10.84U
+ PD=10.84U
* device instance $266 r0 *1 49.39,19.06 pfet
M$266 \$848 \$639 \$847 \$949 pfet L=0.5U W=5U AS=2.1P AD=2.1P PS=10.84U
+ PD=10.84U
* device instance $267 r0 *1 51.13,19.06 pfet
M$267 \$850 \$642 \$849 \$949 pfet L=0.5U W=5U AS=2.1P AD=2.1P PS=10.84U
+ PD=10.84U
* device instance $268 r0 *1 52.87,19.06 pfet
M$268 \$852 \$645 \$851 \$949 pfet L=0.5U W=5U AS=2.1P AD=2.1P PS=10.84U
+ PD=10.84U
* device instance $269 r0 *1 54.61,19.06 pfet
M$269 \$854 \$648 \$853 \$949 pfet L=0.5U W=5U AS=2.1P AD=2.1P PS=10.84U
+ PD=10.84U
* device instance $270 r0 *1 56.35,19.06 pfet
M$270 \$856 \$651 \$855 \$949 pfet L=0.5U W=5U AS=2.1P AD=2.1P PS=10.84U
+ PD=10.84U
* device instance $271 r0 *1 58.09,19.06 pfet
M$271 \$858 \$654 \$857 \$949 pfet L=0.5U W=5U AS=2.1P AD=2.1P PS=10.84U
+ PD=10.84U
* device instance $272 r0 *1 59.83,19.06 pfet
M$272 \$860 \$657 \$859 \$949 pfet L=0.5U W=5U AS=2.1P AD=2.1P PS=10.84U
+ PD=10.84U
* device instance $273 r0 *1 61.57,19.06 pfet
M$273 \$862 \$660 \$861 \$949 pfet L=0.5U W=5U AS=2.1P AD=2.1P PS=10.84U
+ PD=10.84U
* device instance $274 r0 *1 63.31,19.06 pfet
M$274 \$864 \$663 \$863 \$949 pfet L=0.5U W=5U AS=2.1P AD=2.1P PS=10.84U
+ PD=10.84U
* device instance $275 r0 *1 65.05,19.06 pfet
M$275 \$866 \$666 \$865 \$949 pfet L=0.5U W=5U AS=2.1P AD=2.1P PS=10.84U
+ PD=10.84U
* device instance $276 r0 *1 66.79,19.06 pfet
M$276 \$868 \$669 \$867 \$949 pfet L=0.5U W=5U AS=2.1P AD=2.1P PS=10.84U
+ PD=10.84U
* device instance $277 r0 *1 68.53,19.06 pfet
M$277 \$870 \$672 \$869 \$949 pfet L=0.5U W=5U AS=2.1P AD=2.1P PS=10.84U
+ PD=10.84U
* device instance $278 r0 *1 70.27,19.06 pfet
M$278 \$872 \$675 \$871 \$949 pfet L=0.5U W=5U AS=2.1P AD=2.1P PS=10.84U
+ PD=10.84U
* device instance $279 r0 *1 72.01,19.06 pfet
M$279 \$874 \$678 \$873 \$949 pfet L=0.5U W=5U AS=2.1P AD=2.1P PS=10.84U
+ PD=10.84U
* device instance $280 r0 *1 73.75,19.06 pfet
M$280 \$876 \$681 \$875 \$949 pfet L=0.5U W=5U AS=2.1P AD=2.1P PS=10.84U
+ PD=10.84U
* device instance $281 r0 *1 75.49,19.06 pfet
M$281 \$878 \$684 \$877 \$949 pfet L=0.5U W=5U AS=2.1P AD=2.1P PS=10.84U
+ PD=10.84U
* device instance $282 r0 *1 77.23,19.06 pfet
M$282 \$880 \$687 \$879 \$949 pfet L=0.5U W=5U AS=2.1P AD=2.1P PS=10.84U
+ PD=10.84U
* device instance $283 r0 *1 78.97,19.06 pfet
M$283 \$882 \$690 \$881 \$949 pfet L=0.5U W=5U AS=2.1P AD=2.1P PS=10.84U
+ PD=10.84U
* device instance $284 r0 *1 80.71,19.06 pfet
M$284 \$884 \$693 \$883 \$949 pfet L=0.5U W=5U AS=2.1P AD=2.1P PS=10.84U
+ PD=10.84U
* device instance $285 r0 *1 82.45,19.06 pfet
M$285 \$886 \$696 \$885 \$949 pfet L=0.5U W=5U AS=2.1P AD=2.1P PS=10.84U
+ PD=10.84U
* device instance $286 r0 *1 84.19,19.06 pfet
M$286 \$888 \$699 \$887 \$949 pfet L=0.5U W=5U AS=2.1P AD=2.1P PS=10.84U
+ PD=10.84U
* device instance $287 r0 *1 85.93,19.06 pfet
M$287 \$890 \$702 \$889 \$949 pfet L=0.5U W=5U AS=2.1P AD=2.1P PS=10.84U
+ PD=10.84U
* device instance $288 r0 *1 87.67,19.06 pfet
M$288 \$892 \$705 \$891 \$949 pfet L=0.5U W=5U AS=2.1P AD=2.1P PS=10.84U
+ PD=10.84U
* device instance $289 r0 *1 89.41,19.06 pfet
M$289 \$894 \$708 \$893 \$949 pfet L=0.5U W=5U AS=2.1P AD=2.1P PS=10.84U
+ PD=10.84U
* device instance $290 r0 *1 91.15,19.06 pfet
M$290 \$896 \$711 \$895 \$949 pfet L=0.5U W=5U AS=2.1P AD=2.1P PS=10.84U
+ PD=10.84U
* device instance $291 r0 *1 92.89,19.06 pfet
M$291 \$898 \$714 \$897 \$949 pfet L=0.5U W=5U AS=2.1P AD=2.1P PS=10.84U
+ PD=10.84U
* device instance $292 r0 *1 94.63,19.06 pfet
M$292 \$900 \$717 \$899 \$949 pfet L=0.5U W=5U AS=2.1P AD=2.1P PS=10.84U
+ PD=10.84U
* device instance $293 r0 *1 96.37,19.06 pfet
M$293 \$902 \$720 \$901 \$949 pfet L=0.5U W=5U AS=2.1P AD=2.1P PS=10.84U
+ PD=10.84U
* device instance $294 r0 *1 98.11,19.06 pfet
M$294 \$904 \$723 \$903 \$949 pfet L=0.5U W=5U AS=2.1P AD=2.1P PS=10.84U
+ PD=10.84U
* device instance $295 r0 *1 99.85,19.06 pfet
M$295 \$906 \$726 \$905 \$949 pfet L=0.5U W=5U AS=2.1P AD=2.1P PS=10.84U
+ PD=10.84U
* device instance $296 r0 *1 101.59,19.06 pfet
M$296 \$908 \$729 \$907 \$949 pfet L=0.5U W=5U AS=2.1P AD=2.1P PS=10.84U
+ PD=10.84U
* device instance $297 r0 *1 103.33,19.06 pfet
M$297 \$910 \$732 \$909 \$949 pfet L=0.5U W=5U AS=2.1P AD=2.1P PS=10.84U
+ PD=10.84U
* device instance $298 r0 *1 105.07,19.06 pfet
M$298 \$912 \$735 \$911 \$949 pfet L=0.5U W=5U AS=2.1P AD=2.1P PS=10.84U
+ PD=10.84U
* device instance $299 r0 *1 106.81,19.06 pfet
M$299 \$914 \$738 \$913 \$949 pfet L=0.5U W=5U AS=2.1P AD=2.1P PS=10.84U
+ PD=10.84U
* device instance $300 r0 *1 108.55,19.06 pfet
M$300 \$916 \$741 \$915 \$949 pfet L=0.5U W=5U AS=2.1P AD=2.1P PS=10.84U
+ PD=10.84U
* device instance $301 r0 *1 110.29,19.06 pfet
M$301 \$918 \$744 \$917 \$949 pfet L=0.5U W=5U AS=2.1P AD=2.1P PS=10.84U
+ PD=10.84U
* device instance $302 r0 *1 112.03,19.06 pfet
M$302 \$920 \$747 \$919 \$949 pfet L=0.5U W=5U AS=2.1P AD=2.1P PS=10.84U
+ PD=10.84U
* device instance $303 r0 *1 113.77,19.06 pfet
M$303 \$922 \$750 \$921 \$949 pfet L=0.5U W=5U AS=2.1P AD=2.1P PS=10.84U
+ PD=10.84U
* device instance $304 r0 *1 115.51,19.06 pfet
M$304 \$924 \$753 \$923 \$949 pfet L=0.5U W=5U AS=2.1P AD=2.1P PS=10.84U
+ PD=10.84U
* device instance $305 r0 *1 117.25,19.06 pfet
M$305 \$926 \$756 \$925 \$949 pfet L=0.5U W=5U AS=2.1P AD=2.1P PS=10.84U
+ PD=10.84U
* device instance $306 r0 *1 118.99,19.06 pfet
M$306 \$928 \$759 \$927 \$949 pfet L=0.5U W=5U AS=2.1P AD=2.1P PS=10.84U
+ PD=10.84U
* device instance $307 r0 *1 120.73,19.06 pfet
M$307 \$930 \$762 \$929 \$949 pfet L=0.5U W=5U AS=2.1P AD=2.1P PS=10.84U
+ PD=10.84U
* device instance $308 r0 *1 122.47,19.06 pfet
M$308 \$932 \$765 \$931 \$949 pfet L=0.5U W=5U AS=2.1P AD=2.1P PS=10.84U
+ PD=10.84U
* device instance $309 r0 *1 124.21,19.06 pfet
M$309 \$934 \$768 \$933 \$949 pfet L=0.5U W=5U AS=2.1P AD=2.1P PS=10.84U
+ PD=10.84U
* device instance $310 r0 *1 125.95,19.06 pfet
M$310 \$936 \$771 \$935 \$949 pfet L=0.5U W=5U AS=2.1P AD=2.1P PS=10.84U
+ PD=10.84U
* device instance $311 r0 *1 127.69,19.06 pfet
M$311 \$938 \$774 \$937 \$949 pfet L=0.5U W=5U AS=2.1P AD=2.1P PS=10.84U
+ PD=10.84U
* device instance $312 r0 *1 129.43,19.06 pfet
M$312 \$940 \$777 \$939 \$949 pfet L=0.5U W=5U AS=2.1P AD=2.1P PS=10.84U
+ PD=10.84U
* device instance $313 r0 *1 131.17,19.06 pfet
M$313 \$942 \$780 \$941 \$949 pfet L=0.5U W=5U AS=2.1P AD=2.1P PS=10.84U
+ PD=10.84U
* device instance $314 r0 *1 132.91,19.06 pfet
M$314 \$944 \$783 \$943 \$949 pfet L=0.5U W=5U AS=2.1P AD=2.1P PS=10.84U
+ PD=10.84U
* device instance $315 r0 *1 134.65,19.06 pfet
M$315 \$946 \$786 \$945 \$949 pfet L=0.5U W=5U AS=2.1P AD=2.1P PS=10.84U
+ PD=10.84U
* device instance $316 r0 *1 136.39,19.06 pfet
M$316 \$948 \$789 \$947 \$949 pfet L=0.5U W=5U AS=2.1P AD=2.1P PS=10.84U
+ PD=10.84U
.ENDS pll_divider_chain
