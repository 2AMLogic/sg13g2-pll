* extracted by klt extract --deck sg13cmos5l

* cell lock_detector_pfet_w5_l0p5
* pin VDD
.SUBCKT lock_detector_pfet_w5_l0p5 VDD
* device instance $1 r0 *1 3.8,3.11 pfet
X$1 \$38 \$2 \$3 VDD sg13_hv_pmos L=0.5U W=5U AS=2P AD=2P PS=10.8U PD=10.8U
* device instance $2 r0 *1 10.76,3.11 pfet
X$2 \$39 \$4 \$5 VDD sg13_hv_pmos L=0.5U W=5U AS=2P AD=2P PS=10.8U PD=10.8U
* device instance $3 r0 *1 17.72,3.11 pfet
X$3 \$40 \$6 \$7 VDD sg13_hv_pmos L=0.5U W=5U AS=2P AD=2P PS=10.8U PD=10.8U
* device instance $4 r0 *1 24.68,3.11 pfet
X$4 \$41 \$8 \$9 VDD sg13_hv_pmos L=0.5U W=5U AS=2P AD=2P PS=10.8U PD=10.8U
* device instance $5 r0 *1 31.64,3.11 pfet
X$5 \$42 \$10 \$11 VDD sg13_hv_pmos L=0.5U W=5U AS=2P AD=2P PS=10.8U PD=10.8U
* device instance $6 r0 *1 38.6,3.11 pfet
X$6 \$43 \$12 \$13 VDD sg13_hv_pmos L=0.5U W=5U AS=2P AD=2P PS=10.8U PD=10.8U
* device instance $7 r0 *1 45.56,3.11 pfet
X$7 \$44 \$14 \$15 VDD sg13_hv_pmos L=0.5U W=5U AS=2P AD=2P PS=10.8U PD=10.8U
* device instance $8 r0 *1 52.52,3.11 pfet
X$8 \$45 \$16 \$17 VDD sg13_hv_pmos L=0.5U W=5U AS=2P AD=2P PS=10.8U PD=10.8U
* device instance $9 r0 *1 59.48,3.11 pfet
X$9 \$46 \$18 \$19 VDD sg13_hv_pmos L=0.5U W=5U AS=2P AD=2P PS=10.8U PD=10.8U
* device instance $10 r0 *1 66.44,3.11 pfet
X$10 \$47 \$20 \$21 VDD sg13_hv_pmos L=0.5U W=5U AS=2P AD=2P PS=10.8U PD=10.8U
* device instance $11 r0 *1 73.4,3.11 pfet
X$11 \$48 \$22 \$23 VDD sg13_hv_pmos L=0.5U W=5U AS=2P AD=2P PS=10.8U PD=10.8U
* device instance $12 r0 *1 80.36,3.11 pfet
X$12 \$49 \$24 \$25 VDD sg13_hv_pmos L=0.5U W=5U AS=2P AD=2P PS=10.8U PD=10.8U
* device instance $13 r0 *1 87.32,3.11 pfet
X$13 \$50 \$26 \$27 VDD sg13_hv_pmos L=0.5U W=5U AS=2P AD=2P PS=10.8U PD=10.8U
* device instance $14 r0 *1 94.28,3.11 pfet
X$14 \$51 \$28 \$29 VDD sg13_hv_pmos L=0.5U W=5U AS=2P AD=2P PS=10.8U PD=10.8U
* device instance $15 r0 *1 101.24,3.11 pfet
X$15 \$52 \$30 \$31 VDD sg13_hv_pmos L=0.5U W=5U AS=2P AD=2P PS=10.8U PD=10.8U
* device instance $16 r0 *1 108.2,3.11 pfet
X$16 \$53 \$32 \$33 VDD sg13_hv_pmos L=0.5U W=5U AS=2P AD=2P PS=10.8U PD=10.8U
* device instance $17 r0 *1 115.16,3.11 pfet
X$17 \$54 \$34 \$35 VDD sg13_hv_pmos L=0.5U W=5U AS=2P AD=2P PS=10.8U PD=10.8U
* device instance $18 r0 *1 122.12,3.11 pfet
X$18 \$55 \$36 \$37 VDD sg13_hv_pmos L=0.5U W=5U AS=2P AD=2P PS=10.8U PD=10.8U
.ENDS lock_detector_pfet_w5_l0p5
