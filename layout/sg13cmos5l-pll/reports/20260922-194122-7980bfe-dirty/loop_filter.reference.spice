* sg13g2-pll :: loop_filter (SG13CMOS5L) -- generated by design/sg13cmos5l/netlist.sh from loop_filter.sch
* xschem XSCHEM V3.4.7; do not edit by hand.
** sch_path: design/sg13cmos5l/loop_filter.sch
.subckt loop_filter VCTRL VSS
*.iopin VCTRL
*.iopin VSS
R1 VCTRL NZ sub! 351000 rppd L=810U W=0.6U A=486 P=1621.2
XC1 NZ VSS cap_cmomi PARAMS: W=40 L=40
XC2 VCTRL VSS cap_cmomi PARAMS: W=10 L=10
.ends
