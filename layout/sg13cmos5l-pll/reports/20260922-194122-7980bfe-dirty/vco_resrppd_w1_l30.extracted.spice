* extracted by klt extract --deck sg13cmos5l

* cell vco_resrppd_w1_l30
* pin vsubs
.SUBCKT vco_resrppd_w1_l30 vsubs
* device instance $1 r0 *1 15.5,0.7 rppd
R$1 \$1 \$2 vsubs 7800 rppd L=30U W=1U
* device instance $2 r0 *1 16.1,2.7 rppd
R$2 \$3 \$4 vsubs 7800 rppd L=30U W=1U
.ENDS vco_resrppd_w1_l30
