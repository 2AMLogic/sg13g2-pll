* sg13g2-pll :: lock_detector (SG13CMOS5L) -- generated by design/sg13cmos5l/netlist.sh from lock_detector.sch
* xschem XSCHEM V3.4.7; do not edit by hand.
** sch_path: design/sg13cmos5l/lock_detector.sch
.subckt lock_detector UP DN LOCK VDD VSS
*.ipin UP
*.ipin DN
*.opin LOCK
*.iopin VDD
*.iopin VSS
XXOR UP DN ERR VDD VSS xor2_hv
XDW ERR ERRD VDD VSS delaywin_hv
XNW ERR ERRD nwide VDD VSS nand2_hv
XIW nwide WIDE VDD VSS inv_hv
RPU VDD VWIN sub! 1.904e+06 rhigh L=700U W=0.5U A=350 P=1401
MPD VWIN WIDE VSS VSS nfet L=16U W=0.25U
XCW VWIN VSS cap_cmomi PARAMS: W=40 L=40
XSCH VWIN LOCK VDD VSS schmitt_hv
.ends

* expanding   symbol:  xor2_hv.sym # of pins=5
** sym_path: design/sg13cmos5l/xor2_hv.sym
** sch_path: design/sg13cmos5l/xor2_hv.sch
.subckt xor2_hv A B Y VDD VSS
*.ipin A
*.ipin B
*.opin Y
*.iopin VDD
*.iopin VSS
XN1 A B n1 VDD VSS nand2_hv
XN2 A n1 n2 VDD VSS nand2_hv
XN3 B n1 n3 VDD VSS nand2_hv
XN4 n2 n3 Y VDD VSS nand2_hv
.ends

* expanding   symbol:  delaywin_hv.sym # of pins=4
** sym_path: design/sg13cmos5l/delaywin_hv.sym
** sch_path: design/sg13cmos5l/delaywin_hv.sch
.subckt delaywin_hv IN OUT VDD VSS
*.ipin IN
*.opin OUT
*.iopin VDD
*.iopin VSS
XI1 IN d1 VDD VSS inv_hv
XI2 d1 d2 VDD VSS inv_hv
XI3 d2 d3 VDD VSS inv_hv
XI4 d3 OUT VDD VSS inv_hv
XC1__0 OUT VSS cap_cmomi PARAMS: W=40 L=40
XC1__1 OUT VSS cap_cmomi PARAMS: W=40 L=40
.ends

* expanding   symbol:  nand2_hv.sym # of pins=5
** sym_path: design/sg13cmos5l/nand2_hv.sym
** sch_path: design/sg13cmos5l/nand2_hv.sch
.subckt nand2_hv A1 A2 Y VDD VSS
*.opin Y
*.ipin A1
*.ipin A2
*.iopin VDD
*.iopin VSS
MP1 Y A1 VDD VDD pfet L=0.5U W=5U
MP2 Y A2 VDD VDD pfet L=0.5U W=5U
MN1 Y A1 mid1 VSS nfet L=0.5U W=2U
MN2 mid1 A2 VSS VSS nfet L=0.5U W=2U
.ends

* expanding   symbol:  inv_hv.sym # of pins=4
** sym_path: design/sg13cmos5l/inv_hv.sym
** sch_path: design/sg13cmos5l/inv_hv.sch
.subckt inv_hv A Y VDD VSS
*.ipin A
*.opin Y
*.iopin VDD
*.iopin VSS
MP Y A VDD VDD pfet L=0.5U W=5U
MN Y A VSS VSS nfet L=0.5U W=2U
.ends

* expanding   symbol:  schmitt_hv.sym # of pins=4
** sym_path: design/sg13cmos5l/schmitt_hv.sym
** sch_path: design/sg13cmos5l/schmitt_hv.sch
.subckt schmitt_hv IN OUT VDD VSS
*.ipin IN
*.opin OUT
*.iopin VDD
*.iopin VSS
MP1 np IN VDD VDD pfet L=2U W=5U
MP2 OUT IN np VDD pfet L=2U W=5U
MP3 VSS OUT np VDD pfet L=2U W=5U
MN1 OUT IN nn VSS nfet L=2U W=2U
MN2 nn IN VSS VSS nfet L=2U W=2U
MN3 VDD OUT nn VSS nfet L=2U W=2U
.ends
