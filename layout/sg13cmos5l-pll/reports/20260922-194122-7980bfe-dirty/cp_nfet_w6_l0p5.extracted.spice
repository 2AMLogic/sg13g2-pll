* extracted by klt extract --deck sg13cmos5l

* cell cp_nfet_w6_l0p5
* pin vsubs
.SUBCKT cp_nfet_w6_l0p5 vsubs
* device instance $1 r0 *1 4.3,3.11 nfet
X$1 \$2 \$1 \$3 vsubs sg13_hv_nmos L=0.5U W=6U AS=2.4P AD=2.4P PS=12.8U PD=12.8U
.ENDS cp_nfet_w6_l0p5
