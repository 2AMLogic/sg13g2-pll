* extracted by klt extract --deck sg13cmos5l

* cell cp_pfet_w6_l3
* pin VDD
.SUBCKT cp_pfet_w6_l3 VDD
* device instance $1 r0 *1 4.3,4.36 pfet
X$1 \$2 \$1 \$3 VDD sg13_hv_pmos L=3U W=6U AS=2.4P AD=2.4P PS=12.8U PD=12.8U
.ENDS cp_pfet_w6_l3
