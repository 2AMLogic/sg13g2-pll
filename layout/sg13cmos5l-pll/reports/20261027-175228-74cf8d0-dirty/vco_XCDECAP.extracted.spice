* extracted by klt extract --deck sg13cmos5l

* cell vco_XCDECAP
.SUBCKT vco_XCDECAP
* device instance $1 r0 *1 0,0 cap_cmomi
X$1 \$1 \$2 cap_cmomi W=70U L=70U MMIN=1 MMAX=4 FEED=double
.ENDS vco_XCDECAP
