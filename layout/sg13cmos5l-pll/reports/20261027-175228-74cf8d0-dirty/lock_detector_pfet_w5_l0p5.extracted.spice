* extracted by klt extract --deck sg13cmos5l

* cell lock_detector_pfet_w5_l0p5
* pin VDD
.SUBCKT lock_detector_pfet_w5_l0p5 VDD
* device instance $1 r0 *1 3.8,3.11 pfet
X$1 \$32 \$2 \$3 VDD sg13_hv_pmos L=0.5U W=5U AS=2P AD=2P PS=10.8U PD=10.8U
* device instance $2 r0 *1 10.76,3.11 pfet
X$2 \$33 \$4 \$5 VDD sg13_hv_pmos L=0.5U W=5U AS=2P AD=2P PS=10.8U PD=10.8U
* device instance $3 r0 *1 17.72,3.11 pfet
X$3 \$34 \$6 \$7 VDD sg13_hv_pmos L=0.5U W=5U AS=2P AD=2P PS=10.8U PD=10.8U
* device instance $4 r0 *1 24.68,3.11 pfet
X$4 \$35 \$8 \$9 VDD sg13_hv_pmos L=0.5U W=5U AS=2P AD=2P PS=10.8U PD=10.8U
* device instance $5 r0 *1 31.64,3.11 pfet
X$5 \$36 \$10 \$11 VDD sg13_hv_pmos L=0.5U W=5U AS=2P AD=2P PS=10.8U PD=10.8U
* device instance $6 r0 *1 38.6,3.11 pfet
X$6 \$37 \$12 \$13 VDD sg13_hv_pmos L=0.5U W=5U AS=2P AD=2P PS=10.8U PD=10.8U
* device instance $7 r0 *1 45.56,3.11 pfet
X$7 \$38 \$14 \$15 VDD sg13_hv_pmos L=0.5U W=5U AS=2P AD=2P PS=10.8U PD=10.8U
* device instance $8 r0 *1 52.52,3.11 pfet
X$8 \$39 \$16 \$17 VDD sg13_hv_pmos L=0.5U W=5U AS=2P AD=2P PS=10.8U PD=10.8U
* device instance $9 r0 *1 59.48,3.11 pfet
X$9 \$40 \$18 \$19 VDD sg13_hv_pmos L=0.5U W=5U AS=2P AD=2P PS=10.8U PD=10.8U
* device instance $10 r0 *1 66.44,3.11 pfet
X$10 \$41 \$20 \$21 VDD sg13_hv_pmos L=0.5U W=5U AS=2P AD=2P PS=10.8U PD=10.8U
* device instance $11 r0 *1 73.4,3.11 pfet
X$11 \$42 \$22 \$23 VDD sg13_hv_pmos L=0.5U W=5U AS=2P AD=2P PS=10.8U PD=10.8U
* device instance $12 r0 *1 80.36,3.11 pfet
X$12 \$43 \$24 \$25 VDD sg13_hv_pmos L=0.5U W=5U AS=2P AD=2P PS=10.8U PD=10.8U
* device instance $13 r0 *1 87.32,3.11 pfet
X$13 \$44 \$26 \$27 VDD sg13_hv_pmos L=0.5U W=5U AS=2P AD=2P PS=10.8U PD=10.8U
* device instance $14 r0 *1 94.28,3.11 pfet
X$14 \$45 \$28 \$29 VDD sg13_hv_pmos L=0.5U W=5U AS=2P AD=2P PS=10.8U PD=10.8U
* device instance $15 r0 *1 101.24,3.11 pfet
X$15 \$46 \$30 \$31 VDD sg13_hv_pmos L=0.5U W=5U AS=2P AD=2P PS=10.8U PD=10.8U
.ENDS lock_detector_pfet_w5_l0p5
