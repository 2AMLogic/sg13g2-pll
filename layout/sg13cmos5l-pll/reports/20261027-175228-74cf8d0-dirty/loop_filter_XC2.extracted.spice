* extracted by klt extract --deck sg13cmos5l

* cell loop_filter_XC2
.SUBCKT loop_filter_XC2
* device instance $1 r0 *1 0,0 cap_cmomi
X$1 \$1 \$2 cap_cmomi W=10U L=10U MMIN=1 MMAX=4 FEED=double
.ENDS loop_filter_XC2
