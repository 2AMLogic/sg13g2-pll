* extracted by klt extract --deck sg13cmos5l

* cell divider_chain_nfet_w2_l0p5
* pin vsubs
.SUBCKT divider_chain_nfet_w2_l0p5 vsubs
* device instance $1 r0 *1 2.3,3.11 nfet
X$1 \$396 \$2 \$3 vsubs sg13_hv_nmos L=0.5U W=2U AS=0.8P AD=0.8P PS=4.8U PD=4.8U
* device instance $2 r0 *1 6.26,3.11 nfet
X$2 \$397 \$4 \$5 vsubs sg13_hv_nmos L=0.5U W=2U AS=0.8P AD=0.8P PS=4.8U PD=4.8U
* device instance $3 r0 *1 10.22,3.11 nfet
X$3 \$398 \$6 \$7 vsubs sg13_hv_nmos L=0.5U W=2U AS=0.8P AD=0.8P PS=4.8U PD=4.8U
* device instance $4 r0 *1 14.18,3.11 nfet
X$4 \$399 \$8 \$9 vsubs sg13_hv_nmos L=0.5U W=2U AS=0.8P AD=0.8P PS=4.8U PD=4.8U
* device instance $5 r0 *1 18.14,3.11 nfet
X$5 \$400 \$10 \$11 vsubs sg13_hv_nmos L=0.5U W=2U AS=0.8P AD=0.8P PS=4.8U
+ PD=4.8U
* device instance $6 r0 *1 22.1,3.11 nfet
X$6 \$401 \$12 \$13 vsubs sg13_hv_nmos L=0.5U W=2U AS=0.8P AD=0.8P PS=4.8U
+ PD=4.8U
* device instance $7 r0 *1 26.06,3.11 nfet
X$7 \$402 \$14 \$15 vsubs sg13_hv_nmos L=0.5U W=2U AS=0.8P AD=0.8P PS=4.8U
+ PD=4.8U
* device instance $8 r0 *1 30.02,3.11 nfet
X$8 \$403 \$16 \$17 vsubs sg13_hv_nmos L=0.5U W=2U AS=0.8P AD=0.8P PS=4.8U
+ PD=4.8U
* device instance $9 r0 *1 33.98,3.11 nfet
X$9 \$404 \$18 \$19 vsubs sg13_hv_nmos L=0.5U W=2U AS=0.8P AD=0.8P PS=4.8U
+ PD=4.8U
* device instance $10 r0 *1 37.94,3.11 nfet
X$10 \$405 \$20 \$21 vsubs sg13_hv_nmos L=0.5U W=2U AS=0.8P AD=0.8P PS=4.8U
+ PD=4.8U
* device instance $11 r0 *1 41.9,3.11 nfet
X$11 \$406 \$22 \$23 vsubs sg13_hv_nmos L=0.5U W=2U AS=0.8P AD=0.8P PS=4.8U
+ PD=4.8U
* device instance $12 r0 *1 45.86,3.11 nfet
X$12 \$407 \$24 \$25 vsubs sg13_hv_nmos L=0.5U W=2U AS=0.8P AD=0.8P PS=4.8U
+ PD=4.8U
* device instance $13 r0 *1 49.82,3.11 nfet
X$13 \$408 \$26 \$27 vsubs sg13_hv_nmos L=0.5U W=2U AS=0.8P AD=0.8P PS=4.8U
+ PD=4.8U
* device instance $14 r0 *1 53.78,3.11 nfet
X$14 \$409 \$28 \$29 vsubs sg13_hv_nmos L=0.5U W=2U AS=0.8P AD=0.8P PS=4.8U
+ PD=4.8U
* device instance $15 r0 *1 57.74,3.11 nfet
X$15 \$410 \$30 \$31 vsubs sg13_hv_nmos L=0.5U W=2U AS=0.8P AD=0.8P PS=4.8U
+ PD=4.8U
* device instance $16 r0 *1 61.7,3.11 nfet
X$16 \$411 \$32 \$33 vsubs sg13_hv_nmos L=0.5U W=2U AS=0.8P AD=0.8P PS=4.8U
+ PD=4.8U
* device instance $17 r0 *1 65.66,3.11 nfet
X$17 \$412 \$34 \$35 vsubs sg13_hv_nmos L=0.5U W=2U AS=0.8P AD=0.8P PS=4.8U
+ PD=4.8U
* device instance $18 r0 *1 69.62,3.11 nfet
X$18 \$413 \$36 \$37 vsubs sg13_hv_nmos L=0.5U W=2U AS=0.8P AD=0.8P PS=4.8U
+ PD=4.8U
* device instance $19 r0 *1 73.58,3.11 nfet
X$19 \$414 \$38 \$39 vsubs sg13_hv_nmos L=0.5U W=2U AS=0.8P AD=0.8P PS=4.8U
+ PD=4.8U
* device instance $20 r0 *1 77.54,3.11 nfet
X$20 \$415 \$40 \$41 vsubs sg13_hv_nmos L=0.5U W=2U AS=0.8P AD=0.8P PS=4.8U
+ PD=4.8U
* device instance $21 r0 *1 81.5,3.11 nfet
X$21 \$416 \$42 \$43 vsubs sg13_hv_nmos L=0.5U W=2U AS=0.8P AD=0.8P PS=4.8U
+ PD=4.8U
* device instance $22 r0 *1 85.46,3.11 nfet
X$22 \$417 \$44 \$45 vsubs sg13_hv_nmos L=0.5U W=2U AS=0.8P AD=0.8P PS=4.8U
+ PD=4.8U
* device instance $23 r0 *1 89.42,3.11 nfet
X$23 \$418 \$46 \$47 vsubs sg13_hv_nmos L=0.5U W=2U AS=0.8P AD=0.8P PS=4.8U
+ PD=4.8U
* device instance $24 r0 *1 93.38,3.11 nfet
X$24 \$419 \$48 \$49 vsubs sg13_hv_nmos L=0.5U W=2U AS=0.8P AD=0.8P PS=4.8U
+ PD=4.8U
* device instance $25 r0 *1 97.34,3.11 nfet
X$25 \$420 \$50 \$51 vsubs sg13_hv_nmos L=0.5U W=2U AS=0.8P AD=0.8P PS=4.8U
+ PD=4.8U
* device instance $26 r0 *1 101.3,3.11 nfet
X$26 \$421 \$52 \$53 vsubs sg13_hv_nmos L=0.5U W=2U AS=0.8P AD=0.8P PS=4.8U
+ PD=4.8U
* device instance $27 r0 *1 105.26,3.11 nfet
X$27 \$422 \$54 \$55 vsubs sg13_hv_nmos L=0.5U W=2U AS=0.8P AD=0.8P PS=4.8U
+ PD=4.8U
* device instance $28 r0 *1 109.22,3.11 nfet
X$28 \$423 \$56 \$57 vsubs sg13_hv_nmos L=0.5U W=2U AS=0.8P AD=0.8P PS=4.8U
+ PD=4.8U
* device instance $29 r0 *1 113.18,3.11 nfet
X$29 \$424 \$58 \$59 vsubs sg13_hv_nmos L=0.5U W=2U AS=0.8P AD=0.8P PS=4.8U
+ PD=4.8U
* device instance $30 r0 *1 117.14,3.11 nfet
X$30 \$425 \$60 \$61 vsubs sg13_hv_nmos L=0.5U W=2U AS=0.8P AD=0.8P PS=4.8U
+ PD=4.8U
* device instance $31 r0 *1 121.1,3.11 nfet
X$31 \$426 \$62 \$63 vsubs sg13_hv_nmos L=0.5U W=2U AS=0.8P AD=0.8P PS=4.8U
+ PD=4.8U
* device instance $32 r0 *1 125.06,3.11 nfet
X$32 \$427 \$64 \$65 vsubs sg13_hv_nmos L=0.5U W=2U AS=0.8P AD=0.8P PS=4.8U
+ PD=4.8U
* device instance $33 r0 *1 129.02,3.11 nfet
X$33 \$428 \$66 \$67 vsubs sg13_hv_nmos L=0.5U W=2U AS=0.8P AD=0.8P PS=4.8U
+ PD=4.8U
* device instance $34 r0 *1 132.98,3.11 nfet
X$34 \$429 \$68 \$69 vsubs sg13_hv_nmos L=0.5U W=2U AS=0.8P AD=0.8P PS=4.8U
+ PD=4.8U
* device instance $35 r0 *1 136.94,3.11 nfet
X$35 \$430 \$70 \$71 vsubs sg13_hv_nmos L=0.5U W=2U AS=0.8P AD=0.8P PS=4.8U
+ PD=4.8U
* device instance $36 r0 *1 140.9,3.11 nfet
X$36 \$431 \$72 \$73 vsubs sg13_hv_nmos L=0.5U W=2U AS=0.8P AD=0.8P PS=4.8U
+ PD=4.8U
* device instance $37 r0 *1 144.86,3.11 nfet
X$37 \$432 \$74 \$75 vsubs sg13_hv_nmos L=0.5U W=2U AS=0.8P AD=0.8P PS=4.8U
+ PD=4.8U
* device instance $38 r0 *1 148.82,3.11 nfet
X$38 \$433 \$76 \$77 vsubs sg13_hv_nmos L=0.5U W=2U AS=0.8P AD=0.8P PS=4.8U
+ PD=4.8U
* device instance $39 r0 *1 152.78,3.11 nfet
X$39 \$434 \$78 \$79 vsubs sg13_hv_nmos L=0.5U W=2U AS=0.8P AD=0.8P PS=4.8U
+ PD=4.8U
* device instance $40 r0 *1 156.74,3.11 nfet
X$40 \$435 \$80 \$81 vsubs sg13_hv_nmos L=0.5U W=2U AS=0.8P AD=0.8P PS=4.8U
+ PD=4.8U
* device instance $41 r0 *1 160.7,3.11 nfet
X$41 \$436 \$82 \$83 vsubs sg13_hv_nmos L=0.5U W=2U AS=0.8P AD=0.8P PS=4.8U
+ PD=4.8U
* device instance $42 r0 *1 164.66,3.11 nfet
X$42 \$437 \$84 \$85 vsubs sg13_hv_nmos L=0.5U W=2U AS=0.8P AD=0.8P PS=4.8U
+ PD=4.8U
* device instance $43 r0 *1 168.62,3.11 nfet
X$43 \$438 \$86 \$87 vsubs sg13_hv_nmos L=0.5U W=2U AS=0.8P AD=0.8P PS=4.8U
+ PD=4.8U
* device instance $44 r0 *1 172.58,3.11 nfet
X$44 \$439 \$88 \$89 vsubs sg13_hv_nmos L=0.5U W=2U AS=0.8P AD=0.8P PS=4.8U
+ PD=4.8U
* device instance $45 r0 *1 176.54,3.11 nfet
X$45 \$440 \$90 \$91 vsubs sg13_hv_nmos L=0.5U W=2U AS=0.8P AD=0.8P PS=4.8U
+ PD=4.8U
* device instance $46 r0 *1 180.5,3.11 nfet
X$46 \$441 \$92 \$93 vsubs sg13_hv_nmos L=0.5U W=2U AS=0.8P AD=0.8P PS=4.8U
+ PD=4.8U
* device instance $47 r0 *1 184.46,3.11 nfet
X$47 \$442 \$94 \$95 vsubs sg13_hv_nmos L=0.5U W=2U AS=0.8P AD=0.8P PS=4.8U
+ PD=4.8U
* device instance $48 r0 *1 188.42,3.11 nfet
X$48 \$443 \$96 \$97 vsubs sg13_hv_nmos L=0.5U W=2U AS=0.8P AD=0.8P PS=4.8U
+ PD=4.8U
* device instance $49 r0 *1 192.38,3.11 nfet
X$49 \$444 \$98 \$99 vsubs sg13_hv_nmos L=0.5U W=2U AS=0.8P AD=0.8P PS=4.8U
+ PD=4.8U
* device instance $50 r0 *1 196.34,3.11 nfet
X$50 \$445 \$100 \$101 vsubs sg13_hv_nmos L=0.5U W=2U AS=0.8P AD=0.8P PS=4.8U
+ PD=4.8U
* device instance $51 r0 *1 200.3,3.11 nfet
X$51 \$446 \$102 \$103 vsubs sg13_hv_nmos L=0.5U W=2U AS=0.8P AD=0.8P PS=4.8U
+ PD=4.8U
* device instance $52 r0 *1 204.26,3.11 nfet
X$52 \$447 \$104 \$105 vsubs sg13_hv_nmos L=0.5U W=2U AS=0.8P AD=0.8P PS=4.8U
+ PD=4.8U
* device instance $53 r0 *1 208.22,3.11 nfet
X$53 \$448 \$106 \$107 vsubs sg13_hv_nmos L=0.5U W=2U AS=0.8P AD=0.8P PS=4.8U
+ PD=4.8U
* device instance $54 r0 *1 212.18,3.11 nfet
X$54 \$449 \$108 \$109 vsubs sg13_hv_nmos L=0.5U W=2U AS=0.8P AD=0.8P PS=4.8U
+ PD=4.8U
* device instance $55 r0 *1 216.14,3.11 nfet
X$55 \$450 \$110 \$111 vsubs sg13_hv_nmos L=0.5U W=2U AS=0.8P AD=0.8P PS=4.8U
+ PD=4.8U
* device instance $56 r0 *1 220.1,3.11 nfet
X$56 \$451 \$112 \$113 vsubs sg13_hv_nmos L=0.5U W=2U AS=0.8P AD=0.8P PS=4.8U
+ PD=4.8U
* device instance $57 r0 *1 224.06,3.11 nfet
X$57 \$452 \$114 \$115 vsubs sg13_hv_nmos L=0.5U W=2U AS=0.8P AD=0.8P PS=4.8U
+ PD=4.8U
* device instance $58 r0 *1 228.02,3.11 nfet
X$58 \$453 \$116 \$117 vsubs sg13_hv_nmos L=0.5U W=2U AS=0.8P AD=0.8P PS=4.8U
+ PD=4.8U
* device instance $59 r0 *1 231.98,3.11 nfet
X$59 \$454 \$118 \$119 vsubs sg13_hv_nmos L=0.5U W=2U AS=0.8P AD=0.8P PS=4.8U
+ PD=4.8U
* device instance $60 r0 *1 235.94,3.11 nfet
X$60 \$455 \$120 \$121 vsubs sg13_hv_nmos L=0.5U W=2U AS=0.8P AD=0.8P PS=4.8U
+ PD=4.8U
* device instance $61 r0 *1 239.9,3.11 nfet
X$61 \$456 \$122 \$123 vsubs sg13_hv_nmos L=0.5U W=2U AS=0.8P AD=0.8P PS=4.8U
+ PD=4.8U
* device instance $62 r0 *1 243.86,3.11 nfet
X$62 \$457 \$124 \$125 vsubs sg13_hv_nmos L=0.5U W=2U AS=0.8P AD=0.8P PS=4.8U
+ PD=4.8U
* device instance $63 r0 *1 247.82,3.11 nfet
X$63 \$458 \$126 \$127 vsubs sg13_hv_nmos L=0.5U W=2U AS=0.8P AD=0.8P PS=4.8U
+ PD=4.8U
* device instance $64 r0 *1 251.78,3.11 nfet
X$64 \$459 \$128 \$129 vsubs sg13_hv_nmos L=0.5U W=2U AS=0.8P AD=0.8P PS=4.8U
+ PD=4.8U
* device instance $65 r0 *1 255.74,3.11 nfet
X$65 \$460 \$130 \$131 vsubs sg13_hv_nmos L=0.5U W=2U AS=0.8P AD=0.8P PS=4.8U
+ PD=4.8U
* device instance $66 r0 *1 259.7,3.11 nfet
X$66 \$461 \$132 \$133 vsubs sg13_hv_nmos L=0.5U W=2U AS=0.8P AD=0.8P PS=4.8U
+ PD=4.8U
* device instance $67 r0 *1 263.66,3.11 nfet
X$67 \$462 \$134 \$135 vsubs sg13_hv_nmos L=0.5U W=2U AS=0.8P AD=0.8P PS=4.8U
+ PD=4.8U
* device instance $68 r0 *1 267.62,3.11 nfet
X$68 \$463 \$136 \$137 vsubs sg13_hv_nmos L=0.5U W=2U AS=0.8P AD=0.8P PS=4.8U
+ PD=4.8U
* device instance $69 r0 *1 271.58,3.11 nfet
X$69 \$464 \$138 \$139 vsubs sg13_hv_nmos L=0.5U W=2U AS=0.8P AD=0.8P PS=4.8U
+ PD=4.8U
* device instance $70 r0 *1 275.54,3.11 nfet
X$70 \$465 \$140 \$141 vsubs sg13_hv_nmos L=0.5U W=2U AS=0.8P AD=0.8P PS=4.8U
+ PD=4.8U
* device instance $71 r0 *1 279.5,3.11 nfet
X$71 \$466 \$142 \$143 vsubs sg13_hv_nmos L=0.5U W=2U AS=0.8P AD=0.8P PS=4.8U
+ PD=4.8U
* device instance $72 r0 *1 283.46,3.11 nfet
X$72 \$467 \$144 \$145 vsubs sg13_hv_nmos L=0.5U W=2U AS=0.8P AD=0.8P PS=4.8U
+ PD=4.8U
* device instance $73 r0 *1 287.42,3.11 nfet
X$73 \$468 \$146 \$147 vsubs sg13_hv_nmos L=0.5U W=2U AS=0.8P AD=0.8P PS=4.8U
+ PD=4.8U
* device instance $74 r0 *1 291.38,3.11 nfet
X$74 \$469 \$148 \$149 vsubs sg13_hv_nmos L=0.5U W=2U AS=0.8P AD=0.8P PS=4.8U
+ PD=4.8U
* device instance $75 r0 *1 295.34,3.11 nfet
X$75 \$470 \$150 \$151 vsubs sg13_hv_nmos L=0.5U W=2U AS=0.8P AD=0.8P PS=4.8U
+ PD=4.8U
* device instance $76 r0 *1 299.3,3.11 nfet
X$76 \$471 \$152 \$153 vsubs sg13_hv_nmos L=0.5U W=2U AS=0.8P AD=0.8P PS=4.8U
+ PD=4.8U
* device instance $77 r0 *1 303.26,3.11 nfet
X$77 \$472 \$154 \$155 vsubs sg13_hv_nmos L=0.5U W=2U AS=0.8P AD=0.8P PS=4.8U
+ PD=4.8U
* device instance $78 r0 *1 307.22,3.11 nfet
X$78 \$473 \$156 \$157 vsubs sg13_hv_nmos L=0.5U W=2U AS=0.8P AD=0.8P PS=4.8U
+ PD=4.8U
* device instance $79 r0 *1 311.18,3.11 nfet
X$79 \$474 \$158 \$159 vsubs sg13_hv_nmos L=0.5U W=2U AS=0.8P AD=0.8P PS=4.8U
+ PD=4.8U
* device instance $80 r0 *1 315.14,3.11 nfet
X$80 \$475 \$160 \$161 vsubs sg13_hv_nmos L=0.5U W=2U AS=0.8P AD=0.8P PS=4.8U
+ PD=4.8U
* device instance $81 r0 *1 319.1,3.11 nfet
X$81 \$476 \$162 \$163 vsubs sg13_hv_nmos L=0.5U W=2U AS=0.8P AD=0.8P PS=4.8U
+ PD=4.8U
* device instance $82 r0 *1 323.06,3.11 nfet
X$82 \$477 \$164 \$165 vsubs sg13_hv_nmos L=0.5U W=2U AS=0.8P AD=0.8P PS=4.8U
+ PD=4.8U
* device instance $83 r0 *1 327.02,3.11 nfet
X$83 \$478 \$166 \$167 vsubs sg13_hv_nmos L=0.5U W=2U AS=0.8P AD=0.8P PS=4.8U
+ PD=4.8U
* device instance $84 r0 *1 330.98,3.11 nfet
X$84 \$479 \$168 \$169 vsubs sg13_hv_nmos L=0.5U W=2U AS=0.8P AD=0.8P PS=4.8U
+ PD=4.8U
* device instance $85 r0 *1 334.94,3.11 nfet
X$85 \$480 \$170 \$171 vsubs sg13_hv_nmos L=0.5U W=2U AS=0.8P AD=0.8P PS=4.8U
+ PD=4.8U
* device instance $86 r0 *1 338.9,3.11 nfet
X$86 \$481 \$172 \$173 vsubs sg13_hv_nmos L=0.5U W=2U AS=0.8P AD=0.8P PS=4.8U
+ PD=4.8U
* device instance $87 r0 *1 342.86,3.11 nfet
X$87 \$482 \$174 \$175 vsubs sg13_hv_nmos L=0.5U W=2U AS=0.8P AD=0.8P PS=4.8U
+ PD=4.8U
* device instance $88 r0 *1 346.82,3.11 nfet
X$88 \$483 \$176 \$177 vsubs sg13_hv_nmos L=0.5U W=2U AS=0.8P AD=0.8P PS=4.8U
+ PD=4.8U
* device instance $89 r0 *1 350.78,3.11 nfet
X$89 \$484 \$178 \$179 vsubs sg13_hv_nmos L=0.5U W=2U AS=0.8P AD=0.8P PS=4.8U
+ PD=4.8U
* device instance $90 r0 *1 354.74,3.11 nfet
X$90 \$485 \$180 \$181 vsubs sg13_hv_nmos L=0.5U W=2U AS=0.8P AD=0.8P PS=4.8U
+ PD=4.8U
* device instance $91 r0 *1 358.7,3.11 nfet
X$91 \$486 \$182 \$183 vsubs sg13_hv_nmos L=0.5U W=2U AS=0.8P AD=0.8P PS=4.8U
+ PD=4.8U
* device instance $92 r0 *1 362.66,3.11 nfet
X$92 \$487 \$184 \$185 vsubs sg13_hv_nmos L=0.5U W=2U AS=0.8P AD=0.8P PS=4.8U
+ PD=4.8U
* device instance $93 r0 *1 366.62,3.11 nfet
X$93 \$488 \$186 \$187 vsubs sg13_hv_nmos L=0.5U W=2U AS=0.8P AD=0.8P PS=4.8U
+ PD=4.8U
* device instance $94 r0 *1 370.58,3.11 nfet
X$94 \$489 \$188 \$189 vsubs sg13_hv_nmos L=0.5U W=2U AS=0.8P AD=0.8P PS=4.8U
+ PD=4.8U
* device instance $95 r0 *1 374.54,3.11 nfet
X$95 \$490 \$190 \$191 vsubs sg13_hv_nmos L=0.5U W=2U AS=0.8P AD=0.8P PS=4.8U
+ PD=4.8U
* device instance $96 r0 *1 378.5,3.11 nfet
X$96 \$491 \$192 \$193 vsubs sg13_hv_nmos L=0.5U W=2U AS=0.8P AD=0.8P PS=4.8U
+ PD=4.8U
* device instance $97 r0 *1 382.46,3.11 nfet
X$97 \$492 \$194 \$195 vsubs sg13_hv_nmos L=0.5U W=2U AS=0.8P AD=0.8P PS=4.8U
+ PD=4.8U
* device instance $98 r0 *1 386.42,3.11 nfet
X$98 \$493 \$196 \$197 vsubs sg13_hv_nmos L=0.5U W=2U AS=0.8P AD=0.8P PS=4.8U
+ PD=4.8U
* device instance $99 r0 *1 390.38,3.11 nfet
X$99 \$494 \$198 \$199 vsubs sg13_hv_nmos L=0.5U W=2U AS=0.8P AD=0.8P PS=4.8U
+ PD=4.8U
* device instance $100 r0 *1 394.34,3.11 nfet
X$100 \$495 \$200 \$201 vsubs sg13_hv_nmos L=0.5U W=2U AS=0.8P AD=0.8P PS=4.8U
+ PD=4.8U
* device instance $101 r0 *1 398.3,3.11 nfet
X$101 \$496 \$202 \$203 vsubs sg13_hv_nmos L=0.5U W=2U AS=0.8P AD=0.8P PS=4.8U
+ PD=4.8U
* device instance $102 r0 *1 402.26,3.11 nfet
X$102 \$497 \$204 \$205 vsubs sg13_hv_nmos L=0.5U W=2U AS=0.8P AD=0.8P PS=4.8U
+ PD=4.8U
* device instance $103 r0 *1 406.22,3.11 nfet
X$103 \$498 \$206 \$207 vsubs sg13_hv_nmos L=0.5U W=2U AS=0.8P AD=0.8P PS=4.8U
+ PD=4.8U
* device instance $104 r0 *1 410.18,3.11 nfet
X$104 \$499 \$208 \$209 vsubs sg13_hv_nmos L=0.5U W=2U AS=0.8P AD=0.8P PS=4.8U
+ PD=4.8U
* device instance $105 r0 *1 414.14,3.11 nfet
X$105 \$500 \$210 \$211 vsubs sg13_hv_nmos L=0.5U W=2U AS=0.8P AD=0.8P PS=4.8U
+ PD=4.8U
* device instance $106 r0 *1 418.1,3.11 nfet
X$106 \$501 \$212 \$213 vsubs sg13_hv_nmos L=0.5U W=2U AS=0.8P AD=0.8P PS=4.8U
+ PD=4.8U
* device instance $107 r0 *1 422.06,3.11 nfet
X$107 \$502 \$214 \$215 vsubs sg13_hv_nmos L=0.5U W=2U AS=0.8P AD=0.8P PS=4.8U
+ PD=4.8U
* device instance $108 r0 *1 426.02,3.11 nfet
X$108 \$503 \$216 \$217 vsubs sg13_hv_nmos L=0.5U W=2U AS=0.8P AD=0.8P PS=4.8U
+ PD=4.8U
* device instance $109 r0 *1 429.98,3.11 nfet
X$109 \$504 \$218 \$219 vsubs sg13_hv_nmos L=0.5U W=2U AS=0.8P AD=0.8P PS=4.8U
+ PD=4.8U
* device instance $110 r0 *1 433.94,3.11 nfet
X$110 \$505 \$220 \$221 vsubs sg13_hv_nmos L=0.5U W=2U AS=0.8P AD=0.8P PS=4.8U
+ PD=4.8U
* device instance $111 r0 *1 437.9,3.11 nfet
X$111 \$506 \$222 \$223 vsubs sg13_hv_nmos L=0.5U W=2U AS=0.8P AD=0.8P PS=4.8U
+ PD=4.8U
* device instance $112 r0 *1 441.86,3.11 nfet
X$112 \$507 \$224 \$225 vsubs sg13_hv_nmos L=0.5U W=2U AS=0.8P AD=0.8P PS=4.8U
+ PD=4.8U
* device instance $113 r0 *1 445.82,3.11 nfet
X$113 \$508 \$226 \$227 vsubs sg13_hv_nmos L=0.5U W=2U AS=0.8P AD=0.8P PS=4.8U
+ PD=4.8U
* device instance $114 r0 *1 449.78,3.11 nfet
X$114 \$509 \$228 \$229 vsubs sg13_hv_nmos L=0.5U W=2U AS=0.8P AD=0.8P PS=4.8U
+ PD=4.8U
* device instance $115 r0 *1 453.74,3.11 nfet
X$115 \$510 \$230 \$231 vsubs sg13_hv_nmos L=0.5U W=2U AS=0.8P AD=0.8P PS=4.8U
+ PD=4.8U
* device instance $116 r0 *1 457.7,3.11 nfet
X$116 \$511 \$232 \$233 vsubs sg13_hv_nmos L=0.5U W=2U AS=0.8P AD=0.8P PS=4.8U
+ PD=4.8U
* device instance $117 r0 *1 461.66,3.11 nfet
X$117 \$512 \$234 \$235 vsubs sg13_hv_nmos L=0.5U W=2U AS=0.8P AD=0.8P PS=4.8U
+ PD=4.8U
* device instance $118 r0 *1 465.62,3.11 nfet
X$118 \$513 \$236 \$237 vsubs sg13_hv_nmos L=0.5U W=2U AS=0.8P AD=0.8P PS=4.8U
+ PD=4.8U
* device instance $119 r0 *1 469.58,3.11 nfet
X$119 \$514 \$238 \$239 vsubs sg13_hv_nmos L=0.5U W=2U AS=0.8P AD=0.8P PS=4.8U
+ PD=4.8U
* device instance $120 r0 *1 473.54,3.11 nfet
X$120 \$515 \$240 \$241 vsubs sg13_hv_nmos L=0.5U W=2U AS=0.8P AD=0.8P PS=4.8U
+ PD=4.8U
* device instance $121 r0 *1 477.5,3.11 nfet
X$121 \$516 \$242 \$243 vsubs sg13_hv_nmos L=0.5U W=2U AS=0.8P AD=0.8P PS=4.8U
+ PD=4.8U
* device instance $122 r0 *1 481.46,3.11 nfet
X$122 \$517 \$244 \$245 vsubs sg13_hv_nmos L=0.5U W=2U AS=0.8P AD=0.8P PS=4.8U
+ PD=4.8U
* device instance $123 r0 *1 485.42,3.11 nfet
X$123 \$518 \$246 \$247 vsubs sg13_hv_nmos L=0.5U W=2U AS=0.8P AD=0.8P PS=4.8U
+ PD=4.8U
* device instance $124 r0 *1 489.38,3.11 nfet
X$124 \$519 \$248 \$249 vsubs sg13_hv_nmos L=0.5U W=2U AS=0.8P AD=0.8P PS=4.8U
+ PD=4.8U
* device instance $125 r0 *1 493.34,3.11 nfet
X$125 \$520 \$250 \$251 vsubs sg13_hv_nmos L=0.5U W=2U AS=0.8P AD=0.8P PS=4.8U
+ PD=4.8U
* device instance $126 r0 *1 497.3,3.11 nfet
X$126 \$521 \$252 \$253 vsubs sg13_hv_nmos L=0.5U W=2U AS=0.8P AD=0.8P PS=4.8U
+ PD=4.8U
* device instance $127 r0 *1 501.26,3.11 nfet
X$127 \$522 \$254 \$255 vsubs sg13_hv_nmos L=0.5U W=2U AS=0.8P AD=0.8P PS=4.8U
+ PD=4.8U
* device instance $128 r0 *1 505.22,3.11 nfet
X$128 \$523 \$256 \$257 vsubs sg13_hv_nmos L=0.5U W=2U AS=0.8P AD=0.8P PS=4.8U
+ PD=4.8U
* device instance $129 r0 *1 509.18,3.11 nfet
X$129 \$524 \$258 \$259 vsubs sg13_hv_nmos L=0.5U W=2U AS=0.8P AD=0.8P PS=4.8U
+ PD=4.8U
* device instance $130 r0 *1 513.14,3.11 nfet
X$130 \$525 \$260 \$261 vsubs sg13_hv_nmos L=0.5U W=2U AS=0.8P AD=0.8P PS=4.8U
+ PD=4.8U
* device instance $131 r0 *1 517.1,3.11 nfet
X$131 \$526 \$262 \$263 vsubs sg13_hv_nmos L=0.5U W=2U AS=0.8P AD=0.8P PS=4.8U
+ PD=4.8U
* device instance $132 r0 *1 521.06,3.11 nfet
X$132 \$527 \$264 \$265 vsubs sg13_hv_nmos L=0.5U W=2U AS=0.8P AD=0.8P PS=4.8U
+ PD=4.8U
* device instance $133 r0 *1 525.02,3.11 nfet
X$133 \$528 \$266 \$267 vsubs sg13_hv_nmos L=0.5U W=2U AS=0.8P AD=0.8P PS=4.8U
+ PD=4.8U
* device instance $134 r0 *1 528.98,3.11 nfet
X$134 \$529 \$268 \$269 vsubs sg13_hv_nmos L=0.5U W=2U AS=0.8P AD=0.8P PS=4.8U
+ PD=4.8U
* device instance $135 r0 *1 532.94,3.11 nfet
X$135 \$530 \$270 \$271 vsubs sg13_hv_nmos L=0.5U W=2U AS=0.8P AD=0.8P PS=4.8U
+ PD=4.8U
* device instance $136 r0 *1 536.9,3.11 nfet
X$136 \$531 \$272 \$273 vsubs sg13_hv_nmos L=0.5U W=2U AS=0.8P AD=0.8P PS=4.8U
+ PD=4.8U
* device instance $137 r0 *1 540.86,3.11 nfet
X$137 \$532 \$274 \$275 vsubs sg13_hv_nmos L=0.5U W=2U AS=0.8P AD=0.8P PS=4.8U
+ PD=4.8U
* device instance $138 r0 *1 544.82,3.11 nfet
X$138 \$533 \$276 \$277 vsubs sg13_hv_nmos L=0.5U W=2U AS=0.8P AD=0.8P PS=4.8U
+ PD=4.8U
* device instance $139 r0 *1 548.78,3.11 nfet
X$139 \$534 \$278 \$279 vsubs sg13_hv_nmos L=0.5U W=2U AS=0.8P AD=0.8P PS=4.8U
+ PD=4.8U
* device instance $140 r0 *1 552.74,3.11 nfet
X$140 \$535 \$280 \$281 vsubs sg13_hv_nmos L=0.5U W=2U AS=0.8P AD=0.8P PS=4.8U
+ PD=4.8U
* device instance $141 r0 *1 556.7,3.11 nfet
X$141 \$536 \$282 \$283 vsubs sg13_hv_nmos L=0.5U W=2U AS=0.8P AD=0.8P PS=4.8U
+ PD=4.8U
* device instance $142 r0 *1 560.66,3.11 nfet
X$142 \$537 \$284 \$285 vsubs sg13_hv_nmos L=0.5U W=2U AS=0.8P AD=0.8P PS=4.8U
+ PD=4.8U
* device instance $143 r0 *1 564.62,3.11 nfet
X$143 \$538 \$286 \$287 vsubs sg13_hv_nmos L=0.5U W=2U AS=0.8P AD=0.8P PS=4.8U
+ PD=4.8U
* device instance $144 r0 *1 568.58,3.11 nfet
X$144 \$539 \$288 \$289 vsubs sg13_hv_nmos L=0.5U W=2U AS=0.8P AD=0.8P PS=4.8U
+ PD=4.8U
* device instance $145 r0 *1 572.54,3.11 nfet
X$145 \$540 \$290 \$291 vsubs sg13_hv_nmos L=0.5U W=2U AS=0.8P AD=0.8P PS=4.8U
+ PD=4.8U
* device instance $146 r0 *1 576.5,3.11 nfet
X$146 \$541 \$292 \$293 vsubs sg13_hv_nmos L=0.5U W=2U AS=0.8P AD=0.8P PS=4.8U
+ PD=4.8U
* device instance $147 r0 *1 580.46,3.11 nfet
X$147 \$542 \$294 \$295 vsubs sg13_hv_nmos L=0.5U W=2U AS=0.8P AD=0.8P PS=4.8U
+ PD=4.8U
* device instance $148 r0 *1 584.42,3.11 nfet
X$148 \$543 \$296 \$297 vsubs sg13_hv_nmos L=0.5U W=2U AS=0.8P AD=0.8P PS=4.8U
+ PD=4.8U
* device instance $149 r0 *1 588.38,3.11 nfet
X$149 \$544 \$298 \$299 vsubs sg13_hv_nmos L=0.5U W=2U AS=0.8P AD=0.8P PS=4.8U
+ PD=4.8U
* device instance $150 r0 *1 592.34,3.11 nfet
X$150 \$545 \$300 \$301 vsubs sg13_hv_nmos L=0.5U W=2U AS=0.8P AD=0.8P PS=4.8U
+ PD=4.8U
* device instance $151 r0 *1 596.3,3.11 nfet
X$151 \$546 \$302 \$303 vsubs sg13_hv_nmos L=0.5U W=2U AS=0.8P AD=0.8P PS=4.8U
+ PD=4.8U
* device instance $152 r0 *1 600.26,3.11 nfet
X$152 \$547 \$304 \$305 vsubs sg13_hv_nmos L=0.5U W=2U AS=0.8P AD=0.8P PS=4.8U
+ PD=4.8U
* device instance $153 r0 *1 604.22,3.11 nfet
X$153 \$548 \$306 \$307 vsubs sg13_hv_nmos L=0.5U W=2U AS=0.8P AD=0.8P PS=4.8U
+ PD=4.8U
* device instance $154 r0 *1 608.18,3.11 nfet
X$154 \$549 \$308 \$309 vsubs sg13_hv_nmos L=0.5U W=2U AS=0.8P AD=0.8P PS=4.8U
+ PD=4.8U
* device instance $155 r0 *1 612.14,3.11 nfet
X$155 \$550 \$310 \$311 vsubs sg13_hv_nmos L=0.5U W=2U AS=0.8P AD=0.8P PS=4.8U
+ PD=4.8U
* device instance $156 r0 *1 616.1,3.11 nfet
X$156 \$551 \$312 \$313 vsubs sg13_hv_nmos L=0.5U W=2U AS=0.8P AD=0.8P PS=4.8U
+ PD=4.8U
* device instance $157 r0 *1 620.06,3.11 nfet
X$157 \$552 \$314 \$315 vsubs sg13_hv_nmos L=0.5U W=2U AS=0.8P AD=0.8P PS=4.8U
+ PD=4.8U
* device instance $158 r0 *1 624.02,3.11 nfet
X$158 \$553 \$316 \$317 vsubs sg13_hv_nmos L=0.5U W=2U AS=0.8P AD=0.8P PS=4.8U
+ PD=4.8U
* device instance $159 r0 *1 627.98,3.11 nfet
X$159 \$554 \$318 \$319 vsubs sg13_hv_nmos L=0.5U W=2U AS=0.8P AD=0.8P PS=4.8U
+ PD=4.8U
* device instance $160 r0 *1 631.94,3.11 nfet
X$160 \$555 \$320 \$321 vsubs sg13_hv_nmos L=0.5U W=2U AS=0.8P AD=0.8P PS=4.8U
+ PD=4.8U
* device instance $161 r0 *1 635.9,3.11 nfet
X$161 \$556 \$322 \$323 vsubs sg13_hv_nmos L=0.5U W=2U AS=0.8P AD=0.8P PS=4.8U
+ PD=4.8U
* device instance $162 r0 *1 639.86,3.11 nfet
X$162 \$557 \$324 \$325 vsubs sg13_hv_nmos L=0.5U W=2U AS=0.8P AD=0.8P PS=4.8U
+ PD=4.8U
* device instance $163 r0 *1 643.82,3.11 nfet
X$163 \$558 \$326 \$327 vsubs sg13_hv_nmos L=0.5U W=2U AS=0.8P AD=0.8P PS=4.8U
+ PD=4.8U
* device instance $164 r0 *1 647.78,3.11 nfet
X$164 \$559 \$328 \$329 vsubs sg13_hv_nmos L=0.5U W=2U AS=0.8P AD=0.8P PS=4.8U
+ PD=4.8U
* device instance $165 r0 *1 651.74,3.11 nfet
X$165 \$560 \$330 \$331 vsubs sg13_hv_nmos L=0.5U W=2U AS=0.8P AD=0.8P PS=4.8U
+ PD=4.8U
* device instance $166 r0 *1 655.7,3.11 nfet
X$166 \$561 \$332 \$333 vsubs sg13_hv_nmos L=0.5U W=2U AS=0.8P AD=0.8P PS=4.8U
+ PD=4.8U
* device instance $167 r0 *1 659.66,3.11 nfet
X$167 \$562 \$334 \$335 vsubs sg13_hv_nmos L=0.5U W=2U AS=0.8P AD=0.8P PS=4.8U
+ PD=4.8U
* device instance $168 r0 *1 663.62,3.11 nfet
X$168 \$563 \$336 \$337 vsubs sg13_hv_nmos L=0.5U W=2U AS=0.8P AD=0.8P PS=4.8U
+ PD=4.8U
* device instance $169 r0 *1 667.58,3.11 nfet
X$169 \$564 \$338 \$339 vsubs sg13_hv_nmos L=0.5U W=2U AS=0.8P AD=0.8P PS=4.8U
+ PD=4.8U
* device instance $170 r0 *1 671.54,3.11 nfet
X$170 \$565 \$340 \$341 vsubs sg13_hv_nmos L=0.5U W=2U AS=0.8P AD=0.8P PS=4.8U
+ PD=4.8U
* device instance $171 r0 *1 675.5,3.11 nfet
X$171 \$566 \$342 \$343 vsubs sg13_hv_nmos L=0.5U W=2U AS=0.8P AD=0.8P PS=4.8U
+ PD=4.8U
* device instance $172 r0 *1 679.46,3.11 nfet
X$172 \$567 \$344 \$345 vsubs sg13_hv_nmos L=0.5U W=2U AS=0.8P AD=0.8P PS=4.8U
+ PD=4.8U
* device instance $173 r0 *1 683.42,3.11 nfet
X$173 \$568 \$346 \$347 vsubs sg13_hv_nmos L=0.5U W=2U AS=0.8P AD=0.8P PS=4.8U
+ PD=4.8U
* device instance $174 r0 *1 687.38,3.11 nfet
X$174 \$569 \$348 \$349 vsubs sg13_hv_nmos L=0.5U W=2U AS=0.8P AD=0.8P PS=4.8U
+ PD=4.8U
* device instance $175 r0 *1 691.34,3.11 nfet
X$175 \$570 \$350 \$351 vsubs sg13_hv_nmos L=0.5U W=2U AS=0.8P AD=0.8P PS=4.8U
+ PD=4.8U
* device instance $176 r0 *1 695.3,3.11 nfet
X$176 \$571 \$352 \$353 vsubs sg13_hv_nmos L=0.5U W=2U AS=0.8P AD=0.8P PS=4.8U
+ PD=4.8U
* device instance $177 r0 *1 699.26,3.11 nfet
X$177 \$572 \$354 \$355 vsubs sg13_hv_nmos L=0.5U W=2U AS=0.8P AD=0.8P PS=4.8U
+ PD=4.8U
* device instance $178 r0 *1 703.22,3.11 nfet
X$178 \$573 \$356 \$357 vsubs sg13_hv_nmos L=0.5U W=2U AS=0.8P AD=0.8P PS=4.8U
+ PD=4.8U
* device instance $179 r0 *1 707.18,3.11 nfet
X$179 \$574 \$358 \$359 vsubs sg13_hv_nmos L=0.5U W=2U AS=0.8P AD=0.8P PS=4.8U
+ PD=4.8U
* device instance $180 r0 *1 711.14,3.11 nfet
X$180 \$575 \$360 \$361 vsubs sg13_hv_nmos L=0.5U W=2U AS=0.8P AD=0.8P PS=4.8U
+ PD=4.8U
* device instance $181 r0 *1 715.1,3.11 nfet
X$181 \$576 \$362 \$363 vsubs sg13_hv_nmos L=0.5U W=2U AS=0.8P AD=0.8P PS=4.8U
+ PD=4.8U
* device instance $182 r0 *1 719.06,3.11 nfet
X$182 \$577 \$364 \$365 vsubs sg13_hv_nmos L=0.5U W=2U AS=0.8P AD=0.8P PS=4.8U
+ PD=4.8U
* device instance $183 r0 *1 723.02,3.11 nfet
X$183 \$578 \$366 \$367 vsubs sg13_hv_nmos L=0.5U W=2U AS=0.8P AD=0.8P PS=4.8U
+ PD=4.8U
* device instance $184 r0 *1 726.98,3.11 nfet
X$184 \$579 \$368 \$369 vsubs sg13_hv_nmos L=0.5U W=2U AS=0.8P AD=0.8P PS=4.8U
+ PD=4.8U
* device instance $185 r0 *1 730.94,3.11 nfet
X$185 \$580 \$370 \$371 vsubs sg13_hv_nmos L=0.5U W=2U AS=0.8P AD=0.8P PS=4.8U
+ PD=4.8U
* device instance $186 r0 *1 734.9,3.11 nfet
X$186 \$581 \$372 \$373 vsubs sg13_hv_nmos L=0.5U W=2U AS=0.8P AD=0.8P PS=4.8U
+ PD=4.8U
* device instance $187 r0 *1 738.86,3.11 nfet
X$187 \$582 \$374 \$375 vsubs sg13_hv_nmos L=0.5U W=2U AS=0.8P AD=0.8P PS=4.8U
+ PD=4.8U
* device instance $188 r0 *1 742.82,3.11 nfet
X$188 \$583 \$376 \$377 vsubs sg13_hv_nmos L=0.5U W=2U AS=0.8P AD=0.8P PS=4.8U
+ PD=4.8U
* device instance $189 r0 *1 746.78,3.11 nfet
X$189 \$584 \$378 \$379 vsubs sg13_hv_nmos L=0.5U W=2U AS=0.8P AD=0.8P PS=4.8U
+ PD=4.8U
* device instance $190 r0 *1 750.74,3.11 nfet
X$190 \$585 \$380 \$381 vsubs sg13_hv_nmos L=0.5U W=2U AS=0.8P AD=0.8P PS=4.8U
+ PD=4.8U
* device instance $191 r0 *1 754.7,3.11 nfet
X$191 \$586 \$382 \$383 vsubs sg13_hv_nmos L=0.5U W=2U AS=0.8P AD=0.8P PS=4.8U
+ PD=4.8U
* device instance $192 r0 *1 758.66,3.11 nfet
X$192 \$587 \$384 \$385 vsubs sg13_hv_nmos L=0.5U W=2U AS=0.8P AD=0.8P PS=4.8U
+ PD=4.8U
* device instance $193 r0 *1 762.62,3.11 nfet
X$193 \$588 \$386 \$387 vsubs sg13_hv_nmos L=0.5U W=2U AS=0.8P AD=0.8P PS=4.8U
+ PD=4.8U
* device instance $194 r0 *1 766.58,3.11 nfet
X$194 \$589 \$388 \$389 vsubs sg13_hv_nmos L=0.5U W=2U AS=0.8P AD=0.8P PS=4.8U
+ PD=4.8U
* device instance $195 r0 *1 770.54,3.11 nfet
X$195 \$590 \$390 \$391 vsubs sg13_hv_nmos L=0.5U W=2U AS=0.8P AD=0.8P PS=4.8U
+ PD=4.8U
* device instance $196 r0 *1 774.5,3.11 nfet
X$196 \$591 \$392 \$393 vsubs sg13_hv_nmos L=0.5U W=2U AS=0.8P AD=0.8P PS=4.8U
+ PD=4.8U
* device instance $197 r0 *1 778.46,3.11 nfet
X$197 \$592 \$394 \$395 vsubs sg13_hv_nmos L=0.5U W=2U AS=0.8P AD=0.8P PS=4.8U
+ PD=4.8U
.ENDS divider_chain_nfet_w2_l0p5
