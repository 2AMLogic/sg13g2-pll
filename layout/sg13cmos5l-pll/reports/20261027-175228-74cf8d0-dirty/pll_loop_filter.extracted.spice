* extracted by klt extract --deck sg13cmos5l

* cell pll_loop_filter
* pin NZ
* pin VCTRL
* pin VSS
* pin vsubs
.SUBCKT pll_loop_filter NZ VCTRL VSS vsubs
* device instance $1 r0 *1 817,0 cap_cmomi
X$1 NZ VSS cap_cmomi W=40U L=40U MMIN=1 MMAX=4 FEED=double
* device instance $2 r0 *1 863,0 cap_cmomi
X$2 VCTRL VSS cap_cmomi W=10U L=10U MMIN=1 MMAX=4 FEED=double
* device instance $3 r0 *1 405.5,0.5 rppd
X$3 VCTRL NZ vsubs rppd r=347641.419142 L=810U W=0.6U
.ENDS pll_loop_filter
