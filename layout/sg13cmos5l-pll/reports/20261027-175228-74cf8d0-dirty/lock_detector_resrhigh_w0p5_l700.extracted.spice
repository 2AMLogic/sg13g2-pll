* extracted by klt extract --deck sg13cmos5l

* cell lock_detector_resrhigh_w0p5_l700
* pin vsubs
.SUBCKT lock_detector_resrhigh_w0p5_l700 vsubs
* device instance $1 r0 *1 350.5,0.45 rhigh
X$1 \$1 \$2 vsubs rhigh r=2069885.21739 L=700U W=0.5U
.ENDS lock_detector_resrhigh_w0p5_l700
