* extracted by klt extract --deck sg13cmos5l

* cell vco_nfet_w4_l0p3
* pin vsubs
.SUBCKT vco_nfet_w4_l0p3 vsubs
* device instance $1 r0 *1 3.3,3.01 nfet
X$1 \$3 \$1 \$4 vsubs sg13_hv_nmos L=0.3U W=4U AS=1.6P AD=1.6P PS=8.8U PD=8.8U
* device instance $2 r0 *1 9.26,3.01 nfet
X$2 \$5 \$2 \$6 vsubs sg13_hv_nmos L=0.3U W=4U AS=1.6P AD=1.6P PS=8.8U PD=8.8U
.ENDS vco_nfet_w4_l0p3
