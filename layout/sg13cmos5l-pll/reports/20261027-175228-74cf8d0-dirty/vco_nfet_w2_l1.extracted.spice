* extracted by klt extract --deck sg13cmos5l

* cell vco_nfet_w2_l1
* pin vsubs
.SUBCKT vco_nfet_w2_l1 vsubs
* device instance $1 r0 *1 2.3,3.36 nfet
X$1 \$4 \$1 \$5 vsubs sg13_hv_nmos L=1U W=2U AS=0.8P AD=0.8P PS=4.8U PD=4.8U
* device instance $2 r0 *1 6.26,3.36 nfet
X$2 \$6 \$2 \$7 vsubs sg13_hv_nmos L=1U W=2U AS=0.8P AD=0.8P PS=4.8U PD=4.8U
* device instance $3 r0 *1 10.22,3.36 nfet
X$3 \$8 \$3 \$9 vsubs sg13_hv_nmos L=1U W=2U AS=0.8P AD=0.8P PS=4.8U PD=4.8U
.ENDS vco_nfet_w2_l1
