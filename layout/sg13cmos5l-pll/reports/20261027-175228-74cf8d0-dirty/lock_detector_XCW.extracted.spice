* extracted by klt extract --deck sg13cmos5l

* cell lock_detector_XCW
.SUBCKT lock_detector_XCW
* device instance $1 r0 *1 0,0 cap_cmomi
X$1 \$1 \$2 cap_cmomi W=40U L=40U MMIN=1 MMAX=4 FEED=double
.ENDS lock_detector_XCW
