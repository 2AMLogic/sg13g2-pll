* sg13g2-pll :: vco (SG13CMOS5L) -- generated by design/sg13cmos5l/netlist.sh from vco.sch
* xschem XSCHEM V3.4.7; do not edit by hand.
** sch_path: design/sg13cmos5l/vco.sch
.subckt vco VCTRL B0 B1 CLK VDD_VCO GND_VCO
*.ipin VCTRL
*.ipin B0
*.ipin B1
*.opin CLK
*.iopin VDD_VCO
*.iopin GND_VCO
XBIAS VCTRL B0 B1 VBP VBN VDD_VCO GND_VCO vco_bias
XS1 ring5 VBP VBN ring1 VDD_VCO GND_VCO vco_stage
XS2 ring1 VBP VBN ring2 VDD_VCO GND_VCO vco_stage
XS3 ring2 VBP VBN ring3 VDD_VCO GND_VCO vco_stage
XS4 ring3 VBP VBN ring4 VDD_VCO GND_VCO vco_stage
XS5 ring4 VBP VBN ring5 VDD_VCO GND_VCO vco_stage
XBUF1 ring1 bufmid VDD_VCO GND_VCO inv2x_hv
XBUF2 bufmid CLK VDD_VCO GND_VCO inv2x_hv
XCDECAP VDD_VCO GND_VCO cap_cmomi PARAMS: W=70 L=70
.ends

* expanding   symbol:  vco_bias.sym # of pins=7
** sym_path: design/sg13cmos5l/vco_bias.sym
** sch_path: design/sg13cmos5l/vco_bias.sch
.subckt vco_bias VCTRL B0 B1 VBP VBN VDD VSS
*.ipin VCTRL
*.ipin B0
*.ipin B1
*.opin VBP
*.opin VBN
*.iopin VDD
*.iopin VSS
MP1 vb1 vb1 VDD VDD pfet L=1U W=6U
MP2 vb2 vb1 VDD VDD pfet L=1U W=6U
MN1 vb1 vb2 VSS VSS nfet L=1U W=2U
MN2 vb2 vb2 n2s VSS nfet L=1U W=8U
RS n2s VSS VSS 7800 rppd L=30U W=1U A=30 P=62
RSTART VDD vb2 VSS 21760 rhigh L=8U W=0.5U A=4 P=17
MP5 VFIX vb1 VDD VDD pfet L=1U W=3U
MN5 VFIX VFIX vfixmid VSS nfet L=1U W=2U
MN6 vfixmid vfixmid VSS VSS nfet L=1U W=2U
M6 VBP VBP VDD VDD pfet L=1U W=10U
M7 VBP VFIX dega VSS nfet L=1U W=4U
RDEGA dega VSS VSS 15600 rppd L=60U W=1U A=60 P=122
M8 VBP VCTRL degb VSS nfet L=1U W=4U
RDEGB0 degb VSS VSS 15600 rppd L=60U W=1U A=60 P=122
MSWB0 degb B0 nb0 VSS nfet L=0.3U W=4U
RDEGB1 nb0 VSS VSS 15600 rppd L=60U W=1U A=60 P=122
MSWB1 degb B1 nb1 VSS nfet L=0.3U W=4U
RDEGB2 nb1 VSS VSS 7800 rppd L=30U W=1U A=30 P=62
M11 VBN VBP VDD VDD pfet L=1U W=10U
M10 VBN VBN VSS VSS nfet L=1U W=4U
.ends

* expanding   symbol:  vco_stage.sym # of pins=6
** sym_path: design/sg13cmos5l/vco_stage.sym
** sch_path: design/sg13cmos5l/vco_stage.sch
.subckt vco_stage IN VBP VBN OUT VDDV GNDV
*.ipin IN
*.opin OUT
*.ipin VBP
*.ipin VBN
*.iopin VDDV
*.iopin GNDV
MPH nh VBP VDDV VDDV pfet L=0.5U W=10U
MP OUT IN nh VDDV pfet L=0.28U W=5U
MN OUT IN nt GNDV nfet L=0.28U W=2U
MNT nt VBN GNDV GNDV nfet L=0.5U W=4U
.ends

* expanding   symbol:  inv2x_hv.sym # of pins=4
** sym_path: design/sg13cmos5l/inv2x_hv.sym
** sch_path: design/sg13cmos5l/inv2x_hv.sch
.subckt inv2x_hv A Y VDD VSS
*.ipin A
*.opin Y
*.iopin VDD
*.iopin VSS
MP Y A VDD VDD pfet L=0.5U W=10U
MN Y A VSS VSS nfet L=0.5U W=4U
.ends
