* extracted by klt extract --deck sg13cmos5l

* cell cp_pfet_w24_l1
* pin VDD
.SUBCKT cp_pfet_w24_l1 VDD
* device instance $1 r0 *1 13.3,3.36 pfet
X$1 \$14 \$2 \$3 VDD sg13_hv_pmos L=1U W=24U AS=9.6P AD=9.6P PS=48.8U PD=48.8U
* device instance $2 r0 *1 39.26,3.36 pfet
X$2 \$15 \$4 \$5 VDD sg13_hv_pmos L=1U W=24U AS=9.6P AD=9.6P PS=48.8U PD=48.8U
* device instance $3 r0 *1 65.22,3.36 pfet
X$3 \$16 \$6 \$7 VDD sg13_hv_pmos L=1U W=24U AS=9.6P AD=9.6P PS=48.8U PD=48.8U
* device instance $4 r0 *1 91.18,3.36 pfet
X$4 \$17 \$8 \$9 VDD sg13_hv_pmos L=1U W=24U AS=9.6P AD=9.6P PS=48.8U PD=48.8U
* device instance $5 r0 *1 117.14,3.36 pfet
X$5 \$18 \$10 \$11 VDD sg13_hv_pmos L=1U W=24U AS=9.6P AD=9.6P PS=48.8U PD=48.8U
* device instance $6 r0 *1 143.1,3.36 pfet
X$6 \$19 \$12 \$13 VDD sg13_hv_pmos L=1U W=24U AS=9.6P AD=9.6P PS=48.8U PD=48.8U
.ENDS cp_pfet_w24_l1
