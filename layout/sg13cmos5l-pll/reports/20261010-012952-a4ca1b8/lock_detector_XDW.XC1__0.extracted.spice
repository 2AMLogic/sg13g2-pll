* extracted by klt extract --deck sg13cmos5l

* cell lock_detector_XDW.XC1__0
.SUBCKT lock_detector_XDW.XC1__0
* device instance $1 r0 *1 0,0 cap_cmomi
XD_$1 \$1 \$2 cap_cmomi PARAMS: W=40 L=40
.ENDS lock_detector_XDW.XC1__0
