* extracted by klt extract --deck sg13cmos5l

* cell cp_pfet_w6_l0p5
* pin XBUF_PSRC
.SUBCKT cp_pfet_w6_l0p5 XBUF_PSRC
* device instance $1 r0 *1 4.3,3.11 pfet
X$1 \$6 \$2 \$3 XBUF_PSRC sg13_hv_pmos L=0.5U W=6U AS=2.4P AD=2.4P PS=12.8U
+ PD=12.8U
* device instance $2 r0 *1 12.26,3.11 pfet
X$2 \$7 \$4 \$5 XBUF_PSRC sg13_hv_pmos L=0.5U W=6U AS=2.4P AD=2.4P PS=12.8U
+ PD=12.8U
.ENDS cp_pfet_w6_l0p5
