* extracted by klt extract --deck sg13cmos5l

* cell vco_nfet_w4_l1
* pin vsubs
.SUBCKT vco_nfet_w4_l1 vsubs
* device instance $1 r0 *1 3.3,3.36 nfet
X$1 \$8 \$2 \$3 vsubs sg13_hv_nmos L=1U W=4U AS=1.6P AD=1.6P PS=8.8U PD=8.8U
* device instance $2 r0 *1 9.26,3.36 nfet
X$2 \$9 \$4 \$5 vsubs sg13_hv_nmos L=1U W=4U AS=1.6P AD=1.6P PS=8.8U PD=8.8U
* device instance $3 r0 *1 15.22,3.36 nfet
X$3 \$10 \$6 \$7 vsubs sg13_hv_nmos L=1U W=4U AS=1.6P AD=1.6P PS=8.8U PD=8.8U
.ENDS vco_nfet_w4_l1
