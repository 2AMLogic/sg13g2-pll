* extracted by klt extract --deck sg13cmos5l

* cell divider_chain_pfet_w5_l0p5
* pin VDD_DIV
.SUBCKT divider_chain_pfet_w5_l0p5 VDD_DIV
* device instance $1 r0 *1 3.8,3.11 pfet
X$1 \$396 \$2 \$3 VDD_DIV sg13_hv_pmos L=0.5U W=5U AS=2P AD=2P PS=10.8U PD=10.8U
* device instance $2 r0 *1 10.76,3.11 pfet
X$2 \$397 \$4 \$5 VDD_DIV sg13_hv_pmos L=0.5U W=5U AS=2P AD=2P PS=10.8U PD=10.8U
* device instance $3 r0 *1 17.72,3.11 pfet
X$3 \$398 \$6 \$7 VDD_DIV sg13_hv_pmos L=0.5U W=5U AS=2P AD=2P PS=10.8U PD=10.8U
* device instance $4 r0 *1 24.68,3.11 pfet
X$4 \$399 \$8 \$9 VDD_DIV sg13_hv_pmos L=0.5U W=5U AS=2P AD=2P PS=10.8U PD=10.8U
* device instance $5 r0 *1 31.64,3.11 pfet
X$5 \$400 \$10 \$11 VDD_DIV sg13_hv_pmos L=0.5U W=5U AS=2P AD=2P PS=10.8U
+ PD=10.8U
* device instance $6 r0 *1 38.6,3.11 pfet
X$6 \$401 \$12 \$13 VDD_DIV sg13_hv_pmos L=0.5U W=5U AS=2P AD=2P PS=10.8U
+ PD=10.8U
* device instance $7 r0 *1 45.56,3.11 pfet
X$7 \$402 \$14 \$15 VDD_DIV sg13_hv_pmos L=0.5U W=5U AS=2P AD=2P PS=10.8U
+ PD=10.8U
* device instance $8 r0 *1 52.52,3.11 pfet
X$8 \$403 \$16 \$17 VDD_DIV sg13_hv_pmos L=0.5U W=5U AS=2P AD=2P PS=10.8U
+ PD=10.8U
* device instance $9 r0 *1 59.48,3.11 pfet
X$9 \$404 \$18 \$19 VDD_DIV sg13_hv_pmos L=0.5U W=5U AS=2P AD=2P PS=10.8U
+ PD=10.8U
* device instance $10 r0 *1 66.44,3.11 pfet
X$10 \$405 \$20 \$21 VDD_DIV sg13_hv_pmos L=0.5U W=5U AS=2P AD=2P PS=10.8U
+ PD=10.8U
* device instance $11 r0 *1 73.4,3.11 pfet
X$11 \$406 \$22 \$23 VDD_DIV sg13_hv_pmos L=0.5U W=5U AS=2P AD=2P PS=10.8U
+ PD=10.8U
* device instance $12 r0 *1 80.36,3.11 pfet
X$12 \$407 \$24 \$25 VDD_DIV sg13_hv_pmos L=0.5U W=5U AS=2P AD=2P PS=10.8U
+ PD=10.8U
* device instance $13 r0 *1 87.32,3.11 pfet
X$13 \$408 \$26 \$27 VDD_DIV sg13_hv_pmos L=0.5U W=5U AS=2P AD=2P PS=10.8U
+ PD=10.8U
* device instance $14 r0 *1 94.28,3.11 pfet
X$14 \$409 \$28 \$29 VDD_DIV sg13_hv_pmos L=0.5U W=5U AS=2P AD=2P PS=10.8U
+ PD=10.8U
* device instance $15 r0 *1 101.24,3.11 pfet
X$15 \$410 \$30 \$31 VDD_DIV sg13_hv_pmos L=0.5U W=5U AS=2P AD=2P PS=10.8U
+ PD=10.8U
* device instance $16 r0 *1 108.2,3.11 pfet
X$16 \$411 \$32 \$33 VDD_DIV sg13_hv_pmos L=0.5U W=5U AS=2P AD=2P PS=10.8U
+ PD=10.8U
* device instance $17 r0 *1 115.16,3.11 pfet
X$17 \$412 \$34 \$35 VDD_DIV sg13_hv_pmos L=0.5U W=5U AS=2P AD=2P PS=10.8U
+ PD=10.8U
* device instance $18 r0 *1 122.12,3.11 pfet
X$18 \$413 \$36 \$37 VDD_DIV sg13_hv_pmos L=0.5U W=5U AS=2P AD=2P PS=10.8U
+ PD=10.8U
* device instance $19 r0 *1 129.08,3.11 pfet
X$19 \$414 \$38 \$39 VDD_DIV sg13_hv_pmos L=0.5U W=5U AS=2P AD=2P PS=10.8U
+ PD=10.8U
* device instance $20 r0 *1 136.04,3.11 pfet
X$20 \$415 \$40 \$41 VDD_DIV sg13_hv_pmos L=0.5U W=5U AS=2P AD=2P PS=10.8U
+ PD=10.8U
* device instance $21 r0 *1 143,3.11 pfet
X$21 \$416 \$42 \$43 VDD_DIV sg13_hv_pmos L=0.5U W=5U AS=2P AD=2P PS=10.8U
+ PD=10.8U
* device instance $22 r0 *1 149.96,3.11 pfet
X$22 \$417 \$44 \$45 VDD_DIV sg13_hv_pmos L=0.5U W=5U AS=2P AD=2P PS=10.8U
+ PD=10.8U
* device instance $23 r0 *1 156.92,3.11 pfet
X$23 \$418 \$46 \$47 VDD_DIV sg13_hv_pmos L=0.5U W=5U AS=2P AD=2P PS=10.8U
+ PD=10.8U
* device instance $24 r0 *1 163.88,3.11 pfet
X$24 \$419 \$48 \$49 VDD_DIV sg13_hv_pmos L=0.5U W=5U AS=2P AD=2P PS=10.8U
+ PD=10.8U
* device instance $25 r0 *1 170.84,3.11 pfet
X$25 \$420 \$50 \$51 VDD_DIV sg13_hv_pmos L=0.5U W=5U AS=2P AD=2P PS=10.8U
+ PD=10.8U
* device instance $26 r0 *1 177.8,3.11 pfet
X$26 \$421 \$52 \$53 VDD_DIV sg13_hv_pmos L=0.5U W=5U AS=2P AD=2P PS=10.8U
+ PD=10.8U
* device instance $27 r0 *1 184.76,3.11 pfet
X$27 \$422 \$54 \$55 VDD_DIV sg13_hv_pmos L=0.5U W=5U AS=2P AD=2P PS=10.8U
+ PD=10.8U
* device instance $28 r0 *1 191.72,3.11 pfet
X$28 \$423 \$56 \$57 VDD_DIV sg13_hv_pmos L=0.5U W=5U AS=2P AD=2P PS=10.8U
+ PD=10.8U
* device instance $29 r0 *1 198.68,3.11 pfet
X$29 \$424 \$58 \$59 VDD_DIV sg13_hv_pmos L=0.5U W=5U AS=2P AD=2P PS=10.8U
+ PD=10.8U
* device instance $30 r0 *1 205.64,3.11 pfet
X$30 \$425 \$60 \$61 VDD_DIV sg13_hv_pmos L=0.5U W=5U AS=2P AD=2P PS=10.8U
+ PD=10.8U
* device instance $31 r0 *1 212.6,3.11 pfet
X$31 \$426 \$62 \$63 VDD_DIV sg13_hv_pmos L=0.5U W=5U AS=2P AD=2P PS=10.8U
+ PD=10.8U
* device instance $32 r0 *1 219.56,3.11 pfet
X$32 \$427 \$64 \$65 VDD_DIV sg13_hv_pmos L=0.5U W=5U AS=2P AD=2P PS=10.8U
+ PD=10.8U
* device instance $33 r0 *1 226.52,3.11 pfet
X$33 \$428 \$66 \$67 VDD_DIV sg13_hv_pmos L=0.5U W=5U AS=2P AD=2P PS=10.8U
+ PD=10.8U
* device instance $34 r0 *1 233.48,3.11 pfet
X$34 \$429 \$68 \$69 VDD_DIV sg13_hv_pmos L=0.5U W=5U AS=2P AD=2P PS=10.8U
+ PD=10.8U
* device instance $35 r0 *1 240.44,3.11 pfet
X$35 \$430 \$70 \$71 VDD_DIV sg13_hv_pmos L=0.5U W=5U AS=2P AD=2P PS=10.8U
+ PD=10.8U
* device instance $36 r0 *1 247.4,3.11 pfet
X$36 \$431 \$72 \$73 VDD_DIV sg13_hv_pmos L=0.5U W=5U AS=2P AD=2P PS=10.8U
+ PD=10.8U
* device instance $37 r0 *1 254.36,3.11 pfet
X$37 \$432 \$74 \$75 VDD_DIV sg13_hv_pmos L=0.5U W=5U AS=2P AD=2P PS=10.8U
+ PD=10.8U
* device instance $38 r0 *1 261.32,3.11 pfet
X$38 \$433 \$76 \$77 VDD_DIV sg13_hv_pmos L=0.5U W=5U AS=2P AD=2P PS=10.8U
+ PD=10.8U
* device instance $39 r0 *1 268.28,3.11 pfet
X$39 \$434 \$78 \$79 VDD_DIV sg13_hv_pmos L=0.5U W=5U AS=2P AD=2P PS=10.8U
+ PD=10.8U
* device instance $40 r0 *1 275.24,3.11 pfet
X$40 \$435 \$80 \$81 VDD_DIV sg13_hv_pmos L=0.5U W=5U AS=2P AD=2P PS=10.8U
+ PD=10.8U
* device instance $41 r0 *1 282.2,3.11 pfet
X$41 \$436 \$82 \$83 VDD_DIV sg13_hv_pmos L=0.5U W=5U AS=2P AD=2P PS=10.8U
+ PD=10.8U
* device instance $42 r0 *1 289.16,3.11 pfet
X$42 \$437 \$84 \$85 VDD_DIV sg13_hv_pmos L=0.5U W=5U AS=2P AD=2P PS=10.8U
+ PD=10.8U
* device instance $43 r0 *1 296.12,3.11 pfet
X$43 \$438 \$86 \$87 VDD_DIV sg13_hv_pmos L=0.5U W=5U AS=2P AD=2P PS=10.8U
+ PD=10.8U
* device instance $44 r0 *1 303.08,3.11 pfet
X$44 \$439 \$88 \$89 VDD_DIV sg13_hv_pmos L=0.5U W=5U AS=2P AD=2P PS=10.8U
+ PD=10.8U
* device instance $45 r0 *1 310.04,3.11 pfet
X$45 \$440 \$90 \$91 VDD_DIV sg13_hv_pmos L=0.5U W=5U AS=2P AD=2P PS=10.8U
+ PD=10.8U
* device instance $46 r0 *1 317,3.11 pfet
X$46 \$441 \$92 \$93 VDD_DIV sg13_hv_pmos L=0.5U W=5U AS=2P AD=2P PS=10.8U
+ PD=10.8U
* device instance $47 r0 *1 323.96,3.11 pfet
X$47 \$442 \$94 \$95 VDD_DIV sg13_hv_pmos L=0.5U W=5U AS=2P AD=2P PS=10.8U
+ PD=10.8U
* device instance $48 r0 *1 330.92,3.11 pfet
X$48 \$443 \$96 \$97 VDD_DIV sg13_hv_pmos L=0.5U W=5U AS=2P AD=2P PS=10.8U
+ PD=10.8U
* device instance $49 r0 *1 337.88,3.11 pfet
X$49 \$444 \$98 \$99 VDD_DIV sg13_hv_pmos L=0.5U W=5U AS=2P AD=2P PS=10.8U
+ PD=10.8U
* device instance $50 r0 *1 344.84,3.11 pfet
X$50 \$445 \$100 \$101 VDD_DIV sg13_hv_pmos L=0.5U W=5U AS=2P AD=2P PS=10.8U
+ PD=10.8U
* device instance $51 r0 *1 351.8,3.11 pfet
X$51 \$446 \$102 \$103 VDD_DIV sg13_hv_pmos L=0.5U W=5U AS=2P AD=2P PS=10.8U
+ PD=10.8U
* device instance $52 r0 *1 358.76,3.11 pfet
X$52 \$447 \$104 \$105 VDD_DIV sg13_hv_pmos L=0.5U W=5U AS=2P AD=2P PS=10.8U
+ PD=10.8U
* device instance $53 r0 *1 365.72,3.11 pfet
X$53 \$448 \$106 \$107 VDD_DIV sg13_hv_pmos L=0.5U W=5U AS=2P AD=2P PS=10.8U
+ PD=10.8U
* device instance $54 r0 *1 372.68,3.11 pfet
X$54 \$449 \$108 \$109 VDD_DIV sg13_hv_pmos L=0.5U W=5U AS=2P AD=2P PS=10.8U
+ PD=10.8U
* device instance $55 r0 *1 379.64,3.11 pfet
X$55 \$450 \$110 \$111 VDD_DIV sg13_hv_pmos L=0.5U W=5U AS=2P AD=2P PS=10.8U
+ PD=10.8U
* device instance $56 r0 *1 386.6,3.11 pfet
X$56 \$451 \$112 \$113 VDD_DIV sg13_hv_pmos L=0.5U W=5U AS=2P AD=2P PS=10.8U
+ PD=10.8U
* device instance $57 r0 *1 393.56,3.11 pfet
X$57 \$452 \$114 \$115 VDD_DIV sg13_hv_pmos L=0.5U W=5U AS=2P AD=2P PS=10.8U
+ PD=10.8U
* device instance $58 r0 *1 400.52,3.11 pfet
X$58 \$453 \$116 \$117 VDD_DIV sg13_hv_pmos L=0.5U W=5U AS=2P AD=2P PS=10.8U
+ PD=10.8U
* device instance $59 r0 *1 407.48,3.11 pfet
X$59 \$454 \$118 \$119 VDD_DIV sg13_hv_pmos L=0.5U W=5U AS=2P AD=2P PS=10.8U
+ PD=10.8U
* device instance $60 r0 *1 414.44,3.11 pfet
X$60 \$455 \$120 \$121 VDD_DIV sg13_hv_pmos L=0.5U W=5U AS=2P AD=2P PS=10.8U
+ PD=10.8U
* device instance $61 r0 *1 421.4,3.11 pfet
X$61 \$456 \$122 \$123 VDD_DIV sg13_hv_pmos L=0.5U W=5U AS=2P AD=2P PS=10.8U
+ PD=10.8U
* device instance $62 r0 *1 428.36,3.11 pfet
X$62 \$457 \$124 \$125 VDD_DIV sg13_hv_pmos L=0.5U W=5U AS=2P AD=2P PS=10.8U
+ PD=10.8U
* device instance $63 r0 *1 435.32,3.11 pfet
X$63 \$458 \$126 \$127 VDD_DIV sg13_hv_pmos L=0.5U W=5U AS=2P AD=2P PS=10.8U
+ PD=10.8U
* device instance $64 r0 *1 442.28,3.11 pfet
X$64 \$459 \$128 \$129 VDD_DIV sg13_hv_pmos L=0.5U W=5U AS=2P AD=2P PS=10.8U
+ PD=10.8U
* device instance $65 r0 *1 449.24,3.11 pfet
X$65 \$460 \$130 \$131 VDD_DIV sg13_hv_pmos L=0.5U W=5U AS=2P AD=2P PS=10.8U
+ PD=10.8U
* device instance $66 r0 *1 456.2,3.11 pfet
X$66 \$461 \$132 \$133 VDD_DIV sg13_hv_pmos L=0.5U W=5U AS=2P AD=2P PS=10.8U
+ PD=10.8U
* device instance $67 r0 *1 463.16,3.11 pfet
X$67 \$462 \$134 \$135 VDD_DIV sg13_hv_pmos L=0.5U W=5U AS=2P AD=2P PS=10.8U
+ PD=10.8U
* device instance $68 r0 *1 470.12,3.11 pfet
X$68 \$463 \$136 \$137 VDD_DIV sg13_hv_pmos L=0.5U W=5U AS=2P AD=2P PS=10.8U
+ PD=10.8U
* device instance $69 r0 *1 477.08,3.11 pfet
X$69 \$464 \$138 \$139 VDD_DIV sg13_hv_pmos L=0.5U W=5U AS=2P AD=2P PS=10.8U
+ PD=10.8U
* device instance $70 r0 *1 484.04,3.11 pfet
X$70 \$465 \$140 \$141 VDD_DIV sg13_hv_pmos L=0.5U W=5U AS=2P AD=2P PS=10.8U
+ PD=10.8U
* device instance $71 r0 *1 491,3.11 pfet
X$71 \$466 \$142 \$143 VDD_DIV sg13_hv_pmos L=0.5U W=5U AS=2P AD=2P PS=10.8U
+ PD=10.8U
* device instance $72 r0 *1 497.96,3.11 pfet
X$72 \$467 \$144 \$145 VDD_DIV sg13_hv_pmos L=0.5U W=5U AS=2P AD=2P PS=10.8U
+ PD=10.8U
* device instance $73 r0 *1 504.92,3.11 pfet
X$73 \$468 \$146 \$147 VDD_DIV sg13_hv_pmos L=0.5U W=5U AS=2P AD=2P PS=10.8U
+ PD=10.8U
* device instance $74 r0 *1 511.88,3.11 pfet
X$74 \$469 \$148 \$149 VDD_DIV sg13_hv_pmos L=0.5U W=5U AS=2P AD=2P PS=10.8U
+ PD=10.8U
* device instance $75 r0 *1 518.84,3.11 pfet
X$75 \$470 \$150 \$151 VDD_DIV sg13_hv_pmos L=0.5U W=5U AS=2P AD=2P PS=10.8U
+ PD=10.8U
* device instance $76 r0 *1 525.8,3.11 pfet
X$76 \$471 \$152 \$153 VDD_DIV sg13_hv_pmos L=0.5U W=5U AS=2P AD=2P PS=10.8U
+ PD=10.8U
* device instance $77 r0 *1 532.76,3.11 pfet
X$77 \$472 \$154 \$155 VDD_DIV sg13_hv_pmos L=0.5U W=5U AS=2P AD=2P PS=10.8U
+ PD=10.8U
* device instance $78 r0 *1 539.72,3.11 pfet
X$78 \$473 \$156 \$157 VDD_DIV sg13_hv_pmos L=0.5U W=5U AS=2P AD=2P PS=10.8U
+ PD=10.8U
* device instance $79 r0 *1 546.68,3.11 pfet
X$79 \$474 \$158 \$159 VDD_DIV sg13_hv_pmos L=0.5U W=5U AS=2P AD=2P PS=10.8U
+ PD=10.8U
* device instance $80 r0 *1 553.64,3.11 pfet
X$80 \$475 \$160 \$161 VDD_DIV sg13_hv_pmos L=0.5U W=5U AS=2P AD=2P PS=10.8U
+ PD=10.8U
* device instance $81 r0 *1 560.6,3.11 pfet
X$81 \$476 \$162 \$163 VDD_DIV sg13_hv_pmos L=0.5U W=5U AS=2P AD=2P PS=10.8U
+ PD=10.8U
* device instance $82 r0 *1 567.56,3.11 pfet
X$82 \$477 \$164 \$165 VDD_DIV sg13_hv_pmos L=0.5U W=5U AS=2P AD=2P PS=10.8U
+ PD=10.8U
* device instance $83 r0 *1 574.52,3.11 pfet
X$83 \$478 \$166 \$167 VDD_DIV sg13_hv_pmos L=0.5U W=5U AS=2P AD=2P PS=10.8U
+ PD=10.8U
* device instance $84 r0 *1 581.48,3.11 pfet
X$84 \$479 \$168 \$169 VDD_DIV sg13_hv_pmos L=0.5U W=5U AS=2P AD=2P PS=10.8U
+ PD=10.8U
* device instance $85 r0 *1 588.44,3.11 pfet
X$85 \$480 \$170 \$171 VDD_DIV sg13_hv_pmos L=0.5U W=5U AS=2P AD=2P PS=10.8U
+ PD=10.8U
* device instance $86 r0 *1 595.4,3.11 pfet
X$86 \$481 \$172 \$173 VDD_DIV sg13_hv_pmos L=0.5U W=5U AS=2P AD=2P PS=10.8U
+ PD=10.8U
* device instance $87 r0 *1 602.36,3.11 pfet
X$87 \$482 \$174 \$175 VDD_DIV sg13_hv_pmos L=0.5U W=5U AS=2P AD=2P PS=10.8U
+ PD=10.8U
* device instance $88 r0 *1 609.32,3.11 pfet
X$88 \$483 \$176 \$177 VDD_DIV sg13_hv_pmos L=0.5U W=5U AS=2P AD=2P PS=10.8U
+ PD=10.8U
* device instance $89 r0 *1 616.28,3.11 pfet
X$89 \$484 \$178 \$179 VDD_DIV sg13_hv_pmos L=0.5U W=5U AS=2P AD=2P PS=10.8U
+ PD=10.8U
* device instance $90 r0 *1 623.24,3.11 pfet
X$90 \$485 \$180 \$181 VDD_DIV sg13_hv_pmos L=0.5U W=5U AS=2P AD=2P PS=10.8U
+ PD=10.8U
* device instance $91 r0 *1 630.2,3.11 pfet
X$91 \$486 \$182 \$183 VDD_DIV sg13_hv_pmos L=0.5U W=5U AS=2P AD=2P PS=10.8U
+ PD=10.8U
* device instance $92 r0 *1 637.16,3.11 pfet
X$92 \$487 \$184 \$185 VDD_DIV sg13_hv_pmos L=0.5U W=5U AS=2P AD=2P PS=10.8U
+ PD=10.8U
* device instance $93 r0 *1 644.12,3.11 pfet
X$93 \$488 \$186 \$187 VDD_DIV sg13_hv_pmos L=0.5U W=5U AS=2P AD=2P PS=10.8U
+ PD=10.8U
* device instance $94 r0 *1 651.08,3.11 pfet
X$94 \$489 \$188 \$189 VDD_DIV sg13_hv_pmos L=0.5U W=5U AS=2P AD=2P PS=10.8U
+ PD=10.8U
* device instance $95 r0 *1 658.04,3.11 pfet
X$95 \$490 \$190 \$191 VDD_DIV sg13_hv_pmos L=0.5U W=5U AS=2P AD=2P PS=10.8U
+ PD=10.8U
* device instance $96 r0 *1 665,3.11 pfet
X$96 \$491 \$192 \$193 VDD_DIV sg13_hv_pmos L=0.5U W=5U AS=2P AD=2P PS=10.8U
+ PD=10.8U
* device instance $97 r0 *1 671.96,3.11 pfet
X$97 \$492 \$194 \$195 VDD_DIV sg13_hv_pmos L=0.5U W=5U AS=2P AD=2P PS=10.8U
+ PD=10.8U
* device instance $98 r0 *1 678.92,3.11 pfet
X$98 \$493 \$196 \$197 VDD_DIV sg13_hv_pmos L=0.5U W=5U AS=2P AD=2P PS=10.8U
+ PD=10.8U
* device instance $99 r0 *1 685.88,3.11 pfet
X$99 \$494 \$198 \$199 VDD_DIV sg13_hv_pmos L=0.5U W=5U AS=2P AD=2P PS=10.8U
+ PD=10.8U
* device instance $100 r0 *1 692.84,3.11 pfet
X$100 \$495 \$200 \$201 VDD_DIV sg13_hv_pmos L=0.5U W=5U AS=2P AD=2P PS=10.8U
+ PD=10.8U
* device instance $101 r0 *1 699.8,3.11 pfet
X$101 \$496 \$202 \$203 VDD_DIV sg13_hv_pmos L=0.5U W=5U AS=2P AD=2P PS=10.8U
+ PD=10.8U
* device instance $102 r0 *1 706.76,3.11 pfet
X$102 \$497 \$204 \$205 VDD_DIV sg13_hv_pmos L=0.5U W=5U AS=2P AD=2P PS=10.8U
+ PD=10.8U
* device instance $103 r0 *1 713.72,3.11 pfet
X$103 \$498 \$206 \$207 VDD_DIV sg13_hv_pmos L=0.5U W=5U AS=2P AD=2P PS=10.8U
+ PD=10.8U
* device instance $104 r0 *1 720.68,3.11 pfet
X$104 \$499 \$208 \$209 VDD_DIV sg13_hv_pmos L=0.5U W=5U AS=2P AD=2P PS=10.8U
+ PD=10.8U
* device instance $105 r0 *1 727.64,3.11 pfet
X$105 \$500 \$210 \$211 VDD_DIV sg13_hv_pmos L=0.5U W=5U AS=2P AD=2P PS=10.8U
+ PD=10.8U
* device instance $106 r0 *1 734.6,3.11 pfet
X$106 \$501 \$212 \$213 VDD_DIV sg13_hv_pmos L=0.5U W=5U AS=2P AD=2P PS=10.8U
+ PD=10.8U
* device instance $107 r0 *1 741.56,3.11 pfet
X$107 \$502 \$214 \$215 VDD_DIV sg13_hv_pmos L=0.5U W=5U AS=2P AD=2P PS=10.8U
+ PD=10.8U
* device instance $108 r0 *1 748.52,3.11 pfet
X$108 \$503 \$216 \$217 VDD_DIV sg13_hv_pmos L=0.5U W=5U AS=2P AD=2P PS=10.8U
+ PD=10.8U
* device instance $109 r0 *1 755.48,3.11 pfet
X$109 \$504 \$218 \$219 VDD_DIV sg13_hv_pmos L=0.5U W=5U AS=2P AD=2P PS=10.8U
+ PD=10.8U
* device instance $110 r0 *1 762.44,3.11 pfet
X$110 \$505 \$220 \$221 VDD_DIV sg13_hv_pmos L=0.5U W=5U AS=2P AD=2P PS=10.8U
+ PD=10.8U
* device instance $111 r0 *1 769.4,3.11 pfet
X$111 \$506 \$222 \$223 VDD_DIV sg13_hv_pmos L=0.5U W=5U AS=2P AD=2P PS=10.8U
+ PD=10.8U
* device instance $112 r0 *1 776.36,3.11 pfet
X$112 \$507 \$224 \$225 VDD_DIV sg13_hv_pmos L=0.5U W=5U AS=2P AD=2P PS=10.8U
+ PD=10.8U
* device instance $113 r0 *1 783.32,3.11 pfet
X$113 \$508 \$226 \$227 VDD_DIV sg13_hv_pmos L=0.5U W=5U AS=2P AD=2P PS=10.8U
+ PD=10.8U
* device instance $114 r0 *1 790.28,3.11 pfet
X$114 \$509 \$228 \$229 VDD_DIV sg13_hv_pmos L=0.5U W=5U AS=2P AD=2P PS=10.8U
+ PD=10.8U
* device instance $115 r0 *1 797.24,3.11 pfet
X$115 \$510 \$230 \$231 VDD_DIV sg13_hv_pmos L=0.5U W=5U AS=2P AD=2P PS=10.8U
+ PD=10.8U
* device instance $116 r0 *1 804.2,3.11 pfet
X$116 \$511 \$232 \$233 VDD_DIV sg13_hv_pmos L=0.5U W=5U AS=2P AD=2P PS=10.8U
+ PD=10.8U
* device instance $117 r0 *1 811.16,3.11 pfet
X$117 \$512 \$234 \$235 VDD_DIV sg13_hv_pmos L=0.5U W=5U AS=2P AD=2P PS=10.8U
+ PD=10.8U
* device instance $118 r0 *1 818.12,3.11 pfet
X$118 \$513 \$236 \$237 VDD_DIV sg13_hv_pmos L=0.5U W=5U AS=2P AD=2P PS=10.8U
+ PD=10.8U
* device instance $119 r0 *1 825.08,3.11 pfet
X$119 \$514 \$238 \$239 VDD_DIV sg13_hv_pmos L=0.5U W=5U AS=2P AD=2P PS=10.8U
+ PD=10.8U
* device instance $120 r0 *1 832.04,3.11 pfet
X$120 \$515 \$240 \$241 VDD_DIV sg13_hv_pmos L=0.5U W=5U AS=2P AD=2P PS=10.8U
+ PD=10.8U
* device instance $121 r0 *1 839,3.11 pfet
X$121 \$516 \$242 \$243 VDD_DIV sg13_hv_pmos L=0.5U W=5U AS=2P AD=2P PS=10.8U
+ PD=10.8U
* device instance $122 r0 *1 845.96,3.11 pfet
X$122 \$517 \$244 \$245 VDD_DIV sg13_hv_pmos L=0.5U W=5U AS=2P AD=2P PS=10.8U
+ PD=10.8U
* device instance $123 r0 *1 852.92,3.11 pfet
X$123 \$518 \$246 \$247 VDD_DIV sg13_hv_pmos L=0.5U W=5U AS=2P AD=2P PS=10.8U
+ PD=10.8U
* device instance $124 r0 *1 859.88,3.11 pfet
X$124 \$519 \$248 \$249 VDD_DIV sg13_hv_pmos L=0.5U W=5U AS=2P AD=2P PS=10.8U
+ PD=10.8U
* device instance $125 r0 *1 866.84,3.11 pfet
X$125 \$520 \$250 \$251 VDD_DIV sg13_hv_pmos L=0.5U W=5U AS=2P AD=2P PS=10.8U
+ PD=10.8U
* device instance $126 r0 *1 873.8,3.11 pfet
X$126 \$521 \$252 \$253 VDD_DIV sg13_hv_pmos L=0.5U W=5U AS=2P AD=2P PS=10.8U
+ PD=10.8U
* device instance $127 r0 *1 880.76,3.11 pfet
X$127 \$522 \$254 \$255 VDD_DIV sg13_hv_pmos L=0.5U W=5U AS=2P AD=2P PS=10.8U
+ PD=10.8U
* device instance $128 r0 *1 887.72,3.11 pfet
X$128 \$523 \$256 \$257 VDD_DIV sg13_hv_pmos L=0.5U W=5U AS=2P AD=2P PS=10.8U
+ PD=10.8U
* device instance $129 r0 *1 894.68,3.11 pfet
X$129 \$524 \$258 \$259 VDD_DIV sg13_hv_pmos L=0.5U W=5U AS=2P AD=2P PS=10.8U
+ PD=10.8U
* device instance $130 r0 *1 901.64,3.11 pfet
X$130 \$525 \$260 \$261 VDD_DIV sg13_hv_pmos L=0.5U W=5U AS=2P AD=2P PS=10.8U
+ PD=10.8U
* device instance $131 r0 *1 908.6,3.11 pfet
X$131 \$526 \$262 \$263 VDD_DIV sg13_hv_pmos L=0.5U W=5U AS=2P AD=2P PS=10.8U
+ PD=10.8U
* device instance $132 r0 *1 915.56,3.11 pfet
X$132 \$527 \$264 \$265 VDD_DIV sg13_hv_pmos L=0.5U W=5U AS=2P AD=2P PS=10.8U
+ PD=10.8U
* device instance $133 r0 *1 922.52,3.11 pfet
X$133 \$528 \$266 \$267 VDD_DIV sg13_hv_pmos L=0.5U W=5U AS=2P AD=2P PS=10.8U
+ PD=10.8U
* device instance $134 r0 *1 929.48,3.11 pfet
X$134 \$529 \$268 \$269 VDD_DIV sg13_hv_pmos L=0.5U W=5U AS=2P AD=2P PS=10.8U
+ PD=10.8U
* device instance $135 r0 *1 936.44,3.11 pfet
X$135 \$530 \$270 \$271 VDD_DIV sg13_hv_pmos L=0.5U W=5U AS=2P AD=2P PS=10.8U
+ PD=10.8U
* device instance $136 r0 *1 943.4,3.11 pfet
X$136 \$531 \$272 \$273 VDD_DIV sg13_hv_pmos L=0.5U W=5U AS=2P AD=2P PS=10.8U
+ PD=10.8U
* device instance $137 r0 *1 950.36,3.11 pfet
X$137 \$532 \$274 \$275 VDD_DIV sg13_hv_pmos L=0.5U W=5U AS=2P AD=2P PS=10.8U
+ PD=10.8U
* device instance $138 r0 *1 957.32,3.11 pfet
X$138 \$533 \$276 \$277 VDD_DIV sg13_hv_pmos L=0.5U W=5U AS=2P AD=2P PS=10.8U
+ PD=10.8U
* device instance $139 r0 *1 964.28,3.11 pfet
X$139 \$534 \$278 \$279 VDD_DIV sg13_hv_pmos L=0.5U W=5U AS=2P AD=2P PS=10.8U
+ PD=10.8U
* device instance $140 r0 *1 971.24,3.11 pfet
X$140 \$535 \$280 \$281 VDD_DIV sg13_hv_pmos L=0.5U W=5U AS=2P AD=2P PS=10.8U
+ PD=10.8U
* device instance $141 r0 *1 978.2,3.11 pfet
X$141 \$536 \$282 \$283 VDD_DIV sg13_hv_pmos L=0.5U W=5U AS=2P AD=2P PS=10.8U
+ PD=10.8U
* device instance $142 r0 *1 985.16,3.11 pfet
X$142 \$537 \$284 \$285 VDD_DIV sg13_hv_pmos L=0.5U W=5U AS=2P AD=2P PS=10.8U
+ PD=10.8U
* device instance $143 r0 *1 992.12,3.11 pfet
X$143 \$538 \$286 \$287 VDD_DIV sg13_hv_pmos L=0.5U W=5U AS=2P AD=2P PS=10.8U
+ PD=10.8U
* device instance $144 r0 *1 999.08,3.11 pfet
X$144 \$539 \$288 \$289 VDD_DIV sg13_hv_pmos L=0.5U W=5U AS=2P AD=2P PS=10.8U
+ PD=10.8U
* device instance $145 r0 *1 1006.04,3.11 pfet
X$145 \$540 \$290 \$291 VDD_DIV sg13_hv_pmos L=0.5U W=5U AS=2P AD=2P PS=10.8U
+ PD=10.8U
* device instance $146 r0 *1 1013,3.11 pfet
X$146 \$541 \$292 \$293 VDD_DIV sg13_hv_pmos L=0.5U W=5U AS=2P AD=2P PS=10.8U
+ PD=10.8U
* device instance $147 r0 *1 1019.96,3.11 pfet
X$147 \$542 \$294 \$295 VDD_DIV sg13_hv_pmos L=0.5U W=5U AS=2P AD=2P PS=10.8U
+ PD=10.8U
* device instance $148 r0 *1 1026.92,3.11 pfet
X$148 \$543 \$296 \$297 VDD_DIV sg13_hv_pmos L=0.5U W=5U AS=2P AD=2P PS=10.8U
+ PD=10.8U
* device instance $149 r0 *1 1033.88,3.11 pfet
X$149 \$544 \$298 \$299 VDD_DIV sg13_hv_pmos L=0.5U W=5U AS=2P AD=2P PS=10.8U
+ PD=10.8U
* device instance $150 r0 *1 1040.84,3.11 pfet
X$150 \$545 \$300 \$301 VDD_DIV sg13_hv_pmos L=0.5U W=5U AS=2P AD=2P PS=10.8U
+ PD=10.8U
* device instance $151 r0 *1 1047.8,3.11 pfet
X$151 \$546 \$302 \$303 VDD_DIV sg13_hv_pmos L=0.5U W=5U AS=2P AD=2P PS=10.8U
+ PD=10.8U
* device instance $152 r0 *1 1054.76,3.11 pfet
X$152 \$547 \$304 \$305 VDD_DIV sg13_hv_pmos L=0.5U W=5U AS=2P AD=2P PS=10.8U
+ PD=10.8U
* device instance $153 r0 *1 1061.72,3.11 pfet
X$153 \$548 \$306 \$307 VDD_DIV sg13_hv_pmos L=0.5U W=5U AS=2P AD=2P PS=10.8U
+ PD=10.8U
* device instance $154 r0 *1 1068.68,3.11 pfet
X$154 \$549 \$308 \$309 VDD_DIV sg13_hv_pmos L=0.5U W=5U AS=2P AD=2P PS=10.8U
+ PD=10.8U
* device instance $155 r0 *1 1075.64,3.11 pfet
X$155 \$550 \$310 \$311 VDD_DIV sg13_hv_pmos L=0.5U W=5U AS=2P AD=2P PS=10.8U
+ PD=10.8U
* device instance $156 r0 *1 1082.6,3.11 pfet
X$156 \$551 \$312 \$313 VDD_DIV sg13_hv_pmos L=0.5U W=5U AS=2P AD=2P PS=10.8U
+ PD=10.8U
* device instance $157 r0 *1 1089.56,3.11 pfet
X$157 \$552 \$314 \$315 VDD_DIV sg13_hv_pmos L=0.5U W=5U AS=2P AD=2P PS=10.8U
+ PD=10.8U
* device instance $158 r0 *1 1096.52,3.11 pfet
X$158 \$553 \$316 \$317 VDD_DIV sg13_hv_pmos L=0.5U W=5U AS=2P AD=2P PS=10.8U
+ PD=10.8U
* device instance $159 r0 *1 1103.48,3.11 pfet
X$159 \$554 \$318 \$319 VDD_DIV sg13_hv_pmos L=0.5U W=5U AS=2P AD=2P PS=10.8U
+ PD=10.8U
* device instance $160 r0 *1 1110.44,3.11 pfet
X$160 \$555 \$320 \$321 VDD_DIV sg13_hv_pmos L=0.5U W=5U AS=2P AD=2P PS=10.8U
+ PD=10.8U
* device instance $161 r0 *1 1117.4,3.11 pfet
X$161 \$556 \$322 \$323 VDD_DIV sg13_hv_pmos L=0.5U W=5U AS=2P AD=2P PS=10.8U
+ PD=10.8U
* device instance $162 r0 *1 1124.36,3.11 pfet
X$162 \$557 \$324 \$325 VDD_DIV sg13_hv_pmos L=0.5U W=5U AS=2P AD=2P PS=10.8U
+ PD=10.8U
* device instance $163 r0 *1 1131.32,3.11 pfet
X$163 \$558 \$326 \$327 VDD_DIV sg13_hv_pmos L=0.5U W=5U AS=2P AD=2P PS=10.8U
+ PD=10.8U
* device instance $164 r0 *1 1138.28,3.11 pfet
X$164 \$559 \$328 \$329 VDD_DIV sg13_hv_pmos L=0.5U W=5U AS=2P AD=2P PS=10.8U
+ PD=10.8U
* device instance $165 r0 *1 1145.24,3.11 pfet
X$165 \$560 \$330 \$331 VDD_DIV sg13_hv_pmos L=0.5U W=5U AS=2P AD=2P PS=10.8U
+ PD=10.8U
* device instance $166 r0 *1 1152.2,3.11 pfet
X$166 \$561 \$332 \$333 VDD_DIV sg13_hv_pmos L=0.5U W=5U AS=2P AD=2P PS=10.8U
+ PD=10.8U
* device instance $167 r0 *1 1159.16,3.11 pfet
X$167 \$562 \$334 \$335 VDD_DIV sg13_hv_pmos L=0.5U W=5U AS=2P AD=2P PS=10.8U
+ PD=10.8U
* device instance $168 r0 *1 1166.12,3.11 pfet
X$168 \$563 \$336 \$337 VDD_DIV sg13_hv_pmos L=0.5U W=5U AS=2P AD=2P PS=10.8U
+ PD=10.8U
* device instance $169 r0 *1 1173.08,3.11 pfet
X$169 \$564 \$338 \$339 VDD_DIV sg13_hv_pmos L=0.5U W=5U AS=2P AD=2P PS=10.8U
+ PD=10.8U
* device instance $170 r0 *1 1180.04,3.11 pfet
X$170 \$565 \$340 \$341 VDD_DIV sg13_hv_pmos L=0.5U W=5U AS=2P AD=2P PS=10.8U
+ PD=10.8U
* device instance $171 r0 *1 1187,3.11 pfet
X$171 \$566 \$342 \$343 VDD_DIV sg13_hv_pmos L=0.5U W=5U AS=2P AD=2P PS=10.8U
+ PD=10.8U
* device instance $172 r0 *1 1193.96,3.11 pfet
X$172 \$567 \$344 \$345 VDD_DIV sg13_hv_pmos L=0.5U W=5U AS=2P AD=2P PS=10.8U
+ PD=10.8U
* device instance $173 r0 *1 1200.92,3.11 pfet
X$173 \$568 \$346 \$347 VDD_DIV sg13_hv_pmos L=0.5U W=5U AS=2P AD=2P PS=10.8U
+ PD=10.8U
* device instance $174 r0 *1 1207.88,3.11 pfet
X$174 \$569 \$348 \$349 VDD_DIV sg13_hv_pmos L=0.5U W=5U AS=2P AD=2P PS=10.8U
+ PD=10.8U
* device instance $175 r0 *1 1214.84,3.11 pfet
X$175 \$570 \$350 \$351 VDD_DIV sg13_hv_pmos L=0.5U W=5U AS=2P AD=2P PS=10.8U
+ PD=10.8U
* device instance $176 r0 *1 1221.8,3.11 pfet
X$176 \$571 \$352 \$353 VDD_DIV sg13_hv_pmos L=0.5U W=5U AS=2P AD=2P PS=10.8U
+ PD=10.8U
* device instance $177 r0 *1 1228.76,3.11 pfet
X$177 \$572 \$354 \$355 VDD_DIV sg13_hv_pmos L=0.5U W=5U AS=2P AD=2P PS=10.8U
+ PD=10.8U
* device instance $178 r0 *1 1235.72,3.11 pfet
X$178 \$573 \$356 \$357 VDD_DIV sg13_hv_pmos L=0.5U W=5U AS=2P AD=2P PS=10.8U
+ PD=10.8U
* device instance $179 r0 *1 1242.68,3.11 pfet
X$179 \$574 \$358 \$359 VDD_DIV sg13_hv_pmos L=0.5U W=5U AS=2P AD=2P PS=10.8U
+ PD=10.8U
* device instance $180 r0 *1 1249.64,3.11 pfet
X$180 \$575 \$360 \$361 VDD_DIV sg13_hv_pmos L=0.5U W=5U AS=2P AD=2P PS=10.8U
+ PD=10.8U
* device instance $181 r0 *1 1256.6,3.11 pfet
X$181 \$576 \$362 \$363 VDD_DIV sg13_hv_pmos L=0.5U W=5U AS=2P AD=2P PS=10.8U
+ PD=10.8U
* device instance $182 r0 *1 1263.56,3.11 pfet
X$182 \$577 \$364 \$365 VDD_DIV sg13_hv_pmos L=0.5U W=5U AS=2P AD=2P PS=10.8U
+ PD=10.8U
* device instance $183 r0 *1 1270.52,3.11 pfet
X$183 \$578 \$366 \$367 VDD_DIV sg13_hv_pmos L=0.5U W=5U AS=2P AD=2P PS=10.8U
+ PD=10.8U
* device instance $184 r0 *1 1277.48,3.11 pfet
X$184 \$579 \$368 \$369 VDD_DIV sg13_hv_pmos L=0.5U W=5U AS=2P AD=2P PS=10.8U
+ PD=10.8U
* device instance $185 r0 *1 1284.44,3.11 pfet
X$185 \$580 \$370 \$371 VDD_DIV sg13_hv_pmos L=0.5U W=5U AS=2P AD=2P PS=10.8U
+ PD=10.8U
* device instance $186 r0 *1 1291.4,3.11 pfet
X$186 \$581 \$372 \$373 VDD_DIV sg13_hv_pmos L=0.5U W=5U AS=2P AD=2P PS=10.8U
+ PD=10.8U
* device instance $187 r0 *1 1298.36,3.11 pfet
X$187 \$582 \$374 \$375 VDD_DIV sg13_hv_pmos L=0.5U W=5U AS=2P AD=2P PS=10.8U
+ PD=10.8U
* device instance $188 r0 *1 1305.32,3.11 pfet
X$188 \$583 \$376 \$377 VDD_DIV sg13_hv_pmos L=0.5U W=5U AS=2P AD=2P PS=10.8U
+ PD=10.8U
* device instance $189 r0 *1 1312.28,3.11 pfet
X$189 \$584 \$378 \$379 VDD_DIV sg13_hv_pmos L=0.5U W=5U AS=2P AD=2P PS=10.8U
+ PD=10.8U
* device instance $190 r0 *1 1319.24,3.11 pfet
X$190 \$585 \$380 \$381 VDD_DIV sg13_hv_pmos L=0.5U W=5U AS=2P AD=2P PS=10.8U
+ PD=10.8U
* device instance $191 r0 *1 1326.2,3.11 pfet
X$191 \$586 \$382 \$383 VDD_DIV sg13_hv_pmos L=0.5U W=5U AS=2P AD=2P PS=10.8U
+ PD=10.8U
* device instance $192 r0 *1 1333.16,3.11 pfet
X$192 \$587 \$384 \$385 VDD_DIV sg13_hv_pmos L=0.5U W=5U AS=2P AD=2P PS=10.8U
+ PD=10.8U
* device instance $193 r0 *1 1340.12,3.11 pfet
X$193 \$588 \$386 \$387 VDD_DIV sg13_hv_pmos L=0.5U W=5U AS=2P AD=2P PS=10.8U
+ PD=10.8U
* device instance $194 r0 *1 1347.08,3.11 pfet
X$194 \$589 \$388 \$389 VDD_DIV sg13_hv_pmos L=0.5U W=5U AS=2P AD=2P PS=10.8U
+ PD=10.8U
* device instance $195 r0 *1 1354.04,3.11 pfet
X$195 \$590 \$390 \$391 VDD_DIV sg13_hv_pmos L=0.5U W=5U AS=2P AD=2P PS=10.8U
+ PD=10.8U
* device instance $196 r0 *1 1361,3.11 pfet
X$196 \$591 \$392 \$393 VDD_DIV sg13_hv_pmos L=0.5U W=5U AS=2P AD=2P PS=10.8U
+ PD=10.8U
* device instance $197 r0 *1 1367.96,3.11 pfet
X$197 \$592 \$394 \$395 VDD_DIV sg13_hv_pmos L=0.5U W=5U AS=2P AD=2P PS=10.8U
+ PD=10.8U
.ENDS divider_chain_pfet_w5_l0p5
