* extracted by klt extract --deck sg13cmos5l

* cell loop_filter_XC1
.SUBCKT loop_filter_XC1
* device instance $1 r0 *1 0,0 cap_cmomi
XD_$1 \$1 \$2 cap_cmomi PARAMS: W=40 L=40
.ENDS loop_filter_XC1
