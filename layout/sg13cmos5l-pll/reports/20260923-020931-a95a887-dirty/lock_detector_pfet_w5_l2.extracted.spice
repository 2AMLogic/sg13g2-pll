* extracted by klt extract --deck sg13cmos5l

* cell lock_detector_pfet_w5_l2
* pin VDD
.SUBCKT lock_detector_pfet_w5_l2 VDD
* device instance $1 r0 *1 3.8,3.86 pfet
X$1 \$8 \$2 \$3 VDD sg13_hv_pmos L=2U W=5U AS=2P AD=2P PS=10.8U PD=10.8U
* device instance $2 r0 *1 10.76,3.86 pfet
X$2 \$9 \$4 \$5 VDD sg13_hv_pmos L=2U W=5U AS=2P AD=2P PS=10.8U PD=10.8U
* device instance $3 r0 *1 17.72,3.86 pfet
X$3 \$10 \$6 \$7 VDD sg13_hv_pmos L=2U W=5U AS=2P AD=2P PS=10.8U PD=10.8U
.ENDS lock_detector_pfet_w5_l2
