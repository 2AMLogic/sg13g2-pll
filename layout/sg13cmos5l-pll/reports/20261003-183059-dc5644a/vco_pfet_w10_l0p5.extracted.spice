* extracted by klt extract --deck sg13cmos5l

* cell vco_pfet_w10_l0p5
* pin VDD_VCO
.SUBCKT vco_pfet_w10_l0p5 VDD_VCO
* device instance $1 r0 *1 6.3,3.11 pfet
X$1 \$16 \$2 \$3 VDD_VCO sg13_hv_pmos L=0.5U W=10U AS=4P AD=4P PS=20.8U PD=20.8U
* device instance $2 r0 *1 18.26,3.11 pfet
X$2 \$17 \$4 \$5 VDD_VCO sg13_hv_pmos L=0.5U W=10U AS=4P AD=4P PS=20.8U PD=20.8U
* device instance $3 r0 *1 30.22,3.11 pfet
X$3 \$18 \$6 \$7 VDD_VCO sg13_hv_pmos L=0.5U W=10U AS=4P AD=4P PS=20.8U PD=20.8U
* device instance $4 r0 *1 42.18,3.11 pfet
X$4 \$19 \$8 \$9 VDD_VCO sg13_hv_pmos L=0.5U W=10U AS=4P AD=4P PS=20.8U PD=20.8U
* device instance $5 r0 *1 54.14,3.11 pfet
X$5 \$20 \$10 \$11 VDD_VCO sg13_hv_pmos L=0.5U W=10U AS=4P AD=4P PS=20.8U
+ PD=20.8U
* device instance $6 r0 *1 66.1,3.11 pfet
X$6 \$21 \$12 \$13 VDD_VCO sg13_hv_pmos L=0.5U W=10U AS=4P AD=4P PS=20.8U
+ PD=20.8U
* device instance $7 r0 *1 78.06,3.11 pfet
X$7 \$22 \$14 \$15 VDD_VCO sg13_hv_pmos L=0.5U W=10U AS=4P AD=4P PS=20.8U
+ PD=20.8U
.ENDS vco_pfet_w10_l0p5
