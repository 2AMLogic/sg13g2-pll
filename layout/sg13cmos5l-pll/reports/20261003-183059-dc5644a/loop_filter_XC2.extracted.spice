* extracted by klt extract --deck sg13cmos5l

* cell loop_filter_XC2
.SUBCKT loop_filter_XC2
* device instance $1 r0 *1 0,0 cap_cmomi
XD_$1 \$1 \$2 cap_cmomi PARAMS: W=10 L=10
.ENDS loop_filter_XC2
