* sg13g2-pll :: cp (SG13CMOS5L) -- generated by design/sg13cmos5l/netlist.sh from cp.sch
* xschem XSCHEM V3.4.7; do not edit by hand.
** sch_path: design/sg13cmos5l/cp.sch
.subckt cp UP DN IBP ICP IBN ICN VOUT VDD VSS
*.ipin UP
*.ipin DN
*.iopin IBP
*.iopin ICP
*.iopin IBN
*.iopin ICN
*.opin VOUT
*.iopin VDD
*.iopin VSS
XIUP UP UPB VDD VSS inv_hv
XIDN DN DNB VDD VSS inv_hv
XLEGP IBP ICP UP UPB VOUT VDUMP VDD cp_leg_p
XLEGN IBN ICN DN DNB VOUT VDUMP VSS cp_leg_n
XBUF VOUT IBN VDUMP VDD VSS cp_dumpbuf
MBP nxp IBP VDD VDD pfet L=1U W=24U
MBPC IBP ICP nxp VDD pfet L=1U W=24U
MCP ICP ICP VDD VDD pfet L=3U W=6U
MBN nxn IBN VSS VSS nfet L=1U W=8U
MBNC IBN ICN nxn VSS nfet L=1U W=8U
MCN ICN ICN VSS VSS nfet L=3U W=2U
.ends

* expanding   symbol:  inv_hv.sym # of pins=4
** sym_path: design/sg13cmos5l/inv_hv.sym
** sch_path: design/sg13cmos5l/inv_hv.sch
.subckt inv_hv A Y VDD VSS
*.ipin A
*.opin Y
*.iopin VDD
*.iopin VSS
MP Y A VDD VDD pfet L=0.5U W=5U
MN Y A VSS VSS nfet L=0.5U W=2U
.ends

* expanding   symbol:  cp_leg_p.sym # of pins=7
** sym_path: design/sg13cmos5l/cp_leg_p.sym
** sch_path: design/sg13cmos5l/cp_leg_p.sch
.subckt cp_leg_p IBP ICP UP UPB VOUT VDUMP VDD
*.ipin IBP
*.ipin ICP
*.ipin UP
*.ipin UPB
*.opin VOUT
*.opin VDUMP
*.iopin VDD
M1 tail IBP VDD VDD pfet L=1U W=24U
M2 sw ICP tail VDD pfet L=1U W=24U
MSWO VOUT UPB sw VDD pfet L=0.3U W=6U
MSWD VDUMP UP sw VDD pfet L=0.3U W=6U
.ends

* expanding   symbol:  cp_leg_n.sym # of pins=7
** sym_path: design/sg13cmos5l/cp_leg_n.sym
** sch_path: design/sg13cmos5l/cp_leg_n.sch
.subckt cp_leg_n IBN ICN DN DNB VOUT VDUMP VSS
*.ipin IBN
*.ipin ICN
*.ipin DNB
*.ipin DN
*.opin VOUT
*.opin VDUMP
*.iopin VSS
M1 tail IBN VSS VSS nfet L=1U W=8U
M2 sw ICN tail VSS nfet L=1U W=8U
MSWO VOUT DN sw VSS nfet L=0.3U W=6U
MSWD VDUMP DNB sw VSS nfet L=0.3U W=6U
.ends

* expanding   symbol:  cp_dumpbuf.sym # of pins=5
** sym_path: design/sg13cmos5l/cp_dumpbuf.sym
** sch_path: design/sg13cmos5l/cp_dumpbuf.sch
.subckt cp_dumpbuf VOUT IBIAS VDUMP VDD VSS
*.ipin VOUT
*.ipin IBIAS
*.opin VDUMP
*.iopin VDD
*.iopin VSS
M1 VDD VOUT VDUMP VSS nfet L=0.5U W=6U
M2 VDUMP IBIAS VSS VSS nfet L=1U W=4U
.ends
