* extracted by klt extract --deck sg13cmos5l

* cell vco_pfet_w6_l1
* pin VDD_VCO
.SUBCKT vco_pfet_w6_l1 VDD_VCO
* device instance $1 r0 *1 4.3,3.36 pfet
X$1 \$6 \$2 \$3 VDD_VCO sg13_hv_pmos L=1U W=6U AS=2.4P AD=2.4P PS=12.8U PD=12.8U
* device instance $2 r0 *1 12.26,3.36 pfet
X$2 \$7 \$4 \$5 VDD_VCO sg13_hv_pmos L=1U W=6U AS=2.4P AD=2.4P PS=12.8U PD=12.8U
.ENDS vco_pfet_w6_l1
