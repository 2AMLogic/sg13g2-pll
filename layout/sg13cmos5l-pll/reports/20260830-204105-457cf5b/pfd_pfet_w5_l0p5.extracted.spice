* extracted by klt extract --deck sg13cmos5l

* cell pfd_pfet_w5_l0p5
* pin VDD
.SUBCKT pfd_pfet_w5_l0p5 VDD
* device instance $1 r0 *1 3.8,3.11 pfet
X$1 \$66 \$2 \$3 VDD sg13_hv_pmos L=0.5U W=5U AS=2P AD=2P PS=10.8U PD=10.8U
* device instance $2 r0 *1 10.76,3.11 pfet
X$2 \$67 \$4 \$5 VDD sg13_hv_pmos L=0.5U W=5U AS=2P AD=2P PS=10.8U PD=10.8U
* device instance $3 r0 *1 17.72,3.11 pfet
X$3 \$68 \$6 \$7 VDD sg13_hv_pmos L=0.5U W=5U AS=2P AD=2P PS=10.8U PD=10.8U
* device instance $4 r0 *1 24.68,3.11 pfet
X$4 \$69 \$8 \$9 VDD sg13_hv_pmos L=0.5U W=5U AS=2P AD=2P PS=10.8U PD=10.8U
* device instance $5 r0 *1 31.64,3.11 pfet
X$5 \$70 \$10 \$11 VDD sg13_hv_pmos L=0.5U W=5U AS=2P AD=2P PS=10.8U PD=10.8U
* device instance $6 r0 *1 38.6,3.11 pfet
X$6 \$71 \$12 \$13 VDD sg13_hv_pmos L=0.5U W=5U AS=2P AD=2P PS=10.8U PD=10.8U
* device instance $7 r0 *1 45.56,3.11 pfet
X$7 \$72 \$14 \$15 VDD sg13_hv_pmos L=0.5U W=5U AS=2P AD=2P PS=10.8U PD=10.8U
* device instance $8 r0 *1 52.52,3.11 pfet
X$8 \$73 \$16 \$17 VDD sg13_hv_pmos L=0.5U W=5U AS=2P AD=2P PS=10.8U PD=10.8U
* device instance $9 r0 *1 59.48,3.11 pfet
X$9 \$74 \$18 \$19 VDD sg13_hv_pmos L=0.5U W=5U AS=2P AD=2P PS=10.8U PD=10.8U
* device instance $10 r0 *1 66.44,3.11 pfet
X$10 \$75 \$20 \$21 VDD sg13_hv_pmos L=0.5U W=5U AS=2P AD=2P PS=10.8U PD=10.8U
* device instance $11 r0 *1 73.4,3.11 pfet
X$11 \$76 \$22 \$23 VDD sg13_hv_pmos L=0.5U W=5U AS=2P AD=2P PS=10.8U PD=10.8U
* device instance $12 r0 *1 80.36,3.11 pfet
X$12 \$77 \$24 \$25 VDD sg13_hv_pmos L=0.5U W=5U AS=2P AD=2P PS=10.8U PD=10.8U
* device instance $13 r0 *1 87.32,3.11 pfet
X$13 \$78 \$26 \$27 VDD sg13_hv_pmos L=0.5U W=5U AS=2P AD=2P PS=10.8U PD=10.8U
* device instance $14 r0 *1 94.28,3.11 pfet
X$14 \$79 \$28 \$29 VDD sg13_hv_pmos L=0.5U W=5U AS=2P AD=2P PS=10.8U PD=10.8U
* device instance $15 r0 *1 101.24,3.11 pfet
X$15 \$80 \$30 \$31 VDD sg13_hv_pmos L=0.5U W=5U AS=2P AD=2P PS=10.8U PD=10.8U
* device instance $16 r0 *1 108.2,3.11 pfet
X$16 \$81 \$32 \$33 VDD sg13_hv_pmos L=0.5U W=5U AS=2P AD=2P PS=10.8U PD=10.8U
* device instance $17 r0 *1 115.16,3.11 pfet
X$17 \$82 \$34 \$35 VDD sg13_hv_pmos L=0.5U W=5U AS=2P AD=2P PS=10.8U PD=10.8U
* device instance $18 r0 *1 122.12,3.11 pfet
X$18 \$83 \$36 \$37 VDD sg13_hv_pmos L=0.5U W=5U AS=2P AD=2P PS=10.8U PD=10.8U
* device instance $19 r0 *1 129.08,3.11 pfet
X$19 \$84 \$38 \$39 VDD sg13_hv_pmos L=0.5U W=5U AS=2P AD=2P PS=10.8U PD=10.8U
* device instance $20 r0 *1 136.04,3.11 pfet
X$20 \$85 \$40 \$41 VDD sg13_hv_pmos L=0.5U W=5U AS=2P AD=2P PS=10.8U PD=10.8U
* device instance $21 r0 *1 143,3.11 pfet
X$21 \$86 \$42 \$43 VDD sg13_hv_pmos L=0.5U W=5U AS=2P AD=2P PS=10.8U PD=10.8U
* device instance $22 r0 *1 149.96,3.11 pfet
X$22 \$87 \$44 \$45 VDD sg13_hv_pmos L=0.5U W=5U AS=2P AD=2P PS=10.8U PD=10.8U
* device instance $23 r0 *1 156.92,3.11 pfet
X$23 \$88 \$46 \$47 VDD sg13_hv_pmos L=0.5U W=5U AS=2P AD=2P PS=10.8U PD=10.8U
* device instance $24 r0 *1 163.88,3.11 pfet
X$24 \$89 \$48 \$49 VDD sg13_hv_pmos L=0.5U W=5U AS=2P AD=2P PS=10.8U PD=10.8U
* device instance $25 r0 *1 170.84,3.11 pfet
X$25 \$90 \$50 \$51 VDD sg13_hv_pmos L=0.5U W=5U AS=2P AD=2P PS=10.8U PD=10.8U
* device instance $26 r0 *1 177.8,3.11 pfet
X$26 \$91 \$52 \$53 VDD sg13_hv_pmos L=0.5U W=5U AS=2P AD=2P PS=10.8U PD=10.8U
* device instance $27 r0 *1 184.76,3.11 pfet
X$27 \$92 \$54 \$55 VDD sg13_hv_pmos L=0.5U W=5U AS=2P AD=2P PS=10.8U PD=10.8U
* device instance $28 r0 *1 191.72,3.11 pfet
X$28 \$93 \$56 \$57 VDD sg13_hv_pmos L=0.5U W=5U AS=2P AD=2P PS=10.8U PD=10.8U
* device instance $29 r0 *1 198.68,3.11 pfet
X$29 \$94 \$58 \$59 VDD sg13_hv_pmos L=0.5U W=5U AS=2P AD=2P PS=10.8U PD=10.8U
* device instance $30 r0 *1 205.64,3.11 pfet
X$30 \$95 \$60 \$61 VDD sg13_hv_pmos L=0.5U W=5U AS=2P AD=2P PS=10.8U PD=10.8U
* device instance $31 r0 *1 212.6,3.11 pfet
X$31 \$96 \$62 \$63 VDD sg13_hv_pmos L=0.5U W=5U AS=2P AD=2P PS=10.8U PD=10.8U
* device instance $32 r0 *1 219.56,3.11 pfet
X$32 \$97 \$64 \$65 VDD sg13_hv_pmos L=0.5U W=5U AS=2P AD=2P PS=10.8U PD=10.8U
.ENDS pfd_pfet_w5_l0p5
