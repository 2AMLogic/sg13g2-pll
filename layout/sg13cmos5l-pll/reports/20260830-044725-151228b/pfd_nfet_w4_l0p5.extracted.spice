* extracted by klt extract --deck sg13cmos5l

* cell pfd_nfet_w4_l0p5
* pin vsubs
.SUBCKT pfd_nfet_w4_l0p5 vsubs
* device instance $1 r0 *1 3.3,3.11 nfet
X$1 \$2 \$1 \$3 vsubs sg13_hv_nmos L=0.5U W=4U AS=1.6P AD=1.6P PS=8.8U PD=8.8U
.ENDS pfd_nfet_w4_l0p5
