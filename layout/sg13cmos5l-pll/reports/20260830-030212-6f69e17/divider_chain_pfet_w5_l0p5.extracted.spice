* extracted by klt extract --deck sg13cmos5l

* cell divider_chain_pfet_w5_l0p5
* pin divider_chain_pfet_w5_l0p5_B
.SUBCKT divider_chain_pfet_w5_l0p5 divider_chain_pfet_w5_l0p5_B
* device instance $1 r0 *1 3.7,3.11 pfet
X$1 \$160 \$2 \$3 divider_chain_pfet_w5_l0p5_B sg13_hv_pmos L=0.5U W=5U AS=2P
+ AD=2P PS=10.8U PD=10.8U
* device instance $2 r0 *1 10.46,3.11 pfet
X$2 \$161 \$4 \$5 divider_chain_pfet_w5_l0p5_B sg13_hv_pmos L=0.5U W=5U AS=2P
+ AD=2P PS=10.8U PD=10.8U
* device instance $3 r0 *1 17.22,3.11 pfet
X$3 \$162 \$6 \$7 divider_chain_pfet_w5_l0p5_B sg13_hv_pmos L=0.5U W=5U AS=2P
+ AD=2P PS=10.8U PD=10.8U
* device instance $4 r0 *1 23.98,3.11 pfet
X$4 \$163 \$8 \$9 divider_chain_pfet_w5_l0p5_B sg13_hv_pmos L=0.5U W=5U AS=2P
+ AD=2P PS=10.8U PD=10.8U
* device instance $5 r0 *1 30.74,3.11 pfet
X$5 \$164 \$10 \$11 divider_chain_pfet_w5_l0p5_B sg13_hv_pmos L=0.5U W=5U AS=2P
+ AD=2P PS=10.8U PD=10.8U
* device instance $6 r0 *1 37.5,3.11 pfet
X$6 \$165 \$12 \$13 divider_chain_pfet_w5_l0p5_B sg13_hv_pmos L=0.5U W=5U AS=2P
+ AD=2P PS=10.8U PD=10.8U
* device instance $7 r0 *1 44.26,3.11 pfet
X$7 \$166 \$14 \$15 divider_chain_pfet_w5_l0p5_B sg13_hv_pmos L=0.5U W=5U AS=2P
+ AD=2P PS=10.8U PD=10.8U
* device instance $8 r0 *1 51.02,3.11 pfet
X$8 \$167 \$16 \$17 divider_chain_pfet_w5_l0p5_B sg13_hv_pmos L=0.5U W=5U AS=2P
+ AD=2P PS=10.8U PD=10.8U
* device instance $9 r0 *1 57.78,3.11 pfet
X$9 \$168 \$18 \$19 divider_chain_pfet_w5_l0p5_B sg13_hv_pmos L=0.5U W=5U AS=2P
+ AD=2P PS=10.8U PD=10.8U
* device instance $10 r0 *1 64.54,3.11 pfet
X$10 \$169 \$20 \$21 divider_chain_pfet_w5_l0p5_B sg13_hv_pmos L=0.5U W=5U
+ AS=2P AD=2P PS=10.8U PD=10.8U
* device instance $11 r0 *1 71.3,3.11 pfet
X$11 \$170 \$22 \$23 divider_chain_pfet_w5_l0p5_B sg13_hv_pmos L=0.5U W=5U
+ AS=2P AD=2P PS=10.8U PD=10.8U
* device instance $12 r0 *1 78.06,3.11 pfet
X$12 \$171 \$24 \$25 divider_chain_pfet_w5_l0p5_B sg13_hv_pmos L=0.5U W=5U
+ AS=2P AD=2P PS=10.8U PD=10.8U
* device instance $13 r0 *1 84.82,3.11 pfet
X$13 \$172 \$26 \$27 divider_chain_pfet_w5_l0p5_B sg13_hv_pmos L=0.5U W=5U
+ AS=2P AD=2P PS=10.8U PD=10.8U
* device instance $14 r0 *1 91.58,3.11 pfet
X$14 \$173 \$28 \$29 divider_chain_pfet_w5_l0p5_B sg13_hv_pmos L=0.5U W=5U
+ AS=2P AD=2P PS=10.8U PD=10.8U
* device instance $15 r0 *1 98.34,3.11 pfet
X$15 \$174 \$30 \$31 divider_chain_pfet_w5_l0p5_B sg13_hv_pmos L=0.5U W=5U
+ AS=2P AD=2P PS=10.8U PD=10.8U
* device instance $16 r0 *1 105.1,3.11 pfet
X$16 \$175 \$32 \$33 divider_chain_pfet_w5_l0p5_B sg13_hv_pmos L=0.5U W=5U
+ AS=2P AD=2P PS=10.8U PD=10.8U
* device instance $17 r0 *1 111.86,3.11 pfet
X$17 \$176 \$34 \$35 divider_chain_pfet_w5_l0p5_B sg13_hv_pmos L=0.5U W=5U
+ AS=2P AD=2P PS=10.8U PD=10.8U
* device instance $18 r0 *1 118.62,3.11 pfet
X$18 \$177 \$36 \$37 divider_chain_pfet_w5_l0p5_B sg13_hv_pmos L=0.5U W=5U
+ AS=2P AD=2P PS=10.8U PD=10.8U
* device instance $19 r0 *1 125.38,3.11 pfet
X$19 \$178 \$38 \$39 divider_chain_pfet_w5_l0p5_B sg13_hv_pmos L=0.5U W=5U
+ AS=2P AD=2P PS=10.8U PD=10.8U
* device instance $20 r0 *1 132.14,3.11 pfet
X$20 \$179 \$40 \$41 divider_chain_pfet_w5_l0p5_B sg13_hv_pmos L=0.5U W=5U
+ AS=2P AD=2P PS=10.8U PD=10.8U
* device instance $21 r0 *1 138.9,3.11 pfet
X$21 \$180 \$42 \$43 divider_chain_pfet_w5_l0p5_B sg13_hv_pmos L=0.5U W=5U
+ AS=2P AD=2P PS=10.8U PD=10.8U
* device instance $22 r0 *1 145.66,3.11 pfet
X$22 \$181 \$44 \$45 divider_chain_pfet_w5_l0p5_B sg13_hv_pmos L=0.5U W=5U
+ AS=2P AD=2P PS=10.8U PD=10.8U
* device instance $23 r0 *1 152.42,3.11 pfet
X$23 \$182 \$46 \$47 divider_chain_pfet_w5_l0p5_B sg13_hv_pmos L=0.5U W=5U
+ AS=2P AD=2P PS=10.8U PD=10.8U
* device instance $24 r0 *1 159.18,3.11 pfet
X$24 \$183 \$48 \$49 divider_chain_pfet_w5_l0p5_B sg13_hv_pmos L=0.5U W=5U
+ AS=2P AD=2P PS=10.8U PD=10.8U
* device instance $25 r0 *1 165.94,3.11 pfet
X$25 \$184 \$50 \$51 divider_chain_pfet_w5_l0p5_B sg13_hv_pmos L=0.5U W=5U
+ AS=2P AD=2P PS=10.8U PD=10.8U
* device instance $26 r0 *1 172.7,3.11 pfet
X$26 \$185 \$52 \$53 divider_chain_pfet_w5_l0p5_B sg13_hv_pmos L=0.5U W=5U
+ AS=2P AD=2P PS=10.8U PD=10.8U
* device instance $27 r0 *1 179.46,3.11 pfet
X$27 \$186 \$54 \$55 divider_chain_pfet_w5_l0p5_B sg13_hv_pmos L=0.5U W=5U
+ AS=2P AD=2P PS=10.8U PD=10.8U
* device instance $28 r0 *1 186.22,3.11 pfet
X$28 \$187 \$56 \$57 divider_chain_pfet_w5_l0p5_B sg13_hv_pmos L=0.5U W=5U
+ AS=2P AD=2P PS=10.8U PD=10.8U
* device instance $29 r0 *1 192.98,3.11 pfet
X$29 \$188 \$58 \$59 divider_chain_pfet_w5_l0p5_B sg13_hv_pmos L=0.5U W=5U
+ AS=2P AD=2P PS=10.8U PD=10.8U
* device instance $30 r0 *1 199.74,3.11 pfet
X$30 \$189 \$60 \$61 divider_chain_pfet_w5_l0p5_B sg13_hv_pmos L=0.5U W=5U
+ AS=2P AD=2P PS=10.8U PD=10.8U
* device instance $31 r0 *1 206.5,3.11 pfet
X$31 \$190 \$62 \$63 divider_chain_pfet_w5_l0p5_B sg13_hv_pmos L=0.5U W=5U
+ AS=2P AD=2P PS=10.8U PD=10.8U
* device instance $32 r0 *1 213.26,3.11 pfet
X$32 \$191 \$64 \$65 divider_chain_pfet_w5_l0p5_B sg13_hv_pmos L=0.5U W=5U
+ AS=2P AD=2P PS=10.8U PD=10.8U
* device instance $33 r0 *1 220.02,3.11 pfet
X$33 \$192 \$66 \$67 divider_chain_pfet_w5_l0p5_B sg13_hv_pmos L=0.5U W=5U
+ AS=2P AD=2P PS=10.8U PD=10.8U
* device instance $34 r0 *1 226.78,3.11 pfet
X$34 \$193 \$68 \$69 divider_chain_pfet_w5_l0p5_B sg13_hv_pmos L=0.5U W=5U
+ AS=2P AD=2P PS=10.8U PD=10.8U
* device instance $35 r0 *1 233.54,3.11 pfet
X$35 \$194 \$70 \$71 divider_chain_pfet_w5_l0p5_B sg13_hv_pmos L=0.5U W=5U
+ AS=2P AD=2P PS=10.8U PD=10.8U
* device instance $36 r0 *1 240.3,3.11 pfet
X$36 \$195 \$72 \$73 divider_chain_pfet_w5_l0p5_B sg13_hv_pmos L=0.5U W=5U
+ AS=2P AD=2P PS=10.8U PD=10.8U
* device instance $37 r0 *1 247.06,3.11 pfet
X$37 \$196 \$74 \$75 divider_chain_pfet_w5_l0p5_B sg13_hv_pmos L=0.5U W=5U
+ AS=2P AD=2P PS=10.8U PD=10.8U
* device instance $38 r0 *1 253.82,3.11 pfet
X$38 \$197 \$76 \$77 divider_chain_pfet_w5_l0p5_B sg13_hv_pmos L=0.5U W=5U
+ AS=2P AD=2P PS=10.8U PD=10.8U
* device instance $39 r0 *1 260.58,3.11 pfet
X$39 \$198 \$78 \$79 divider_chain_pfet_w5_l0p5_B sg13_hv_pmos L=0.5U W=5U
+ AS=2P AD=2P PS=10.8U PD=10.8U
* device instance $40 r0 *1 267.34,3.11 pfet
X$40 \$199 \$80 \$81 divider_chain_pfet_w5_l0p5_B sg13_hv_pmos L=0.5U W=5U
+ AS=2P AD=2P PS=10.8U PD=10.8U
* device instance $41 r0 *1 274.1,3.11 pfet
X$41 \$200 \$82 \$83 divider_chain_pfet_w5_l0p5_B sg13_hv_pmos L=0.5U W=5U
+ AS=2P AD=2P PS=10.8U PD=10.8U
* device instance $42 r0 *1 280.86,3.11 pfet
X$42 \$201 \$84 \$85 divider_chain_pfet_w5_l0p5_B sg13_hv_pmos L=0.5U W=5U
+ AS=2P AD=2P PS=10.8U PD=10.8U
* device instance $43 r0 *1 287.62,3.11 pfet
X$43 \$202 \$86 \$87 divider_chain_pfet_w5_l0p5_B sg13_hv_pmos L=0.5U W=5U
+ AS=2P AD=2P PS=10.8U PD=10.8U
* device instance $44 r0 *1 294.38,3.11 pfet
X$44 \$203 \$88 \$89 divider_chain_pfet_w5_l0p5_B sg13_hv_pmos L=0.5U W=5U
+ AS=2P AD=2P PS=10.8U PD=10.8U
* device instance $45 r0 *1 301.14,3.11 pfet
X$45 \$204 \$90 \$91 divider_chain_pfet_w5_l0p5_B sg13_hv_pmos L=0.5U W=5U
+ AS=2P AD=2P PS=10.8U PD=10.8U
* device instance $46 r0 *1 307.9,3.11 pfet
X$46 \$205 \$92 \$93 divider_chain_pfet_w5_l0p5_B sg13_hv_pmos L=0.5U W=5U
+ AS=2P AD=2P PS=10.8U PD=10.8U
* device instance $47 r0 *1 314.66,3.11 pfet
X$47 \$206 \$94 \$95 divider_chain_pfet_w5_l0p5_B sg13_hv_pmos L=0.5U W=5U
+ AS=2P AD=2P PS=10.8U PD=10.8U
* device instance $48 r0 *1 321.42,3.11 pfet
X$48 \$207 \$96 \$97 divider_chain_pfet_w5_l0p5_B sg13_hv_pmos L=0.5U W=5U
+ AS=2P AD=2P PS=10.8U PD=10.8U
* device instance $49 r0 *1 328.18,3.11 pfet
X$49 \$208 \$98 \$99 divider_chain_pfet_w5_l0p5_B sg13_hv_pmos L=0.5U W=5U
+ AS=2P AD=2P PS=10.8U PD=10.8U
* device instance $50 r0 *1 334.94,3.11 pfet
X$50 \$209 \$100 \$101 divider_chain_pfet_w5_l0p5_B sg13_hv_pmos L=0.5U W=5U
+ AS=2P AD=2P PS=10.8U PD=10.8U
* device instance $51 r0 *1 341.7,3.11 pfet
X$51 \$210 \$102 \$103 divider_chain_pfet_w5_l0p5_B sg13_hv_pmos L=0.5U W=5U
+ AS=2P AD=2P PS=10.8U PD=10.8U
* device instance $52 r0 *1 348.46,3.11 pfet
X$52 \$211 \$104 \$105 divider_chain_pfet_w5_l0p5_B sg13_hv_pmos L=0.5U W=5U
+ AS=2P AD=2P PS=10.8U PD=10.8U
* device instance $53 r0 *1 355.22,3.11 pfet
X$53 \$212 \$106 \$107 divider_chain_pfet_w5_l0p5_B sg13_hv_pmos L=0.5U W=5U
+ AS=2P AD=2P PS=10.8U PD=10.8U
* device instance $54 r0 *1 361.98,3.11 pfet
X$54 \$213 \$108 \$109 divider_chain_pfet_w5_l0p5_B sg13_hv_pmos L=0.5U W=5U
+ AS=2P AD=2P PS=10.8U PD=10.8U
* device instance $55 r0 *1 368.74,3.11 pfet
X$55 \$214 \$110 \$111 divider_chain_pfet_w5_l0p5_B sg13_hv_pmos L=0.5U W=5U
+ AS=2P AD=2P PS=10.8U PD=10.8U
* device instance $56 r0 *1 375.5,3.11 pfet
X$56 \$215 \$112 \$113 divider_chain_pfet_w5_l0p5_B sg13_hv_pmos L=0.5U W=5U
+ AS=2P AD=2P PS=10.8U PD=10.8U
* device instance $57 r0 *1 382.26,3.11 pfet
X$57 \$216 \$114 \$115 divider_chain_pfet_w5_l0p5_B sg13_hv_pmos L=0.5U W=5U
+ AS=2P AD=2P PS=10.8U PD=10.8U
* device instance $58 r0 *1 389.02,3.11 pfet
X$58 \$217 \$116 \$117 divider_chain_pfet_w5_l0p5_B sg13_hv_pmos L=0.5U W=5U
+ AS=2P AD=2P PS=10.8U PD=10.8U
* device instance $59 r0 *1 395.78,3.11 pfet
X$59 \$218 \$118 \$119 divider_chain_pfet_w5_l0p5_B sg13_hv_pmos L=0.5U W=5U
+ AS=2P AD=2P PS=10.8U PD=10.8U
* device instance $60 r0 *1 402.54,3.11 pfet
X$60 \$219 \$120 \$121 divider_chain_pfet_w5_l0p5_B sg13_hv_pmos L=0.5U W=5U
+ AS=2P AD=2P PS=10.8U PD=10.8U
* device instance $61 r0 *1 409.3,3.11 pfet
X$61 \$220 \$122 \$123 divider_chain_pfet_w5_l0p5_B sg13_hv_pmos L=0.5U W=5U
+ AS=2P AD=2P PS=10.8U PD=10.8U
* device instance $62 r0 *1 416.06,3.11 pfet
X$62 \$221 \$124 \$125 divider_chain_pfet_w5_l0p5_B sg13_hv_pmos L=0.5U W=5U
+ AS=2P AD=2P PS=10.8U PD=10.8U
* device instance $63 r0 *1 422.82,3.11 pfet
X$63 \$222 \$126 \$127 divider_chain_pfet_w5_l0p5_B sg13_hv_pmos L=0.5U W=5U
+ AS=2P AD=2P PS=10.8U PD=10.8U
* device instance $64 r0 *1 429.58,3.11 pfet
X$64 \$223 \$128 \$129 divider_chain_pfet_w5_l0p5_B sg13_hv_pmos L=0.5U W=5U
+ AS=2P AD=2P PS=10.8U PD=10.8U
* device instance $65 r0 *1 436.34,3.11 pfet
X$65 \$224 \$130 \$131 divider_chain_pfet_w5_l0p5_B sg13_hv_pmos L=0.5U W=5U
+ AS=2P AD=2P PS=10.8U PD=10.8U
* device instance $66 r0 *1 443.1,3.11 pfet
X$66 \$225 \$132 \$133 divider_chain_pfet_w5_l0p5_B sg13_hv_pmos L=0.5U W=5U
+ AS=2P AD=2P PS=10.8U PD=10.8U
* device instance $67 r0 *1 449.86,3.11 pfet
X$67 \$226 \$134 \$135 divider_chain_pfet_w5_l0p5_B sg13_hv_pmos L=0.5U W=5U
+ AS=2P AD=2P PS=10.8U PD=10.8U
* device instance $68 r0 *1 456.62,3.11 pfet
X$68 \$227 \$136 \$137 divider_chain_pfet_w5_l0p5_B sg13_hv_pmos L=0.5U W=5U
+ AS=2P AD=2P PS=10.8U PD=10.8U
* device instance $69 r0 *1 463.38,3.11 pfet
X$69 \$228 \$138 \$139 divider_chain_pfet_w5_l0p5_B sg13_hv_pmos L=0.5U W=5U
+ AS=2P AD=2P PS=10.8U PD=10.8U
* device instance $70 r0 *1 470.14,3.11 pfet
X$70 \$229 \$140 \$141 divider_chain_pfet_w5_l0p5_B sg13_hv_pmos L=0.5U W=5U
+ AS=2P AD=2P PS=10.8U PD=10.8U
* device instance $71 r0 *1 476.9,3.11 pfet
X$71 \$230 \$142 \$143 divider_chain_pfet_w5_l0p5_B sg13_hv_pmos L=0.5U W=5U
+ AS=2P AD=2P PS=10.8U PD=10.8U
* device instance $72 r0 *1 483.66,3.11 pfet
X$72 \$231 \$144 \$145 divider_chain_pfet_w5_l0p5_B sg13_hv_pmos L=0.5U W=5U
+ AS=2P AD=2P PS=10.8U PD=10.8U
* device instance $73 r0 *1 490.42,3.11 pfet
X$73 \$232 \$146 \$147 divider_chain_pfet_w5_l0p5_B sg13_hv_pmos L=0.5U W=5U
+ AS=2P AD=2P PS=10.8U PD=10.8U
* device instance $74 r0 *1 497.18,3.11 pfet
X$74 \$233 \$148 \$149 divider_chain_pfet_w5_l0p5_B sg13_hv_pmos L=0.5U W=5U
+ AS=2P AD=2P PS=10.8U PD=10.8U
* device instance $75 r0 *1 503.94,3.11 pfet
X$75 \$234 \$150 \$151 divider_chain_pfet_w5_l0p5_B sg13_hv_pmos L=0.5U W=5U
+ AS=2P AD=2P PS=10.8U PD=10.8U
* device instance $76 r0 *1 510.7,3.11 pfet
X$76 \$235 \$152 \$153 divider_chain_pfet_w5_l0p5_B sg13_hv_pmos L=0.5U W=5U
+ AS=2P AD=2P PS=10.8U PD=10.8U
* device instance $77 r0 *1 517.46,3.11 pfet
X$77 \$236 \$154 \$155 divider_chain_pfet_w5_l0p5_B sg13_hv_pmos L=0.5U W=5U
+ AS=2P AD=2P PS=10.8U PD=10.8U
* device instance $78 r0 *1 524.22,3.11 pfet
X$78 \$237 \$156 \$157 divider_chain_pfet_w5_l0p5_B sg13_hv_pmos L=0.5U W=5U
+ AS=2P AD=2P PS=10.8U PD=10.8U
* device instance $79 r0 *1 530.98,3.11 pfet
X$79 \$238 \$158 \$159 divider_chain_pfet_w5_l0p5_B sg13_hv_pmos L=0.5U W=5U
+ AS=2P AD=2P PS=10.8U PD=10.8U
* device instance $80 r0 *1 3.7,5.69 pfet
X$80 \$319 \$318 \$239 divider_chain_pfet_w5_l0p5_B sg13_hv_pmos L=0.5U W=5U
+ AS=2P AD=2P PS=10.8U PD=10.8U
* device instance $81 r0 *1 10.46,5.69 pfet
X$81 \$321 \$320 \$240 divider_chain_pfet_w5_l0p5_B sg13_hv_pmos L=0.5U W=5U
+ AS=2P AD=2P PS=10.8U PD=10.8U
* device instance $82 r0 *1 17.22,5.69 pfet
X$82 \$323 \$322 \$241 divider_chain_pfet_w5_l0p5_B sg13_hv_pmos L=0.5U W=5U
+ AS=2P AD=2P PS=10.8U PD=10.8U
* device instance $83 r0 *1 23.98,5.69 pfet
X$83 \$325 \$324 \$242 divider_chain_pfet_w5_l0p5_B sg13_hv_pmos L=0.5U W=5U
+ AS=2P AD=2P PS=10.8U PD=10.8U
* device instance $84 r0 *1 30.74,5.69 pfet
X$84 \$327 \$326 \$243 divider_chain_pfet_w5_l0p5_B sg13_hv_pmos L=0.5U W=5U
+ AS=2P AD=2P PS=10.8U PD=10.8U
* device instance $85 r0 *1 37.5,5.69 pfet
X$85 \$329 \$328 \$244 divider_chain_pfet_w5_l0p5_B sg13_hv_pmos L=0.5U W=5U
+ AS=2P AD=2P PS=10.8U PD=10.8U
* device instance $86 r0 *1 44.26,5.69 pfet
X$86 \$331 \$330 \$245 divider_chain_pfet_w5_l0p5_B sg13_hv_pmos L=0.5U W=5U
+ AS=2P AD=2P PS=10.8U PD=10.8U
* device instance $87 r0 *1 51.02,5.69 pfet
X$87 \$333 \$332 \$246 divider_chain_pfet_w5_l0p5_B sg13_hv_pmos L=0.5U W=5U
+ AS=2P AD=2P PS=10.8U PD=10.8U
* device instance $88 r0 *1 57.78,5.69 pfet
X$88 \$335 \$334 \$247 divider_chain_pfet_w5_l0p5_B sg13_hv_pmos L=0.5U W=5U
+ AS=2P AD=2P PS=10.8U PD=10.8U
* device instance $89 r0 *1 64.54,5.69 pfet
X$89 \$337 \$336 \$248 divider_chain_pfet_w5_l0p5_B sg13_hv_pmos L=0.5U W=5U
+ AS=2P AD=2P PS=10.8U PD=10.8U
* device instance $90 r0 *1 71.3,5.69 pfet
X$90 \$339 \$338 \$249 divider_chain_pfet_w5_l0p5_B sg13_hv_pmos L=0.5U W=5U
+ AS=2P AD=2P PS=10.8U PD=10.8U
* device instance $91 r0 *1 78.06,5.69 pfet
X$91 \$341 \$340 \$250 divider_chain_pfet_w5_l0p5_B sg13_hv_pmos L=0.5U W=5U
+ AS=2P AD=2P PS=10.8U PD=10.8U
* device instance $92 r0 *1 84.82,5.69 pfet
X$92 \$343 \$342 \$251 divider_chain_pfet_w5_l0p5_B sg13_hv_pmos L=0.5U W=5U
+ AS=2P AD=2P PS=10.8U PD=10.8U
* device instance $93 r0 *1 91.58,5.69 pfet
X$93 \$345 \$344 \$252 divider_chain_pfet_w5_l0p5_B sg13_hv_pmos L=0.5U W=5U
+ AS=2P AD=2P PS=10.8U PD=10.8U
* device instance $94 r0 *1 98.34,5.69 pfet
X$94 \$347 \$346 \$253 divider_chain_pfet_w5_l0p5_B sg13_hv_pmos L=0.5U W=5U
+ AS=2P AD=2P PS=10.8U PD=10.8U
* device instance $95 r0 *1 105.1,5.69 pfet
X$95 \$349 \$348 \$254 divider_chain_pfet_w5_l0p5_B sg13_hv_pmos L=0.5U W=5U
+ AS=2P AD=2P PS=10.8U PD=10.8U
* device instance $96 r0 *1 111.86,5.69 pfet
X$96 \$351 \$350 \$255 divider_chain_pfet_w5_l0p5_B sg13_hv_pmos L=0.5U W=5U
+ AS=2P AD=2P PS=10.8U PD=10.8U
* device instance $97 r0 *1 118.62,5.69 pfet
X$97 \$353 \$352 \$256 divider_chain_pfet_w5_l0p5_B sg13_hv_pmos L=0.5U W=5U
+ AS=2P AD=2P PS=10.8U PD=10.8U
* device instance $98 r0 *1 125.38,5.69 pfet
X$98 \$355 \$354 \$257 divider_chain_pfet_w5_l0p5_B sg13_hv_pmos L=0.5U W=5U
+ AS=2P AD=2P PS=10.8U PD=10.8U
* device instance $99 r0 *1 132.14,5.69 pfet
X$99 \$357 \$356 \$258 divider_chain_pfet_w5_l0p5_B sg13_hv_pmos L=0.5U W=5U
+ AS=2P AD=2P PS=10.8U PD=10.8U
* device instance $100 r0 *1 138.9,5.69 pfet
X$100 \$359 \$358 \$259 divider_chain_pfet_w5_l0p5_B sg13_hv_pmos L=0.5U W=5U
+ AS=2P AD=2P PS=10.8U PD=10.8U
* device instance $101 r0 *1 145.66,5.69 pfet
X$101 \$361 \$360 \$260 divider_chain_pfet_w5_l0p5_B sg13_hv_pmos L=0.5U W=5U
+ AS=2P AD=2P PS=10.8U PD=10.8U
* device instance $102 r0 *1 152.42,5.69 pfet
X$102 \$363 \$362 \$261 divider_chain_pfet_w5_l0p5_B sg13_hv_pmos L=0.5U W=5U
+ AS=2P AD=2P PS=10.8U PD=10.8U
* device instance $103 r0 *1 159.18,5.69 pfet
X$103 \$365 \$364 \$262 divider_chain_pfet_w5_l0p5_B sg13_hv_pmos L=0.5U W=5U
+ AS=2P AD=2P PS=10.8U PD=10.8U
* device instance $104 r0 *1 165.94,5.69 pfet
X$104 \$367 \$366 \$263 divider_chain_pfet_w5_l0p5_B sg13_hv_pmos L=0.5U W=5U
+ AS=2P AD=2P PS=10.8U PD=10.8U
* device instance $105 r0 *1 172.7,5.69 pfet
X$105 \$369 \$368 \$264 divider_chain_pfet_w5_l0p5_B sg13_hv_pmos L=0.5U W=5U
+ AS=2P AD=2P PS=10.8U PD=10.8U
* device instance $106 r0 *1 179.46,5.69 pfet
X$106 \$371 \$370 \$265 divider_chain_pfet_w5_l0p5_B sg13_hv_pmos L=0.5U W=5U
+ AS=2P AD=2P PS=10.8U PD=10.8U
* device instance $107 r0 *1 186.22,5.69 pfet
X$107 \$373 \$372 \$266 divider_chain_pfet_w5_l0p5_B sg13_hv_pmos L=0.5U W=5U
+ AS=2P AD=2P PS=10.8U PD=10.8U
* device instance $108 r0 *1 192.98,5.69 pfet
X$108 \$375 \$374 \$267 divider_chain_pfet_w5_l0p5_B sg13_hv_pmos L=0.5U W=5U
+ AS=2P AD=2P PS=10.8U PD=10.8U
* device instance $109 r0 *1 199.74,5.69 pfet
X$109 \$377 \$376 \$268 divider_chain_pfet_w5_l0p5_B sg13_hv_pmos L=0.5U W=5U
+ AS=2P AD=2P PS=10.8U PD=10.8U
* device instance $110 r0 *1 206.5,5.69 pfet
X$110 \$379 \$378 \$269 divider_chain_pfet_w5_l0p5_B sg13_hv_pmos L=0.5U W=5U
+ AS=2P AD=2P PS=10.8U PD=10.8U
* device instance $111 r0 *1 213.26,5.69 pfet
X$111 \$381 \$380 \$270 divider_chain_pfet_w5_l0p5_B sg13_hv_pmos L=0.5U W=5U
+ AS=2P AD=2P PS=10.8U PD=10.8U
* device instance $112 r0 *1 220.02,5.69 pfet
X$112 \$383 \$382 \$271 divider_chain_pfet_w5_l0p5_B sg13_hv_pmos L=0.5U W=5U
+ AS=2P AD=2P PS=10.8U PD=10.8U
* device instance $113 r0 *1 226.78,5.69 pfet
X$113 \$385 \$384 \$272 divider_chain_pfet_w5_l0p5_B sg13_hv_pmos L=0.5U W=5U
+ AS=2P AD=2P PS=10.8U PD=10.8U
* device instance $114 r0 *1 233.54,5.69 pfet
X$114 \$387 \$386 \$273 divider_chain_pfet_w5_l0p5_B sg13_hv_pmos L=0.5U W=5U
+ AS=2P AD=2P PS=10.8U PD=10.8U
* device instance $115 r0 *1 240.3,5.69 pfet
X$115 \$389 \$388 \$274 divider_chain_pfet_w5_l0p5_B sg13_hv_pmos L=0.5U W=5U
+ AS=2P AD=2P PS=10.8U PD=10.8U
* device instance $116 r0 *1 247.06,5.69 pfet
X$116 \$391 \$390 \$275 divider_chain_pfet_w5_l0p5_B sg13_hv_pmos L=0.5U W=5U
+ AS=2P AD=2P PS=10.8U PD=10.8U
* device instance $117 r0 *1 253.82,5.69 pfet
X$117 \$393 \$392 \$276 divider_chain_pfet_w5_l0p5_B sg13_hv_pmos L=0.5U W=5U
+ AS=2P AD=2P PS=10.8U PD=10.8U
* device instance $118 r0 *1 260.58,5.69 pfet
X$118 \$395 \$394 \$277 divider_chain_pfet_w5_l0p5_B sg13_hv_pmos L=0.5U W=5U
+ AS=2P AD=2P PS=10.8U PD=10.8U
* device instance $119 r0 *1 267.34,5.69 pfet
X$119 \$397 \$396 \$278 divider_chain_pfet_w5_l0p5_B sg13_hv_pmos L=0.5U W=5U
+ AS=2P AD=2P PS=10.8U PD=10.8U
* device instance $120 r0 *1 274.1,5.69 pfet
X$120 \$399 \$398 \$279 divider_chain_pfet_w5_l0p5_B sg13_hv_pmos L=0.5U W=5U
+ AS=2P AD=2P PS=10.8U PD=10.8U
* device instance $121 r0 *1 280.86,5.69 pfet
X$121 \$401 \$400 \$280 divider_chain_pfet_w5_l0p5_B sg13_hv_pmos L=0.5U W=5U
+ AS=2P AD=2P PS=10.8U PD=10.8U
* device instance $122 r0 *1 287.62,5.69 pfet
X$122 \$403 \$402 \$281 divider_chain_pfet_w5_l0p5_B sg13_hv_pmos L=0.5U W=5U
+ AS=2P AD=2P PS=10.8U PD=10.8U
* device instance $123 r0 *1 294.38,5.69 pfet
X$123 \$405 \$404 \$282 divider_chain_pfet_w5_l0p5_B sg13_hv_pmos L=0.5U W=5U
+ AS=2P AD=2P PS=10.8U PD=10.8U
* device instance $124 r0 *1 301.14,5.69 pfet
X$124 \$407 \$406 \$283 divider_chain_pfet_w5_l0p5_B sg13_hv_pmos L=0.5U W=5U
+ AS=2P AD=2P PS=10.8U PD=10.8U
* device instance $125 r0 *1 307.9,5.69 pfet
X$125 \$409 \$408 \$284 divider_chain_pfet_w5_l0p5_B sg13_hv_pmos L=0.5U W=5U
+ AS=2P AD=2P PS=10.8U PD=10.8U
* device instance $126 r0 *1 314.66,5.69 pfet
X$126 \$411 \$410 \$285 divider_chain_pfet_w5_l0p5_B sg13_hv_pmos L=0.5U W=5U
+ AS=2P AD=2P PS=10.8U PD=10.8U
* device instance $127 r0 *1 321.42,5.69 pfet
X$127 \$413 \$412 \$286 divider_chain_pfet_w5_l0p5_B sg13_hv_pmos L=0.5U W=5U
+ AS=2P AD=2P PS=10.8U PD=10.8U
* device instance $128 r0 *1 328.18,5.69 pfet
X$128 \$415 \$414 \$287 divider_chain_pfet_w5_l0p5_B sg13_hv_pmos L=0.5U W=5U
+ AS=2P AD=2P PS=10.8U PD=10.8U
* device instance $129 r0 *1 334.94,5.69 pfet
X$129 \$417 \$416 \$288 divider_chain_pfet_w5_l0p5_B sg13_hv_pmos L=0.5U W=5U
+ AS=2P AD=2P PS=10.8U PD=10.8U
* device instance $130 r0 *1 341.7,5.69 pfet
X$130 \$419 \$418 \$289 divider_chain_pfet_w5_l0p5_B sg13_hv_pmos L=0.5U W=5U
+ AS=2P AD=2P PS=10.8U PD=10.8U
* device instance $131 r0 *1 348.46,5.69 pfet
X$131 \$421 \$420 \$290 divider_chain_pfet_w5_l0p5_B sg13_hv_pmos L=0.5U W=5U
+ AS=2P AD=2P PS=10.8U PD=10.8U
* device instance $132 r0 *1 355.22,5.69 pfet
X$132 \$423 \$422 \$291 divider_chain_pfet_w5_l0p5_B sg13_hv_pmos L=0.5U W=5U
+ AS=2P AD=2P PS=10.8U PD=10.8U
* device instance $133 r0 *1 361.98,5.69 pfet
X$133 \$425 \$424 \$292 divider_chain_pfet_w5_l0p5_B sg13_hv_pmos L=0.5U W=5U
+ AS=2P AD=2P PS=10.8U PD=10.8U
* device instance $134 r0 *1 368.74,5.69 pfet
X$134 \$427 \$426 \$293 divider_chain_pfet_w5_l0p5_B sg13_hv_pmos L=0.5U W=5U
+ AS=2P AD=2P PS=10.8U PD=10.8U
* device instance $135 r0 *1 375.5,5.69 pfet
X$135 \$429 \$428 \$294 divider_chain_pfet_w5_l0p5_B sg13_hv_pmos L=0.5U W=5U
+ AS=2P AD=2P PS=10.8U PD=10.8U
* device instance $136 r0 *1 382.26,5.69 pfet
X$136 \$431 \$430 \$295 divider_chain_pfet_w5_l0p5_B sg13_hv_pmos L=0.5U W=5U
+ AS=2P AD=2P PS=10.8U PD=10.8U
* device instance $137 r0 *1 389.02,5.69 pfet
X$137 \$433 \$432 \$296 divider_chain_pfet_w5_l0p5_B sg13_hv_pmos L=0.5U W=5U
+ AS=2P AD=2P PS=10.8U PD=10.8U
* device instance $138 r0 *1 395.78,5.69 pfet
X$138 \$435 \$434 \$297 divider_chain_pfet_w5_l0p5_B sg13_hv_pmos L=0.5U W=5U
+ AS=2P AD=2P PS=10.8U PD=10.8U
* device instance $139 r0 *1 402.54,5.69 pfet
X$139 \$437 \$436 \$298 divider_chain_pfet_w5_l0p5_B sg13_hv_pmos L=0.5U W=5U
+ AS=2P AD=2P PS=10.8U PD=10.8U
* device instance $140 r0 *1 409.3,5.69 pfet
X$140 \$439 \$438 \$299 divider_chain_pfet_w5_l0p5_B sg13_hv_pmos L=0.5U W=5U
+ AS=2P AD=2P PS=10.8U PD=10.8U
* device instance $141 r0 *1 416.06,5.69 pfet
X$141 \$441 \$440 \$300 divider_chain_pfet_w5_l0p5_B sg13_hv_pmos L=0.5U W=5U
+ AS=2P AD=2P PS=10.8U PD=10.8U
* device instance $142 r0 *1 422.82,5.69 pfet
X$142 \$443 \$442 \$301 divider_chain_pfet_w5_l0p5_B sg13_hv_pmos L=0.5U W=5U
+ AS=2P AD=2P PS=10.8U PD=10.8U
* device instance $143 r0 *1 429.58,5.69 pfet
X$143 \$445 \$444 \$302 divider_chain_pfet_w5_l0p5_B sg13_hv_pmos L=0.5U W=5U
+ AS=2P AD=2P PS=10.8U PD=10.8U
* device instance $144 r0 *1 436.34,5.69 pfet
X$144 \$447 \$446 \$303 divider_chain_pfet_w5_l0p5_B sg13_hv_pmos L=0.5U W=5U
+ AS=2P AD=2P PS=10.8U PD=10.8U
* device instance $145 r0 *1 443.1,5.69 pfet
X$145 \$449 \$448 \$304 divider_chain_pfet_w5_l0p5_B sg13_hv_pmos L=0.5U W=5U
+ AS=2P AD=2P PS=10.8U PD=10.8U
* device instance $146 r0 *1 449.86,5.69 pfet
X$146 \$451 \$450 \$305 divider_chain_pfet_w5_l0p5_B sg13_hv_pmos L=0.5U W=5U
+ AS=2P AD=2P PS=10.8U PD=10.8U
* device instance $147 r0 *1 456.62,5.69 pfet
X$147 \$453 \$452 \$306 divider_chain_pfet_w5_l0p5_B sg13_hv_pmos L=0.5U W=5U
+ AS=2P AD=2P PS=10.8U PD=10.8U
* device instance $148 r0 *1 463.38,5.69 pfet
X$148 \$455 \$454 \$307 divider_chain_pfet_w5_l0p5_B sg13_hv_pmos L=0.5U W=5U
+ AS=2P AD=2P PS=10.8U PD=10.8U
* device instance $149 r0 *1 470.14,5.69 pfet
X$149 \$457 \$456 \$308 divider_chain_pfet_w5_l0p5_B sg13_hv_pmos L=0.5U W=5U
+ AS=2P AD=2P PS=10.8U PD=10.8U
* device instance $150 r0 *1 476.9,5.69 pfet
X$150 \$459 \$458 \$309 divider_chain_pfet_w5_l0p5_B sg13_hv_pmos L=0.5U W=5U
+ AS=2P AD=2P PS=10.8U PD=10.8U
* device instance $151 r0 *1 483.66,5.69 pfet
X$151 \$461 \$460 \$310 divider_chain_pfet_w5_l0p5_B sg13_hv_pmos L=0.5U W=5U
+ AS=2P AD=2P PS=10.8U PD=10.8U
* device instance $152 r0 *1 490.42,5.69 pfet
X$152 \$463 \$462 \$311 divider_chain_pfet_w5_l0p5_B sg13_hv_pmos L=0.5U W=5U
+ AS=2P AD=2P PS=10.8U PD=10.8U
* device instance $153 r0 *1 497.18,5.69 pfet
X$153 \$465 \$464 \$312 divider_chain_pfet_w5_l0p5_B sg13_hv_pmos L=0.5U W=5U
+ AS=2P AD=2P PS=10.8U PD=10.8U
* device instance $154 r0 *1 503.94,5.69 pfet
X$154 \$467 \$466 \$313 divider_chain_pfet_w5_l0p5_B sg13_hv_pmos L=0.5U W=5U
+ AS=2P AD=2P PS=10.8U PD=10.8U
* device instance $155 r0 *1 510.7,5.69 pfet
X$155 \$469 \$468 \$314 divider_chain_pfet_w5_l0p5_B sg13_hv_pmos L=0.5U W=5U
+ AS=2P AD=2P PS=10.8U PD=10.8U
* device instance $156 r0 *1 517.46,5.69 pfet
X$156 \$471 \$470 \$315 divider_chain_pfet_w5_l0p5_B sg13_hv_pmos L=0.5U W=5U
+ AS=2P AD=2P PS=10.8U PD=10.8U
* device instance $157 r0 *1 524.22,5.69 pfet
X$157 \$473 \$472 \$316 divider_chain_pfet_w5_l0p5_B sg13_hv_pmos L=0.5U W=5U
+ AS=2P AD=2P PS=10.8U PD=10.8U
* device instance $158 r0 *1 530.98,5.69 pfet
X$158 \$475 \$474 \$317 divider_chain_pfet_w5_l0p5_B sg13_hv_pmos L=0.5U W=5U
+ AS=2P AD=2P PS=10.8U PD=10.8U
.ENDS divider_chain_pfet_w5_l0p5
