* extracted by klt extract --deck sg13cmos5l

* cell vco_pfet_w10_l1
* pin vco_pfet_w10_l1_B
.SUBCKT vco_pfet_w10_l1 vco_pfet_w10_l1_B
* device instance $1 r0 *1 6.2,3.36 pfet
X$1 \$6 \$2 \$3 vco_pfet_w10_l1_B sg13_hv_pmos L=1U W=10U AS=4P AD=4P PS=20.8U
+ PD=20.8U
* device instance $2 r0 *1 17.96,3.36 pfet
X$2 \$7 \$4 \$5 vco_pfet_w10_l1_B sg13_hv_pmos L=1U W=10U AS=4P AD=4P PS=20.8U
+ PD=20.8U
.ENDS vco_pfet_w10_l1
