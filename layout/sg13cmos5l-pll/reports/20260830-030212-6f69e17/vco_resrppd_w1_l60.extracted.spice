* extracted by klt extract --deck sg13cmos5l

* cell vco_resrppd_w1_l60
* pin vsubs
.SUBCKT vco_resrppd_w1_l60 vsubs
* device instance $1 r0 *1 30.5,0.7 rppd
R$1 \$1 \$2 vsubs 15600 rppd
* device instance $2 r0 *1 30.5,2.7 rppd
R$2 \$3 \$4 vsubs 15600 rppd
* device instance $3 r0 *1 30.5,4.7 rppd
R$3 \$5 \$6 vsubs 15600 rppd
.ENDS vco_resrppd_w1_l60
