* extracted by klt extract --deck sg13cmos5l

* cell vco_pfet_w10_l0p5
* pin vco_pfet_w10_l0p5_B
.SUBCKT vco_pfet_w10_l0p5 vco_pfet_w10_l0p5_B
* device instance $1 r0 *1 6.2,3.11 pfet
X$1 \$16 \$2 \$3 vco_pfet_w10_l0p5_B sg13_hv_pmos L=0.5U W=10U AS=4P AD=4P
+ PS=20.8U PD=20.8U
* device instance $2 r0 *1 17.96,3.11 pfet
X$2 \$17 \$4 \$5 vco_pfet_w10_l0p5_B sg13_hv_pmos L=0.5U W=10U AS=4P AD=4P
+ PS=20.8U PD=20.8U
* device instance $3 r0 *1 29.72,3.11 pfet
X$3 \$18 \$6 \$7 vco_pfet_w10_l0p5_B sg13_hv_pmos L=0.5U W=10U AS=4P AD=4P
+ PS=20.8U PD=20.8U
* device instance $4 r0 *1 41.48,3.11 pfet
X$4 \$19 \$8 \$9 vco_pfet_w10_l0p5_B sg13_hv_pmos L=0.5U W=10U AS=4P AD=4P
+ PS=20.8U PD=20.8U
* device instance $5 r0 *1 53.24,3.11 pfet
X$5 \$20 \$10 \$11 vco_pfet_w10_l0p5_B sg13_hv_pmos L=0.5U W=10U AS=4P AD=4P
+ PS=20.8U PD=20.8U
* device instance $6 r0 *1 65,3.11 pfet
X$6 \$21 \$12 \$13 vco_pfet_w10_l0p5_B sg13_hv_pmos L=0.5U W=10U AS=4P AD=4P
+ PS=20.8U PD=20.8U
* device instance $7 r0 *1 76.76,3.11 pfet
X$7 \$22 \$14 \$15 vco_pfet_w10_l0p5_B sg13_hv_pmos L=0.5U W=10U AS=4P AD=4P
+ PS=20.8U PD=20.8U
.ENDS vco_pfet_w10_l0p5
