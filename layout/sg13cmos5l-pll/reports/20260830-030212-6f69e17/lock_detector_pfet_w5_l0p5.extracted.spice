* extracted by klt extract --deck sg13cmos5l

* cell lock_detector_pfet_w5_l0p5
* pin lock_detector_pfet_w5_l0p5_B
.SUBCKT lock_detector_pfet_w5_l0p5 lock_detector_pfet_w5_l0p5_B
* device instance $1 r0 *1 3.7,3.11 pfet
X$1 \$14 \$2 \$3 lock_detector_pfet_w5_l0p5_B sg13_hv_pmos L=0.5U W=5U AS=2P
+ AD=2P PS=10.8U PD=10.8U
* device instance $2 r0 *1 10.46,3.11 pfet
X$2 \$15 \$4 \$5 lock_detector_pfet_w5_l0p5_B sg13_hv_pmos L=0.5U W=5U AS=2P
+ AD=2P PS=10.8U PD=10.8U
* device instance $3 r0 *1 17.22,3.11 pfet
X$3 \$16 \$6 \$7 lock_detector_pfet_w5_l0p5_B sg13_hv_pmos L=0.5U W=5U AS=2P
+ AD=2P PS=10.8U PD=10.8U
* device instance $4 r0 *1 23.98,3.11 pfet
X$4 \$17 \$8 \$9 lock_detector_pfet_w5_l0p5_B sg13_hv_pmos L=0.5U W=5U AS=2P
+ AD=2P PS=10.8U PD=10.8U
* device instance $5 r0 *1 30.74,3.11 pfet
X$5 \$18 \$10 \$11 lock_detector_pfet_w5_l0p5_B sg13_hv_pmos L=0.5U W=5U AS=2P
+ AD=2P PS=10.8U PD=10.8U
* device instance $6 r0 *1 37.5,3.11 pfet
X$6 \$19 \$12 \$13 lock_detector_pfet_w5_l0p5_B sg13_hv_pmos L=0.5U W=5U AS=2P
+ AD=2P PS=10.8U PD=10.8U
* device instance $7 r0 *1 3.7,5.69 pfet
X$7 \$27 \$26 \$20 lock_detector_pfet_w5_l0p5_B sg13_hv_pmos L=0.5U W=5U AS=2P
+ AD=2P PS=10.8U PD=10.8U
* device instance $8 r0 *1 10.46,5.69 pfet
X$8 \$29 \$28 \$21 lock_detector_pfet_w5_l0p5_B sg13_hv_pmos L=0.5U W=5U AS=2P
+ AD=2P PS=10.8U PD=10.8U
* device instance $9 r0 *1 17.22,5.69 pfet
X$9 \$31 \$30 \$22 lock_detector_pfet_w5_l0p5_B sg13_hv_pmos L=0.5U W=5U AS=2P
+ AD=2P PS=10.8U PD=10.8U
* device instance $10 r0 *1 23.98,5.69 pfet
X$10 \$33 \$32 \$23 lock_detector_pfet_w5_l0p5_B sg13_hv_pmos L=0.5U W=5U AS=2P
+ AD=2P PS=10.8U PD=10.8U
* device instance $11 r0 *1 30.74,5.69 pfet
X$11 \$35 \$34 \$24 lock_detector_pfet_w5_l0p5_B sg13_hv_pmos L=0.5U W=5U AS=2P
+ AD=2P PS=10.8U PD=10.8U
* device instance $12 r0 *1 37.5,5.69 pfet
X$12 \$37 \$36 \$25 lock_detector_pfet_w5_l0p5_B sg13_hv_pmos L=0.5U W=5U AS=2P
+ AD=2P PS=10.8U PD=10.8U
* device instance $13 r0 *1 3.7,8.27 pfet
X$13 \$50 \$38 \$39 lock_detector_pfet_w5_l0p5_B sg13_hv_pmos L=0.5U W=5U AS=2P
+ AD=2P PS=10.8U PD=10.8U
* device instance $14 r0 *1 10.46,8.27 pfet
X$14 \$51 \$40 \$41 lock_detector_pfet_w5_l0p5_B sg13_hv_pmos L=0.5U W=5U AS=2P
+ AD=2P PS=10.8U PD=10.8U
* device instance $15 r0 *1 17.22,8.27 pfet
X$15 \$52 \$42 \$43 lock_detector_pfet_w5_l0p5_B sg13_hv_pmos L=0.5U W=5U AS=2P
+ AD=2P PS=10.8U PD=10.8U
* device instance $16 r0 *1 23.98,8.27 pfet
X$16 \$53 \$44 \$45 lock_detector_pfet_w5_l0p5_B sg13_hv_pmos L=0.5U W=5U AS=2P
+ AD=2P PS=10.8U PD=10.8U
* device instance $17 r0 *1 30.74,8.27 pfet
X$17 \$54 \$46 \$47 lock_detector_pfet_w5_l0p5_B sg13_hv_pmos L=0.5U W=5U AS=2P
+ AD=2P PS=10.8U PD=10.8U
* device instance $18 r0 *1 37.5,8.27 pfet
X$18 \$55 \$48 \$49 lock_detector_pfet_w5_l0p5_B sg13_hv_pmos L=0.5U W=5U AS=2P
+ AD=2P PS=10.8U PD=10.8U
.ENDS lock_detector_pfet_w5_l0p5
