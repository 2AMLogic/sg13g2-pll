* extracted by klt extract --deck sg13cmos5l

* cell vco_nfet_w8_l1
* pin vsubs
.SUBCKT vco_nfet_w8_l1 vsubs
* device instance $1 r0 *1 4.89,3.36 nfet
X$1 \$2 \$1 \$3 vsubs sg13_hv_nmos L=1U W=8U AS=3.2P AD=3.2P PS=16.8U PD=16.8U
.ENDS vco_nfet_w8_l1
