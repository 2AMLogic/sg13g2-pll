* extracted by klt extract --deck sg13cmos5l

* cell pll_loop_filter
* pin vsubs
.SUBCKT pll_loop_filter vsubs
* device instance $1 r0 *1 60.5,2.2 rppd
R$1 \$1 \$2 vsubs 7800 rppd
.ENDS pll_loop_filter
