* extracted by klt extract --deck sg13cmos5l

* cell divider_chain_nfet_w2_l0p5
* pin vsubs
.SUBCKT divider_chain_nfet_w2_l0p5 vsubs
* device instance $1 r0 *1 1.89,3.11 nfet
X$1 \$160 \$2 \$3 vsubs sg13_hv_nmos L=0.5U W=2U AS=0.8P AD=0.8P PS=4.8U PD=4.8U
* device instance $2 r0 *1 5.03,3.11 nfet
X$2 \$161 \$4 \$5 vsubs sg13_hv_nmos L=0.5U W=2U AS=0.8P AD=0.8P PS=4.8U PD=4.8U
* device instance $3 r0 *1 8.17,3.11 nfet
X$3 \$162 \$6 \$7 vsubs sg13_hv_nmos L=0.5U W=2U AS=0.8P AD=0.8P PS=4.8U PD=4.8U
* device instance $4 r0 *1 11.31,3.11 nfet
X$4 \$163 \$8 \$9 vsubs sg13_hv_nmos L=0.5U W=2U AS=0.8P AD=0.8P PS=4.8U PD=4.8U
* device instance $5 r0 *1 14.45,3.11 nfet
X$5 \$164 \$10 \$11 vsubs sg13_hv_nmos L=0.5U W=2U AS=0.8P AD=0.8P PS=4.8U
+ PD=4.8U
* device instance $6 r0 *1 17.59,3.11 nfet
X$6 \$165 \$12 \$13 vsubs sg13_hv_nmos L=0.5U W=2U AS=0.8P AD=0.8P PS=4.8U
+ PD=4.8U
* device instance $7 r0 *1 20.73,3.11 nfet
X$7 \$166 \$14 \$15 vsubs sg13_hv_nmos L=0.5U W=2U AS=0.8P AD=0.8P PS=4.8U
+ PD=4.8U
* device instance $8 r0 *1 23.87,3.11 nfet
X$8 \$167 \$16 \$17 vsubs sg13_hv_nmos L=0.5U W=2U AS=0.8P AD=0.8P PS=4.8U
+ PD=4.8U
* device instance $9 r0 *1 27.01,3.11 nfet
X$9 \$168 \$18 \$19 vsubs sg13_hv_nmos L=0.5U W=2U AS=0.8P AD=0.8P PS=4.8U
+ PD=4.8U
* device instance $10 r0 *1 30.15,3.11 nfet
X$10 \$169 \$20 \$21 vsubs sg13_hv_nmos L=0.5U W=2U AS=0.8P AD=0.8P PS=4.8U
+ PD=4.8U
* device instance $11 r0 *1 33.29,3.11 nfet
X$11 \$170 \$22 \$23 vsubs sg13_hv_nmos L=0.5U W=2U AS=0.8P AD=0.8P PS=4.8U
+ PD=4.8U
* device instance $12 r0 *1 36.43,3.11 nfet
X$12 \$171 \$24 \$25 vsubs sg13_hv_nmos L=0.5U W=2U AS=0.8P AD=0.8P PS=4.8U
+ PD=4.8U
* device instance $13 r0 *1 39.57,3.11 nfet
X$13 \$172 \$26 \$27 vsubs sg13_hv_nmos L=0.5U W=2U AS=0.8P AD=0.8P PS=4.8U
+ PD=4.8U
* device instance $14 r0 *1 42.71,3.11 nfet
X$14 \$173 \$28 \$29 vsubs sg13_hv_nmos L=0.5U W=2U AS=0.8P AD=0.8P PS=4.8U
+ PD=4.8U
* device instance $15 r0 *1 45.85,3.11 nfet
X$15 \$174 \$30 \$31 vsubs sg13_hv_nmos L=0.5U W=2U AS=0.8P AD=0.8P PS=4.8U
+ PD=4.8U
* device instance $16 r0 *1 48.99,3.11 nfet
X$16 \$175 \$32 \$33 vsubs sg13_hv_nmos L=0.5U W=2U AS=0.8P AD=0.8P PS=4.8U
+ PD=4.8U
* device instance $17 r0 *1 52.13,3.11 nfet
X$17 \$176 \$34 \$35 vsubs sg13_hv_nmos L=0.5U W=2U AS=0.8P AD=0.8P PS=4.8U
+ PD=4.8U
* device instance $18 r0 *1 55.27,3.11 nfet
X$18 \$177 \$36 \$37 vsubs sg13_hv_nmos L=0.5U W=2U AS=0.8P AD=0.8P PS=4.8U
+ PD=4.8U
* device instance $19 r0 *1 58.41,3.11 nfet
X$19 \$178 \$38 \$39 vsubs sg13_hv_nmos L=0.5U W=2U AS=0.8P AD=0.8P PS=4.8U
+ PD=4.8U
* device instance $20 r0 *1 61.55,3.11 nfet
X$20 \$179 \$40 \$41 vsubs sg13_hv_nmos L=0.5U W=2U AS=0.8P AD=0.8P PS=4.8U
+ PD=4.8U
* device instance $21 r0 *1 64.69,3.11 nfet
X$21 \$180 \$42 \$43 vsubs sg13_hv_nmos L=0.5U W=2U AS=0.8P AD=0.8P PS=4.8U
+ PD=4.8U
* device instance $22 r0 *1 67.83,3.11 nfet
X$22 \$181 \$44 \$45 vsubs sg13_hv_nmos L=0.5U W=2U AS=0.8P AD=0.8P PS=4.8U
+ PD=4.8U
* device instance $23 r0 *1 70.97,3.11 nfet
X$23 \$182 \$46 \$47 vsubs sg13_hv_nmos L=0.5U W=2U AS=0.8P AD=0.8P PS=4.8U
+ PD=4.8U
* device instance $24 r0 *1 74.11,3.11 nfet
X$24 \$183 \$48 \$49 vsubs sg13_hv_nmos L=0.5U W=2U AS=0.8P AD=0.8P PS=4.8U
+ PD=4.8U
* device instance $25 r0 *1 77.25,3.11 nfet
X$25 \$184 \$50 \$51 vsubs sg13_hv_nmos L=0.5U W=2U AS=0.8P AD=0.8P PS=4.8U
+ PD=4.8U
* device instance $26 r0 *1 80.39,3.11 nfet
X$26 \$185 \$52 \$53 vsubs sg13_hv_nmos L=0.5U W=2U AS=0.8P AD=0.8P PS=4.8U
+ PD=4.8U
* device instance $27 r0 *1 83.53,3.11 nfet
X$27 \$186 \$54 \$55 vsubs sg13_hv_nmos L=0.5U W=2U AS=0.8P AD=0.8P PS=4.8U
+ PD=4.8U
* device instance $28 r0 *1 86.67,3.11 nfet
X$28 \$187 \$56 \$57 vsubs sg13_hv_nmos L=0.5U W=2U AS=0.8P AD=0.8P PS=4.8U
+ PD=4.8U
* device instance $29 r0 *1 89.81,3.11 nfet
X$29 \$188 \$58 \$59 vsubs sg13_hv_nmos L=0.5U W=2U AS=0.8P AD=0.8P PS=4.8U
+ PD=4.8U
* device instance $30 r0 *1 92.95,3.11 nfet
X$30 \$189 \$60 \$61 vsubs sg13_hv_nmos L=0.5U W=2U AS=0.8P AD=0.8P PS=4.8U
+ PD=4.8U
* device instance $31 r0 *1 96.09,3.11 nfet
X$31 \$190 \$62 \$63 vsubs sg13_hv_nmos L=0.5U W=2U AS=0.8P AD=0.8P PS=4.8U
+ PD=4.8U
* device instance $32 r0 *1 99.23,3.11 nfet
X$32 \$191 \$64 \$65 vsubs sg13_hv_nmos L=0.5U W=2U AS=0.8P AD=0.8P PS=4.8U
+ PD=4.8U
* device instance $33 r0 *1 102.37,3.11 nfet
X$33 \$192 \$66 \$67 vsubs sg13_hv_nmos L=0.5U W=2U AS=0.8P AD=0.8P PS=4.8U
+ PD=4.8U
* device instance $34 r0 *1 105.51,3.11 nfet
X$34 \$193 \$68 \$69 vsubs sg13_hv_nmos L=0.5U W=2U AS=0.8P AD=0.8P PS=4.8U
+ PD=4.8U
* device instance $35 r0 *1 108.65,3.11 nfet
X$35 \$194 \$70 \$71 vsubs sg13_hv_nmos L=0.5U W=2U AS=0.8P AD=0.8P PS=4.8U
+ PD=4.8U
* device instance $36 r0 *1 111.79,3.11 nfet
X$36 \$195 \$72 \$73 vsubs sg13_hv_nmos L=0.5U W=2U AS=0.8P AD=0.8P PS=4.8U
+ PD=4.8U
* device instance $37 r0 *1 114.93,3.11 nfet
X$37 \$196 \$74 \$75 vsubs sg13_hv_nmos L=0.5U W=2U AS=0.8P AD=0.8P PS=4.8U
+ PD=4.8U
* device instance $38 r0 *1 118.07,3.11 nfet
X$38 \$197 \$76 \$77 vsubs sg13_hv_nmos L=0.5U W=2U AS=0.8P AD=0.8P PS=4.8U
+ PD=4.8U
* device instance $39 r0 *1 121.21,3.11 nfet
X$39 \$198 \$78 \$79 vsubs sg13_hv_nmos L=0.5U W=2U AS=0.8P AD=0.8P PS=4.8U
+ PD=4.8U
* device instance $40 r0 *1 124.35,3.11 nfet
X$40 \$199 \$80 \$81 vsubs sg13_hv_nmos L=0.5U W=2U AS=0.8P AD=0.8P PS=4.8U
+ PD=4.8U
* device instance $41 r0 *1 127.49,3.11 nfet
X$41 \$200 \$82 \$83 vsubs sg13_hv_nmos L=0.5U W=2U AS=0.8P AD=0.8P PS=4.8U
+ PD=4.8U
* device instance $42 r0 *1 130.63,3.11 nfet
X$42 \$201 \$84 \$85 vsubs sg13_hv_nmos L=0.5U W=2U AS=0.8P AD=0.8P PS=4.8U
+ PD=4.8U
* device instance $43 r0 *1 133.77,3.11 nfet
X$43 \$202 \$86 \$87 vsubs sg13_hv_nmos L=0.5U W=2U AS=0.8P AD=0.8P PS=4.8U
+ PD=4.8U
* device instance $44 r0 *1 136.91,3.11 nfet
X$44 \$203 \$88 \$89 vsubs sg13_hv_nmos L=0.5U W=2U AS=0.8P AD=0.8P PS=4.8U
+ PD=4.8U
* device instance $45 r0 *1 140.05,3.11 nfet
X$45 \$204 \$90 \$91 vsubs sg13_hv_nmos L=0.5U W=2U AS=0.8P AD=0.8P PS=4.8U
+ PD=4.8U
* device instance $46 r0 *1 143.19,3.11 nfet
X$46 \$205 \$92 \$93 vsubs sg13_hv_nmos L=0.5U W=2U AS=0.8P AD=0.8P PS=4.8U
+ PD=4.8U
* device instance $47 r0 *1 146.33,3.11 nfet
X$47 \$206 \$94 \$95 vsubs sg13_hv_nmos L=0.5U W=2U AS=0.8P AD=0.8P PS=4.8U
+ PD=4.8U
* device instance $48 r0 *1 149.47,3.11 nfet
X$48 \$207 \$96 \$97 vsubs sg13_hv_nmos L=0.5U W=2U AS=0.8P AD=0.8P PS=4.8U
+ PD=4.8U
* device instance $49 r0 *1 152.61,3.11 nfet
X$49 \$208 \$98 \$99 vsubs sg13_hv_nmos L=0.5U W=2U AS=0.8P AD=0.8P PS=4.8U
+ PD=4.8U
* device instance $50 r0 *1 155.75,3.11 nfet
X$50 \$209 \$100 \$101 vsubs sg13_hv_nmos L=0.5U W=2U AS=0.8P AD=0.8P PS=4.8U
+ PD=4.8U
* device instance $51 r0 *1 158.89,3.11 nfet
X$51 \$210 \$102 \$103 vsubs sg13_hv_nmos L=0.5U W=2U AS=0.8P AD=0.8P PS=4.8U
+ PD=4.8U
* device instance $52 r0 *1 162.03,3.11 nfet
X$52 \$211 \$104 \$105 vsubs sg13_hv_nmos L=0.5U W=2U AS=0.8P AD=0.8P PS=4.8U
+ PD=4.8U
* device instance $53 r0 *1 165.17,3.11 nfet
X$53 \$212 \$106 \$107 vsubs sg13_hv_nmos L=0.5U W=2U AS=0.8P AD=0.8P PS=4.8U
+ PD=4.8U
* device instance $54 r0 *1 168.31,3.11 nfet
X$54 \$213 \$108 \$109 vsubs sg13_hv_nmos L=0.5U W=2U AS=0.8P AD=0.8P PS=4.8U
+ PD=4.8U
* device instance $55 r0 *1 171.45,3.11 nfet
X$55 \$214 \$110 \$111 vsubs sg13_hv_nmos L=0.5U W=2U AS=0.8P AD=0.8P PS=4.8U
+ PD=4.8U
* device instance $56 r0 *1 174.59,3.11 nfet
X$56 \$215 \$112 \$113 vsubs sg13_hv_nmos L=0.5U W=2U AS=0.8P AD=0.8P PS=4.8U
+ PD=4.8U
* device instance $57 r0 *1 177.73,3.11 nfet
X$57 \$216 \$114 \$115 vsubs sg13_hv_nmos L=0.5U W=2U AS=0.8P AD=0.8P PS=4.8U
+ PD=4.8U
* device instance $58 r0 *1 180.87,3.11 nfet
X$58 \$217 \$116 \$117 vsubs sg13_hv_nmos L=0.5U W=2U AS=0.8P AD=0.8P PS=4.8U
+ PD=4.8U
* device instance $59 r0 *1 184.01,3.11 nfet
X$59 \$218 \$118 \$119 vsubs sg13_hv_nmos L=0.5U W=2U AS=0.8P AD=0.8P PS=4.8U
+ PD=4.8U
* device instance $60 r0 *1 187.15,3.11 nfet
X$60 \$219 \$120 \$121 vsubs sg13_hv_nmos L=0.5U W=2U AS=0.8P AD=0.8P PS=4.8U
+ PD=4.8U
* device instance $61 r0 *1 190.29,3.11 nfet
X$61 \$220 \$122 \$123 vsubs sg13_hv_nmos L=0.5U W=2U AS=0.8P AD=0.8P PS=4.8U
+ PD=4.8U
* device instance $62 r0 *1 193.43,3.11 nfet
X$62 \$221 \$124 \$125 vsubs sg13_hv_nmos L=0.5U W=2U AS=0.8P AD=0.8P PS=4.8U
+ PD=4.8U
* device instance $63 r0 *1 196.57,3.11 nfet
X$63 \$222 \$126 \$127 vsubs sg13_hv_nmos L=0.5U W=2U AS=0.8P AD=0.8P PS=4.8U
+ PD=4.8U
* device instance $64 r0 *1 199.71,3.11 nfet
X$64 \$223 \$128 \$129 vsubs sg13_hv_nmos L=0.5U W=2U AS=0.8P AD=0.8P PS=4.8U
+ PD=4.8U
* device instance $65 r0 *1 202.85,3.11 nfet
X$65 \$224 \$130 \$131 vsubs sg13_hv_nmos L=0.5U W=2U AS=0.8P AD=0.8P PS=4.8U
+ PD=4.8U
* device instance $66 r0 *1 205.99,3.11 nfet
X$66 \$225 \$132 \$133 vsubs sg13_hv_nmos L=0.5U W=2U AS=0.8P AD=0.8P PS=4.8U
+ PD=4.8U
* device instance $67 r0 *1 209.13,3.11 nfet
X$67 \$226 \$134 \$135 vsubs sg13_hv_nmos L=0.5U W=2U AS=0.8P AD=0.8P PS=4.8U
+ PD=4.8U
* device instance $68 r0 *1 212.27,3.11 nfet
X$68 \$227 \$136 \$137 vsubs sg13_hv_nmos L=0.5U W=2U AS=0.8P AD=0.8P PS=4.8U
+ PD=4.8U
* device instance $69 r0 *1 215.41,3.11 nfet
X$69 \$228 \$138 \$139 vsubs sg13_hv_nmos L=0.5U W=2U AS=0.8P AD=0.8P PS=4.8U
+ PD=4.8U
* device instance $70 r0 *1 218.55,3.11 nfet
X$70 \$229 \$140 \$141 vsubs sg13_hv_nmos L=0.5U W=2U AS=0.8P AD=0.8P PS=4.8U
+ PD=4.8U
* device instance $71 r0 *1 221.69,3.11 nfet
X$71 \$230 \$142 \$143 vsubs sg13_hv_nmos L=0.5U W=2U AS=0.8P AD=0.8P PS=4.8U
+ PD=4.8U
* device instance $72 r0 *1 224.83,3.11 nfet
X$72 \$231 \$144 \$145 vsubs sg13_hv_nmos L=0.5U W=2U AS=0.8P AD=0.8P PS=4.8U
+ PD=4.8U
* device instance $73 r0 *1 227.97,3.11 nfet
X$73 \$232 \$146 \$147 vsubs sg13_hv_nmos L=0.5U W=2U AS=0.8P AD=0.8P PS=4.8U
+ PD=4.8U
* device instance $74 r0 *1 231.11,3.11 nfet
X$74 \$233 \$148 \$149 vsubs sg13_hv_nmos L=0.5U W=2U AS=0.8P AD=0.8P PS=4.8U
+ PD=4.8U
* device instance $75 r0 *1 234.25,3.11 nfet
X$75 \$234 \$150 \$151 vsubs sg13_hv_nmos L=0.5U W=2U AS=0.8P AD=0.8P PS=4.8U
+ PD=4.8U
* device instance $76 r0 *1 237.39,3.11 nfet
X$76 \$235 \$152 \$153 vsubs sg13_hv_nmos L=0.5U W=2U AS=0.8P AD=0.8P PS=4.8U
+ PD=4.8U
* device instance $77 r0 *1 240.53,3.11 nfet
X$77 \$236 \$154 \$155 vsubs sg13_hv_nmos L=0.5U W=2U AS=0.8P AD=0.8P PS=4.8U
+ PD=4.8U
* device instance $78 r0 *1 243.67,3.11 nfet
X$78 \$237 \$156 \$157 vsubs sg13_hv_nmos L=0.5U W=2U AS=0.8P AD=0.8P PS=4.8U
+ PD=4.8U
* device instance $79 r0 *1 246.81,3.11 nfet
X$79 \$238 \$158 \$159 vsubs sg13_hv_nmos L=0.5U W=2U AS=0.8P AD=0.8P PS=4.8U
+ PD=4.8U
* device instance $80 r0 *1 1.89,5.69 nfet
X$80 \$319 \$318 \$239 vsubs sg13_hv_nmos L=0.5U W=2U AS=0.8P AD=0.8P PS=4.8U
+ PD=4.8U
* device instance $81 r0 *1 5.03,5.69 nfet
X$81 \$321 \$320 \$240 vsubs sg13_hv_nmos L=0.5U W=2U AS=0.8P AD=0.8P PS=4.8U
+ PD=4.8U
* device instance $82 r0 *1 8.17,5.69 nfet
X$82 \$323 \$322 \$241 vsubs sg13_hv_nmos L=0.5U W=2U AS=0.8P AD=0.8P PS=4.8U
+ PD=4.8U
* device instance $83 r0 *1 11.31,5.69 nfet
X$83 \$325 \$324 \$242 vsubs sg13_hv_nmos L=0.5U W=2U AS=0.8P AD=0.8P PS=4.8U
+ PD=4.8U
* device instance $84 r0 *1 14.45,5.69 nfet
X$84 \$327 \$326 \$243 vsubs sg13_hv_nmos L=0.5U W=2U AS=0.8P AD=0.8P PS=4.8U
+ PD=4.8U
* device instance $85 r0 *1 17.59,5.69 nfet
X$85 \$329 \$328 \$244 vsubs sg13_hv_nmos L=0.5U W=2U AS=0.8P AD=0.8P PS=4.8U
+ PD=4.8U
* device instance $86 r0 *1 20.73,5.69 nfet
X$86 \$331 \$330 \$245 vsubs sg13_hv_nmos L=0.5U W=2U AS=0.8P AD=0.8P PS=4.8U
+ PD=4.8U
* device instance $87 r0 *1 23.87,5.69 nfet
X$87 \$333 \$332 \$246 vsubs sg13_hv_nmos L=0.5U W=2U AS=0.8P AD=0.8P PS=4.8U
+ PD=4.8U
* device instance $88 r0 *1 27.01,5.69 nfet
X$88 \$335 \$334 \$247 vsubs sg13_hv_nmos L=0.5U W=2U AS=0.8P AD=0.8P PS=4.8U
+ PD=4.8U
* device instance $89 r0 *1 30.15,5.69 nfet
X$89 \$337 \$336 \$248 vsubs sg13_hv_nmos L=0.5U W=2U AS=0.8P AD=0.8P PS=4.8U
+ PD=4.8U
* device instance $90 r0 *1 33.29,5.69 nfet
X$90 \$339 \$338 \$249 vsubs sg13_hv_nmos L=0.5U W=2U AS=0.8P AD=0.8P PS=4.8U
+ PD=4.8U
* device instance $91 r0 *1 36.43,5.69 nfet
X$91 \$341 \$340 \$250 vsubs sg13_hv_nmos L=0.5U W=2U AS=0.8P AD=0.8P PS=4.8U
+ PD=4.8U
* device instance $92 r0 *1 39.57,5.69 nfet
X$92 \$343 \$342 \$251 vsubs sg13_hv_nmos L=0.5U W=2U AS=0.8P AD=0.8P PS=4.8U
+ PD=4.8U
* device instance $93 r0 *1 42.71,5.69 nfet
X$93 \$345 \$344 \$252 vsubs sg13_hv_nmos L=0.5U W=2U AS=0.8P AD=0.8P PS=4.8U
+ PD=4.8U
* device instance $94 r0 *1 45.85,5.69 nfet
X$94 \$347 \$346 \$253 vsubs sg13_hv_nmos L=0.5U W=2U AS=0.8P AD=0.8P PS=4.8U
+ PD=4.8U
* device instance $95 r0 *1 48.99,5.69 nfet
X$95 \$349 \$348 \$254 vsubs sg13_hv_nmos L=0.5U W=2U AS=0.8P AD=0.8P PS=4.8U
+ PD=4.8U
* device instance $96 r0 *1 52.13,5.69 nfet
X$96 \$351 \$350 \$255 vsubs sg13_hv_nmos L=0.5U W=2U AS=0.8P AD=0.8P PS=4.8U
+ PD=4.8U
* device instance $97 r0 *1 55.27,5.69 nfet
X$97 \$353 \$352 \$256 vsubs sg13_hv_nmos L=0.5U W=2U AS=0.8P AD=0.8P PS=4.8U
+ PD=4.8U
* device instance $98 r0 *1 58.41,5.69 nfet
X$98 \$355 \$354 \$257 vsubs sg13_hv_nmos L=0.5U W=2U AS=0.8P AD=0.8P PS=4.8U
+ PD=4.8U
* device instance $99 r0 *1 61.55,5.69 nfet
X$99 \$357 \$356 \$258 vsubs sg13_hv_nmos L=0.5U W=2U AS=0.8P AD=0.8P PS=4.8U
+ PD=4.8U
* device instance $100 r0 *1 64.69,5.69 nfet
X$100 \$359 \$358 \$259 vsubs sg13_hv_nmos L=0.5U W=2U AS=0.8P AD=0.8P PS=4.8U
+ PD=4.8U
* device instance $101 r0 *1 67.83,5.69 nfet
X$101 \$361 \$360 \$260 vsubs sg13_hv_nmos L=0.5U W=2U AS=0.8P AD=0.8P PS=4.8U
+ PD=4.8U
* device instance $102 r0 *1 70.97,5.69 nfet
X$102 \$363 \$362 \$261 vsubs sg13_hv_nmos L=0.5U W=2U AS=0.8P AD=0.8P PS=4.8U
+ PD=4.8U
* device instance $103 r0 *1 74.11,5.69 nfet
X$103 \$365 \$364 \$262 vsubs sg13_hv_nmos L=0.5U W=2U AS=0.8P AD=0.8P PS=4.8U
+ PD=4.8U
* device instance $104 r0 *1 77.25,5.69 nfet
X$104 \$367 \$366 \$263 vsubs sg13_hv_nmos L=0.5U W=2U AS=0.8P AD=0.8P PS=4.8U
+ PD=4.8U
* device instance $105 r0 *1 80.39,5.69 nfet
X$105 \$369 \$368 \$264 vsubs sg13_hv_nmos L=0.5U W=2U AS=0.8P AD=0.8P PS=4.8U
+ PD=4.8U
* device instance $106 r0 *1 83.53,5.69 nfet
X$106 \$371 \$370 \$265 vsubs sg13_hv_nmos L=0.5U W=2U AS=0.8P AD=0.8P PS=4.8U
+ PD=4.8U
* device instance $107 r0 *1 86.67,5.69 nfet
X$107 \$373 \$372 \$266 vsubs sg13_hv_nmos L=0.5U W=2U AS=0.8P AD=0.8P PS=4.8U
+ PD=4.8U
* device instance $108 r0 *1 89.81,5.69 nfet
X$108 \$375 \$374 \$267 vsubs sg13_hv_nmos L=0.5U W=2U AS=0.8P AD=0.8P PS=4.8U
+ PD=4.8U
* device instance $109 r0 *1 92.95,5.69 nfet
X$109 \$377 \$376 \$268 vsubs sg13_hv_nmos L=0.5U W=2U AS=0.8P AD=0.8P PS=4.8U
+ PD=4.8U
* device instance $110 r0 *1 96.09,5.69 nfet
X$110 \$379 \$378 \$269 vsubs sg13_hv_nmos L=0.5U W=2U AS=0.8P AD=0.8P PS=4.8U
+ PD=4.8U
* device instance $111 r0 *1 99.23,5.69 nfet
X$111 \$381 \$380 \$270 vsubs sg13_hv_nmos L=0.5U W=2U AS=0.8P AD=0.8P PS=4.8U
+ PD=4.8U
* device instance $112 r0 *1 102.37,5.69 nfet
X$112 \$383 \$382 \$271 vsubs sg13_hv_nmos L=0.5U W=2U AS=0.8P AD=0.8P PS=4.8U
+ PD=4.8U
* device instance $113 r0 *1 105.51,5.69 nfet
X$113 \$385 \$384 \$272 vsubs sg13_hv_nmos L=0.5U W=2U AS=0.8P AD=0.8P PS=4.8U
+ PD=4.8U
* device instance $114 r0 *1 108.65,5.69 nfet
X$114 \$387 \$386 \$273 vsubs sg13_hv_nmos L=0.5U W=2U AS=0.8P AD=0.8P PS=4.8U
+ PD=4.8U
* device instance $115 r0 *1 111.79,5.69 nfet
X$115 \$389 \$388 \$274 vsubs sg13_hv_nmos L=0.5U W=2U AS=0.8P AD=0.8P PS=4.8U
+ PD=4.8U
* device instance $116 r0 *1 114.93,5.69 nfet
X$116 \$391 \$390 \$275 vsubs sg13_hv_nmos L=0.5U W=2U AS=0.8P AD=0.8P PS=4.8U
+ PD=4.8U
* device instance $117 r0 *1 118.07,5.69 nfet
X$117 \$393 \$392 \$276 vsubs sg13_hv_nmos L=0.5U W=2U AS=0.8P AD=0.8P PS=4.8U
+ PD=4.8U
* device instance $118 r0 *1 121.21,5.69 nfet
X$118 \$395 \$394 \$277 vsubs sg13_hv_nmos L=0.5U W=2U AS=0.8P AD=0.8P PS=4.8U
+ PD=4.8U
* device instance $119 r0 *1 124.35,5.69 nfet
X$119 \$397 \$396 \$278 vsubs sg13_hv_nmos L=0.5U W=2U AS=0.8P AD=0.8P PS=4.8U
+ PD=4.8U
* device instance $120 r0 *1 127.49,5.69 nfet
X$120 \$399 \$398 \$279 vsubs sg13_hv_nmos L=0.5U W=2U AS=0.8P AD=0.8P PS=4.8U
+ PD=4.8U
* device instance $121 r0 *1 130.63,5.69 nfet
X$121 \$401 \$400 \$280 vsubs sg13_hv_nmos L=0.5U W=2U AS=0.8P AD=0.8P PS=4.8U
+ PD=4.8U
* device instance $122 r0 *1 133.77,5.69 nfet
X$122 \$403 \$402 \$281 vsubs sg13_hv_nmos L=0.5U W=2U AS=0.8P AD=0.8P PS=4.8U
+ PD=4.8U
* device instance $123 r0 *1 136.91,5.69 nfet
X$123 \$405 \$404 \$282 vsubs sg13_hv_nmos L=0.5U W=2U AS=0.8P AD=0.8P PS=4.8U
+ PD=4.8U
* device instance $124 r0 *1 140.05,5.69 nfet
X$124 \$407 \$406 \$283 vsubs sg13_hv_nmos L=0.5U W=2U AS=0.8P AD=0.8P PS=4.8U
+ PD=4.8U
* device instance $125 r0 *1 143.19,5.69 nfet
X$125 \$409 \$408 \$284 vsubs sg13_hv_nmos L=0.5U W=2U AS=0.8P AD=0.8P PS=4.8U
+ PD=4.8U
* device instance $126 r0 *1 146.33,5.69 nfet
X$126 \$411 \$410 \$285 vsubs sg13_hv_nmos L=0.5U W=2U AS=0.8P AD=0.8P PS=4.8U
+ PD=4.8U
* device instance $127 r0 *1 149.47,5.69 nfet
X$127 \$413 \$412 \$286 vsubs sg13_hv_nmos L=0.5U W=2U AS=0.8P AD=0.8P PS=4.8U
+ PD=4.8U
* device instance $128 r0 *1 152.61,5.69 nfet
X$128 \$415 \$414 \$287 vsubs sg13_hv_nmos L=0.5U W=2U AS=0.8P AD=0.8P PS=4.8U
+ PD=4.8U
* device instance $129 r0 *1 155.75,5.69 nfet
X$129 \$417 \$416 \$288 vsubs sg13_hv_nmos L=0.5U W=2U AS=0.8P AD=0.8P PS=4.8U
+ PD=4.8U
* device instance $130 r0 *1 158.89,5.69 nfet
X$130 \$419 \$418 \$289 vsubs sg13_hv_nmos L=0.5U W=2U AS=0.8P AD=0.8P PS=4.8U
+ PD=4.8U
* device instance $131 r0 *1 162.03,5.69 nfet
X$131 \$421 \$420 \$290 vsubs sg13_hv_nmos L=0.5U W=2U AS=0.8P AD=0.8P PS=4.8U
+ PD=4.8U
* device instance $132 r0 *1 165.17,5.69 nfet
X$132 \$423 \$422 \$291 vsubs sg13_hv_nmos L=0.5U W=2U AS=0.8P AD=0.8P PS=4.8U
+ PD=4.8U
* device instance $133 r0 *1 168.31,5.69 nfet
X$133 \$425 \$424 \$292 vsubs sg13_hv_nmos L=0.5U W=2U AS=0.8P AD=0.8P PS=4.8U
+ PD=4.8U
* device instance $134 r0 *1 171.45,5.69 nfet
X$134 \$427 \$426 \$293 vsubs sg13_hv_nmos L=0.5U W=2U AS=0.8P AD=0.8P PS=4.8U
+ PD=4.8U
* device instance $135 r0 *1 174.59,5.69 nfet
X$135 \$429 \$428 \$294 vsubs sg13_hv_nmos L=0.5U W=2U AS=0.8P AD=0.8P PS=4.8U
+ PD=4.8U
* device instance $136 r0 *1 177.73,5.69 nfet
X$136 \$431 \$430 \$295 vsubs sg13_hv_nmos L=0.5U W=2U AS=0.8P AD=0.8P PS=4.8U
+ PD=4.8U
* device instance $137 r0 *1 180.87,5.69 nfet
X$137 \$433 \$432 \$296 vsubs sg13_hv_nmos L=0.5U W=2U AS=0.8P AD=0.8P PS=4.8U
+ PD=4.8U
* device instance $138 r0 *1 184.01,5.69 nfet
X$138 \$435 \$434 \$297 vsubs sg13_hv_nmos L=0.5U W=2U AS=0.8P AD=0.8P PS=4.8U
+ PD=4.8U
* device instance $139 r0 *1 187.15,5.69 nfet
X$139 \$437 \$436 \$298 vsubs sg13_hv_nmos L=0.5U W=2U AS=0.8P AD=0.8P PS=4.8U
+ PD=4.8U
* device instance $140 r0 *1 190.29,5.69 nfet
X$140 \$439 \$438 \$299 vsubs sg13_hv_nmos L=0.5U W=2U AS=0.8P AD=0.8P PS=4.8U
+ PD=4.8U
* device instance $141 r0 *1 193.43,5.69 nfet
X$141 \$441 \$440 \$300 vsubs sg13_hv_nmos L=0.5U W=2U AS=0.8P AD=0.8P PS=4.8U
+ PD=4.8U
* device instance $142 r0 *1 196.57,5.69 nfet
X$142 \$443 \$442 \$301 vsubs sg13_hv_nmos L=0.5U W=2U AS=0.8P AD=0.8P PS=4.8U
+ PD=4.8U
* device instance $143 r0 *1 199.71,5.69 nfet
X$143 \$445 \$444 \$302 vsubs sg13_hv_nmos L=0.5U W=2U AS=0.8P AD=0.8P PS=4.8U
+ PD=4.8U
* device instance $144 r0 *1 202.85,5.69 nfet
X$144 \$447 \$446 \$303 vsubs sg13_hv_nmos L=0.5U W=2U AS=0.8P AD=0.8P PS=4.8U
+ PD=4.8U
* device instance $145 r0 *1 205.99,5.69 nfet
X$145 \$449 \$448 \$304 vsubs sg13_hv_nmos L=0.5U W=2U AS=0.8P AD=0.8P PS=4.8U
+ PD=4.8U
* device instance $146 r0 *1 209.13,5.69 nfet
X$146 \$451 \$450 \$305 vsubs sg13_hv_nmos L=0.5U W=2U AS=0.8P AD=0.8P PS=4.8U
+ PD=4.8U
* device instance $147 r0 *1 212.27,5.69 nfet
X$147 \$453 \$452 \$306 vsubs sg13_hv_nmos L=0.5U W=2U AS=0.8P AD=0.8P PS=4.8U
+ PD=4.8U
* device instance $148 r0 *1 215.41,5.69 nfet
X$148 \$455 \$454 \$307 vsubs sg13_hv_nmos L=0.5U W=2U AS=0.8P AD=0.8P PS=4.8U
+ PD=4.8U
* device instance $149 r0 *1 218.55,5.69 nfet
X$149 \$457 \$456 \$308 vsubs sg13_hv_nmos L=0.5U W=2U AS=0.8P AD=0.8P PS=4.8U
+ PD=4.8U
* device instance $150 r0 *1 221.69,5.69 nfet
X$150 \$459 \$458 \$309 vsubs sg13_hv_nmos L=0.5U W=2U AS=0.8P AD=0.8P PS=4.8U
+ PD=4.8U
* device instance $151 r0 *1 224.83,5.69 nfet
X$151 \$461 \$460 \$310 vsubs sg13_hv_nmos L=0.5U W=2U AS=0.8P AD=0.8P PS=4.8U
+ PD=4.8U
* device instance $152 r0 *1 227.97,5.69 nfet
X$152 \$463 \$462 \$311 vsubs sg13_hv_nmos L=0.5U W=2U AS=0.8P AD=0.8P PS=4.8U
+ PD=4.8U
* device instance $153 r0 *1 231.11,5.69 nfet
X$153 \$465 \$464 \$312 vsubs sg13_hv_nmos L=0.5U W=2U AS=0.8P AD=0.8P PS=4.8U
+ PD=4.8U
* device instance $154 r0 *1 234.25,5.69 nfet
X$154 \$467 \$466 \$313 vsubs sg13_hv_nmos L=0.5U W=2U AS=0.8P AD=0.8P PS=4.8U
+ PD=4.8U
* device instance $155 r0 *1 237.39,5.69 nfet
X$155 \$469 \$468 \$314 vsubs sg13_hv_nmos L=0.5U W=2U AS=0.8P AD=0.8P PS=4.8U
+ PD=4.8U
* device instance $156 r0 *1 240.53,5.69 nfet
X$156 \$471 \$470 \$315 vsubs sg13_hv_nmos L=0.5U W=2U AS=0.8P AD=0.8P PS=4.8U
+ PD=4.8U
* device instance $157 r0 *1 243.67,5.69 nfet
X$157 \$473 \$472 \$316 vsubs sg13_hv_nmos L=0.5U W=2U AS=0.8P AD=0.8P PS=4.8U
+ PD=4.8U
* device instance $158 r0 *1 246.81,5.69 nfet
X$158 \$475 \$474 \$317 vsubs sg13_hv_nmos L=0.5U W=2U AS=0.8P AD=0.8P PS=4.8U
+ PD=4.8U
.ENDS divider_chain_nfet_w2_l0p5
