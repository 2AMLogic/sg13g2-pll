* extracted by klt extract --deck sg13cmos5l

* cell pfd_pfet_w5_l0p5
* pin pfd_pfet_w5_l0p5_B
.SUBCKT pfd_pfet_w5_l0p5 pfd_pfet_w5_l0p5_B
* device instance $1 r0 *1 3.7,3.11 pfet
X$1 \$64 \$2 \$3 pfd_pfet_w5_l0p5_B sg13_hv_pmos L=0.5U W=5U AS=2P AD=2P
+ PS=10.8U PD=10.8U
* device instance $2 r0 *1 10.46,3.11 pfet
X$2 \$65 \$4 \$5 pfd_pfet_w5_l0p5_B sg13_hv_pmos L=0.5U W=5U AS=2P AD=2P
+ PS=10.8U PD=10.8U
* device instance $3 r0 *1 17.22,3.11 pfet
X$3 \$66 \$6 \$7 pfd_pfet_w5_l0p5_B sg13_hv_pmos L=0.5U W=5U AS=2P AD=2P
+ PS=10.8U PD=10.8U
* device instance $4 r0 *1 23.98,3.11 pfet
X$4 \$67 \$8 \$9 pfd_pfet_w5_l0p5_B sg13_hv_pmos L=0.5U W=5U AS=2P AD=2P
+ PS=10.8U PD=10.8U
* device instance $5 r0 *1 30.74,3.11 pfet
X$5 \$68 \$10 \$11 pfd_pfet_w5_l0p5_B sg13_hv_pmos L=0.5U W=5U AS=2P AD=2P
+ PS=10.8U PD=10.8U
* device instance $6 r0 *1 37.5,3.11 pfet
X$6 \$69 \$12 \$13 pfd_pfet_w5_l0p5_B sg13_hv_pmos L=0.5U W=5U AS=2P AD=2P
+ PS=10.8U PD=10.8U
* device instance $7 r0 *1 44.26,3.11 pfet
X$7 \$70 \$14 \$15 pfd_pfet_w5_l0p5_B sg13_hv_pmos L=0.5U W=5U AS=2P AD=2P
+ PS=10.8U PD=10.8U
* device instance $8 r0 *1 51.02,3.11 pfet
X$8 \$71 \$16 \$17 pfd_pfet_w5_l0p5_B sg13_hv_pmos L=0.5U W=5U AS=2P AD=2P
+ PS=10.8U PD=10.8U
* device instance $9 r0 *1 57.78,3.11 pfet
X$9 \$72 \$18 \$19 pfd_pfet_w5_l0p5_B sg13_hv_pmos L=0.5U W=5U AS=2P AD=2P
+ PS=10.8U PD=10.8U
* device instance $10 r0 *1 64.54,3.11 pfet
X$10 \$73 \$20 \$21 pfd_pfet_w5_l0p5_B sg13_hv_pmos L=0.5U W=5U AS=2P AD=2P
+ PS=10.8U PD=10.8U
* device instance $11 r0 *1 71.3,3.11 pfet
X$11 \$74 \$22 \$23 pfd_pfet_w5_l0p5_B sg13_hv_pmos L=0.5U W=5U AS=2P AD=2P
+ PS=10.8U PD=10.8U
* device instance $12 r0 *1 78.06,3.11 pfet
X$12 \$75 \$24 \$25 pfd_pfet_w5_l0p5_B sg13_hv_pmos L=0.5U W=5U AS=2P AD=2P
+ PS=10.8U PD=10.8U
* device instance $13 r0 *1 84.82,3.11 pfet
X$13 \$76 \$26 \$27 pfd_pfet_w5_l0p5_B sg13_hv_pmos L=0.5U W=5U AS=2P AD=2P
+ PS=10.8U PD=10.8U
* device instance $14 r0 *1 91.58,3.11 pfet
X$14 \$77 \$28 \$29 pfd_pfet_w5_l0p5_B sg13_hv_pmos L=0.5U W=5U AS=2P AD=2P
+ PS=10.8U PD=10.8U
* device instance $15 r0 *1 98.34,3.11 pfet
X$15 \$78 \$30 \$31 pfd_pfet_w5_l0p5_B sg13_hv_pmos L=0.5U W=5U AS=2P AD=2P
+ PS=10.8U PD=10.8U
* device instance $16 r0 *1 105.1,3.11 pfet
X$16 \$79 \$32 \$33 pfd_pfet_w5_l0p5_B sg13_hv_pmos L=0.5U W=5U AS=2P AD=2P
+ PS=10.8U PD=10.8U
* device instance $17 r0 *1 111.86,3.11 pfet
X$17 \$80 \$34 \$35 pfd_pfet_w5_l0p5_B sg13_hv_pmos L=0.5U W=5U AS=2P AD=2P
+ PS=10.8U PD=10.8U
* device instance $18 r0 *1 118.62,3.11 pfet
X$18 \$81 \$36 \$37 pfd_pfet_w5_l0p5_B sg13_hv_pmos L=0.5U W=5U AS=2P AD=2P
+ PS=10.8U PD=10.8U
* device instance $19 r0 *1 125.38,3.11 pfet
X$19 \$82 \$38 \$39 pfd_pfet_w5_l0p5_B sg13_hv_pmos L=0.5U W=5U AS=2P AD=2P
+ PS=10.8U PD=10.8U
* device instance $20 r0 *1 132.14,3.11 pfet
X$20 \$83 \$40 \$41 pfd_pfet_w5_l0p5_B sg13_hv_pmos L=0.5U W=5U AS=2P AD=2P
+ PS=10.8U PD=10.8U
* device instance $21 r0 *1 138.9,3.11 pfet
X$21 \$84 \$42 \$43 pfd_pfet_w5_l0p5_B sg13_hv_pmos L=0.5U W=5U AS=2P AD=2P
+ PS=10.8U PD=10.8U
* device instance $22 r0 *1 145.66,3.11 pfet
X$22 \$85 \$44 \$45 pfd_pfet_w5_l0p5_B sg13_hv_pmos L=0.5U W=5U AS=2P AD=2P
+ PS=10.8U PD=10.8U
* device instance $23 r0 *1 152.42,3.11 pfet
X$23 \$86 \$46 \$47 pfd_pfet_w5_l0p5_B sg13_hv_pmos L=0.5U W=5U AS=2P AD=2P
+ PS=10.8U PD=10.8U
* device instance $24 r0 *1 159.18,3.11 pfet
X$24 \$87 \$48 \$49 pfd_pfet_w5_l0p5_B sg13_hv_pmos L=0.5U W=5U AS=2P AD=2P
+ PS=10.8U PD=10.8U
* device instance $25 r0 *1 165.94,3.11 pfet
X$25 \$88 \$50 \$51 pfd_pfet_w5_l0p5_B sg13_hv_pmos L=0.5U W=5U AS=2P AD=2P
+ PS=10.8U PD=10.8U
* device instance $26 r0 *1 172.7,3.11 pfet
X$26 \$89 \$52 \$53 pfd_pfet_w5_l0p5_B sg13_hv_pmos L=0.5U W=5U AS=2P AD=2P
+ PS=10.8U PD=10.8U
* device instance $27 r0 *1 179.46,3.11 pfet
X$27 \$90 \$54 \$55 pfd_pfet_w5_l0p5_B sg13_hv_pmos L=0.5U W=5U AS=2P AD=2P
+ PS=10.8U PD=10.8U
* device instance $28 r0 *1 186.22,3.11 pfet
X$28 \$91 \$56 \$57 pfd_pfet_w5_l0p5_B sg13_hv_pmos L=0.5U W=5U AS=2P AD=2P
+ PS=10.8U PD=10.8U
* device instance $29 r0 *1 192.98,3.11 pfet
X$29 \$92 \$58 \$59 pfd_pfet_w5_l0p5_B sg13_hv_pmos L=0.5U W=5U AS=2P AD=2P
+ PS=10.8U PD=10.8U
* device instance $30 r0 *1 199.74,3.11 pfet
X$30 \$93 \$60 \$61 pfd_pfet_w5_l0p5_B sg13_hv_pmos L=0.5U W=5U AS=2P AD=2P
+ PS=10.8U PD=10.8U
* device instance $31 r0 *1 206.5,3.11 pfet
X$31 \$94 \$62 \$63 pfd_pfet_w5_l0p5_B sg13_hv_pmos L=0.5U W=5U AS=2P AD=2P
+ PS=10.8U PD=10.8U
.ENDS pfd_pfet_w5_l0p5
