* extracted by klt extract --deck sg13cmos5l

* cell pll_divider_chain
* pin divider_chain_pfet_w5_l0p5_B
* pin vsubs
.SUBCKT pll_divider_chain divider_chain_pfet_w5_l0p5_B vsubs
* device instance $1 r0 *1 1.89,3.11 nfet
X$1 \$160 \$2 \$3 vsubs sg13_hv_nmos L=0.5U W=2U AS=0.8P AD=0.8P PS=4.8U PD=4.8U
* device instance $2 r0 *1 5.03,3.11 nfet
X$2 \$161 \$4 \$5 vsubs sg13_hv_nmos L=0.5U W=2U AS=0.8P AD=0.8P PS=4.8U PD=4.8U
* device instance $3 r0 *1 8.17,3.11 nfet
X$3 \$162 \$6 \$7 vsubs sg13_hv_nmos L=0.5U W=2U AS=0.8P AD=0.8P PS=4.8U PD=4.8U
* device instance $4 r0 *1 11.31,3.11 nfet
X$4 \$163 \$8 \$9 vsubs sg13_hv_nmos L=0.5U W=2U AS=0.8P AD=0.8P PS=4.8U PD=4.8U
* device instance $5 r0 *1 14.45,3.11 nfet
X$5 \$164 \$10 \$11 vsubs sg13_hv_nmos L=0.5U W=2U AS=0.8P AD=0.8P PS=4.8U
+ PD=4.8U
* device instance $6 r0 *1 17.59,3.11 nfet
X$6 \$165 \$12 \$13 vsubs sg13_hv_nmos L=0.5U W=2U AS=0.8P AD=0.8P PS=4.8U
+ PD=4.8U
* device instance $7 r0 *1 20.73,3.11 nfet
X$7 \$166 \$14 \$15 vsubs sg13_hv_nmos L=0.5U W=2U AS=0.8P AD=0.8P PS=4.8U
+ PD=4.8U
* device instance $8 r0 *1 23.87,3.11 nfet
X$8 \$167 \$16 \$17 vsubs sg13_hv_nmos L=0.5U W=2U AS=0.8P AD=0.8P PS=4.8U
+ PD=4.8U
* device instance $9 r0 *1 27.01,3.11 nfet
X$9 \$168 \$18 \$19 vsubs sg13_hv_nmos L=0.5U W=2U AS=0.8P AD=0.8P PS=4.8U
+ PD=4.8U
* device instance $10 r0 *1 30.15,3.11 nfet
X$10 \$169 \$20 \$21 vsubs sg13_hv_nmos L=0.5U W=2U AS=0.8P AD=0.8P PS=4.8U
+ PD=4.8U
* device instance $11 r0 *1 33.29,3.11 nfet
X$11 \$170 \$22 \$23 vsubs sg13_hv_nmos L=0.5U W=2U AS=0.8P AD=0.8P PS=4.8U
+ PD=4.8U
* device instance $12 r0 *1 36.43,3.11 nfet
X$12 \$171 \$24 \$25 vsubs sg13_hv_nmos L=0.5U W=2U AS=0.8P AD=0.8P PS=4.8U
+ PD=4.8U
* device instance $13 r0 *1 39.57,3.11 nfet
X$13 \$172 \$26 \$27 vsubs sg13_hv_nmos L=0.5U W=2U AS=0.8P AD=0.8P PS=4.8U
+ PD=4.8U
* device instance $14 r0 *1 42.71,3.11 nfet
X$14 \$173 \$28 \$29 vsubs sg13_hv_nmos L=0.5U W=2U AS=0.8P AD=0.8P PS=4.8U
+ PD=4.8U
* device instance $15 r0 *1 45.85,3.11 nfet
X$15 \$174 \$30 \$31 vsubs sg13_hv_nmos L=0.5U W=2U AS=0.8P AD=0.8P PS=4.8U
+ PD=4.8U
* device instance $16 r0 *1 48.99,3.11 nfet
X$16 \$175 \$32 \$33 vsubs sg13_hv_nmos L=0.5U W=2U AS=0.8P AD=0.8P PS=4.8U
+ PD=4.8U
* device instance $17 r0 *1 52.13,3.11 nfet
X$17 \$176 \$34 \$35 vsubs sg13_hv_nmos L=0.5U W=2U AS=0.8P AD=0.8P PS=4.8U
+ PD=4.8U
* device instance $18 r0 *1 55.27,3.11 nfet
X$18 \$177 \$36 \$37 vsubs sg13_hv_nmos L=0.5U W=2U AS=0.8P AD=0.8P PS=4.8U
+ PD=4.8U
* device instance $19 r0 *1 58.41,3.11 nfet
X$19 \$178 \$38 \$39 vsubs sg13_hv_nmos L=0.5U W=2U AS=0.8P AD=0.8P PS=4.8U
+ PD=4.8U
* device instance $20 r0 *1 61.55,3.11 nfet
X$20 \$179 \$40 \$41 vsubs sg13_hv_nmos L=0.5U W=2U AS=0.8P AD=0.8P PS=4.8U
+ PD=4.8U
* device instance $21 r0 *1 64.69,3.11 nfet
X$21 \$180 \$42 \$43 vsubs sg13_hv_nmos L=0.5U W=2U AS=0.8P AD=0.8P PS=4.8U
+ PD=4.8U
* device instance $22 r0 *1 67.83,3.11 nfet
X$22 \$181 \$44 \$45 vsubs sg13_hv_nmos L=0.5U W=2U AS=0.8P AD=0.8P PS=4.8U
+ PD=4.8U
* device instance $23 r0 *1 70.97,3.11 nfet
X$23 \$182 \$46 \$47 vsubs sg13_hv_nmos L=0.5U W=2U AS=0.8P AD=0.8P PS=4.8U
+ PD=4.8U
* device instance $24 r0 *1 74.11,3.11 nfet
X$24 \$183 \$48 \$49 vsubs sg13_hv_nmos L=0.5U W=2U AS=0.8P AD=0.8P PS=4.8U
+ PD=4.8U
* device instance $25 r0 *1 77.25,3.11 nfet
X$25 \$184 \$50 \$51 vsubs sg13_hv_nmos L=0.5U W=2U AS=0.8P AD=0.8P PS=4.8U
+ PD=4.8U
* device instance $26 r0 *1 80.39,3.11 nfet
X$26 \$185 \$52 \$53 vsubs sg13_hv_nmos L=0.5U W=2U AS=0.8P AD=0.8P PS=4.8U
+ PD=4.8U
* device instance $27 r0 *1 83.53,3.11 nfet
X$27 \$186 \$54 \$55 vsubs sg13_hv_nmos L=0.5U W=2U AS=0.8P AD=0.8P PS=4.8U
+ PD=4.8U
* device instance $28 r0 *1 86.67,3.11 nfet
X$28 \$187 \$56 \$57 vsubs sg13_hv_nmos L=0.5U W=2U AS=0.8P AD=0.8P PS=4.8U
+ PD=4.8U
* device instance $29 r0 *1 89.81,3.11 nfet
X$29 \$188 \$58 \$59 vsubs sg13_hv_nmos L=0.5U W=2U AS=0.8P AD=0.8P PS=4.8U
+ PD=4.8U
* device instance $30 r0 *1 92.95,3.11 nfet
X$30 \$189 \$60 \$61 vsubs sg13_hv_nmos L=0.5U W=2U AS=0.8P AD=0.8P PS=4.8U
+ PD=4.8U
* device instance $31 r0 *1 96.09,3.11 nfet
X$31 \$190 \$62 \$63 vsubs sg13_hv_nmos L=0.5U W=2U AS=0.8P AD=0.8P PS=4.8U
+ PD=4.8U
* device instance $32 r0 *1 99.23,3.11 nfet
X$32 \$191 \$64 \$65 vsubs sg13_hv_nmos L=0.5U W=2U AS=0.8P AD=0.8P PS=4.8U
+ PD=4.8U
* device instance $33 r0 *1 102.37,3.11 nfet
X$33 \$192 \$66 \$67 vsubs sg13_hv_nmos L=0.5U W=2U AS=0.8P AD=0.8P PS=4.8U
+ PD=4.8U
* device instance $34 r0 *1 105.51,3.11 nfet
X$34 \$193 \$68 \$69 vsubs sg13_hv_nmos L=0.5U W=2U AS=0.8P AD=0.8P PS=4.8U
+ PD=4.8U
* device instance $35 r0 *1 108.65,3.11 nfet
X$35 \$194 \$70 \$71 vsubs sg13_hv_nmos L=0.5U W=2U AS=0.8P AD=0.8P PS=4.8U
+ PD=4.8U
* device instance $36 r0 *1 111.79,3.11 nfet
X$36 \$195 \$72 \$73 vsubs sg13_hv_nmos L=0.5U W=2U AS=0.8P AD=0.8P PS=4.8U
+ PD=4.8U
* device instance $37 r0 *1 114.93,3.11 nfet
X$37 \$196 \$74 \$75 vsubs sg13_hv_nmos L=0.5U W=2U AS=0.8P AD=0.8P PS=4.8U
+ PD=4.8U
* device instance $38 r0 *1 118.07,3.11 nfet
X$38 \$197 \$76 \$77 vsubs sg13_hv_nmos L=0.5U W=2U AS=0.8P AD=0.8P PS=4.8U
+ PD=4.8U
* device instance $39 r0 *1 121.21,3.11 nfet
X$39 \$198 \$78 \$79 vsubs sg13_hv_nmos L=0.5U W=2U AS=0.8P AD=0.8P PS=4.8U
+ PD=4.8U
* device instance $40 r0 *1 124.35,3.11 nfet
X$40 \$199 \$80 \$81 vsubs sg13_hv_nmos L=0.5U W=2U AS=0.8P AD=0.8P PS=4.8U
+ PD=4.8U
* device instance $41 r0 *1 127.49,3.11 nfet
X$41 \$200 \$82 \$83 vsubs sg13_hv_nmos L=0.5U W=2U AS=0.8P AD=0.8P PS=4.8U
+ PD=4.8U
* device instance $42 r0 *1 130.63,3.11 nfet
X$42 \$201 \$84 \$85 vsubs sg13_hv_nmos L=0.5U W=2U AS=0.8P AD=0.8P PS=4.8U
+ PD=4.8U
* device instance $43 r0 *1 133.77,3.11 nfet
X$43 \$202 \$86 \$87 vsubs sg13_hv_nmos L=0.5U W=2U AS=0.8P AD=0.8P PS=4.8U
+ PD=4.8U
* device instance $44 r0 *1 136.91,3.11 nfet
X$44 \$203 \$88 \$89 vsubs sg13_hv_nmos L=0.5U W=2U AS=0.8P AD=0.8P PS=4.8U
+ PD=4.8U
* device instance $45 r0 *1 140.05,3.11 nfet
X$45 \$204 \$90 \$91 vsubs sg13_hv_nmos L=0.5U W=2U AS=0.8P AD=0.8P PS=4.8U
+ PD=4.8U
* device instance $46 r0 *1 143.19,3.11 nfet
X$46 \$205 \$92 \$93 vsubs sg13_hv_nmos L=0.5U W=2U AS=0.8P AD=0.8P PS=4.8U
+ PD=4.8U
* device instance $47 r0 *1 146.33,3.11 nfet
X$47 \$206 \$94 \$95 vsubs sg13_hv_nmos L=0.5U W=2U AS=0.8P AD=0.8P PS=4.8U
+ PD=4.8U
* device instance $48 r0 *1 149.47,3.11 nfet
X$48 \$207 \$96 \$97 vsubs sg13_hv_nmos L=0.5U W=2U AS=0.8P AD=0.8P PS=4.8U
+ PD=4.8U
* device instance $49 r0 *1 152.61,3.11 nfet
X$49 \$208 \$98 \$99 vsubs sg13_hv_nmos L=0.5U W=2U AS=0.8P AD=0.8P PS=4.8U
+ PD=4.8U
* device instance $50 r0 *1 155.75,3.11 nfet
X$50 \$209 \$100 \$101 vsubs sg13_hv_nmos L=0.5U W=2U AS=0.8P AD=0.8P PS=4.8U
+ PD=4.8U
* device instance $51 r0 *1 158.89,3.11 nfet
X$51 \$210 \$102 \$103 vsubs sg13_hv_nmos L=0.5U W=2U AS=0.8P AD=0.8P PS=4.8U
+ PD=4.8U
* device instance $52 r0 *1 162.03,3.11 nfet
X$52 \$211 \$104 \$105 vsubs sg13_hv_nmos L=0.5U W=2U AS=0.8P AD=0.8P PS=4.8U
+ PD=4.8U
* device instance $53 r0 *1 165.17,3.11 nfet
X$53 \$212 \$106 \$107 vsubs sg13_hv_nmos L=0.5U W=2U AS=0.8P AD=0.8P PS=4.8U
+ PD=4.8U
* device instance $54 r0 *1 168.31,3.11 nfet
X$54 \$213 \$108 \$109 vsubs sg13_hv_nmos L=0.5U W=2U AS=0.8P AD=0.8P PS=4.8U
+ PD=4.8U
* device instance $55 r0 *1 171.45,3.11 nfet
X$55 \$214 \$110 \$111 vsubs sg13_hv_nmos L=0.5U W=2U AS=0.8P AD=0.8P PS=4.8U
+ PD=4.8U
* device instance $56 r0 *1 174.59,3.11 nfet
X$56 \$215 \$112 \$113 vsubs sg13_hv_nmos L=0.5U W=2U AS=0.8P AD=0.8P PS=4.8U
+ PD=4.8U
* device instance $57 r0 *1 177.73,3.11 nfet
X$57 \$216 \$114 \$115 vsubs sg13_hv_nmos L=0.5U W=2U AS=0.8P AD=0.8P PS=4.8U
+ PD=4.8U
* device instance $58 r0 *1 180.87,3.11 nfet
X$58 \$217 \$116 \$117 vsubs sg13_hv_nmos L=0.5U W=2U AS=0.8P AD=0.8P PS=4.8U
+ PD=4.8U
* device instance $59 r0 *1 184.01,3.11 nfet
X$59 \$218 \$118 \$119 vsubs sg13_hv_nmos L=0.5U W=2U AS=0.8P AD=0.8P PS=4.8U
+ PD=4.8U
* device instance $60 r0 *1 187.15,3.11 nfet
X$60 \$219 \$120 \$121 vsubs sg13_hv_nmos L=0.5U W=2U AS=0.8P AD=0.8P PS=4.8U
+ PD=4.8U
* device instance $61 r0 *1 190.29,3.11 nfet
X$61 \$220 \$122 \$123 vsubs sg13_hv_nmos L=0.5U W=2U AS=0.8P AD=0.8P PS=4.8U
+ PD=4.8U
* device instance $62 r0 *1 193.43,3.11 nfet
X$62 \$221 \$124 \$125 vsubs sg13_hv_nmos L=0.5U W=2U AS=0.8P AD=0.8P PS=4.8U
+ PD=4.8U
* device instance $63 r0 *1 196.57,3.11 nfet
X$63 \$222 \$126 \$127 vsubs sg13_hv_nmos L=0.5U W=2U AS=0.8P AD=0.8P PS=4.8U
+ PD=4.8U
* device instance $64 r0 *1 199.71,3.11 nfet
X$64 \$223 \$128 \$129 vsubs sg13_hv_nmos L=0.5U W=2U AS=0.8P AD=0.8P PS=4.8U
+ PD=4.8U
* device instance $65 r0 *1 202.85,3.11 nfet
X$65 \$224 \$130 \$131 vsubs sg13_hv_nmos L=0.5U W=2U AS=0.8P AD=0.8P PS=4.8U
+ PD=4.8U
* device instance $66 r0 *1 205.99,3.11 nfet
X$66 \$225 \$132 \$133 vsubs sg13_hv_nmos L=0.5U W=2U AS=0.8P AD=0.8P PS=4.8U
+ PD=4.8U
* device instance $67 r0 *1 209.13,3.11 nfet
X$67 \$226 \$134 \$135 vsubs sg13_hv_nmos L=0.5U W=2U AS=0.8P AD=0.8P PS=4.8U
+ PD=4.8U
* device instance $68 r0 *1 212.27,3.11 nfet
X$68 \$227 \$136 \$137 vsubs sg13_hv_nmos L=0.5U W=2U AS=0.8P AD=0.8P PS=4.8U
+ PD=4.8U
* device instance $69 r0 *1 215.41,3.11 nfet
X$69 \$228 \$138 \$139 vsubs sg13_hv_nmos L=0.5U W=2U AS=0.8P AD=0.8P PS=4.8U
+ PD=4.8U
* device instance $70 r0 *1 218.55,3.11 nfet
X$70 \$229 \$140 \$141 vsubs sg13_hv_nmos L=0.5U W=2U AS=0.8P AD=0.8P PS=4.8U
+ PD=4.8U
* device instance $71 r0 *1 221.69,3.11 nfet
X$71 \$230 \$142 \$143 vsubs sg13_hv_nmos L=0.5U W=2U AS=0.8P AD=0.8P PS=4.8U
+ PD=4.8U
* device instance $72 r0 *1 224.83,3.11 nfet
X$72 \$231 \$144 \$145 vsubs sg13_hv_nmos L=0.5U W=2U AS=0.8P AD=0.8P PS=4.8U
+ PD=4.8U
* device instance $73 r0 *1 227.97,3.11 nfet
X$73 \$232 \$146 \$147 vsubs sg13_hv_nmos L=0.5U W=2U AS=0.8P AD=0.8P PS=4.8U
+ PD=4.8U
* device instance $74 r0 *1 231.11,3.11 nfet
X$74 \$233 \$148 \$149 vsubs sg13_hv_nmos L=0.5U W=2U AS=0.8P AD=0.8P PS=4.8U
+ PD=4.8U
* device instance $75 r0 *1 234.25,3.11 nfet
X$75 \$234 \$150 \$151 vsubs sg13_hv_nmos L=0.5U W=2U AS=0.8P AD=0.8P PS=4.8U
+ PD=4.8U
* device instance $76 r0 *1 237.39,3.11 nfet
X$76 \$235 \$152 \$153 vsubs sg13_hv_nmos L=0.5U W=2U AS=0.8P AD=0.8P PS=4.8U
+ PD=4.8U
* device instance $77 r0 *1 240.53,3.11 nfet
X$77 \$236 \$154 \$155 vsubs sg13_hv_nmos L=0.5U W=2U AS=0.8P AD=0.8P PS=4.8U
+ PD=4.8U
* device instance $78 r0 *1 243.67,3.11 nfet
X$78 \$237 \$156 \$157 vsubs sg13_hv_nmos L=0.5U W=2U AS=0.8P AD=0.8P PS=4.8U
+ PD=4.8U
* device instance $79 r0 *1 246.81,3.11 nfet
X$79 \$238 \$158 \$159 vsubs sg13_hv_nmos L=0.5U W=2U AS=0.8P AD=0.8P PS=4.8U
+ PD=4.8U
* device instance $80 r0 *1 1.89,5.69 nfet
X$80 \$319 \$318 \$239 vsubs sg13_hv_nmos L=0.5U W=2U AS=0.8P AD=0.8P PS=4.8U
+ PD=4.8U
* device instance $81 r0 *1 5.03,5.69 nfet
X$81 \$321 \$320 \$240 vsubs sg13_hv_nmos L=0.5U W=2U AS=0.8P AD=0.8P PS=4.8U
+ PD=4.8U
* device instance $82 r0 *1 8.17,5.69 nfet
X$82 \$323 \$322 \$241 vsubs sg13_hv_nmos L=0.5U W=2U AS=0.8P AD=0.8P PS=4.8U
+ PD=4.8U
* device instance $83 r0 *1 11.31,5.69 nfet
X$83 \$325 \$324 \$242 vsubs sg13_hv_nmos L=0.5U W=2U AS=0.8P AD=0.8P PS=4.8U
+ PD=4.8U
* device instance $84 r0 *1 14.45,5.69 nfet
X$84 \$327 \$326 \$243 vsubs sg13_hv_nmos L=0.5U W=2U AS=0.8P AD=0.8P PS=4.8U
+ PD=4.8U
* device instance $85 r0 *1 17.59,5.69 nfet
X$85 \$329 \$328 \$244 vsubs sg13_hv_nmos L=0.5U W=2U AS=0.8P AD=0.8P PS=4.8U
+ PD=4.8U
* device instance $86 r0 *1 20.73,5.69 nfet
X$86 \$331 \$330 \$245 vsubs sg13_hv_nmos L=0.5U W=2U AS=0.8P AD=0.8P PS=4.8U
+ PD=4.8U
* device instance $87 r0 *1 23.87,5.69 nfet
X$87 \$333 \$332 \$246 vsubs sg13_hv_nmos L=0.5U W=2U AS=0.8P AD=0.8P PS=4.8U
+ PD=4.8U
* device instance $88 r0 *1 27.01,5.69 nfet
X$88 \$335 \$334 \$247 vsubs sg13_hv_nmos L=0.5U W=2U AS=0.8P AD=0.8P PS=4.8U
+ PD=4.8U
* device instance $89 r0 *1 30.15,5.69 nfet
X$89 \$337 \$336 \$248 vsubs sg13_hv_nmos L=0.5U W=2U AS=0.8P AD=0.8P PS=4.8U
+ PD=4.8U
* device instance $90 r0 *1 33.29,5.69 nfet
X$90 \$339 \$338 \$249 vsubs sg13_hv_nmos L=0.5U W=2U AS=0.8P AD=0.8P PS=4.8U
+ PD=4.8U
* device instance $91 r0 *1 36.43,5.69 nfet
X$91 \$341 \$340 \$250 vsubs sg13_hv_nmos L=0.5U W=2U AS=0.8P AD=0.8P PS=4.8U
+ PD=4.8U
* device instance $92 r0 *1 39.57,5.69 nfet
X$92 \$343 \$342 \$251 vsubs sg13_hv_nmos L=0.5U W=2U AS=0.8P AD=0.8P PS=4.8U
+ PD=4.8U
* device instance $93 r0 *1 42.71,5.69 nfet
X$93 \$345 \$344 \$252 vsubs sg13_hv_nmos L=0.5U W=2U AS=0.8P AD=0.8P PS=4.8U
+ PD=4.8U
* device instance $94 r0 *1 45.85,5.69 nfet
X$94 \$347 \$346 \$253 vsubs sg13_hv_nmos L=0.5U W=2U AS=0.8P AD=0.8P PS=4.8U
+ PD=4.8U
* device instance $95 r0 *1 48.99,5.69 nfet
X$95 \$349 \$348 \$254 vsubs sg13_hv_nmos L=0.5U W=2U AS=0.8P AD=0.8P PS=4.8U
+ PD=4.8U
* device instance $96 r0 *1 52.13,5.69 nfet
X$96 \$351 \$350 \$255 vsubs sg13_hv_nmos L=0.5U W=2U AS=0.8P AD=0.8P PS=4.8U
+ PD=4.8U
* device instance $97 r0 *1 55.27,5.69 nfet
X$97 \$353 \$352 \$256 vsubs sg13_hv_nmos L=0.5U W=2U AS=0.8P AD=0.8P PS=4.8U
+ PD=4.8U
* device instance $98 r0 *1 58.41,5.69 nfet
X$98 \$355 \$354 \$257 vsubs sg13_hv_nmos L=0.5U W=2U AS=0.8P AD=0.8P PS=4.8U
+ PD=4.8U
* device instance $99 r0 *1 61.55,5.69 nfet
X$99 \$357 \$356 \$258 vsubs sg13_hv_nmos L=0.5U W=2U AS=0.8P AD=0.8P PS=4.8U
+ PD=4.8U
* device instance $100 r0 *1 64.69,5.69 nfet
X$100 \$359 \$358 \$259 vsubs sg13_hv_nmos L=0.5U W=2U AS=0.8P AD=0.8P PS=4.8U
+ PD=4.8U
* device instance $101 r0 *1 67.83,5.69 nfet
X$101 \$361 \$360 \$260 vsubs sg13_hv_nmos L=0.5U W=2U AS=0.8P AD=0.8P PS=4.8U
+ PD=4.8U
* device instance $102 r0 *1 70.97,5.69 nfet
X$102 \$363 \$362 \$261 vsubs sg13_hv_nmos L=0.5U W=2U AS=0.8P AD=0.8P PS=4.8U
+ PD=4.8U
* device instance $103 r0 *1 74.11,5.69 nfet
X$103 \$365 \$364 \$262 vsubs sg13_hv_nmos L=0.5U W=2U AS=0.8P AD=0.8P PS=4.8U
+ PD=4.8U
* device instance $104 r0 *1 77.25,5.69 nfet
X$104 \$367 \$366 \$263 vsubs sg13_hv_nmos L=0.5U W=2U AS=0.8P AD=0.8P PS=4.8U
+ PD=4.8U
* device instance $105 r0 *1 80.39,5.69 nfet
X$105 \$369 \$368 \$264 vsubs sg13_hv_nmos L=0.5U W=2U AS=0.8P AD=0.8P PS=4.8U
+ PD=4.8U
* device instance $106 r0 *1 83.53,5.69 nfet
X$106 \$371 \$370 \$265 vsubs sg13_hv_nmos L=0.5U W=2U AS=0.8P AD=0.8P PS=4.8U
+ PD=4.8U
* device instance $107 r0 *1 86.67,5.69 nfet
X$107 \$373 \$372 \$266 vsubs sg13_hv_nmos L=0.5U W=2U AS=0.8P AD=0.8P PS=4.8U
+ PD=4.8U
* device instance $108 r0 *1 89.81,5.69 nfet
X$108 \$375 \$374 \$267 vsubs sg13_hv_nmos L=0.5U W=2U AS=0.8P AD=0.8P PS=4.8U
+ PD=4.8U
* device instance $109 r0 *1 92.95,5.69 nfet
X$109 \$377 \$376 \$268 vsubs sg13_hv_nmos L=0.5U W=2U AS=0.8P AD=0.8P PS=4.8U
+ PD=4.8U
* device instance $110 r0 *1 96.09,5.69 nfet
X$110 \$379 \$378 \$269 vsubs sg13_hv_nmos L=0.5U W=2U AS=0.8P AD=0.8P PS=4.8U
+ PD=4.8U
* device instance $111 r0 *1 99.23,5.69 nfet
X$111 \$381 \$380 \$270 vsubs sg13_hv_nmos L=0.5U W=2U AS=0.8P AD=0.8P PS=4.8U
+ PD=4.8U
* device instance $112 r0 *1 102.37,5.69 nfet
X$112 \$383 \$382 \$271 vsubs sg13_hv_nmos L=0.5U W=2U AS=0.8P AD=0.8P PS=4.8U
+ PD=4.8U
* device instance $113 r0 *1 105.51,5.69 nfet
X$113 \$385 \$384 \$272 vsubs sg13_hv_nmos L=0.5U W=2U AS=0.8P AD=0.8P PS=4.8U
+ PD=4.8U
* device instance $114 r0 *1 108.65,5.69 nfet
X$114 \$387 \$386 \$273 vsubs sg13_hv_nmos L=0.5U W=2U AS=0.8P AD=0.8P PS=4.8U
+ PD=4.8U
* device instance $115 r0 *1 111.79,5.69 nfet
X$115 \$389 \$388 \$274 vsubs sg13_hv_nmos L=0.5U W=2U AS=0.8P AD=0.8P PS=4.8U
+ PD=4.8U
* device instance $116 r0 *1 114.93,5.69 nfet
X$116 \$391 \$390 \$275 vsubs sg13_hv_nmos L=0.5U W=2U AS=0.8P AD=0.8P PS=4.8U
+ PD=4.8U
* device instance $117 r0 *1 118.07,5.69 nfet
X$117 \$393 \$392 \$276 vsubs sg13_hv_nmos L=0.5U W=2U AS=0.8P AD=0.8P PS=4.8U
+ PD=4.8U
* device instance $118 r0 *1 121.21,5.69 nfet
X$118 \$395 \$394 \$277 vsubs sg13_hv_nmos L=0.5U W=2U AS=0.8P AD=0.8P PS=4.8U
+ PD=4.8U
* device instance $119 r0 *1 124.35,5.69 nfet
X$119 \$397 \$396 \$278 vsubs sg13_hv_nmos L=0.5U W=2U AS=0.8P AD=0.8P PS=4.8U
+ PD=4.8U
* device instance $120 r0 *1 127.49,5.69 nfet
X$120 \$399 \$398 \$279 vsubs sg13_hv_nmos L=0.5U W=2U AS=0.8P AD=0.8P PS=4.8U
+ PD=4.8U
* device instance $121 r0 *1 130.63,5.69 nfet
X$121 \$401 \$400 \$280 vsubs sg13_hv_nmos L=0.5U W=2U AS=0.8P AD=0.8P PS=4.8U
+ PD=4.8U
* device instance $122 r0 *1 133.77,5.69 nfet
X$122 \$403 \$402 \$281 vsubs sg13_hv_nmos L=0.5U W=2U AS=0.8P AD=0.8P PS=4.8U
+ PD=4.8U
* device instance $123 r0 *1 136.91,5.69 nfet
X$123 \$405 \$404 \$282 vsubs sg13_hv_nmos L=0.5U W=2U AS=0.8P AD=0.8P PS=4.8U
+ PD=4.8U
* device instance $124 r0 *1 140.05,5.69 nfet
X$124 \$407 \$406 \$283 vsubs sg13_hv_nmos L=0.5U W=2U AS=0.8P AD=0.8P PS=4.8U
+ PD=4.8U
* device instance $125 r0 *1 143.19,5.69 nfet
X$125 \$409 \$408 \$284 vsubs sg13_hv_nmos L=0.5U W=2U AS=0.8P AD=0.8P PS=4.8U
+ PD=4.8U
* device instance $126 r0 *1 146.33,5.69 nfet
X$126 \$411 \$410 \$285 vsubs sg13_hv_nmos L=0.5U W=2U AS=0.8P AD=0.8P PS=4.8U
+ PD=4.8U
* device instance $127 r0 *1 149.47,5.69 nfet
X$127 \$413 \$412 \$286 vsubs sg13_hv_nmos L=0.5U W=2U AS=0.8P AD=0.8P PS=4.8U
+ PD=4.8U
* device instance $128 r0 *1 152.61,5.69 nfet
X$128 \$415 \$414 \$287 vsubs sg13_hv_nmos L=0.5U W=2U AS=0.8P AD=0.8P PS=4.8U
+ PD=4.8U
* device instance $129 r0 *1 155.75,5.69 nfet
X$129 \$417 \$416 \$288 vsubs sg13_hv_nmos L=0.5U W=2U AS=0.8P AD=0.8P PS=4.8U
+ PD=4.8U
* device instance $130 r0 *1 158.89,5.69 nfet
X$130 \$419 \$418 \$289 vsubs sg13_hv_nmos L=0.5U W=2U AS=0.8P AD=0.8P PS=4.8U
+ PD=4.8U
* device instance $131 r0 *1 162.03,5.69 nfet
X$131 \$421 \$420 \$290 vsubs sg13_hv_nmos L=0.5U W=2U AS=0.8P AD=0.8P PS=4.8U
+ PD=4.8U
* device instance $132 r0 *1 165.17,5.69 nfet
X$132 \$423 \$422 \$291 vsubs sg13_hv_nmos L=0.5U W=2U AS=0.8P AD=0.8P PS=4.8U
+ PD=4.8U
* device instance $133 r0 *1 168.31,5.69 nfet
X$133 \$425 \$424 \$292 vsubs sg13_hv_nmos L=0.5U W=2U AS=0.8P AD=0.8P PS=4.8U
+ PD=4.8U
* device instance $134 r0 *1 171.45,5.69 nfet
X$134 \$427 \$426 \$293 vsubs sg13_hv_nmos L=0.5U W=2U AS=0.8P AD=0.8P PS=4.8U
+ PD=4.8U
* device instance $135 r0 *1 174.59,5.69 nfet
X$135 \$429 \$428 \$294 vsubs sg13_hv_nmos L=0.5U W=2U AS=0.8P AD=0.8P PS=4.8U
+ PD=4.8U
* device instance $136 r0 *1 177.73,5.69 nfet
X$136 \$431 \$430 \$295 vsubs sg13_hv_nmos L=0.5U W=2U AS=0.8P AD=0.8P PS=4.8U
+ PD=4.8U
* device instance $137 r0 *1 180.87,5.69 nfet
X$137 \$433 \$432 \$296 vsubs sg13_hv_nmos L=0.5U W=2U AS=0.8P AD=0.8P PS=4.8U
+ PD=4.8U
* device instance $138 r0 *1 184.01,5.69 nfet
X$138 \$435 \$434 \$297 vsubs sg13_hv_nmos L=0.5U W=2U AS=0.8P AD=0.8P PS=4.8U
+ PD=4.8U
* device instance $139 r0 *1 187.15,5.69 nfet
X$139 \$437 \$436 \$298 vsubs sg13_hv_nmos L=0.5U W=2U AS=0.8P AD=0.8P PS=4.8U
+ PD=4.8U
* device instance $140 r0 *1 190.29,5.69 nfet
X$140 \$439 \$438 \$299 vsubs sg13_hv_nmos L=0.5U W=2U AS=0.8P AD=0.8P PS=4.8U
+ PD=4.8U
* device instance $141 r0 *1 193.43,5.69 nfet
X$141 \$441 \$440 \$300 vsubs sg13_hv_nmos L=0.5U W=2U AS=0.8P AD=0.8P PS=4.8U
+ PD=4.8U
* device instance $142 r0 *1 196.57,5.69 nfet
X$142 \$443 \$442 \$301 vsubs sg13_hv_nmos L=0.5U W=2U AS=0.8P AD=0.8P PS=4.8U
+ PD=4.8U
* device instance $143 r0 *1 199.71,5.69 nfet
X$143 \$445 \$444 \$302 vsubs sg13_hv_nmos L=0.5U W=2U AS=0.8P AD=0.8P PS=4.8U
+ PD=4.8U
* device instance $144 r0 *1 202.85,5.69 nfet
X$144 \$447 \$446 \$303 vsubs sg13_hv_nmos L=0.5U W=2U AS=0.8P AD=0.8P PS=4.8U
+ PD=4.8U
* device instance $145 r0 *1 205.99,5.69 nfet
X$145 \$449 \$448 \$304 vsubs sg13_hv_nmos L=0.5U W=2U AS=0.8P AD=0.8P PS=4.8U
+ PD=4.8U
* device instance $146 r0 *1 209.13,5.69 nfet
X$146 \$451 \$450 \$305 vsubs sg13_hv_nmos L=0.5U W=2U AS=0.8P AD=0.8P PS=4.8U
+ PD=4.8U
* device instance $147 r0 *1 212.27,5.69 nfet
X$147 \$453 \$452 \$306 vsubs sg13_hv_nmos L=0.5U W=2U AS=0.8P AD=0.8P PS=4.8U
+ PD=4.8U
* device instance $148 r0 *1 215.41,5.69 nfet
X$148 \$455 \$454 \$307 vsubs sg13_hv_nmos L=0.5U W=2U AS=0.8P AD=0.8P PS=4.8U
+ PD=4.8U
* device instance $149 r0 *1 218.55,5.69 nfet
X$149 \$457 \$456 \$308 vsubs sg13_hv_nmos L=0.5U W=2U AS=0.8P AD=0.8P PS=4.8U
+ PD=4.8U
* device instance $150 r0 *1 221.69,5.69 nfet
X$150 \$459 \$458 \$309 vsubs sg13_hv_nmos L=0.5U W=2U AS=0.8P AD=0.8P PS=4.8U
+ PD=4.8U
* device instance $151 r0 *1 224.83,5.69 nfet
X$151 \$461 \$460 \$310 vsubs sg13_hv_nmos L=0.5U W=2U AS=0.8P AD=0.8P PS=4.8U
+ PD=4.8U
* device instance $152 r0 *1 227.97,5.69 nfet
X$152 \$463 \$462 \$311 vsubs sg13_hv_nmos L=0.5U W=2U AS=0.8P AD=0.8P PS=4.8U
+ PD=4.8U
* device instance $153 r0 *1 231.11,5.69 nfet
X$153 \$465 \$464 \$312 vsubs sg13_hv_nmos L=0.5U W=2U AS=0.8P AD=0.8P PS=4.8U
+ PD=4.8U
* device instance $154 r0 *1 234.25,5.69 nfet
X$154 \$467 \$466 \$313 vsubs sg13_hv_nmos L=0.5U W=2U AS=0.8P AD=0.8P PS=4.8U
+ PD=4.8U
* device instance $155 r0 *1 237.39,5.69 nfet
X$155 \$469 \$468 \$314 vsubs sg13_hv_nmos L=0.5U W=2U AS=0.8P AD=0.8P PS=4.8U
+ PD=4.8U
* device instance $156 r0 *1 240.53,5.69 nfet
X$156 \$471 \$470 \$315 vsubs sg13_hv_nmos L=0.5U W=2U AS=0.8P AD=0.8P PS=4.8U
+ PD=4.8U
* device instance $157 r0 *1 243.67,5.69 nfet
X$157 \$473 \$472 \$316 vsubs sg13_hv_nmos L=0.5U W=2U AS=0.8P AD=0.8P PS=4.8U
+ PD=4.8U
* device instance $158 r0 *1 246.81,5.69 nfet
X$158 \$475 \$474 \$317 vsubs sg13_hv_nmos L=0.5U W=2U AS=0.8P AD=0.8P PS=4.8U
+ PD=4.8U
* device instance $159 r0 *1 3.7,16.41 pfet
X$159 \$635 \$477 \$478 divider_chain_pfet_w5_l0p5_B sg13_hv_pmos L=0.5U W=5U
+ AS=2P AD=2P PS=10.8U PD=10.8U
* device instance $160 r0 *1 10.46,16.41 pfet
X$160 \$636 \$479 \$480 divider_chain_pfet_w5_l0p5_B sg13_hv_pmos L=0.5U W=5U
+ AS=2P AD=2P PS=10.8U PD=10.8U
* device instance $161 r0 *1 17.22,16.41 pfet
X$161 \$637 \$481 \$482 divider_chain_pfet_w5_l0p5_B sg13_hv_pmos L=0.5U W=5U
+ AS=2P AD=2P PS=10.8U PD=10.8U
* device instance $162 r0 *1 23.98,16.41 pfet
X$162 \$638 \$483 \$484 divider_chain_pfet_w5_l0p5_B sg13_hv_pmos L=0.5U W=5U
+ AS=2P AD=2P PS=10.8U PD=10.8U
* device instance $163 r0 *1 30.74,16.41 pfet
X$163 \$639 \$485 \$486 divider_chain_pfet_w5_l0p5_B sg13_hv_pmos L=0.5U W=5U
+ AS=2P AD=2P PS=10.8U PD=10.8U
* device instance $164 r0 *1 37.5,16.41 pfet
X$164 \$640 \$487 \$488 divider_chain_pfet_w5_l0p5_B sg13_hv_pmos L=0.5U W=5U
+ AS=2P AD=2P PS=10.8U PD=10.8U
* device instance $165 r0 *1 44.26,16.41 pfet
X$165 \$641 \$489 \$490 divider_chain_pfet_w5_l0p5_B sg13_hv_pmos L=0.5U W=5U
+ AS=2P AD=2P PS=10.8U PD=10.8U
* device instance $166 r0 *1 51.02,16.41 pfet
X$166 \$642 \$491 \$492 divider_chain_pfet_w5_l0p5_B sg13_hv_pmos L=0.5U W=5U
+ AS=2P AD=2P PS=10.8U PD=10.8U
* device instance $167 r0 *1 57.78,16.41 pfet
X$167 \$643 \$493 \$494 divider_chain_pfet_w5_l0p5_B sg13_hv_pmos L=0.5U W=5U
+ AS=2P AD=2P PS=10.8U PD=10.8U
* device instance $168 r0 *1 64.54,16.41 pfet
X$168 \$644 \$495 \$496 divider_chain_pfet_w5_l0p5_B sg13_hv_pmos L=0.5U W=5U
+ AS=2P AD=2P PS=10.8U PD=10.8U
* device instance $169 r0 *1 71.3,16.41 pfet
X$169 \$645 \$497 \$498 divider_chain_pfet_w5_l0p5_B sg13_hv_pmos L=0.5U W=5U
+ AS=2P AD=2P PS=10.8U PD=10.8U
* device instance $170 r0 *1 78.06,16.41 pfet
X$170 \$646 \$499 \$500 divider_chain_pfet_w5_l0p5_B sg13_hv_pmos L=0.5U W=5U
+ AS=2P AD=2P PS=10.8U PD=10.8U
* device instance $171 r0 *1 84.82,16.41 pfet
X$171 \$647 \$501 \$502 divider_chain_pfet_w5_l0p5_B sg13_hv_pmos L=0.5U W=5U
+ AS=2P AD=2P PS=10.8U PD=10.8U
* device instance $172 r0 *1 91.58,16.41 pfet
X$172 \$648 \$503 \$504 divider_chain_pfet_w5_l0p5_B sg13_hv_pmos L=0.5U W=5U
+ AS=2P AD=2P PS=10.8U PD=10.8U
* device instance $173 r0 *1 98.34,16.41 pfet
X$173 \$649 \$505 \$506 divider_chain_pfet_w5_l0p5_B sg13_hv_pmos L=0.5U W=5U
+ AS=2P AD=2P PS=10.8U PD=10.8U
* device instance $174 r0 *1 105.1,16.41 pfet
X$174 \$650 \$507 \$508 divider_chain_pfet_w5_l0p5_B sg13_hv_pmos L=0.5U W=5U
+ AS=2P AD=2P PS=10.8U PD=10.8U
* device instance $175 r0 *1 111.86,16.41 pfet
X$175 \$651 \$509 \$510 divider_chain_pfet_w5_l0p5_B sg13_hv_pmos L=0.5U W=5U
+ AS=2P AD=2P PS=10.8U PD=10.8U
* device instance $176 r0 *1 118.62,16.41 pfet
X$176 \$652 \$511 \$512 divider_chain_pfet_w5_l0p5_B sg13_hv_pmos L=0.5U W=5U
+ AS=2P AD=2P PS=10.8U PD=10.8U
* device instance $177 r0 *1 125.38,16.41 pfet
X$177 \$653 \$513 \$514 divider_chain_pfet_w5_l0p5_B sg13_hv_pmos L=0.5U W=5U
+ AS=2P AD=2P PS=10.8U PD=10.8U
* device instance $178 r0 *1 132.14,16.41 pfet
X$178 \$654 \$515 \$516 divider_chain_pfet_w5_l0p5_B sg13_hv_pmos L=0.5U W=5U
+ AS=2P AD=2P PS=10.8U PD=10.8U
* device instance $179 r0 *1 138.9,16.41 pfet
X$179 \$655 \$517 \$518 divider_chain_pfet_w5_l0p5_B sg13_hv_pmos L=0.5U W=5U
+ AS=2P AD=2P PS=10.8U PD=10.8U
* device instance $180 r0 *1 145.66,16.41 pfet
X$180 \$656 \$519 \$520 divider_chain_pfet_w5_l0p5_B sg13_hv_pmos L=0.5U W=5U
+ AS=2P AD=2P PS=10.8U PD=10.8U
* device instance $181 r0 *1 152.42,16.41 pfet
X$181 \$657 \$521 \$522 divider_chain_pfet_w5_l0p5_B sg13_hv_pmos L=0.5U W=5U
+ AS=2P AD=2P PS=10.8U PD=10.8U
* device instance $182 r0 *1 159.18,16.41 pfet
X$182 \$658 \$523 \$524 divider_chain_pfet_w5_l0p5_B sg13_hv_pmos L=0.5U W=5U
+ AS=2P AD=2P PS=10.8U PD=10.8U
* device instance $183 r0 *1 165.94,16.41 pfet
X$183 \$659 \$525 \$526 divider_chain_pfet_w5_l0p5_B sg13_hv_pmos L=0.5U W=5U
+ AS=2P AD=2P PS=10.8U PD=10.8U
* device instance $184 r0 *1 172.7,16.41 pfet
X$184 \$660 \$527 \$528 divider_chain_pfet_w5_l0p5_B sg13_hv_pmos L=0.5U W=5U
+ AS=2P AD=2P PS=10.8U PD=10.8U
* device instance $185 r0 *1 179.46,16.41 pfet
X$185 \$661 \$529 \$530 divider_chain_pfet_w5_l0p5_B sg13_hv_pmos L=0.5U W=5U
+ AS=2P AD=2P PS=10.8U PD=10.8U
* device instance $186 r0 *1 186.22,16.41 pfet
X$186 \$662 \$531 \$532 divider_chain_pfet_w5_l0p5_B sg13_hv_pmos L=0.5U W=5U
+ AS=2P AD=2P PS=10.8U PD=10.8U
* device instance $187 r0 *1 192.98,16.41 pfet
X$187 \$663 \$533 \$534 divider_chain_pfet_w5_l0p5_B sg13_hv_pmos L=0.5U W=5U
+ AS=2P AD=2P PS=10.8U PD=10.8U
* device instance $188 r0 *1 199.74,16.41 pfet
X$188 \$664 \$535 \$536 divider_chain_pfet_w5_l0p5_B sg13_hv_pmos L=0.5U W=5U
+ AS=2P AD=2P PS=10.8U PD=10.8U
* device instance $189 r0 *1 206.5,16.41 pfet
X$189 \$665 \$537 \$538 divider_chain_pfet_w5_l0p5_B sg13_hv_pmos L=0.5U W=5U
+ AS=2P AD=2P PS=10.8U PD=10.8U
* device instance $190 r0 *1 213.26,16.41 pfet
X$190 \$666 \$539 \$540 divider_chain_pfet_w5_l0p5_B sg13_hv_pmos L=0.5U W=5U
+ AS=2P AD=2P PS=10.8U PD=10.8U
* device instance $191 r0 *1 220.02,16.41 pfet
X$191 \$667 \$541 \$542 divider_chain_pfet_w5_l0p5_B sg13_hv_pmos L=0.5U W=5U
+ AS=2P AD=2P PS=10.8U PD=10.8U
* device instance $192 r0 *1 226.78,16.41 pfet
X$192 \$668 \$543 \$544 divider_chain_pfet_w5_l0p5_B sg13_hv_pmos L=0.5U W=5U
+ AS=2P AD=2P PS=10.8U PD=10.8U
* device instance $193 r0 *1 233.54,16.41 pfet
X$193 \$669 \$545 \$546 divider_chain_pfet_w5_l0p5_B sg13_hv_pmos L=0.5U W=5U
+ AS=2P AD=2P PS=10.8U PD=10.8U
* device instance $194 r0 *1 240.3,16.41 pfet
X$194 \$670 \$547 \$548 divider_chain_pfet_w5_l0p5_B sg13_hv_pmos L=0.5U W=5U
+ AS=2P AD=2P PS=10.8U PD=10.8U
* device instance $195 r0 *1 247.06,16.41 pfet
X$195 \$671 \$549 \$550 divider_chain_pfet_w5_l0p5_B sg13_hv_pmos L=0.5U W=5U
+ AS=2P AD=2P PS=10.8U PD=10.8U
* device instance $196 r0 *1 253.82,16.41 pfet
X$196 \$672 \$551 \$552 divider_chain_pfet_w5_l0p5_B sg13_hv_pmos L=0.5U W=5U
+ AS=2P AD=2P PS=10.8U PD=10.8U
* device instance $197 r0 *1 260.58,16.41 pfet
X$197 \$673 \$553 \$554 divider_chain_pfet_w5_l0p5_B sg13_hv_pmos L=0.5U W=5U
+ AS=2P AD=2P PS=10.8U PD=10.8U
* device instance $198 r0 *1 267.34,16.41 pfet
X$198 \$674 \$555 \$556 divider_chain_pfet_w5_l0p5_B sg13_hv_pmos L=0.5U W=5U
+ AS=2P AD=2P PS=10.8U PD=10.8U
* device instance $199 r0 *1 274.1,16.41 pfet
X$199 \$675 \$557 \$558 divider_chain_pfet_w5_l0p5_B sg13_hv_pmos L=0.5U W=5U
+ AS=2P AD=2P PS=10.8U PD=10.8U
* device instance $200 r0 *1 280.86,16.41 pfet
X$200 \$676 \$559 \$560 divider_chain_pfet_w5_l0p5_B sg13_hv_pmos L=0.5U W=5U
+ AS=2P AD=2P PS=10.8U PD=10.8U
* device instance $201 r0 *1 287.62,16.41 pfet
X$201 \$677 \$561 \$562 divider_chain_pfet_w5_l0p5_B sg13_hv_pmos L=0.5U W=5U
+ AS=2P AD=2P PS=10.8U PD=10.8U
* device instance $202 r0 *1 294.38,16.41 pfet
X$202 \$678 \$563 \$564 divider_chain_pfet_w5_l0p5_B sg13_hv_pmos L=0.5U W=5U
+ AS=2P AD=2P PS=10.8U PD=10.8U
* device instance $203 r0 *1 301.14,16.41 pfet
X$203 \$679 \$565 \$566 divider_chain_pfet_w5_l0p5_B sg13_hv_pmos L=0.5U W=5U
+ AS=2P AD=2P PS=10.8U PD=10.8U
* device instance $204 r0 *1 307.9,16.41 pfet
X$204 \$680 \$567 \$568 divider_chain_pfet_w5_l0p5_B sg13_hv_pmos L=0.5U W=5U
+ AS=2P AD=2P PS=10.8U PD=10.8U
* device instance $205 r0 *1 314.66,16.41 pfet
X$205 \$681 \$569 \$570 divider_chain_pfet_w5_l0p5_B sg13_hv_pmos L=0.5U W=5U
+ AS=2P AD=2P PS=10.8U PD=10.8U
* device instance $206 r0 *1 321.42,16.41 pfet
X$206 \$682 \$571 \$572 divider_chain_pfet_w5_l0p5_B sg13_hv_pmos L=0.5U W=5U
+ AS=2P AD=2P PS=10.8U PD=10.8U
* device instance $207 r0 *1 328.18,16.41 pfet
X$207 \$683 \$573 \$574 divider_chain_pfet_w5_l0p5_B sg13_hv_pmos L=0.5U W=5U
+ AS=2P AD=2P PS=10.8U PD=10.8U
* device instance $208 r0 *1 334.94,16.41 pfet
X$208 \$684 \$575 \$576 divider_chain_pfet_w5_l0p5_B sg13_hv_pmos L=0.5U W=5U
+ AS=2P AD=2P PS=10.8U PD=10.8U
* device instance $209 r0 *1 341.7,16.41 pfet
X$209 \$685 \$577 \$578 divider_chain_pfet_w5_l0p5_B sg13_hv_pmos L=0.5U W=5U
+ AS=2P AD=2P PS=10.8U PD=10.8U
* device instance $210 r0 *1 348.46,16.41 pfet
X$210 \$686 \$579 \$580 divider_chain_pfet_w5_l0p5_B sg13_hv_pmos L=0.5U W=5U
+ AS=2P AD=2P PS=10.8U PD=10.8U
* device instance $211 r0 *1 355.22,16.41 pfet
X$211 \$687 \$581 \$582 divider_chain_pfet_w5_l0p5_B sg13_hv_pmos L=0.5U W=5U
+ AS=2P AD=2P PS=10.8U PD=10.8U
* device instance $212 r0 *1 361.98,16.41 pfet
X$212 \$688 \$583 \$584 divider_chain_pfet_w5_l0p5_B sg13_hv_pmos L=0.5U W=5U
+ AS=2P AD=2P PS=10.8U PD=10.8U
* device instance $213 r0 *1 368.74,16.41 pfet
X$213 \$689 \$585 \$586 divider_chain_pfet_w5_l0p5_B sg13_hv_pmos L=0.5U W=5U
+ AS=2P AD=2P PS=10.8U PD=10.8U
* device instance $214 r0 *1 375.5,16.41 pfet
X$214 \$690 \$587 \$588 divider_chain_pfet_w5_l0p5_B sg13_hv_pmos L=0.5U W=5U
+ AS=2P AD=2P PS=10.8U PD=10.8U
* device instance $215 r0 *1 382.26,16.41 pfet
X$215 \$691 \$589 \$590 divider_chain_pfet_w5_l0p5_B sg13_hv_pmos L=0.5U W=5U
+ AS=2P AD=2P PS=10.8U PD=10.8U
* device instance $216 r0 *1 389.02,16.41 pfet
X$216 \$692 \$591 \$592 divider_chain_pfet_w5_l0p5_B sg13_hv_pmos L=0.5U W=5U
+ AS=2P AD=2P PS=10.8U PD=10.8U
* device instance $217 r0 *1 395.78,16.41 pfet
X$217 \$693 \$593 \$594 divider_chain_pfet_w5_l0p5_B sg13_hv_pmos L=0.5U W=5U
+ AS=2P AD=2P PS=10.8U PD=10.8U
* device instance $218 r0 *1 402.54,16.41 pfet
X$218 \$694 \$595 \$596 divider_chain_pfet_w5_l0p5_B sg13_hv_pmos L=0.5U W=5U
+ AS=2P AD=2P PS=10.8U PD=10.8U
* device instance $219 r0 *1 409.3,16.41 pfet
X$219 \$695 \$597 \$598 divider_chain_pfet_w5_l0p5_B sg13_hv_pmos L=0.5U W=5U
+ AS=2P AD=2P PS=10.8U PD=10.8U
* device instance $220 r0 *1 416.06,16.41 pfet
X$220 \$696 \$599 \$600 divider_chain_pfet_w5_l0p5_B sg13_hv_pmos L=0.5U W=5U
+ AS=2P AD=2P PS=10.8U PD=10.8U
* device instance $221 r0 *1 422.82,16.41 pfet
X$221 \$697 \$601 \$602 divider_chain_pfet_w5_l0p5_B sg13_hv_pmos L=0.5U W=5U
+ AS=2P AD=2P PS=10.8U PD=10.8U
* device instance $222 r0 *1 429.58,16.41 pfet
X$222 \$698 \$603 \$604 divider_chain_pfet_w5_l0p5_B sg13_hv_pmos L=0.5U W=5U
+ AS=2P AD=2P PS=10.8U PD=10.8U
* device instance $223 r0 *1 436.34,16.41 pfet
X$223 \$699 \$605 \$606 divider_chain_pfet_w5_l0p5_B sg13_hv_pmos L=0.5U W=5U
+ AS=2P AD=2P PS=10.8U PD=10.8U
* device instance $224 r0 *1 443.1,16.41 pfet
X$224 \$700 \$607 \$608 divider_chain_pfet_w5_l0p5_B sg13_hv_pmos L=0.5U W=5U
+ AS=2P AD=2P PS=10.8U PD=10.8U
* device instance $225 r0 *1 449.86,16.41 pfet
X$225 \$701 \$609 \$610 divider_chain_pfet_w5_l0p5_B sg13_hv_pmos L=0.5U W=5U
+ AS=2P AD=2P PS=10.8U PD=10.8U
* device instance $226 r0 *1 456.62,16.41 pfet
X$226 \$702 \$611 \$612 divider_chain_pfet_w5_l0p5_B sg13_hv_pmos L=0.5U W=5U
+ AS=2P AD=2P PS=10.8U PD=10.8U
* device instance $227 r0 *1 463.38,16.41 pfet
X$227 \$703 \$613 \$614 divider_chain_pfet_w5_l0p5_B sg13_hv_pmos L=0.5U W=5U
+ AS=2P AD=2P PS=10.8U PD=10.8U
* device instance $228 r0 *1 470.14,16.41 pfet
X$228 \$704 \$615 \$616 divider_chain_pfet_w5_l0p5_B sg13_hv_pmos L=0.5U W=5U
+ AS=2P AD=2P PS=10.8U PD=10.8U
* device instance $229 r0 *1 476.9,16.41 pfet
X$229 \$705 \$617 \$618 divider_chain_pfet_w5_l0p5_B sg13_hv_pmos L=0.5U W=5U
+ AS=2P AD=2P PS=10.8U PD=10.8U
* device instance $230 r0 *1 483.66,16.41 pfet
X$230 \$706 \$619 \$620 divider_chain_pfet_w5_l0p5_B sg13_hv_pmos L=0.5U W=5U
+ AS=2P AD=2P PS=10.8U PD=10.8U
* device instance $231 r0 *1 490.42,16.41 pfet
X$231 \$707 \$621 \$622 divider_chain_pfet_w5_l0p5_B sg13_hv_pmos L=0.5U W=5U
+ AS=2P AD=2P PS=10.8U PD=10.8U
* device instance $232 r0 *1 497.18,16.41 pfet
X$232 \$708 \$623 \$624 divider_chain_pfet_w5_l0p5_B sg13_hv_pmos L=0.5U W=5U
+ AS=2P AD=2P PS=10.8U PD=10.8U
* device instance $233 r0 *1 503.94,16.41 pfet
X$233 \$709 \$625 \$626 divider_chain_pfet_w5_l0p5_B sg13_hv_pmos L=0.5U W=5U
+ AS=2P AD=2P PS=10.8U PD=10.8U
* device instance $234 r0 *1 510.7,16.41 pfet
X$234 \$710 \$627 \$628 divider_chain_pfet_w5_l0p5_B sg13_hv_pmos L=0.5U W=5U
+ AS=2P AD=2P PS=10.8U PD=10.8U
* device instance $235 r0 *1 517.46,16.41 pfet
X$235 \$711 \$629 \$630 divider_chain_pfet_w5_l0p5_B sg13_hv_pmos L=0.5U W=5U
+ AS=2P AD=2P PS=10.8U PD=10.8U
* device instance $236 r0 *1 524.22,16.41 pfet
X$236 \$712 \$631 \$632 divider_chain_pfet_w5_l0p5_B sg13_hv_pmos L=0.5U W=5U
+ AS=2P AD=2P PS=10.8U PD=10.8U
* device instance $237 r0 *1 530.98,16.41 pfet
X$237 \$713 \$633 \$634 divider_chain_pfet_w5_l0p5_B sg13_hv_pmos L=0.5U W=5U
+ AS=2P AD=2P PS=10.8U PD=10.8U
* device instance $238 r0 *1 3.7,18.99 pfet
X$238 \$794 \$793 \$714 divider_chain_pfet_w5_l0p5_B sg13_hv_pmos L=0.5U W=5U
+ AS=2P AD=2P PS=10.8U PD=10.8U
* device instance $239 r0 *1 10.46,18.99 pfet
X$239 \$796 \$795 \$715 divider_chain_pfet_w5_l0p5_B sg13_hv_pmos L=0.5U W=5U
+ AS=2P AD=2P PS=10.8U PD=10.8U
* device instance $240 r0 *1 17.22,18.99 pfet
X$240 \$798 \$797 \$716 divider_chain_pfet_w5_l0p5_B sg13_hv_pmos L=0.5U W=5U
+ AS=2P AD=2P PS=10.8U PD=10.8U
* device instance $241 r0 *1 23.98,18.99 pfet
X$241 \$800 \$799 \$717 divider_chain_pfet_w5_l0p5_B sg13_hv_pmos L=0.5U W=5U
+ AS=2P AD=2P PS=10.8U PD=10.8U
* device instance $242 r0 *1 30.74,18.99 pfet
X$242 \$802 \$801 \$718 divider_chain_pfet_w5_l0p5_B sg13_hv_pmos L=0.5U W=5U
+ AS=2P AD=2P PS=10.8U PD=10.8U
* device instance $243 r0 *1 37.5,18.99 pfet
X$243 \$804 \$803 \$719 divider_chain_pfet_w5_l0p5_B sg13_hv_pmos L=0.5U W=5U
+ AS=2P AD=2P PS=10.8U PD=10.8U
* device instance $244 r0 *1 44.26,18.99 pfet
X$244 \$806 \$805 \$720 divider_chain_pfet_w5_l0p5_B sg13_hv_pmos L=0.5U W=5U
+ AS=2P AD=2P PS=10.8U PD=10.8U
* device instance $245 r0 *1 51.02,18.99 pfet
X$245 \$808 \$807 \$721 divider_chain_pfet_w5_l0p5_B sg13_hv_pmos L=0.5U W=5U
+ AS=2P AD=2P PS=10.8U PD=10.8U
* device instance $246 r0 *1 57.78,18.99 pfet
X$246 \$810 \$809 \$722 divider_chain_pfet_w5_l0p5_B sg13_hv_pmos L=0.5U W=5U
+ AS=2P AD=2P PS=10.8U PD=10.8U
* device instance $247 r0 *1 64.54,18.99 pfet
X$247 \$812 \$811 \$723 divider_chain_pfet_w5_l0p5_B sg13_hv_pmos L=0.5U W=5U
+ AS=2P AD=2P PS=10.8U PD=10.8U
* device instance $248 r0 *1 71.3,18.99 pfet
X$248 \$814 \$813 \$724 divider_chain_pfet_w5_l0p5_B sg13_hv_pmos L=0.5U W=5U
+ AS=2P AD=2P PS=10.8U PD=10.8U
* device instance $249 r0 *1 78.06,18.99 pfet
X$249 \$816 \$815 \$725 divider_chain_pfet_w5_l0p5_B sg13_hv_pmos L=0.5U W=5U
+ AS=2P AD=2P PS=10.8U PD=10.8U
* device instance $250 r0 *1 84.82,18.99 pfet
X$250 \$818 \$817 \$726 divider_chain_pfet_w5_l0p5_B sg13_hv_pmos L=0.5U W=5U
+ AS=2P AD=2P PS=10.8U PD=10.8U
* device instance $251 r0 *1 91.58,18.99 pfet
X$251 \$820 \$819 \$727 divider_chain_pfet_w5_l0p5_B sg13_hv_pmos L=0.5U W=5U
+ AS=2P AD=2P PS=10.8U PD=10.8U
* device instance $252 r0 *1 98.34,18.99 pfet
X$252 \$822 \$821 \$728 divider_chain_pfet_w5_l0p5_B sg13_hv_pmos L=0.5U W=5U
+ AS=2P AD=2P PS=10.8U PD=10.8U
* device instance $253 r0 *1 105.1,18.99 pfet
X$253 \$824 \$823 \$729 divider_chain_pfet_w5_l0p5_B sg13_hv_pmos L=0.5U W=5U
+ AS=2P AD=2P PS=10.8U PD=10.8U
* device instance $254 r0 *1 111.86,18.99 pfet
X$254 \$826 \$825 \$730 divider_chain_pfet_w5_l0p5_B sg13_hv_pmos L=0.5U W=5U
+ AS=2P AD=2P PS=10.8U PD=10.8U
* device instance $255 r0 *1 118.62,18.99 pfet
X$255 \$828 \$827 \$731 divider_chain_pfet_w5_l0p5_B sg13_hv_pmos L=0.5U W=5U
+ AS=2P AD=2P PS=10.8U PD=10.8U
* device instance $256 r0 *1 125.38,18.99 pfet
X$256 \$830 \$829 \$732 divider_chain_pfet_w5_l0p5_B sg13_hv_pmos L=0.5U W=5U
+ AS=2P AD=2P PS=10.8U PD=10.8U
* device instance $257 r0 *1 132.14,18.99 pfet
X$257 \$832 \$831 \$733 divider_chain_pfet_w5_l0p5_B sg13_hv_pmos L=0.5U W=5U
+ AS=2P AD=2P PS=10.8U PD=10.8U
* device instance $258 r0 *1 138.9,18.99 pfet
X$258 \$834 \$833 \$734 divider_chain_pfet_w5_l0p5_B sg13_hv_pmos L=0.5U W=5U
+ AS=2P AD=2P PS=10.8U PD=10.8U
* device instance $259 r0 *1 145.66,18.99 pfet
X$259 \$836 \$835 \$735 divider_chain_pfet_w5_l0p5_B sg13_hv_pmos L=0.5U W=5U
+ AS=2P AD=2P PS=10.8U PD=10.8U
* device instance $260 r0 *1 152.42,18.99 pfet
X$260 \$838 \$837 \$736 divider_chain_pfet_w5_l0p5_B sg13_hv_pmos L=0.5U W=5U
+ AS=2P AD=2P PS=10.8U PD=10.8U
* device instance $261 r0 *1 159.18,18.99 pfet
X$261 \$840 \$839 \$737 divider_chain_pfet_w5_l0p5_B sg13_hv_pmos L=0.5U W=5U
+ AS=2P AD=2P PS=10.8U PD=10.8U
* device instance $262 r0 *1 165.94,18.99 pfet
X$262 \$842 \$841 \$738 divider_chain_pfet_w5_l0p5_B sg13_hv_pmos L=0.5U W=5U
+ AS=2P AD=2P PS=10.8U PD=10.8U
* device instance $263 r0 *1 172.7,18.99 pfet
X$263 \$844 \$843 \$739 divider_chain_pfet_w5_l0p5_B sg13_hv_pmos L=0.5U W=5U
+ AS=2P AD=2P PS=10.8U PD=10.8U
* device instance $264 r0 *1 179.46,18.99 pfet
X$264 \$846 \$845 \$740 divider_chain_pfet_w5_l0p5_B sg13_hv_pmos L=0.5U W=5U
+ AS=2P AD=2P PS=10.8U PD=10.8U
* device instance $265 r0 *1 186.22,18.99 pfet
X$265 \$848 \$847 \$741 divider_chain_pfet_w5_l0p5_B sg13_hv_pmos L=0.5U W=5U
+ AS=2P AD=2P PS=10.8U PD=10.8U
* device instance $266 r0 *1 192.98,18.99 pfet
X$266 \$850 \$849 \$742 divider_chain_pfet_w5_l0p5_B sg13_hv_pmos L=0.5U W=5U
+ AS=2P AD=2P PS=10.8U PD=10.8U
* device instance $267 r0 *1 199.74,18.99 pfet
X$267 \$852 \$851 \$743 divider_chain_pfet_w5_l0p5_B sg13_hv_pmos L=0.5U W=5U
+ AS=2P AD=2P PS=10.8U PD=10.8U
* device instance $268 r0 *1 206.5,18.99 pfet
X$268 \$854 \$853 \$744 divider_chain_pfet_w5_l0p5_B sg13_hv_pmos L=0.5U W=5U
+ AS=2P AD=2P PS=10.8U PD=10.8U
* device instance $269 r0 *1 213.26,18.99 pfet
X$269 \$856 \$855 \$745 divider_chain_pfet_w5_l0p5_B sg13_hv_pmos L=0.5U W=5U
+ AS=2P AD=2P PS=10.8U PD=10.8U
* device instance $270 r0 *1 220.02,18.99 pfet
X$270 \$858 \$857 \$746 divider_chain_pfet_w5_l0p5_B sg13_hv_pmos L=0.5U W=5U
+ AS=2P AD=2P PS=10.8U PD=10.8U
* device instance $271 r0 *1 226.78,18.99 pfet
X$271 \$860 \$859 \$747 divider_chain_pfet_w5_l0p5_B sg13_hv_pmos L=0.5U W=5U
+ AS=2P AD=2P PS=10.8U PD=10.8U
* device instance $272 r0 *1 233.54,18.99 pfet
X$272 \$862 \$861 \$748 divider_chain_pfet_w5_l0p5_B sg13_hv_pmos L=0.5U W=5U
+ AS=2P AD=2P PS=10.8U PD=10.8U
* device instance $273 r0 *1 240.3,18.99 pfet
X$273 \$864 \$863 \$749 divider_chain_pfet_w5_l0p5_B sg13_hv_pmos L=0.5U W=5U
+ AS=2P AD=2P PS=10.8U PD=10.8U
* device instance $274 r0 *1 247.06,18.99 pfet
X$274 \$866 \$865 \$750 divider_chain_pfet_w5_l0p5_B sg13_hv_pmos L=0.5U W=5U
+ AS=2P AD=2P PS=10.8U PD=10.8U
* device instance $275 r0 *1 253.82,18.99 pfet
X$275 \$868 \$867 \$751 divider_chain_pfet_w5_l0p5_B sg13_hv_pmos L=0.5U W=5U
+ AS=2P AD=2P PS=10.8U PD=10.8U
* device instance $276 r0 *1 260.58,18.99 pfet
X$276 \$870 \$869 \$752 divider_chain_pfet_w5_l0p5_B sg13_hv_pmos L=0.5U W=5U
+ AS=2P AD=2P PS=10.8U PD=10.8U
* device instance $277 r0 *1 267.34,18.99 pfet
X$277 \$872 \$871 \$753 divider_chain_pfet_w5_l0p5_B sg13_hv_pmos L=0.5U W=5U
+ AS=2P AD=2P PS=10.8U PD=10.8U
* device instance $278 r0 *1 274.1,18.99 pfet
X$278 \$874 \$873 \$754 divider_chain_pfet_w5_l0p5_B sg13_hv_pmos L=0.5U W=5U
+ AS=2P AD=2P PS=10.8U PD=10.8U
* device instance $279 r0 *1 280.86,18.99 pfet
X$279 \$876 \$875 \$755 divider_chain_pfet_w5_l0p5_B sg13_hv_pmos L=0.5U W=5U
+ AS=2P AD=2P PS=10.8U PD=10.8U
* device instance $280 r0 *1 287.62,18.99 pfet
X$280 \$878 \$877 \$756 divider_chain_pfet_w5_l0p5_B sg13_hv_pmos L=0.5U W=5U
+ AS=2P AD=2P PS=10.8U PD=10.8U
* device instance $281 r0 *1 294.38,18.99 pfet
X$281 \$880 \$879 \$757 divider_chain_pfet_w5_l0p5_B sg13_hv_pmos L=0.5U W=5U
+ AS=2P AD=2P PS=10.8U PD=10.8U
* device instance $282 r0 *1 301.14,18.99 pfet
X$282 \$882 \$881 \$758 divider_chain_pfet_w5_l0p5_B sg13_hv_pmos L=0.5U W=5U
+ AS=2P AD=2P PS=10.8U PD=10.8U
* device instance $283 r0 *1 307.9,18.99 pfet
X$283 \$884 \$883 \$759 divider_chain_pfet_w5_l0p5_B sg13_hv_pmos L=0.5U W=5U
+ AS=2P AD=2P PS=10.8U PD=10.8U
* device instance $284 r0 *1 314.66,18.99 pfet
X$284 \$886 \$885 \$760 divider_chain_pfet_w5_l0p5_B sg13_hv_pmos L=0.5U W=5U
+ AS=2P AD=2P PS=10.8U PD=10.8U
* device instance $285 r0 *1 321.42,18.99 pfet
X$285 \$888 \$887 \$761 divider_chain_pfet_w5_l0p5_B sg13_hv_pmos L=0.5U W=5U
+ AS=2P AD=2P PS=10.8U PD=10.8U
* device instance $286 r0 *1 328.18,18.99 pfet
X$286 \$890 \$889 \$762 divider_chain_pfet_w5_l0p5_B sg13_hv_pmos L=0.5U W=5U
+ AS=2P AD=2P PS=10.8U PD=10.8U
* device instance $287 r0 *1 334.94,18.99 pfet
X$287 \$892 \$891 \$763 divider_chain_pfet_w5_l0p5_B sg13_hv_pmos L=0.5U W=5U
+ AS=2P AD=2P PS=10.8U PD=10.8U
* device instance $288 r0 *1 341.7,18.99 pfet
X$288 \$894 \$893 \$764 divider_chain_pfet_w5_l0p5_B sg13_hv_pmos L=0.5U W=5U
+ AS=2P AD=2P PS=10.8U PD=10.8U
* device instance $289 r0 *1 348.46,18.99 pfet
X$289 \$896 \$895 \$765 divider_chain_pfet_w5_l0p5_B sg13_hv_pmos L=0.5U W=5U
+ AS=2P AD=2P PS=10.8U PD=10.8U
* device instance $290 r0 *1 355.22,18.99 pfet
X$290 \$898 \$897 \$766 divider_chain_pfet_w5_l0p5_B sg13_hv_pmos L=0.5U W=5U
+ AS=2P AD=2P PS=10.8U PD=10.8U
* device instance $291 r0 *1 361.98,18.99 pfet
X$291 \$900 \$899 \$767 divider_chain_pfet_w5_l0p5_B sg13_hv_pmos L=0.5U W=5U
+ AS=2P AD=2P PS=10.8U PD=10.8U
* device instance $292 r0 *1 368.74,18.99 pfet
X$292 \$902 \$901 \$768 divider_chain_pfet_w5_l0p5_B sg13_hv_pmos L=0.5U W=5U
+ AS=2P AD=2P PS=10.8U PD=10.8U
* device instance $293 r0 *1 375.5,18.99 pfet
X$293 \$904 \$903 \$769 divider_chain_pfet_w5_l0p5_B sg13_hv_pmos L=0.5U W=5U
+ AS=2P AD=2P PS=10.8U PD=10.8U
* device instance $294 r0 *1 382.26,18.99 pfet
X$294 \$906 \$905 \$770 divider_chain_pfet_w5_l0p5_B sg13_hv_pmos L=0.5U W=5U
+ AS=2P AD=2P PS=10.8U PD=10.8U
* device instance $295 r0 *1 389.02,18.99 pfet
X$295 \$908 \$907 \$771 divider_chain_pfet_w5_l0p5_B sg13_hv_pmos L=0.5U W=5U
+ AS=2P AD=2P PS=10.8U PD=10.8U
* device instance $296 r0 *1 395.78,18.99 pfet
X$296 \$910 \$909 \$772 divider_chain_pfet_w5_l0p5_B sg13_hv_pmos L=0.5U W=5U
+ AS=2P AD=2P PS=10.8U PD=10.8U
* device instance $297 r0 *1 402.54,18.99 pfet
X$297 \$912 \$911 \$773 divider_chain_pfet_w5_l0p5_B sg13_hv_pmos L=0.5U W=5U
+ AS=2P AD=2P PS=10.8U PD=10.8U
* device instance $298 r0 *1 409.3,18.99 pfet
X$298 \$914 \$913 \$774 divider_chain_pfet_w5_l0p5_B sg13_hv_pmos L=0.5U W=5U
+ AS=2P AD=2P PS=10.8U PD=10.8U
* device instance $299 r0 *1 416.06,18.99 pfet
X$299 \$916 \$915 \$775 divider_chain_pfet_w5_l0p5_B sg13_hv_pmos L=0.5U W=5U
+ AS=2P AD=2P PS=10.8U PD=10.8U
* device instance $300 r0 *1 422.82,18.99 pfet
X$300 \$918 \$917 \$776 divider_chain_pfet_w5_l0p5_B sg13_hv_pmos L=0.5U W=5U
+ AS=2P AD=2P PS=10.8U PD=10.8U
* device instance $301 r0 *1 429.58,18.99 pfet
X$301 \$920 \$919 \$777 divider_chain_pfet_w5_l0p5_B sg13_hv_pmos L=0.5U W=5U
+ AS=2P AD=2P PS=10.8U PD=10.8U
* device instance $302 r0 *1 436.34,18.99 pfet
X$302 \$922 \$921 \$778 divider_chain_pfet_w5_l0p5_B sg13_hv_pmos L=0.5U W=5U
+ AS=2P AD=2P PS=10.8U PD=10.8U
* device instance $303 r0 *1 443.1,18.99 pfet
X$303 \$924 \$923 \$779 divider_chain_pfet_w5_l0p5_B sg13_hv_pmos L=0.5U W=5U
+ AS=2P AD=2P PS=10.8U PD=10.8U
* device instance $304 r0 *1 449.86,18.99 pfet
X$304 \$926 \$925 \$780 divider_chain_pfet_w5_l0p5_B sg13_hv_pmos L=0.5U W=5U
+ AS=2P AD=2P PS=10.8U PD=10.8U
* device instance $305 r0 *1 456.62,18.99 pfet
X$305 \$928 \$927 \$781 divider_chain_pfet_w5_l0p5_B sg13_hv_pmos L=0.5U W=5U
+ AS=2P AD=2P PS=10.8U PD=10.8U
* device instance $306 r0 *1 463.38,18.99 pfet
X$306 \$930 \$929 \$782 divider_chain_pfet_w5_l0p5_B sg13_hv_pmos L=0.5U W=5U
+ AS=2P AD=2P PS=10.8U PD=10.8U
* device instance $307 r0 *1 470.14,18.99 pfet
X$307 \$932 \$931 \$783 divider_chain_pfet_w5_l0p5_B sg13_hv_pmos L=0.5U W=5U
+ AS=2P AD=2P PS=10.8U PD=10.8U
* device instance $308 r0 *1 476.9,18.99 pfet
X$308 \$934 \$933 \$784 divider_chain_pfet_w5_l0p5_B sg13_hv_pmos L=0.5U W=5U
+ AS=2P AD=2P PS=10.8U PD=10.8U
* device instance $309 r0 *1 483.66,18.99 pfet
X$309 \$936 \$935 \$785 divider_chain_pfet_w5_l0p5_B sg13_hv_pmos L=0.5U W=5U
+ AS=2P AD=2P PS=10.8U PD=10.8U
* device instance $310 r0 *1 490.42,18.99 pfet
X$310 \$938 \$937 \$786 divider_chain_pfet_w5_l0p5_B sg13_hv_pmos L=0.5U W=5U
+ AS=2P AD=2P PS=10.8U PD=10.8U
* device instance $311 r0 *1 497.18,18.99 pfet
X$311 \$940 \$939 \$787 divider_chain_pfet_w5_l0p5_B sg13_hv_pmos L=0.5U W=5U
+ AS=2P AD=2P PS=10.8U PD=10.8U
* device instance $312 r0 *1 503.94,18.99 pfet
X$312 \$942 \$941 \$788 divider_chain_pfet_w5_l0p5_B sg13_hv_pmos L=0.5U W=5U
+ AS=2P AD=2P PS=10.8U PD=10.8U
* device instance $313 r0 *1 510.7,18.99 pfet
X$313 \$944 \$943 \$789 divider_chain_pfet_w5_l0p5_B sg13_hv_pmos L=0.5U W=5U
+ AS=2P AD=2P PS=10.8U PD=10.8U
* device instance $314 r0 *1 517.46,18.99 pfet
X$314 \$946 \$945 \$790 divider_chain_pfet_w5_l0p5_B sg13_hv_pmos L=0.5U W=5U
+ AS=2P AD=2P PS=10.8U PD=10.8U
* device instance $315 r0 *1 524.22,18.99 pfet
X$315 \$948 \$947 \$791 divider_chain_pfet_w5_l0p5_B sg13_hv_pmos L=0.5U W=5U
+ AS=2P AD=2P PS=10.8U PD=10.8U
* device instance $316 r0 *1 530.98,18.99 pfet
X$316 \$950 \$949 \$792 divider_chain_pfet_w5_l0p5_B sg13_hv_pmos L=0.5U W=5U
+ AS=2P AD=2P PS=10.8U PD=10.8U
.ENDS pll_divider_chain
