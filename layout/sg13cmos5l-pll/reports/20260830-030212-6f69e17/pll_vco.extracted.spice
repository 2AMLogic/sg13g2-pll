* extracted by klt extract --deck sg13cmos5l

* cell pll_vco
* pin vco_pfet_w10_l0p5_B
* pin vco_pfet_w10_l1_B
* pin vco_pfet_w3_l1_B
* pin vco_pfet_w5_l0p28_B
* pin vco_pfet_w6_l1_B
* pin vsubs
.SUBCKT pll_vco vco_pfet_w10_l0p5_B vco_pfet_w10_l1_B vco_pfet_w3_l1_B
+ vco_pfet_w5_l0p28_B vco_pfet_w6_l1_B vsubs
* device instance $1 r0 *1 1.89,3 nfet
X$1 \$93 \$13 \$14 vsubs sg13_hv_nmos L=0.28U W=2U AS=0.8P AD=0.8P PS=4.8U
+ PD=4.8U
* device instance $2 r0 *1 5.03,3 nfet
X$2 \$94 \$15 \$16 vsubs sg13_hv_nmos L=0.28U W=2U AS=0.8P AD=0.8P PS=4.8U
+ PD=4.8U
* device instance $3 r0 *1 8.17,3 nfet
X$3 \$95 \$17 \$18 vsubs sg13_hv_nmos L=0.28U W=2U AS=0.8P AD=0.8P PS=4.8U
+ PD=4.8U
* device instance $4 r0 *1 11.31,3 nfet
X$4 \$96 \$19 \$20 vsubs sg13_hv_nmos L=0.28U W=2U AS=0.8P AD=0.8P PS=4.8U
+ PD=4.8U
* device instance $5 r0 *1 14.45,3 nfet
X$5 \$97 \$21 \$22 vsubs sg13_hv_nmos L=0.28U W=2U AS=0.8P AD=0.8P PS=4.8U
+ PD=4.8U
* device instance $6 r0 *1 24.23,3.36 nfet
X$6 \$119 \$23 \$24 vsubs sg13_hv_nmos L=1U W=2U AS=0.8P AD=0.8P PS=4.8U PD=4.8U
* device instance $7 r0 *1 27.37,3.36 nfet
X$7 \$120 \$25 \$26 vsubs sg13_hv_nmos L=1U W=2U AS=0.8P AD=0.8P PS=4.8U PD=4.8U
* device instance $8 r0 *1 30.51,3.36 nfet
X$8 \$121 \$27 \$28 vsubs sg13_hv_nmos L=1U W=2U AS=0.8P AD=0.8P PS=4.8U PD=4.8U
* device instance $9 r0 *1 41.29,3.01 nfet
X$9 \$103 \$29 \$30 vsubs sg13_hv_nmos L=0.3U W=4U AS=1.6P AD=1.6P PS=8.8U
+ PD=8.8U
* device instance $10 r0 *1 46.43,3.01 nfet
X$10 \$104 \$31 \$32 vsubs sg13_hv_nmos L=0.3U W=4U AS=1.6P AD=1.6P PS=8.8U
+ PD=8.8U
* device instance $11 r0 *1 58.21,3.11 nfet
X$11 \$105 \$33 \$34 vsubs sg13_hv_nmos L=0.5U W=4U AS=1.6P AD=1.6P PS=8.8U
+ PD=8.8U
* device instance $12 r0 *1 63.35,3.11 nfet
X$12 \$106 \$35 \$36 vsubs sg13_hv_nmos L=0.5U W=4U AS=1.6P AD=1.6P PS=8.8U
+ PD=8.8U
* device instance $13 r0 *1 68.49,3.11 nfet
X$13 \$107 \$37 \$38 vsubs sg13_hv_nmos L=0.5U W=4U AS=1.6P AD=1.6P PS=8.8U
+ PD=8.8U
* device instance $14 r0 *1 73.63,3.11 nfet
X$14 \$108 \$39 \$40 vsubs sg13_hv_nmos L=0.5U W=4U AS=1.6P AD=1.6P PS=8.8U
+ PD=8.8U
* device instance $15 r0 *1 78.77,3.11 nfet
X$15 \$109 \$41 \$42 vsubs sg13_hv_nmos L=0.5U W=4U AS=1.6P AD=1.6P PS=8.8U
+ PD=8.8U
* device instance $16 r0 *1 83.91,3.11 nfet
X$16 \$110 \$43 \$44 vsubs sg13_hv_nmos L=0.5U W=4U AS=1.6P AD=1.6P PS=8.8U
+ PD=8.8U
* device instance $17 r0 *1 89.05,3.11 nfet
X$17 \$111 \$45 \$46 vsubs sg13_hv_nmos L=0.5U W=4U AS=1.6P AD=1.6P PS=8.8U
+ PD=8.8U
* device instance $18 r0 *1 100.83,3.36 nfet
X$18 \$122 \$47 \$48 vsubs sg13_hv_nmos L=1U W=4U AS=1.6P AD=1.6P PS=8.8U
+ PD=8.8U
* device instance $19 r0 *1 105.97,3.36 nfet
X$19 \$123 \$49 \$50 vsubs sg13_hv_nmos L=1U W=4U AS=1.6P AD=1.6P PS=8.8U
+ PD=8.8U
* device instance $20 r0 *1 111.11,3.36 nfet
X$20 \$124 \$51 \$52 vsubs sg13_hv_nmos L=1U W=4U AS=1.6P AD=1.6P PS=8.8U
+ PD=8.8U
* device instance $21 r0 *1 124.89,3.36 nfet
X$21 \$125 \$53 \$54 vsubs sg13_hv_nmos L=1U W=8U AS=3.2P AD=3.2P PS=16.8U
+ PD=16.8U
* device instance $22 r0 *1 138.48,3.36 pfet
X$22 \$126 \$55 \$56 vco_pfet_w3_l1_B sg13_hv_pmos L=1U W=3U AS=1.2P AD=1.2P
+ PS=6.8U PD=6.8U
* device instance $23 r0 *1 150.88,3 pfet
X$23 \$98 \$57 \$58 vco_pfet_w5_l0p28_B sg13_hv_pmos L=0.28U W=5U AS=2P AD=2P
+ PS=10.8U PD=10.8U
* device instance $24 r0 *1 157.64,3 pfet
X$24 \$99 \$59 \$60 vco_pfet_w5_l0p28_B sg13_hv_pmos L=0.28U W=5U AS=2P AD=2P
+ PS=10.8U PD=10.8U
* device instance $25 r0 *1 164.4,3 pfet
X$25 \$100 \$61 \$62 vco_pfet_w5_l0p28_B sg13_hv_pmos L=0.28U W=5U AS=2P AD=2P
+ PS=10.8U PD=10.8U
* device instance $26 r0 *1 171.16,3 pfet
X$26 \$101 \$63 \$64 vco_pfet_w5_l0p28_B sg13_hv_pmos L=0.28U W=5U AS=2P AD=2P
+ PS=10.8U PD=10.8U
* device instance $27 r0 *1 177.92,3 pfet
X$27 \$102 \$65 \$66 vco_pfet_w5_l0p28_B sg13_hv_pmos L=0.28U W=5U AS=2P AD=2P
+ PS=10.8U PD=10.8U
* device instance $28 r0 *1 191.82,3.36 pfet
X$28 \$127 \$67 \$68 vco_pfet_w6_l1_B sg13_hv_pmos L=1U W=6U AS=2.4P AD=2.4P
+ PS=12.8U PD=12.8U
* device instance $29 r0 *1 199.58,3.36 pfet
X$29 \$128 \$69 \$70 vco_pfet_w6_l1_B sg13_hv_pmos L=1U W=6U AS=2.4P AD=2.4P
+ PS=12.8U PD=12.8U
* device instance $30 r0 *1 215.98,3.11 pfet
X$30 \$112 \$71 \$72 vco_pfet_w10_l0p5_B sg13_hv_pmos L=0.5U W=10U AS=4P AD=4P
+ PS=20.8U PD=20.8U
* device instance $31 r0 *1 227.74,3.11 pfet
X$31 \$113 \$73 \$74 vco_pfet_w10_l0p5_B sg13_hv_pmos L=0.5U W=10U AS=4P AD=4P
+ PS=20.8U PD=20.8U
* device instance $32 r0 *1 239.5,3.11 pfet
X$32 \$114 \$75 \$76 vco_pfet_w10_l0p5_B sg13_hv_pmos L=0.5U W=10U AS=4P AD=4P
+ PS=20.8U PD=20.8U
* device instance $33 r0 *1 251.26,3.11 pfet
X$33 \$115 \$77 \$78 vco_pfet_w10_l0p5_B sg13_hv_pmos L=0.5U W=10U AS=4P AD=4P
+ PS=20.8U PD=20.8U
* device instance $34 r0 *1 263.02,3.11 pfet
X$34 \$116 \$79 \$80 vco_pfet_w10_l0p5_B sg13_hv_pmos L=0.5U W=10U AS=4P AD=4P
+ PS=20.8U PD=20.8U
* device instance $35 r0 *1 274.78,3.11 pfet
X$35 \$117 \$81 \$82 vco_pfet_w10_l0p5_B sg13_hv_pmos L=0.5U W=10U AS=4P AD=4P
+ PS=20.8U PD=20.8U
* device instance $36 r0 *1 286.54,3.11 pfet
X$36 \$118 \$83 \$84 vco_pfet_w10_l0p5_B sg13_hv_pmos L=0.5U W=10U AS=4P AD=4P
+ PS=20.8U PD=20.8U
* device instance $37 r0 *1 304.94,3.36 pfet
X$37 \$129 \$85 \$86 vco_pfet_w10_l1_B sg13_hv_pmos L=1U W=10U AS=4P AD=4P
+ PS=20.8U PD=20.8U
* device instance $38 r0 *1 316.7,3.36 pfet
X$38 \$130 \$87 \$88 vco_pfet_w10_l1_B sg13_hv_pmos L=1U W=10U AS=4P AD=4P
+ PS=20.8U PD=20.8U
* device instance $39 r0 *1 359.4,0.7 rppd
R$39 \$3 \$4 vsubs 7800 rppd
* device instance $40 r0 *1 411.4,0.7 rppd
R$40 \$5 \$6 vsubs 15600 rppd
* device instance $41 r0 *1 359.4,2.7 rppd
R$41 \$89 \$90 vsubs 7800 rppd
* device instance $42 r0 *1 411.4,2.7 rppd
R$42 \$91 \$92 vsubs 15600 rppd
* device instance $43 r0 *1 411.4,4.7 rppd
R$43 \$131 \$132 vsubs 15600 rppd
* device instance $44 r0 *1 333.4,0.45 rhigh
R$44 \$1 \$2 vsubs 21760 rhigh
.ENDS pll_vco
