* extracted by klt extract --deck sg13cmos5l

* cell cp_nfet_w2_l0p5
* pin vsubs
.SUBCKT cp_nfet_w2_l0p5 vsubs
* device instance $1 r0 *1 1.89,3.11 nfet
X$1 \$3 \$1 \$4 vsubs sg13_hv_nmos L=0.5U W=2U AS=0.8P AD=0.8P PS=4.8U PD=4.8U
* device instance $2 r0 *1 5.03,3.11 nfet
X$2 \$5 \$2 \$6 vsubs sg13_hv_nmos L=0.5U W=2U AS=0.8P AD=0.8P PS=4.8U PD=4.8U
.ENDS cp_nfet_w2_l0p5
