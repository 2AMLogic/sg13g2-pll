* extracted by klt extract --deck sg13cmos5l

* cell lock_detector_nfet_w2_l0p5
* pin vsubs
.SUBCKT lock_detector_nfet_w2_l0p5 vsubs
* device instance $1 r0 *1 1.89,3.11 nfet
X$1 \$40 \$2 \$3 vsubs sg13_hv_nmos L=0.5U W=2U AS=0.8P AD=0.8P PS=4.8U PD=4.8U
* device instance $2 r0 *1 5.03,3.11 nfet
X$2 \$41 \$4 \$5 vsubs sg13_hv_nmos L=0.5U W=2U AS=0.8P AD=0.8P PS=4.8U PD=4.8U
* device instance $3 r0 *1 8.17,3.11 nfet
X$3 \$42 \$6 \$7 vsubs sg13_hv_nmos L=0.5U W=2U AS=0.8P AD=0.8P PS=4.8U PD=4.8U
* device instance $4 r0 *1 11.31,3.11 nfet
X$4 \$43 \$8 \$9 vsubs sg13_hv_nmos L=0.5U W=2U AS=0.8P AD=0.8P PS=4.8U PD=4.8U
* device instance $5 r0 *1 14.45,3.11 nfet
X$5 \$44 \$10 \$11 vsubs sg13_hv_nmos L=0.5U W=2U AS=0.8P AD=0.8P PS=4.8U
+ PD=4.8U
* device instance $6 r0 *1 17.59,3.11 nfet
X$6 \$45 \$12 \$13 vsubs sg13_hv_nmos L=0.5U W=2U AS=0.8P AD=0.8P PS=4.8U
+ PD=4.8U
* device instance $7 r0 *1 20.73,3.11 nfet
X$7 \$46 \$14 \$15 vsubs sg13_hv_nmos L=0.5U W=2U AS=0.8P AD=0.8P PS=4.8U
+ PD=4.8U
* device instance $8 r0 *1 23.87,3.11 nfet
X$8 \$47 \$16 \$17 vsubs sg13_hv_nmos L=0.5U W=2U AS=0.8P AD=0.8P PS=4.8U
+ PD=4.8U
* device instance $9 r0 *1 27.01,3.11 nfet
X$9 \$48 \$18 \$19 vsubs sg13_hv_nmos L=0.5U W=2U AS=0.8P AD=0.8P PS=4.8U
+ PD=4.8U
* device instance $10 r0 *1 30.15,3.11 nfet
X$10 \$49 \$20 \$21 vsubs sg13_hv_nmos L=0.5U W=2U AS=0.8P AD=0.8P PS=4.8U
+ PD=4.8U
* device instance $11 r0 *1 33.29,3.11 nfet
X$11 \$50 \$22 \$23 vsubs sg13_hv_nmos L=0.5U W=2U AS=0.8P AD=0.8P PS=4.8U
+ PD=4.8U
* device instance $12 r0 *1 36.43,3.11 nfet
X$12 \$51 \$24 \$25 vsubs sg13_hv_nmos L=0.5U W=2U AS=0.8P AD=0.8P PS=4.8U
+ PD=4.8U
* device instance $13 r0 *1 39.57,3.11 nfet
X$13 \$52 \$26 \$27 vsubs sg13_hv_nmos L=0.5U W=2U AS=0.8P AD=0.8P PS=4.8U
+ PD=4.8U
* device instance $14 r0 *1 42.71,3.11 nfet
X$14 \$53 \$28 \$29 vsubs sg13_hv_nmos L=0.5U W=2U AS=0.8P AD=0.8P PS=4.8U
+ PD=4.8U
* device instance $15 r0 *1 45.85,3.11 nfet
X$15 \$54 \$30 \$31 vsubs sg13_hv_nmos L=0.5U W=2U AS=0.8P AD=0.8P PS=4.8U
+ PD=4.8U
* device instance $16 r0 *1 48.99,3.11 nfet
X$16 \$55 \$32 \$33 vsubs sg13_hv_nmos L=0.5U W=2U AS=0.8P AD=0.8P PS=4.8U
+ PD=4.8U
* device instance $17 r0 *1 52.13,3.11 nfet
X$17 \$56 \$34 \$35 vsubs sg13_hv_nmos L=0.5U W=2U AS=0.8P AD=0.8P PS=4.8U
+ PD=4.8U
* device instance $18 r0 *1 55.27,3.11 nfet
X$18 \$57 \$36 \$37 vsubs sg13_hv_nmos L=0.5U W=2U AS=0.8P AD=0.8P PS=4.8U
+ PD=4.8U
* device instance $19 r0 *1 58.41,3.11 nfet
X$19 \$58 \$38 \$39 vsubs sg13_hv_nmos L=0.5U W=2U AS=0.8P AD=0.8P PS=4.8U
+ PD=4.8U
.ENDS lock_detector_nfet_w2_l0p5
