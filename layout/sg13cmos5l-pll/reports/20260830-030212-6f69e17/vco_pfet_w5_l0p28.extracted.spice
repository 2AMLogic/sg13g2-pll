* extracted by klt extract --deck sg13cmos5l

* cell vco_pfet_w5_l0p28
* pin vco_pfet_w5_l0p28_B
.SUBCKT vco_pfet_w5_l0p28 vco_pfet_w5_l0p28_B
* device instance $1 r0 *1 3.7,3 pfet
X$1 \$12 \$2 \$3 vco_pfet_w5_l0p28_B sg13_hv_pmos L=0.28U W=5U AS=2P AD=2P
+ PS=10.8U PD=10.8U
* device instance $2 r0 *1 10.46,3 pfet
X$2 \$13 \$4 \$5 vco_pfet_w5_l0p28_B sg13_hv_pmos L=0.28U W=5U AS=2P AD=2P
+ PS=10.8U PD=10.8U
* device instance $3 r0 *1 17.22,3 pfet
X$3 \$14 \$6 \$7 vco_pfet_w5_l0p28_B sg13_hv_pmos L=0.28U W=5U AS=2P AD=2P
+ PS=10.8U PD=10.8U
* device instance $4 r0 *1 23.98,3 pfet
X$4 \$15 \$8 \$9 vco_pfet_w5_l0p28_B sg13_hv_pmos L=0.28U W=5U AS=2P AD=2P
+ PS=10.8U PD=10.8U
* device instance $5 r0 *1 30.74,3 pfet
X$5 \$16 \$10 \$11 vco_pfet_w5_l0p28_B sg13_hv_pmos L=0.28U W=5U AS=2P AD=2P
+ PS=10.8U PD=10.8U
.ENDS vco_pfet_w5_l0p28
