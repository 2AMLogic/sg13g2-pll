* extracted by klt extract --deck sg13cmos5l

* cell pll_lock_detector
* pin DN
* pin ERR
* pin ERRD
* pin LOCK
* pin UP
* pin VDD
* pin VSS
* pin VWIN
* pin WIDE
* pin XDW.d1
* pin XDW.d2
* pin XDW.d3
* pin XNW.mid1
* pin XSCH.nn
* pin XSCH.np
* pin XXOR.XN1.mid1
* pin XXOR.XN2.mid1
* pin XXOR.XN3.mid1
* pin XXOR.XN4.mid1
* pin XXOR.n1
* pin XXOR.n2
* pin XXOR.n3
* pin nwide
.SUBCKT pll_lock_detector DN ERR ERRD LOCK UP VDD VSS VWIN WIDE XDW.d1 XDW.d2
+ XDW.d3 XNW.mid1 XSCH.nn XSCH.np XXOR.XN1.mid1 XXOR.XN2.mid1 XXOR.XN3.mid1
+ XXOR.XN4.mid1 XXOR.n1 XXOR.n2 XXOR.n3 nwide
* device instance $1 r0 *1 1.425,10.86 nfet
X$1 \$28 WIDE \$13 VSS sg13_hv_nmos L=16U W=0.25U AS=0.1P AD=0.1P PS=1.3U
+ PD=1.3U
* device instance $2 r0 *1 11.15,3.11 nfet
X$2 XXOR.n1 UP XXOR.XN1.mid1 VSS sg13_hv_nmos L=0.5U W=2U AS=0.8P AD=0.8P
+ PS=4.8U PD=4.8U
* device instance $3 r0 *1 15.11,3.11 nfet
X$3 XXOR.XN1.mid1 DN VSS VSS sg13_hv_nmos L=0.5U W=2U AS=0.8P AD=0.8P PS=4.8U
+ PD=4.8U
* device instance $4 r0 *1 19.07,3.11 nfet
X$4 XXOR.n2 UP XXOR.XN2.mid1 VSS sg13_hv_nmos L=0.5U W=2U AS=0.8P AD=0.8P
+ PS=4.8U PD=4.8U
* device instance $5 r0 *1 23.03,3.11 nfet
X$5 XXOR.XN2.mid1 XXOR.n1 VSS VSS sg13_hv_nmos L=0.5U W=2U AS=0.8P AD=0.8P
+ PS=4.8U PD=4.8U
* device instance $6 r0 *1 26.99,3.11 nfet
X$6 XXOR.n3 DN XXOR.XN3.mid1 VSS sg13_hv_nmos L=0.5U W=2U AS=0.8P AD=0.8P
+ PS=4.8U PD=4.8U
* device instance $7 r0 *1 30.95,3.11 nfet
X$7 XXOR.XN3.mid1 XXOR.n1 VSS VSS sg13_hv_nmos L=0.5U W=2U AS=0.8P AD=0.8P
+ PS=4.8U PD=4.8U
* device instance $8 r0 *1 34.91,3.11 nfet
X$8 ERR XXOR.n2 XXOR.XN4.mid1 VSS sg13_hv_nmos L=0.5U W=2U AS=0.8P AD=0.8P
+ PS=4.8U PD=4.8U
* device instance $9 r0 *1 38.87,3.11 nfet
X$9 XXOR.XN4.mid1 XXOR.n3 VSS VSS sg13_hv_nmos L=0.5U W=2U AS=0.8P AD=0.8P
+ PS=4.8U PD=4.8U
* device instance $10 r0 *1 42.83,3.11 nfet
X$10 XDW.d1 ERR VSS VSS sg13_hv_nmos L=0.5U W=2U AS=0.8P AD=0.8P PS=4.8U PD=4.8U
* device instance $11 r0 *1 46.79,3.11 nfet
X$11 XDW.d2 XDW.d1 VSS VSS sg13_hv_nmos L=0.5U W=2U AS=0.8P AD=0.8P PS=4.8U
+ PD=4.8U
* device instance $12 r0 *1 50.75,3.11 nfet
X$12 XDW.d3 XDW.d2 VSS VSS sg13_hv_nmos L=0.5U W=2U AS=0.8P AD=0.8P PS=4.8U
+ PD=4.8U
* device instance $13 r0 *1 54.71,3.11 nfet
X$13 ERRD XDW.d3 VSS VSS sg13_hv_nmos L=0.5U W=2U AS=0.8P AD=0.8P PS=4.8U
+ PD=4.8U
* device instance $14 r0 *1 58.67,3.11 nfet
X$14 nwide ERR XNW.mid1 VSS sg13_hv_nmos L=0.5U W=2U AS=0.8P AD=0.8P PS=4.8U
+ PD=4.8U
* device instance $15 r0 *1 62.63,3.11 nfet
X$15 XNW.mid1 ERRD VSS VSS sg13_hv_nmos L=0.5U W=2U AS=0.8P AD=0.8P PS=4.8U
+ PD=4.8U
* device instance $16 r0 *1 66.59,3.11 nfet
X$16 WIDE nwide VSS VSS sg13_hv_nmos L=0.5U W=2U AS=0.8P AD=0.8P PS=4.8U PD=4.8U
* device instance $17 r0 *1 77.19,3.86 nfet
X$17 LOCK VWIN XSCH.nn VSS sg13_hv_nmos L=2U W=2U AS=0.8P AD=0.8P PS=4.8U
+ PD=4.8U
* device instance $18 r0 *1 81.15,3.86 nfet
X$18 XSCH.nn VWIN VSS VSS sg13_hv_nmos L=2U W=2U AS=0.8P AD=0.8P PS=4.8U PD=4.8U
* device instance $19 r0 *1 85.11,3.86 nfet
X$19 VDD LOCK XSCH.nn VSS sg13_hv_nmos L=2U W=2U AS=0.8P AD=0.8P PS=4.8U PD=4.8U
* device instance $20 r0 *1 97.21,3.11 pfet
X$20 XXOR.n1 UP VDD VDD sg13_hv_pmos L=0.5U W=5U AS=2P AD=2P PS=10.8U PD=10.8U
* device instance $21 r0 *1 104.17,3.11 pfet
X$21 XXOR.n1 DN VDD VDD sg13_hv_pmos L=0.5U W=5U AS=2P AD=2P PS=10.8U PD=10.8U
* device instance $22 r0 *1 111.13,3.11 pfet
X$22 XXOR.n2 UP VDD VDD sg13_hv_pmos L=0.5U W=5U AS=2P AD=2P PS=10.8U PD=10.8U
* device instance $23 r0 *1 118.09,3.11 pfet
X$23 XXOR.n2 XXOR.n1 VDD VDD sg13_hv_pmos L=0.5U W=5U AS=2P AD=2P PS=10.8U
+ PD=10.8U
* device instance $24 r0 *1 125.05,3.11 pfet
X$24 XXOR.n3 DN VDD VDD sg13_hv_pmos L=0.5U W=5U AS=2P AD=2P PS=10.8U PD=10.8U
* device instance $25 r0 *1 132.01,3.11 pfet
X$25 XXOR.n3 XXOR.n1 VDD VDD sg13_hv_pmos L=0.5U W=5U AS=2P AD=2P PS=10.8U
+ PD=10.8U
* device instance $26 r0 *1 138.97,3.11 pfet
X$26 ERR XXOR.n2 VDD VDD sg13_hv_pmos L=0.5U W=5U AS=2P AD=2P PS=10.8U PD=10.8U
* device instance $27 r0 *1 145.93,3.11 pfet
X$27 ERR XXOR.n3 VDD VDD sg13_hv_pmos L=0.5U W=5U AS=2P AD=2P PS=10.8U PD=10.8U
* device instance $28 r0 *1 152.89,3.11 pfet
X$28 XDW.d1 ERR VDD VDD sg13_hv_pmos L=0.5U W=5U AS=2P AD=2P PS=10.8U PD=10.8U
* device instance $29 r0 *1 159.85,3.11 pfet
X$29 XDW.d2 XDW.d1 VDD VDD sg13_hv_pmos L=0.5U W=5U AS=2P AD=2P PS=10.8U
+ PD=10.8U
* device instance $30 r0 *1 166.81,3.11 pfet
X$30 XDW.d3 XDW.d2 VDD VDD sg13_hv_pmos L=0.5U W=5U AS=2P AD=2P PS=10.8U
+ PD=10.8U
* device instance $31 r0 *1 173.77,3.11 pfet
X$31 ERRD XDW.d3 VDD VDD sg13_hv_pmos L=0.5U W=5U AS=2P AD=2P PS=10.8U PD=10.8U
* device instance $32 r0 *1 180.73,3.11 pfet
X$32 nwide ERR VDD VDD sg13_hv_pmos L=0.5U W=5U AS=2P AD=2P PS=10.8U PD=10.8U
* device instance $33 r0 *1 187.69,3.11 pfet
X$33 nwide ERRD VDD VDD sg13_hv_pmos L=0.5U W=5U AS=2P AD=2P PS=10.8U PD=10.8U
* device instance $34 r0 *1 194.65,3.11 pfet
X$34 WIDE nwide VDD VDD sg13_hv_pmos L=0.5U W=5U AS=2P AD=2P PS=10.8U PD=10.8U
* device instance $35 r0 *1 208.25,3.86 pfet
X$35 XSCH.np VWIN VDD VDD sg13_hv_pmos L=2U W=5U AS=2P AD=2P PS=10.8U PD=10.8U
* device instance $36 r0 *1 215.21,3.86 pfet
X$36 LOCK VWIN XSCH.np VDD sg13_hv_pmos L=2U W=5U AS=2P AD=2P PS=10.8U PD=10.8U
* device instance $37 r0 *1 222.17,3.86 pfet
X$37 VSS LOCK XSCH.np VDD sg13_hv_pmos L=2U W=5U AS=2P AD=2P PS=10.8U PD=10.8U
* device instance $38 r0 *1 582.47,0.45 rhigh
R$38 VDD VWIN VSS 1904000 rhigh
.ENDS pll_lock_detector
