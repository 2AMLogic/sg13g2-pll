* extracted by klt extract --deck sg13cmos5l

* cell genprobe_res
* pin vsubs
.SUBCKT genprobe_res vsubs
* device instance $1 r0 *1 405.42,0.3 rppd
R$1 \$1 \$2 vsubs 351000 rppd
.ENDS genprobe_res
