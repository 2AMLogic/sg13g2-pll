* sg13g2-pll :: cp (SG13CMOS5L) -- generated by design/sg13cmos5l/netlist.sh from cp.sch
* xschem XSCHEM V3.4.7; do not edit by hand.
** sch_path: design/sg13cmos5l/cp.sch
.subckt cp UP DN IBP ICP IBN ICN VOUT VDD VSS
*.ipin UP
*.ipin DN
*.iopin IBP
*.iopin ICP
*.iopin IBN
*.iopin ICN
*.opin VOUT
*.iopin VDD
*.iopin VSS
XIUP UP UPB VDD VSS inv_hv
XIDN DN DNB VDD VSS inv_hv
XLEGP IBP ICP UP UPB VOUT VDUMP VDD cp_leg_p
XLEGN IBN ICN DN DNB VOUT VDUMP VSS cp_leg_n
XBUF VOUT IBN VDUMP VDD VSS cp_dumpbuf
XMBP nxp IBP VDD VDD sg13_hv_pmos w=24u l=1u ng=1 m=1
XMBPC IBP ICP nxp VDD sg13_hv_pmos w=24u l=1u ng=1 m=1
XMCP ICP ICP VDD VDD sg13_hv_pmos w=6u l=3u ng=1 m=1
XMBN nxn IBN VSS VSS sg13_hv_nmos w=8u l=1u ng=1 m=1
XMBNC IBN ICN nxn VSS sg13_hv_nmos w=8u l=1u ng=1 m=1
XMCN ICN ICN VSS VSS sg13_hv_nmos w=2u l=3u ng=1 m=1
.ends

* expanding   symbol:  inv_hv.sym # of pins=4
** sym_path: design/sg13cmos5l/inv_hv.sym
** sch_path: design/sg13cmos5l/inv_hv.sch
.subckt inv_hv A Y VDD VSS
*.ipin A
*.opin Y
*.iopin VDD
*.iopin VSS
XMP Y A VDD VDD sg13_hv_pmos w=5u l=0.5u ng=1 m=1
XMN Y A VSS VSS sg13_hv_nmos w=2u l=0.5u ng=1 m=1
.ends

* expanding   symbol:  cp_leg_p.sym # of pins=7
** sym_path: design/sg13cmos5l/cp_leg_p.sym
** sch_path: design/sg13cmos5l/cp_leg_p.sch
.subckt cp_leg_p IBP ICP UP UPB VOUT VDUMP VDD
*.ipin IBP
*.ipin ICP
*.ipin UP
*.ipin UPB
*.opin VOUT
*.opin VDUMP
*.iopin VDD
XM1 tail IBP VDD VDD sg13_hv_pmos w=24u l=1u ng=1 m=1
XM2 sw ICP tail VDD sg13_hv_pmos w=24u l=1u ng=1 m=1
XSWO VOUT UPB sw VDD sg13_hv_pmos w=6u l=0.3u ng=1 m=1
XSWD VDUMP UP sw VDD sg13_hv_pmos w=6u l=0.3u ng=1 m=1
.ends

* expanding   symbol:  cp_leg_n.sym # of pins=7
** sym_path: design/sg13cmos5l/cp_leg_n.sym
** sch_path: design/sg13cmos5l/cp_leg_n.sch
.subckt cp_leg_n IBN ICN DN DNB VOUT VDUMP VSS
*.ipin IBN
*.ipin ICN
*.ipin DNB
*.ipin DN
*.opin VOUT
*.opin VDUMP
*.iopin VSS
XM1 tail IBN VSS VSS sg13_hv_nmos w=8u l=1u ng=1 m=1
XM2 sw ICN tail VSS sg13_hv_nmos w=8u l=1u ng=1 m=1
XSWO VOUT DN sw VSS sg13_hv_nmos w=6u l=0.3u ng=1 m=1
XSWD VDUMP DNB sw VSS sg13_hv_nmos w=6u l=0.3u ng=1 m=1
.ends

* expanding   symbol:  cp_dumpbuf.sym # of pins=5
** sym_path: design/sg13cmos5l/cp_dumpbuf.sym
** sch_path: design/sg13cmos5l/cp_dumpbuf.sch
.subckt cp_dumpbuf VOUT IBIAS VDUMP VDD VSS
*.ipin VOUT
*.ipin IBIAS
*.opin VDUMP
*.iopin VDD
*.iopin VSS
XM1 VDD VOUT VDUMP VSS sg13_hv_nmos w=6u l=0.5u ng=1 m=1
XM2 VDUMP IBIAS VSS VSS sg13_hv_nmos w=4u l=1u ng=1 m=1
.ends
