* Netlist provenance snapshot -- sim/README.md convention
* Frozen from design/sg13cmos5l/netlist/vco.spice at commit c62d98c9
* ("fix: declare vco's XBIAS resistor bodies on VSS, close the vco LVS
* mismatch (#123)"; file sha256
* 479eacab10a71e3b991f18c7f64b52737dd7152992d27d3151c0bb0115f79d64)
* Simulated by sim/sg13cmos5l-vco-period-jitter/ (issue #518, Part of #16).
* Independent of whatever design/sg13cmos5l/netlist/vco.spice says today.
* sg13g2-pll :: vco (SG13CMOS5L) -- generated by design/sg13cmos5l/netlist.sh from vco.sch
* xschem XSCHEM V3.4.7; do not edit by hand.
** sch_path: design/sg13cmos5l/vco.sch
.subckt vco VCTRL B0 B1 CLK VDD_VCO GND_VCO
*.ipin VCTRL
*.ipin B0
*.ipin B1
*.opin CLK
*.iopin VDD_VCO
*.iopin GND_VCO
XBIAS VCTRL B0 B1 VBP VBN VDD_VCO GND_VCO vco_bias
XS1 ring5 VBP VBN ring1 VDD_VCO GND_VCO vco_stage
XS2 ring1 VBP VBN ring2 VDD_VCO GND_VCO vco_stage
XS3 ring2 VBP VBN ring3 VDD_VCO GND_VCO vco_stage
XS4 ring3 VBP VBN ring4 VDD_VCO GND_VCO vco_stage
XS5 ring4 VBP VBN ring5 VDD_VCO GND_VCO vco_stage
XBUF1 ring1 bufmid VDD_VCO GND_VCO inv2x_hv
XBUF2 bufmid CLK VDD_VCO GND_VCO inv2x_hv
XCDECAP VDD_VCO GND_VCO cap_cmomi w=70u l=70u mmin=1 mmax=4 feed=double subblock=0 m=1 mm_ok=1
.ends

* expanding   symbol:  vco_bias.sym # of pins=7
** sym_path: design/sg13cmos5l/vco_bias.sym
** sch_path: design/sg13cmos5l/vco_bias.sch
.subckt vco_bias VCTRL B0 B1 VBP VBN VDD VSS
*.ipin VCTRL
*.ipin B0
*.ipin B1
*.opin VBP
*.opin VBN
*.iopin VDD
*.iopin VSS
XP1 vb1 vb1 VDD VDD sg13_hv_pmos w=6u l=1u ng=1 m=1
XP2 vb2 vb1 VDD VDD sg13_hv_pmos w=6u l=1u ng=1 m=1
XN1 vb1 vb2 VSS VSS sg13_hv_nmos w=2u l=1u ng=1 m=1
XN2 vb2 vb2 n2s VSS sg13_hv_nmos w=8u l=1u ng=1 m=1
XRS n2s VSS VSS rppd w=1u l=30u m=1 b=0
XRSTART VDD vb2 VSS rhigh w=0.5u l=8u m=1 b=0
XP5 VFIX vb1 VDD VDD sg13_hv_pmos w=3u l=1u ng=1 m=1
XN5 VFIX VFIX vfixmid VSS sg13_hv_nmos w=2u l=1u ng=1 m=1
XN6 vfixmid vfixmid VSS VSS sg13_hv_nmos w=2u l=1u ng=1 m=1
XM6 VBP VBP VDD VDD sg13_hv_pmos w=10u l=1u ng=1 m=1
XM7 VBP VFIX dega VSS sg13_hv_nmos w=4u l=1u ng=1 m=1
XRDEGA dega VSS VSS rppd w=1u l=60u m=1 b=0
XM8 VBP VCTRL degb VSS sg13_hv_nmos w=4u l=1u ng=1 m=1
XRDEGB0 degb VSS VSS rppd w=1u l=60u m=1 b=0
XSWB0 degb B0 nb0 VSS sg13_hv_nmos w=4u l=0.3u ng=1 m=1
XRDEGB1 nb0 VSS VSS rppd w=1u l=60u m=1 b=0
XSWB1 degb B1 nb1 VSS sg13_hv_nmos w=4u l=0.3u ng=1 m=1
XRDEGB2 nb1 VSS VSS rppd w=1u l=30u m=1 b=0
XM11 VBN VBP VDD VDD sg13_hv_pmos w=10u l=1u ng=1 m=1
XM10 VBN VBN VSS VSS sg13_hv_nmos w=4u l=1u ng=1 m=1
.ends

* expanding   symbol:  vco_stage.sym # of pins=6
** sym_path: design/sg13cmos5l/vco_stage.sym
** sch_path: design/sg13cmos5l/vco_stage.sch
.subckt vco_stage IN VBP VBN OUT VDDV GNDV
*.ipin IN
*.opin OUT
*.ipin VBP
*.ipin VBN
*.iopin VDDV
*.iopin GNDV
XMPH nh VBP VDDV VDDV sg13_hv_pmos w=10u l=0.5u ng=1 m=1
XMP OUT IN nh VDDV sg13_hv_pmos w=5u l=0.28u ng=1 m=1
XMN OUT IN nt GNDV sg13_hv_nmos w=2u l=0.28u ng=1 m=1
XMNT nt VBN GNDV GNDV sg13_hv_nmos w=4u l=0.5u ng=1 m=1
.ends

* expanding   symbol:  inv2x_hv.sym # of pins=4
** sym_path: design/sg13cmos5l/inv2x_hv.sym
** sch_path: design/sg13cmos5l/inv2x_hv.sch
.subckt inv2x_hv A Y VDD VSS
*.ipin A
*.opin Y
*.iopin VDD
*.iopin VSS
XMP Y A VDD VDD sg13_hv_pmos w=10u l=0.5u ng=1 m=1
XMN Y A VSS VSS sg13_hv_nmos w=4u l=0.5u ng=1 m=1
.ends
