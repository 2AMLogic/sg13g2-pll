* flattened from ../../design/sg13cmos5l/netlist/divider_chain.spice subckt divider_chain by flatten-schematic.py (device cards verbatim)
.subckt pll_divider_chain CKIN CKIN_VCO DIVOUT FB P0 P1 P2 P3 P4 P5 VDD_DIV VSS
XXD0_XN3_MP1 XD0_nt mod0 VDD_DIV VDD_DIV sg13_hv_pmos w=5u l=0.5u ng=1 m=1
XXD0_XN3_MP2 XD0_nt P0 VDD_DIV VDD_DIV sg13_hv_pmos w=5u l=0.5u ng=1 m=1
XXD0_XN3_MP3 XD0_nt net1 VDD_DIV VDD_DIV sg13_hv_pmos w=5u l=0.5u ng=1 m=1
XXD0_XN3_MN1 XD0_nt mod0 XD0_XN3_mid1 VSS sg13_hv_nmos w=2u l=0.5u ng=1 m=1
XXD0_XN3_MN2 XD0_XN3_mid1 P0 XD0_XN3_mid2 VSS sg13_hv_nmos w=2u l=0.5u ng=1 m=1
XXD0_XN3_MN3 XD0_XN3_mid2 net1 VSS VSS sg13_hv_nmos w=2u l=0.5u ng=1 m=1
XXD0_XI1_MP XD0_t1 XD0_nt VDD_DIV VDD_DIV sg13_hv_pmos w=5u l=0.5u ng=1 m=1
XXD0_XI1_MN XD0_t1 XD0_nt VSS VSS sg13_hv_nmos w=2u l=0.5u ng=1 m=1
XXD0_XNOR_MP1 XD0_XNOR_midp ck1 VDD_DIV VDD_DIV sg13_hv_pmos w=5u l=0.5u ng=1 m=1
XXD0_XNOR_MP2 XD0_dq XD0_t1 XD0_XNOR_midp VDD_DIV sg13_hv_pmos w=5u l=0.5u ng=1 m=1
XXD0_XNOR_MN1 XD0_dq ck1 VSS VSS sg13_hv_nmos w=2u l=0.5u ng=1 m=1
XXD0_XNOR_MN2 XD0_dq XD0_t1 VSS VSS sg13_hv_nmos w=2u l=0.5u ng=1 m=1
XXD0_XDFFQ_XICLK_MP XD0_XDFFQ_CLKB CKIN VDD_DIV VDD_DIV sg13_hv_pmos w=5u l=0.5u ng=1 m=1
XXD0_XDFFQ_XICLK_MN XD0_XDFFQ_CLKB CKIN VSS VSS sg13_hv_nmos w=2u l=0.5u ng=1 m=1
XXD0_XDFFQ_XICKBB_MP XD0_XDFFQ_CKBB XD0_XDFFQ_CLKB VDD_DIV VDD_DIV sg13_hv_pmos w=5u l=0.5u ng=1 m=1
XXD0_XDFFQ_XICKBB_MN XD0_XDFFQ_CKBB XD0_XDFFQ_CLKB VSS VSS sg13_hv_nmos w=2u l=0.5u ng=1 m=1
XXD0_XDFFQ_XTG1_MN XD0_dq XD0_XDFFQ_CLKB XD0_XDFFQ_M VSS sg13_hv_nmos w=2u l=0.5u ng=1 m=1
XXD0_XDFFQ_XTG1_MP XD0_XDFFQ_M XD0_XDFFQ_CKBB XD0_dq VDD_DIV sg13_hv_pmos w=5u l=0.5u ng=1 m=1
XXD0_XDFFQ_XIM_MP XD0_XDFFQ_MB XD0_XDFFQ_M VDD_DIV VDD_DIV sg13_hv_pmos w=5u l=0.5u ng=1 m=1
XXD0_XDFFQ_XIM_MN XD0_XDFFQ_MB XD0_XDFFQ_M VSS VSS sg13_hv_nmos w=2u l=0.5u ng=1 m=1
XXD0_XDFFQ_XIMF_MP XD0_XDFFQ_MFB XD0_XDFFQ_MB VDD_DIV VDD_DIV sg13_hv_pmos w=5u l=0.5u ng=1 m=1
XXD0_XDFFQ_XIMF_MN XD0_XDFFQ_MFB XD0_XDFFQ_MB VSS VSS sg13_hv_nmos w=2u l=0.5u ng=1 m=1
XXD0_XDFFQ_XTGFBM_MN XD0_XDFFQ_MFB XD0_XDFFQ_CKBB XD0_XDFFQ_M VSS sg13_hv_nmos w=2u l=0.5u ng=1 m=1
XXD0_XDFFQ_XTGFBM_MP XD0_XDFFQ_M XD0_XDFFQ_CLKB XD0_XDFFQ_MFB VDD_DIV sg13_hv_pmos w=5u l=0.5u ng=1 m=1
XXD0_XDFFQ_XTG2_MN XD0_XDFFQ_M XD0_XDFFQ_CKBB XD0_XDFFQ_S VSS sg13_hv_nmos w=2u l=0.5u ng=1 m=1
XXD0_XDFFQ_XTG2_MP XD0_XDFFQ_S XD0_XDFFQ_CLKB XD0_XDFFQ_M VDD_DIV sg13_hv_pmos w=5u l=0.5u ng=1 m=1
XXD0_XDFFQ_XIS_MP XD0_XDFFQ_SB XD0_XDFFQ_S VDD_DIV VDD_DIV sg13_hv_pmos w=5u l=0.5u ng=1 m=1
XXD0_XDFFQ_XIS_MN XD0_XDFFQ_SB XD0_XDFFQ_S VSS VSS sg13_hv_nmos w=2u l=0.5u ng=1 m=1
XXD0_XDFFQ_XISF_MP XD0_XDFFQ_SFB XD0_XDFFQ_SB VDD_DIV VDD_DIV sg13_hv_pmos w=5u l=0.5u ng=1 m=1
XXD0_XDFFQ_XISF_MN XD0_XDFFQ_SFB XD0_XDFFQ_SB VSS VSS sg13_hv_nmos w=2u l=0.5u ng=1 m=1
XXD0_XDFFQ_XTGFBS_MN XD0_XDFFQ_SFB XD0_XDFFQ_CLKB XD0_XDFFQ_S VSS sg13_hv_nmos w=2u l=0.5u ng=1 m=1
XXD0_XDFFQ_XTGFBS_MP XD0_XDFFQ_S XD0_XDFFQ_CKBB XD0_XDFFQ_SFB VDD_DIV sg13_hv_pmos w=5u l=0.5u ng=1 m=1
XXD0_XDFFQ_XBQ_MP ck1 XD0_XDFFQ_SB VDD_DIV VDD_DIV sg13_hv_pmos w=5u l=0.5u ng=1 m=1
XXD0_XDFFQ_XBQ_MN ck1 XD0_XDFFQ_SB VSS VSS sg13_hv_nmos w=2u l=0.5u ng=1 m=1
XXD0_XN2_MP1 XD0_nm mod0 VDD_DIV VDD_DIV sg13_hv_pmos w=5u l=0.5u ng=1 m=1
XXD0_XN2_MP2 XD0_nm ck1 VDD_DIV VDD_DIV sg13_hv_pmos w=5u l=0.5u ng=1 m=1
XXD0_XN2_MN1 XD0_nm mod0 XD0_XN2_mid1 VSS sg13_hv_nmos w=2u l=0.5u ng=1 m=1
XXD0_XN2_MN2 XD0_XN2_mid1 ck1 VSS VSS sg13_hv_nmos w=2u l=0.5u ng=1 m=1
XXD0_XI2_MP XD0_dmodout XD0_nm VDD_DIV VDD_DIV sg13_hv_pmos w=5u l=0.5u ng=1 m=1
XXD0_XI2_MN XD0_dmodout XD0_nm VSS VSS sg13_hv_nmos w=2u l=0.5u ng=1 m=1
XXD0_XDFFM_XICLK_MP XD0_XDFFM_CLKB CKIN VDD_DIV VDD_DIV sg13_hv_pmos w=5u l=0.5u ng=1 m=1
XXD0_XDFFM_XICLK_MN XD0_XDFFM_CLKB CKIN VSS VSS sg13_hv_nmos w=2u l=0.5u ng=1 m=1
XXD0_XDFFM_XICKBB_MP XD0_XDFFM_CKBB XD0_XDFFM_CLKB VDD_DIV VDD_DIV sg13_hv_pmos w=5u l=0.5u ng=1 m=1
XXD0_XDFFM_XICKBB_MN XD0_XDFFM_CKBB XD0_XDFFM_CLKB VSS VSS sg13_hv_nmos w=2u l=0.5u ng=1 m=1
XXD0_XDFFM_XTG1_MN XD0_dmodout XD0_XDFFM_CLKB XD0_XDFFM_M VSS sg13_hv_nmos w=2u l=0.5u ng=1 m=1
XXD0_XDFFM_XTG1_MP XD0_XDFFM_M XD0_XDFFM_CKBB XD0_dmodout VDD_DIV sg13_hv_pmos w=5u l=0.5u ng=1 m=1
XXD0_XDFFM_XIM_MP XD0_XDFFM_MB XD0_XDFFM_M VDD_DIV VDD_DIV sg13_hv_pmos w=5u l=0.5u ng=1 m=1
XXD0_XDFFM_XIM_MN XD0_XDFFM_MB XD0_XDFFM_M VSS VSS sg13_hv_nmos w=2u l=0.5u ng=1 m=1
XXD0_XDFFM_XIMF_MP XD0_XDFFM_MFB XD0_XDFFM_MB VDD_DIV VDD_DIV sg13_hv_pmos w=5u l=0.5u ng=1 m=1
XXD0_XDFFM_XIMF_MN XD0_XDFFM_MFB XD0_XDFFM_MB VSS VSS sg13_hv_nmos w=2u l=0.5u ng=1 m=1
XXD0_XDFFM_XTGFBM_MN XD0_XDFFM_MFB XD0_XDFFM_CKBB XD0_XDFFM_M VSS sg13_hv_nmos w=2u l=0.5u ng=1 m=1
XXD0_XDFFM_XTGFBM_MP XD0_XDFFM_M XD0_XDFFM_CLKB XD0_XDFFM_MFB VDD_DIV sg13_hv_pmos w=5u l=0.5u ng=1 m=1
XXD0_XDFFM_XTG2_MN XD0_XDFFM_M XD0_XDFFM_CKBB XD0_XDFFM_S VSS sg13_hv_nmos w=2u l=0.5u ng=1 m=1
XXD0_XDFFM_XTG2_MP XD0_XDFFM_S XD0_XDFFM_CLKB XD0_XDFFM_M VDD_DIV sg13_hv_pmos w=5u l=0.5u ng=1 m=1
XXD0_XDFFM_XIS_MP XD0_XDFFM_SB XD0_XDFFM_S VDD_DIV VDD_DIV sg13_hv_pmos w=5u l=0.5u ng=1 m=1
XXD0_XDFFM_XIS_MN XD0_XDFFM_SB XD0_XDFFM_S VSS VSS sg13_hv_nmos w=2u l=0.5u ng=1 m=1
XXD0_XDFFM_XISF_MP XD0_XDFFM_SFB XD0_XDFFM_SB VDD_DIV VDD_DIV sg13_hv_pmos w=5u l=0.5u ng=1 m=1
XXD0_XDFFM_XISF_MN XD0_XDFFM_SFB XD0_XDFFM_SB VSS VSS sg13_hv_nmos w=2u l=0.5u ng=1 m=1
XXD0_XDFFM_XTGFBS_MN XD0_XDFFM_SFB XD0_XDFFM_CLKB XD0_XDFFM_S VSS sg13_hv_nmos w=2u l=0.5u ng=1 m=1
XXD0_XDFFM_XTGFBS_MP XD0_XDFFM_S XD0_XDFFM_CKBB XD0_XDFFM_SFB VDD_DIV sg13_hv_pmos w=5u l=0.5u ng=1 m=1
XXD0_XDFFM_XBQ_MP net1 XD0_XDFFM_SB VDD_DIV VDD_DIV sg13_hv_pmos w=5u l=0.5u ng=1 m=1
XXD0_XDFFM_XBQ_MN net1 XD0_XDFFM_SB VSS VSS sg13_hv_nmos w=2u l=0.5u ng=1 m=1
XXD1_XN3_MP1 XD1_nt mod1 VDD_DIV VDD_DIV sg13_hv_pmos w=5u l=0.5u ng=1 m=1
XXD1_XN3_MP2 XD1_nt P1 VDD_DIV VDD_DIV sg13_hv_pmos w=5u l=0.5u ng=1 m=1
XXD1_XN3_MP3 XD1_nt mod0 VDD_DIV VDD_DIV sg13_hv_pmos w=5u l=0.5u ng=1 m=1
XXD1_XN3_MN1 XD1_nt mod1 XD1_XN3_mid1 VSS sg13_hv_nmos w=2u l=0.5u ng=1 m=1
XXD1_XN3_MN2 XD1_XN3_mid1 P1 XD1_XN3_mid2 VSS sg13_hv_nmos w=2u l=0.5u ng=1 m=1
XXD1_XN3_MN3 XD1_XN3_mid2 mod0 VSS VSS sg13_hv_nmos w=2u l=0.5u ng=1 m=1
XXD1_XI1_MP XD1_t1 XD1_nt VDD_DIV VDD_DIV sg13_hv_pmos w=5u l=0.5u ng=1 m=1
XXD1_XI1_MN XD1_t1 XD1_nt VSS VSS sg13_hv_nmos w=2u l=0.5u ng=1 m=1
XXD1_XNOR_MP1 XD1_XNOR_midp ck2 VDD_DIV VDD_DIV sg13_hv_pmos w=5u l=0.5u ng=1 m=1
XXD1_XNOR_MP2 XD1_dq XD1_t1 XD1_XNOR_midp VDD_DIV sg13_hv_pmos w=5u l=0.5u ng=1 m=1
XXD1_XNOR_MN1 XD1_dq ck2 VSS VSS sg13_hv_nmos w=2u l=0.5u ng=1 m=1
XXD1_XNOR_MN2 XD1_dq XD1_t1 VSS VSS sg13_hv_nmos w=2u l=0.5u ng=1 m=1
XXD1_XDFFQ_XICLK_MP XD1_XDFFQ_CLKB ck1 VDD_DIV VDD_DIV sg13_hv_pmos w=5u l=0.5u ng=1 m=1
XXD1_XDFFQ_XICLK_MN XD1_XDFFQ_CLKB ck1 VSS VSS sg13_hv_nmos w=2u l=0.5u ng=1 m=1
XXD1_XDFFQ_XICKBB_MP XD1_XDFFQ_CKBB XD1_XDFFQ_CLKB VDD_DIV VDD_DIV sg13_hv_pmos w=5u l=0.5u ng=1 m=1
XXD1_XDFFQ_XICKBB_MN XD1_XDFFQ_CKBB XD1_XDFFQ_CLKB VSS VSS sg13_hv_nmos w=2u l=0.5u ng=1 m=1
XXD1_XDFFQ_XTG1_MN XD1_dq XD1_XDFFQ_CLKB XD1_XDFFQ_M VSS sg13_hv_nmos w=2u l=0.5u ng=1 m=1
XXD1_XDFFQ_XTG1_MP XD1_XDFFQ_M XD1_XDFFQ_CKBB XD1_dq VDD_DIV sg13_hv_pmos w=5u l=0.5u ng=1 m=1
XXD1_XDFFQ_XIM_MP XD1_XDFFQ_MB XD1_XDFFQ_M VDD_DIV VDD_DIV sg13_hv_pmos w=5u l=0.5u ng=1 m=1
XXD1_XDFFQ_XIM_MN XD1_XDFFQ_MB XD1_XDFFQ_M VSS VSS sg13_hv_nmos w=2u l=0.5u ng=1 m=1
XXD1_XDFFQ_XIMF_MP XD1_XDFFQ_MFB XD1_XDFFQ_MB VDD_DIV VDD_DIV sg13_hv_pmos w=5u l=0.5u ng=1 m=1
XXD1_XDFFQ_XIMF_MN XD1_XDFFQ_MFB XD1_XDFFQ_MB VSS VSS sg13_hv_nmos w=2u l=0.5u ng=1 m=1
XXD1_XDFFQ_XTGFBM_MN XD1_XDFFQ_MFB XD1_XDFFQ_CKBB XD1_XDFFQ_M VSS sg13_hv_nmos w=2u l=0.5u ng=1 m=1
XXD1_XDFFQ_XTGFBM_MP XD1_XDFFQ_M XD1_XDFFQ_CLKB XD1_XDFFQ_MFB VDD_DIV sg13_hv_pmos w=5u l=0.5u ng=1 m=1
XXD1_XDFFQ_XTG2_MN XD1_XDFFQ_M XD1_XDFFQ_CKBB XD1_XDFFQ_S VSS sg13_hv_nmos w=2u l=0.5u ng=1 m=1
XXD1_XDFFQ_XTG2_MP XD1_XDFFQ_S XD1_XDFFQ_CLKB XD1_XDFFQ_M VDD_DIV sg13_hv_pmos w=5u l=0.5u ng=1 m=1
XXD1_XDFFQ_XIS_MP XD1_XDFFQ_SB XD1_XDFFQ_S VDD_DIV VDD_DIV sg13_hv_pmos w=5u l=0.5u ng=1 m=1
XXD1_XDFFQ_XIS_MN XD1_XDFFQ_SB XD1_XDFFQ_S VSS VSS sg13_hv_nmos w=2u l=0.5u ng=1 m=1
XXD1_XDFFQ_XISF_MP XD1_XDFFQ_SFB XD1_XDFFQ_SB VDD_DIV VDD_DIV sg13_hv_pmos w=5u l=0.5u ng=1 m=1
XXD1_XDFFQ_XISF_MN XD1_XDFFQ_SFB XD1_XDFFQ_SB VSS VSS sg13_hv_nmos w=2u l=0.5u ng=1 m=1
XXD1_XDFFQ_XTGFBS_MN XD1_XDFFQ_SFB XD1_XDFFQ_CLKB XD1_XDFFQ_S VSS sg13_hv_nmos w=2u l=0.5u ng=1 m=1
XXD1_XDFFQ_XTGFBS_MP XD1_XDFFQ_S XD1_XDFFQ_CKBB XD1_XDFFQ_SFB VDD_DIV sg13_hv_pmos w=5u l=0.5u ng=1 m=1
XXD1_XDFFQ_XBQ_MP ck2 XD1_XDFFQ_SB VDD_DIV VDD_DIV sg13_hv_pmos w=5u l=0.5u ng=1 m=1
XXD1_XDFFQ_XBQ_MN ck2 XD1_XDFFQ_SB VSS VSS sg13_hv_nmos w=2u l=0.5u ng=1 m=1
XXD1_XN2_MP1 XD1_nm mod1 VDD_DIV VDD_DIV sg13_hv_pmos w=5u l=0.5u ng=1 m=1
XXD1_XN2_MP2 XD1_nm ck2 VDD_DIV VDD_DIV sg13_hv_pmos w=5u l=0.5u ng=1 m=1
XXD1_XN2_MN1 XD1_nm mod1 XD1_XN2_mid1 VSS sg13_hv_nmos w=2u l=0.5u ng=1 m=1
XXD1_XN2_MN2 XD1_XN2_mid1 ck2 VSS VSS sg13_hv_nmos w=2u l=0.5u ng=1 m=1
XXD1_XI2_MP XD1_dmodout XD1_nm VDD_DIV VDD_DIV sg13_hv_pmos w=5u l=0.5u ng=1 m=1
XXD1_XI2_MN XD1_dmodout XD1_nm VSS VSS sg13_hv_nmos w=2u l=0.5u ng=1 m=1
XXD1_XDFFM_XICLK_MP XD1_XDFFM_CLKB ck1 VDD_DIV VDD_DIV sg13_hv_pmos w=5u l=0.5u ng=1 m=1
XXD1_XDFFM_XICLK_MN XD1_XDFFM_CLKB ck1 VSS VSS sg13_hv_nmos w=2u l=0.5u ng=1 m=1
XXD1_XDFFM_XICKBB_MP XD1_XDFFM_CKBB XD1_XDFFM_CLKB VDD_DIV VDD_DIV sg13_hv_pmos w=5u l=0.5u ng=1 m=1
XXD1_XDFFM_XICKBB_MN XD1_XDFFM_CKBB XD1_XDFFM_CLKB VSS VSS sg13_hv_nmos w=2u l=0.5u ng=1 m=1
XXD1_XDFFM_XTG1_MN XD1_dmodout XD1_XDFFM_CLKB XD1_XDFFM_M VSS sg13_hv_nmos w=2u l=0.5u ng=1 m=1
XXD1_XDFFM_XTG1_MP XD1_XDFFM_M XD1_XDFFM_CKBB XD1_dmodout VDD_DIV sg13_hv_pmos w=5u l=0.5u ng=1 m=1
XXD1_XDFFM_XIM_MP XD1_XDFFM_MB XD1_XDFFM_M VDD_DIV VDD_DIV sg13_hv_pmos w=5u l=0.5u ng=1 m=1
XXD1_XDFFM_XIM_MN XD1_XDFFM_MB XD1_XDFFM_M VSS VSS sg13_hv_nmos w=2u l=0.5u ng=1 m=1
XXD1_XDFFM_XIMF_MP XD1_XDFFM_MFB XD1_XDFFM_MB VDD_DIV VDD_DIV sg13_hv_pmos w=5u l=0.5u ng=1 m=1
XXD1_XDFFM_XIMF_MN XD1_XDFFM_MFB XD1_XDFFM_MB VSS VSS sg13_hv_nmos w=2u l=0.5u ng=1 m=1
XXD1_XDFFM_XTGFBM_MN XD1_XDFFM_MFB XD1_XDFFM_CKBB XD1_XDFFM_M VSS sg13_hv_nmos w=2u l=0.5u ng=1 m=1
XXD1_XDFFM_XTGFBM_MP XD1_XDFFM_M XD1_XDFFM_CLKB XD1_XDFFM_MFB VDD_DIV sg13_hv_pmos w=5u l=0.5u ng=1 m=1
XXD1_XDFFM_XTG2_MN XD1_XDFFM_M XD1_XDFFM_CKBB XD1_XDFFM_S VSS sg13_hv_nmos w=2u l=0.5u ng=1 m=1
XXD1_XDFFM_XTG2_MP XD1_XDFFM_S XD1_XDFFM_CLKB XD1_XDFFM_M VDD_DIV sg13_hv_pmos w=5u l=0.5u ng=1 m=1
XXD1_XDFFM_XIS_MP XD1_XDFFM_SB XD1_XDFFM_S VDD_DIV VDD_DIV sg13_hv_pmos w=5u l=0.5u ng=1 m=1
XXD1_XDFFM_XIS_MN XD1_XDFFM_SB XD1_XDFFM_S VSS VSS sg13_hv_nmos w=2u l=0.5u ng=1 m=1
XXD1_XDFFM_XISF_MP XD1_XDFFM_SFB XD1_XDFFM_SB VDD_DIV VDD_DIV sg13_hv_pmos w=5u l=0.5u ng=1 m=1
XXD1_XDFFM_XISF_MN XD1_XDFFM_SFB XD1_XDFFM_SB VSS VSS sg13_hv_nmos w=2u l=0.5u ng=1 m=1
XXD1_XDFFM_XTGFBS_MN XD1_XDFFM_SFB XD1_XDFFM_CLKB XD1_XDFFM_S VSS sg13_hv_nmos w=2u l=0.5u ng=1 m=1
XXD1_XDFFM_XTGFBS_MP XD1_XDFFM_S XD1_XDFFM_CKBB XD1_XDFFM_SFB VDD_DIV sg13_hv_pmos w=5u l=0.5u ng=1 m=1
XXD1_XDFFM_XBQ_MP mod0 XD1_XDFFM_SB VDD_DIV VDD_DIV sg13_hv_pmos w=5u l=0.5u ng=1 m=1
XXD1_XDFFM_XBQ_MN mod0 XD1_XDFFM_SB VSS VSS sg13_hv_nmos w=2u l=0.5u ng=1 m=1
XXD2_XN3_MP1 XD2_nt mod2 VDD_DIV VDD_DIV sg13_hv_pmos w=5u l=0.5u ng=1 m=1
XXD2_XN3_MP2 XD2_nt P2 VDD_DIV VDD_DIV sg13_hv_pmos w=5u l=0.5u ng=1 m=1
XXD2_XN3_MP3 XD2_nt mod1 VDD_DIV VDD_DIV sg13_hv_pmos w=5u l=0.5u ng=1 m=1
XXD2_XN3_MN1 XD2_nt mod2 XD2_XN3_mid1 VSS sg13_hv_nmos w=2u l=0.5u ng=1 m=1
XXD2_XN3_MN2 XD2_XN3_mid1 P2 XD2_XN3_mid2 VSS sg13_hv_nmos w=2u l=0.5u ng=1 m=1
XXD2_XN3_MN3 XD2_XN3_mid2 mod1 VSS VSS sg13_hv_nmos w=2u l=0.5u ng=1 m=1
XXD2_XI1_MP XD2_t1 XD2_nt VDD_DIV VDD_DIV sg13_hv_pmos w=5u l=0.5u ng=1 m=1
XXD2_XI1_MN XD2_t1 XD2_nt VSS VSS sg13_hv_nmos w=2u l=0.5u ng=1 m=1
XXD2_XNOR_MP1 XD2_XNOR_midp ck3 VDD_DIV VDD_DIV sg13_hv_pmos w=5u l=0.5u ng=1 m=1
XXD2_XNOR_MP2 XD2_dq XD2_t1 XD2_XNOR_midp VDD_DIV sg13_hv_pmos w=5u l=0.5u ng=1 m=1
XXD2_XNOR_MN1 XD2_dq ck3 VSS VSS sg13_hv_nmos w=2u l=0.5u ng=1 m=1
XXD2_XNOR_MN2 XD2_dq XD2_t1 VSS VSS sg13_hv_nmos w=2u l=0.5u ng=1 m=1
XXD2_XDFFQ_XICLK_MP XD2_XDFFQ_CLKB ck2 VDD_DIV VDD_DIV sg13_hv_pmos w=5u l=0.5u ng=1 m=1
XXD2_XDFFQ_XICLK_MN XD2_XDFFQ_CLKB ck2 VSS VSS sg13_hv_nmos w=2u l=0.5u ng=1 m=1
XXD2_XDFFQ_XICKBB_MP XD2_XDFFQ_CKBB XD2_XDFFQ_CLKB VDD_DIV VDD_DIV sg13_hv_pmos w=5u l=0.5u ng=1 m=1
XXD2_XDFFQ_XICKBB_MN XD2_XDFFQ_CKBB XD2_XDFFQ_CLKB VSS VSS sg13_hv_nmos w=2u l=0.5u ng=1 m=1
XXD2_XDFFQ_XTG1_MN XD2_dq XD2_XDFFQ_CLKB XD2_XDFFQ_M VSS sg13_hv_nmos w=2u l=0.5u ng=1 m=1
XXD2_XDFFQ_XTG1_MP XD2_XDFFQ_M XD2_XDFFQ_CKBB XD2_dq VDD_DIV sg13_hv_pmos w=5u l=0.5u ng=1 m=1
XXD2_XDFFQ_XIM_MP XD2_XDFFQ_MB XD2_XDFFQ_M VDD_DIV VDD_DIV sg13_hv_pmos w=5u l=0.5u ng=1 m=1
XXD2_XDFFQ_XIM_MN XD2_XDFFQ_MB XD2_XDFFQ_M VSS VSS sg13_hv_nmos w=2u l=0.5u ng=1 m=1
XXD2_XDFFQ_XIMF_MP XD2_XDFFQ_MFB XD2_XDFFQ_MB VDD_DIV VDD_DIV sg13_hv_pmos w=5u l=0.5u ng=1 m=1
XXD2_XDFFQ_XIMF_MN XD2_XDFFQ_MFB XD2_XDFFQ_MB VSS VSS sg13_hv_nmos w=2u l=0.5u ng=1 m=1
XXD2_XDFFQ_XTGFBM_MN XD2_XDFFQ_MFB XD2_XDFFQ_CKBB XD2_XDFFQ_M VSS sg13_hv_nmos w=2u l=0.5u ng=1 m=1
XXD2_XDFFQ_XTGFBM_MP XD2_XDFFQ_M XD2_XDFFQ_CLKB XD2_XDFFQ_MFB VDD_DIV sg13_hv_pmos w=5u l=0.5u ng=1 m=1
XXD2_XDFFQ_XTG2_MN XD2_XDFFQ_M XD2_XDFFQ_CKBB XD2_XDFFQ_S VSS sg13_hv_nmos w=2u l=0.5u ng=1 m=1
XXD2_XDFFQ_XTG2_MP XD2_XDFFQ_S XD2_XDFFQ_CLKB XD2_XDFFQ_M VDD_DIV sg13_hv_pmos w=5u l=0.5u ng=1 m=1
XXD2_XDFFQ_XIS_MP XD2_XDFFQ_SB XD2_XDFFQ_S VDD_DIV VDD_DIV sg13_hv_pmos w=5u l=0.5u ng=1 m=1
XXD2_XDFFQ_XIS_MN XD2_XDFFQ_SB XD2_XDFFQ_S VSS VSS sg13_hv_nmos w=2u l=0.5u ng=1 m=1
XXD2_XDFFQ_XISF_MP XD2_XDFFQ_SFB XD2_XDFFQ_SB VDD_DIV VDD_DIV sg13_hv_pmos w=5u l=0.5u ng=1 m=1
XXD2_XDFFQ_XISF_MN XD2_XDFFQ_SFB XD2_XDFFQ_SB VSS VSS sg13_hv_nmos w=2u l=0.5u ng=1 m=1
XXD2_XDFFQ_XTGFBS_MN XD2_XDFFQ_SFB XD2_XDFFQ_CLKB XD2_XDFFQ_S VSS sg13_hv_nmos w=2u l=0.5u ng=1 m=1
XXD2_XDFFQ_XTGFBS_MP XD2_XDFFQ_S XD2_XDFFQ_CKBB XD2_XDFFQ_SFB VDD_DIV sg13_hv_pmos w=5u l=0.5u ng=1 m=1
XXD2_XDFFQ_XBQ_MP ck3 XD2_XDFFQ_SB VDD_DIV VDD_DIV sg13_hv_pmos w=5u l=0.5u ng=1 m=1
XXD2_XDFFQ_XBQ_MN ck3 XD2_XDFFQ_SB VSS VSS sg13_hv_nmos w=2u l=0.5u ng=1 m=1
XXD2_XN2_MP1 XD2_nm mod2 VDD_DIV VDD_DIV sg13_hv_pmos w=5u l=0.5u ng=1 m=1
XXD2_XN2_MP2 XD2_nm ck3 VDD_DIV VDD_DIV sg13_hv_pmos w=5u l=0.5u ng=1 m=1
XXD2_XN2_MN1 XD2_nm mod2 XD2_XN2_mid1 VSS sg13_hv_nmos w=2u l=0.5u ng=1 m=1
XXD2_XN2_MN2 XD2_XN2_mid1 ck3 VSS VSS sg13_hv_nmos w=2u l=0.5u ng=1 m=1
XXD2_XI2_MP XD2_dmodout XD2_nm VDD_DIV VDD_DIV sg13_hv_pmos w=5u l=0.5u ng=1 m=1
XXD2_XI2_MN XD2_dmodout XD2_nm VSS VSS sg13_hv_nmos w=2u l=0.5u ng=1 m=1
XXD2_XDFFM_XICLK_MP XD2_XDFFM_CLKB ck2 VDD_DIV VDD_DIV sg13_hv_pmos w=5u l=0.5u ng=1 m=1
XXD2_XDFFM_XICLK_MN XD2_XDFFM_CLKB ck2 VSS VSS sg13_hv_nmos w=2u l=0.5u ng=1 m=1
XXD2_XDFFM_XICKBB_MP XD2_XDFFM_CKBB XD2_XDFFM_CLKB VDD_DIV VDD_DIV sg13_hv_pmos w=5u l=0.5u ng=1 m=1
XXD2_XDFFM_XICKBB_MN XD2_XDFFM_CKBB XD2_XDFFM_CLKB VSS VSS sg13_hv_nmos w=2u l=0.5u ng=1 m=1
XXD2_XDFFM_XTG1_MN XD2_dmodout XD2_XDFFM_CLKB XD2_XDFFM_M VSS sg13_hv_nmos w=2u l=0.5u ng=1 m=1
XXD2_XDFFM_XTG1_MP XD2_XDFFM_M XD2_XDFFM_CKBB XD2_dmodout VDD_DIV sg13_hv_pmos w=5u l=0.5u ng=1 m=1
XXD2_XDFFM_XIM_MP XD2_XDFFM_MB XD2_XDFFM_M VDD_DIV VDD_DIV sg13_hv_pmos w=5u l=0.5u ng=1 m=1
XXD2_XDFFM_XIM_MN XD2_XDFFM_MB XD2_XDFFM_M VSS VSS sg13_hv_nmos w=2u l=0.5u ng=1 m=1
XXD2_XDFFM_XIMF_MP XD2_XDFFM_MFB XD2_XDFFM_MB VDD_DIV VDD_DIV sg13_hv_pmos w=5u l=0.5u ng=1 m=1
XXD2_XDFFM_XIMF_MN XD2_XDFFM_MFB XD2_XDFFM_MB VSS VSS sg13_hv_nmos w=2u l=0.5u ng=1 m=1
XXD2_XDFFM_XTGFBM_MN XD2_XDFFM_MFB XD2_XDFFM_CKBB XD2_XDFFM_M VSS sg13_hv_nmos w=2u l=0.5u ng=1 m=1
XXD2_XDFFM_XTGFBM_MP XD2_XDFFM_M XD2_XDFFM_CLKB XD2_XDFFM_MFB VDD_DIV sg13_hv_pmos w=5u l=0.5u ng=1 m=1
XXD2_XDFFM_XTG2_MN XD2_XDFFM_M XD2_XDFFM_CKBB XD2_XDFFM_S VSS sg13_hv_nmos w=2u l=0.5u ng=1 m=1
XXD2_XDFFM_XTG2_MP XD2_XDFFM_S XD2_XDFFM_CLKB XD2_XDFFM_M VDD_DIV sg13_hv_pmos w=5u l=0.5u ng=1 m=1
XXD2_XDFFM_XIS_MP XD2_XDFFM_SB XD2_XDFFM_S VDD_DIV VDD_DIV sg13_hv_pmos w=5u l=0.5u ng=1 m=1
XXD2_XDFFM_XIS_MN XD2_XDFFM_SB XD2_XDFFM_S VSS VSS sg13_hv_nmos w=2u l=0.5u ng=1 m=1
XXD2_XDFFM_XISF_MP XD2_XDFFM_SFB XD2_XDFFM_SB VDD_DIV VDD_DIV sg13_hv_pmos w=5u l=0.5u ng=1 m=1
XXD2_XDFFM_XISF_MN XD2_XDFFM_SFB XD2_XDFFM_SB VSS VSS sg13_hv_nmos w=2u l=0.5u ng=1 m=1
XXD2_XDFFM_XTGFBS_MN XD2_XDFFM_SFB XD2_XDFFM_CLKB XD2_XDFFM_S VSS sg13_hv_nmos w=2u l=0.5u ng=1 m=1
XXD2_XDFFM_XTGFBS_MP XD2_XDFFM_S XD2_XDFFM_CKBB XD2_XDFFM_SFB VDD_DIV sg13_hv_pmos w=5u l=0.5u ng=1 m=1
XXD2_XDFFM_XBQ_MP mod1 XD2_XDFFM_SB VDD_DIV VDD_DIV sg13_hv_pmos w=5u l=0.5u ng=1 m=1
XXD2_XDFFM_XBQ_MN mod1 XD2_XDFFM_SB VSS VSS sg13_hv_nmos w=2u l=0.5u ng=1 m=1
XXD3_XN3_MP1 XD3_nt mod3 VDD_DIV VDD_DIV sg13_hv_pmos w=5u l=0.5u ng=1 m=1
XXD3_XN3_MP2 XD3_nt P3 VDD_DIV VDD_DIV sg13_hv_pmos w=5u l=0.5u ng=1 m=1
XXD3_XN3_MP3 XD3_nt mod2 VDD_DIV VDD_DIV sg13_hv_pmos w=5u l=0.5u ng=1 m=1
XXD3_XN3_MN1 XD3_nt mod3 XD3_XN3_mid1 VSS sg13_hv_nmos w=2u l=0.5u ng=1 m=1
XXD3_XN3_MN2 XD3_XN3_mid1 P3 XD3_XN3_mid2 VSS sg13_hv_nmos w=2u l=0.5u ng=1 m=1
XXD3_XN3_MN3 XD3_XN3_mid2 mod2 VSS VSS sg13_hv_nmos w=2u l=0.5u ng=1 m=1
XXD3_XI1_MP XD3_t1 XD3_nt VDD_DIV VDD_DIV sg13_hv_pmos w=5u l=0.5u ng=1 m=1
XXD3_XI1_MN XD3_t1 XD3_nt VSS VSS sg13_hv_nmos w=2u l=0.5u ng=1 m=1
XXD3_XNOR_MP1 XD3_XNOR_midp ck4 VDD_DIV VDD_DIV sg13_hv_pmos w=5u l=0.5u ng=1 m=1
XXD3_XNOR_MP2 XD3_dq XD3_t1 XD3_XNOR_midp VDD_DIV sg13_hv_pmos w=5u l=0.5u ng=1 m=1
XXD3_XNOR_MN1 XD3_dq ck4 VSS VSS sg13_hv_nmos w=2u l=0.5u ng=1 m=1
XXD3_XNOR_MN2 XD3_dq XD3_t1 VSS VSS sg13_hv_nmos w=2u l=0.5u ng=1 m=1
XXD3_XDFFQ_XICLK_MP XD3_XDFFQ_CLKB ck3 VDD_DIV VDD_DIV sg13_hv_pmos w=5u l=0.5u ng=1 m=1
XXD3_XDFFQ_XICLK_MN XD3_XDFFQ_CLKB ck3 VSS VSS sg13_hv_nmos w=2u l=0.5u ng=1 m=1
XXD3_XDFFQ_XICKBB_MP XD3_XDFFQ_CKBB XD3_XDFFQ_CLKB VDD_DIV VDD_DIV sg13_hv_pmos w=5u l=0.5u ng=1 m=1
XXD3_XDFFQ_XICKBB_MN XD3_XDFFQ_CKBB XD3_XDFFQ_CLKB VSS VSS sg13_hv_nmos w=2u l=0.5u ng=1 m=1
XXD3_XDFFQ_XTG1_MN XD3_dq XD3_XDFFQ_CLKB XD3_XDFFQ_M VSS sg13_hv_nmos w=2u l=0.5u ng=1 m=1
XXD3_XDFFQ_XTG1_MP XD3_XDFFQ_M XD3_XDFFQ_CKBB XD3_dq VDD_DIV sg13_hv_pmos w=5u l=0.5u ng=1 m=1
XXD3_XDFFQ_XIM_MP XD3_XDFFQ_MB XD3_XDFFQ_M VDD_DIV VDD_DIV sg13_hv_pmos w=5u l=0.5u ng=1 m=1
XXD3_XDFFQ_XIM_MN XD3_XDFFQ_MB XD3_XDFFQ_M VSS VSS sg13_hv_nmos w=2u l=0.5u ng=1 m=1
XXD3_XDFFQ_XIMF_MP XD3_XDFFQ_MFB XD3_XDFFQ_MB VDD_DIV VDD_DIV sg13_hv_pmos w=5u l=0.5u ng=1 m=1
XXD3_XDFFQ_XIMF_MN XD3_XDFFQ_MFB XD3_XDFFQ_MB VSS VSS sg13_hv_nmos w=2u l=0.5u ng=1 m=1
XXD3_XDFFQ_XTGFBM_MN XD3_XDFFQ_MFB XD3_XDFFQ_CKBB XD3_XDFFQ_M VSS sg13_hv_nmos w=2u l=0.5u ng=1 m=1
XXD3_XDFFQ_XTGFBM_MP XD3_XDFFQ_M XD3_XDFFQ_CLKB XD3_XDFFQ_MFB VDD_DIV sg13_hv_pmos w=5u l=0.5u ng=1 m=1
XXD3_XDFFQ_XTG2_MN XD3_XDFFQ_M XD3_XDFFQ_CKBB XD3_XDFFQ_S VSS sg13_hv_nmos w=2u l=0.5u ng=1 m=1
XXD3_XDFFQ_XTG2_MP XD3_XDFFQ_S XD3_XDFFQ_CLKB XD3_XDFFQ_M VDD_DIV sg13_hv_pmos w=5u l=0.5u ng=1 m=1
XXD3_XDFFQ_XIS_MP XD3_XDFFQ_SB XD3_XDFFQ_S VDD_DIV VDD_DIV sg13_hv_pmos w=5u l=0.5u ng=1 m=1
XXD3_XDFFQ_XIS_MN XD3_XDFFQ_SB XD3_XDFFQ_S VSS VSS sg13_hv_nmos w=2u l=0.5u ng=1 m=1
XXD3_XDFFQ_XISF_MP XD3_XDFFQ_SFB XD3_XDFFQ_SB VDD_DIV VDD_DIV sg13_hv_pmos w=5u l=0.5u ng=1 m=1
XXD3_XDFFQ_XISF_MN XD3_XDFFQ_SFB XD3_XDFFQ_SB VSS VSS sg13_hv_nmos w=2u l=0.5u ng=1 m=1
XXD3_XDFFQ_XTGFBS_MN XD3_XDFFQ_SFB XD3_XDFFQ_CLKB XD3_XDFFQ_S VSS sg13_hv_nmos w=2u l=0.5u ng=1 m=1
XXD3_XDFFQ_XTGFBS_MP XD3_XDFFQ_S XD3_XDFFQ_CKBB XD3_XDFFQ_SFB VDD_DIV sg13_hv_pmos w=5u l=0.5u ng=1 m=1
XXD3_XDFFQ_XBQ_MP ck4 XD3_XDFFQ_SB VDD_DIV VDD_DIV sg13_hv_pmos w=5u l=0.5u ng=1 m=1
XXD3_XDFFQ_XBQ_MN ck4 XD3_XDFFQ_SB VSS VSS sg13_hv_nmos w=2u l=0.5u ng=1 m=1
XXD3_XN2_MP1 XD3_nm mod3 VDD_DIV VDD_DIV sg13_hv_pmos w=5u l=0.5u ng=1 m=1
XXD3_XN2_MP2 XD3_nm ck4 VDD_DIV VDD_DIV sg13_hv_pmos w=5u l=0.5u ng=1 m=1
XXD3_XN2_MN1 XD3_nm mod3 XD3_XN2_mid1 VSS sg13_hv_nmos w=2u l=0.5u ng=1 m=1
XXD3_XN2_MN2 XD3_XN2_mid1 ck4 VSS VSS sg13_hv_nmos w=2u l=0.5u ng=1 m=1
XXD3_XI2_MP XD3_dmodout XD3_nm VDD_DIV VDD_DIV sg13_hv_pmos w=5u l=0.5u ng=1 m=1
XXD3_XI2_MN XD3_dmodout XD3_nm VSS VSS sg13_hv_nmos w=2u l=0.5u ng=1 m=1
XXD3_XDFFM_XICLK_MP XD3_XDFFM_CLKB ck3 VDD_DIV VDD_DIV sg13_hv_pmos w=5u l=0.5u ng=1 m=1
XXD3_XDFFM_XICLK_MN XD3_XDFFM_CLKB ck3 VSS VSS sg13_hv_nmos w=2u l=0.5u ng=1 m=1
XXD3_XDFFM_XICKBB_MP XD3_XDFFM_CKBB XD3_XDFFM_CLKB VDD_DIV VDD_DIV sg13_hv_pmos w=5u l=0.5u ng=1 m=1
XXD3_XDFFM_XICKBB_MN XD3_XDFFM_CKBB XD3_XDFFM_CLKB VSS VSS sg13_hv_nmos w=2u l=0.5u ng=1 m=1
XXD3_XDFFM_XTG1_MN XD3_dmodout XD3_XDFFM_CLKB XD3_XDFFM_M VSS sg13_hv_nmos w=2u l=0.5u ng=1 m=1
XXD3_XDFFM_XTG1_MP XD3_XDFFM_M XD3_XDFFM_CKBB XD3_dmodout VDD_DIV sg13_hv_pmos w=5u l=0.5u ng=1 m=1
XXD3_XDFFM_XIM_MP XD3_XDFFM_MB XD3_XDFFM_M VDD_DIV VDD_DIV sg13_hv_pmos w=5u l=0.5u ng=1 m=1
XXD3_XDFFM_XIM_MN XD3_XDFFM_MB XD3_XDFFM_M VSS VSS sg13_hv_nmos w=2u l=0.5u ng=1 m=1
XXD3_XDFFM_XIMF_MP XD3_XDFFM_MFB XD3_XDFFM_MB VDD_DIV VDD_DIV sg13_hv_pmos w=5u l=0.5u ng=1 m=1
XXD3_XDFFM_XIMF_MN XD3_XDFFM_MFB XD3_XDFFM_MB VSS VSS sg13_hv_nmos w=2u l=0.5u ng=1 m=1
XXD3_XDFFM_XTGFBM_MN XD3_XDFFM_MFB XD3_XDFFM_CKBB XD3_XDFFM_M VSS sg13_hv_nmos w=2u l=0.5u ng=1 m=1
XXD3_XDFFM_XTGFBM_MP XD3_XDFFM_M XD3_XDFFM_CLKB XD3_XDFFM_MFB VDD_DIV sg13_hv_pmos w=5u l=0.5u ng=1 m=1
XXD3_XDFFM_XTG2_MN XD3_XDFFM_M XD3_XDFFM_CKBB XD3_XDFFM_S VSS sg13_hv_nmos w=2u l=0.5u ng=1 m=1
XXD3_XDFFM_XTG2_MP XD3_XDFFM_S XD3_XDFFM_CLKB XD3_XDFFM_M VDD_DIV sg13_hv_pmos w=5u l=0.5u ng=1 m=1
XXD3_XDFFM_XIS_MP XD3_XDFFM_SB XD3_XDFFM_S VDD_DIV VDD_DIV sg13_hv_pmos w=5u l=0.5u ng=1 m=1
XXD3_XDFFM_XIS_MN XD3_XDFFM_SB XD3_XDFFM_S VSS VSS sg13_hv_nmos w=2u l=0.5u ng=1 m=1
XXD3_XDFFM_XISF_MP XD3_XDFFM_SFB XD3_XDFFM_SB VDD_DIV VDD_DIV sg13_hv_pmos w=5u l=0.5u ng=1 m=1
XXD3_XDFFM_XISF_MN XD3_XDFFM_SFB XD3_XDFFM_SB VSS VSS sg13_hv_nmos w=2u l=0.5u ng=1 m=1
XXD3_XDFFM_XTGFBS_MN XD3_XDFFM_SFB XD3_XDFFM_CLKB XD3_XDFFM_S VSS sg13_hv_nmos w=2u l=0.5u ng=1 m=1
XXD3_XDFFM_XTGFBS_MP XD3_XDFFM_S XD3_XDFFM_CKBB XD3_XDFFM_SFB VDD_DIV sg13_hv_pmos w=5u l=0.5u ng=1 m=1
XXD3_XDFFM_XBQ_MP mod2 XD3_XDFFM_SB VDD_DIV VDD_DIV sg13_hv_pmos w=5u l=0.5u ng=1 m=1
XXD3_XDFFM_XBQ_MN mod2 XD3_XDFFM_SB VSS VSS sg13_hv_nmos w=2u l=0.5u ng=1 m=1
XXD4_XN3_MP1 XD4_nt mod4 VDD_DIV VDD_DIV sg13_hv_pmos w=5u l=0.5u ng=1 m=1
XXD4_XN3_MP2 XD4_nt P4 VDD_DIV VDD_DIV sg13_hv_pmos w=5u l=0.5u ng=1 m=1
XXD4_XN3_MP3 XD4_nt mod3 VDD_DIV VDD_DIV sg13_hv_pmos w=5u l=0.5u ng=1 m=1
XXD4_XN3_MN1 XD4_nt mod4 XD4_XN3_mid1 VSS sg13_hv_nmos w=2u l=0.5u ng=1 m=1
XXD4_XN3_MN2 XD4_XN3_mid1 P4 XD4_XN3_mid2 VSS sg13_hv_nmos w=2u l=0.5u ng=1 m=1
XXD4_XN3_MN3 XD4_XN3_mid2 mod3 VSS VSS sg13_hv_nmos w=2u l=0.5u ng=1 m=1
XXD4_XI1_MP XD4_t1 XD4_nt VDD_DIV VDD_DIV sg13_hv_pmos w=5u l=0.5u ng=1 m=1
XXD4_XI1_MN XD4_t1 XD4_nt VSS VSS sg13_hv_nmos w=2u l=0.5u ng=1 m=1
XXD4_XNOR_MP1 XD4_XNOR_midp ck5 VDD_DIV VDD_DIV sg13_hv_pmos w=5u l=0.5u ng=1 m=1
XXD4_XNOR_MP2 XD4_dq XD4_t1 XD4_XNOR_midp VDD_DIV sg13_hv_pmos w=5u l=0.5u ng=1 m=1
XXD4_XNOR_MN1 XD4_dq ck5 VSS VSS sg13_hv_nmos w=2u l=0.5u ng=1 m=1
XXD4_XNOR_MN2 XD4_dq XD4_t1 VSS VSS sg13_hv_nmos w=2u l=0.5u ng=1 m=1
XXD4_XDFFQ_XICLK_MP XD4_XDFFQ_CLKB ck4 VDD_DIV VDD_DIV sg13_hv_pmos w=5u l=0.5u ng=1 m=1
XXD4_XDFFQ_XICLK_MN XD4_XDFFQ_CLKB ck4 VSS VSS sg13_hv_nmos w=2u l=0.5u ng=1 m=1
XXD4_XDFFQ_XICKBB_MP XD4_XDFFQ_CKBB XD4_XDFFQ_CLKB VDD_DIV VDD_DIV sg13_hv_pmos w=5u l=0.5u ng=1 m=1
XXD4_XDFFQ_XICKBB_MN XD4_XDFFQ_CKBB XD4_XDFFQ_CLKB VSS VSS sg13_hv_nmos w=2u l=0.5u ng=1 m=1
XXD4_XDFFQ_XTG1_MN XD4_dq XD4_XDFFQ_CLKB XD4_XDFFQ_M VSS sg13_hv_nmos w=2u l=0.5u ng=1 m=1
XXD4_XDFFQ_XTG1_MP XD4_XDFFQ_M XD4_XDFFQ_CKBB XD4_dq VDD_DIV sg13_hv_pmos w=5u l=0.5u ng=1 m=1
XXD4_XDFFQ_XIM_MP XD4_XDFFQ_MB XD4_XDFFQ_M VDD_DIV VDD_DIV sg13_hv_pmos w=5u l=0.5u ng=1 m=1
XXD4_XDFFQ_XIM_MN XD4_XDFFQ_MB XD4_XDFFQ_M VSS VSS sg13_hv_nmos w=2u l=0.5u ng=1 m=1
XXD4_XDFFQ_XIMF_MP XD4_XDFFQ_MFB XD4_XDFFQ_MB VDD_DIV VDD_DIV sg13_hv_pmos w=5u l=0.5u ng=1 m=1
XXD4_XDFFQ_XIMF_MN XD4_XDFFQ_MFB XD4_XDFFQ_MB VSS VSS sg13_hv_nmos w=2u l=0.5u ng=1 m=1
XXD4_XDFFQ_XTGFBM_MN XD4_XDFFQ_MFB XD4_XDFFQ_CKBB XD4_XDFFQ_M VSS sg13_hv_nmos w=2u l=0.5u ng=1 m=1
XXD4_XDFFQ_XTGFBM_MP XD4_XDFFQ_M XD4_XDFFQ_CLKB XD4_XDFFQ_MFB VDD_DIV sg13_hv_pmos w=5u l=0.5u ng=1 m=1
XXD4_XDFFQ_XTG2_MN XD4_XDFFQ_M XD4_XDFFQ_CKBB XD4_XDFFQ_S VSS sg13_hv_nmos w=2u l=0.5u ng=1 m=1
XXD4_XDFFQ_XTG2_MP XD4_XDFFQ_S XD4_XDFFQ_CLKB XD4_XDFFQ_M VDD_DIV sg13_hv_pmos w=5u l=0.5u ng=1 m=1
XXD4_XDFFQ_XIS_MP XD4_XDFFQ_SB XD4_XDFFQ_S VDD_DIV VDD_DIV sg13_hv_pmos w=5u l=0.5u ng=1 m=1
XXD4_XDFFQ_XIS_MN XD4_XDFFQ_SB XD4_XDFFQ_S VSS VSS sg13_hv_nmos w=2u l=0.5u ng=1 m=1
XXD4_XDFFQ_XISF_MP XD4_XDFFQ_SFB XD4_XDFFQ_SB VDD_DIV VDD_DIV sg13_hv_pmos w=5u l=0.5u ng=1 m=1
XXD4_XDFFQ_XISF_MN XD4_XDFFQ_SFB XD4_XDFFQ_SB VSS VSS sg13_hv_nmos w=2u l=0.5u ng=1 m=1
XXD4_XDFFQ_XTGFBS_MN XD4_XDFFQ_SFB XD4_XDFFQ_CLKB XD4_XDFFQ_S VSS sg13_hv_nmos w=2u l=0.5u ng=1 m=1
XXD4_XDFFQ_XTGFBS_MP XD4_XDFFQ_S XD4_XDFFQ_CKBB XD4_XDFFQ_SFB VDD_DIV sg13_hv_pmos w=5u l=0.5u ng=1 m=1
XXD4_XDFFQ_XBQ_MP ck5 XD4_XDFFQ_SB VDD_DIV VDD_DIV sg13_hv_pmos w=5u l=0.5u ng=1 m=1
XXD4_XDFFQ_XBQ_MN ck5 XD4_XDFFQ_SB VSS VSS sg13_hv_nmos w=2u l=0.5u ng=1 m=1
XXD4_XN2_MP1 XD4_nm mod4 VDD_DIV VDD_DIV sg13_hv_pmos w=5u l=0.5u ng=1 m=1
XXD4_XN2_MP2 XD4_nm ck5 VDD_DIV VDD_DIV sg13_hv_pmos w=5u l=0.5u ng=1 m=1
XXD4_XN2_MN1 XD4_nm mod4 XD4_XN2_mid1 VSS sg13_hv_nmos w=2u l=0.5u ng=1 m=1
XXD4_XN2_MN2 XD4_XN2_mid1 ck5 VSS VSS sg13_hv_nmos w=2u l=0.5u ng=1 m=1
XXD4_XI2_MP XD4_dmodout XD4_nm VDD_DIV VDD_DIV sg13_hv_pmos w=5u l=0.5u ng=1 m=1
XXD4_XI2_MN XD4_dmodout XD4_nm VSS VSS sg13_hv_nmos w=2u l=0.5u ng=1 m=1
XXD4_XDFFM_XICLK_MP XD4_XDFFM_CLKB ck4 VDD_DIV VDD_DIV sg13_hv_pmos w=5u l=0.5u ng=1 m=1
XXD4_XDFFM_XICLK_MN XD4_XDFFM_CLKB ck4 VSS VSS sg13_hv_nmos w=2u l=0.5u ng=1 m=1
XXD4_XDFFM_XICKBB_MP XD4_XDFFM_CKBB XD4_XDFFM_CLKB VDD_DIV VDD_DIV sg13_hv_pmos w=5u l=0.5u ng=1 m=1
XXD4_XDFFM_XICKBB_MN XD4_XDFFM_CKBB XD4_XDFFM_CLKB VSS VSS sg13_hv_nmos w=2u l=0.5u ng=1 m=1
XXD4_XDFFM_XTG1_MN XD4_dmodout XD4_XDFFM_CLKB XD4_XDFFM_M VSS sg13_hv_nmos w=2u l=0.5u ng=1 m=1
XXD4_XDFFM_XTG1_MP XD4_XDFFM_M XD4_XDFFM_CKBB XD4_dmodout VDD_DIV sg13_hv_pmos w=5u l=0.5u ng=1 m=1
XXD4_XDFFM_XIM_MP XD4_XDFFM_MB XD4_XDFFM_M VDD_DIV VDD_DIV sg13_hv_pmos w=5u l=0.5u ng=1 m=1
XXD4_XDFFM_XIM_MN XD4_XDFFM_MB XD4_XDFFM_M VSS VSS sg13_hv_nmos w=2u l=0.5u ng=1 m=1
XXD4_XDFFM_XIMF_MP XD4_XDFFM_MFB XD4_XDFFM_MB VDD_DIV VDD_DIV sg13_hv_pmos w=5u l=0.5u ng=1 m=1
XXD4_XDFFM_XIMF_MN XD4_XDFFM_MFB XD4_XDFFM_MB VSS VSS sg13_hv_nmos w=2u l=0.5u ng=1 m=1
XXD4_XDFFM_XTGFBM_MN XD4_XDFFM_MFB XD4_XDFFM_CKBB XD4_XDFFM_M VSS sg13_hv_nmos w=2u l=0.5u ng=1 m=1
XXD4_XDFFM_XTGFBM_MP XD4_XDFFM_M XD4_XDFFM_CLKB XD4_XDFFM_MFB VDD_DIV sg13_hv_pmos w=5u l=0.5u ng=1 m=1
XXD4_XDFFM_XTG2_MN XD4_XDFFM_M XD4_XDFFM_CKBB XD4_XDFFM_S VSS sg13_hv_nmos w=2u l=0.5u ng=1 m=1
XXD4_XDFFM_XTG2_MP XD4_XDFFM_S XD4_XDFFM_CLKB XD4_XDFFM_M VDD_DIV sg13_hv_pmos w=5u l=0.5u ng=1 m=1
XXD4_XDFFM_XIS_MP XD4_XDFFM_SB XD4_XDFFM_S VDD_DIV VDD_DIV sg13_hv_pmos w=5u l=0.5u ng=1 m=1
XXD4_XDFFM_XIS_MN XD4_XDFFM_SB XD4_XDFFM_S VSS VSS sg13_hv_nmos w=2u l=0.5u ng=1 m=1
XXD4_XDFFM_XISF_MP XD4_XDFFM_SFB XD4_XDFFM_SB VDD_DIV VDD_DIV sg13_hv_pmos w=5u l=0.5u ng=1 m=1
XXD4_XDFFM_XISF_MN XD4_XDFFM_SFB XD4_XDFFM_SB VSS VSS sg13_hv_nmos w=2u l=0.5u ng=1 m=1
XXD4_XDFFM_XTGFBS_MN XD4_XDFFM_SFB XD4_XDFFM_CLKB XD4_XDFFM_S VSS sg13_hv_nmos w=2u l=0.5u ng=1 m=1
XXD4_XDFFM_XTGFBS_MP XD4_XDFFM_S XD4_XDFFM_CKBB XD4_XDFFM_SFB VDD_DIV sg13_hv_pmos w=5u l=0.5u ng=1 m=1
XXD4_XDFFM_XBQ_MP mod3 XD4_XDFFM_SB VDD_DIV VDD_DIV sg13_hv_pmos w=5u l=0.5u ng=1 m=1
XXD4_XDFFM_XBQ_MN mod3 XD4_XDFFM_SB VSS VSS sg13_hv_nmos w=2u l=0.5u ng=1 m=1
XXD5_XN3_MP1 XD5_nt VDD_DIV VDD_DIV VDD_DIV sg13_hv_pmos w=5u l=0.5u ng=1 m=1
XXD5_XN3_MP2 XD5_nt P5 VDD_DIV VDD_DIV sg13_hv_pmos w=5u l=0.5u ng=1 m=1
XXD5_XN3_MP3 XD5_nt mod4 VDD_DIV VDD_DIV sg13_hv_pmos w=5u l=0.5u ng=1 m=1
XXD5_XN3_MN1 XD5_nt VDD_DIV XD5_XN3_mid1 VSS sg13_hv_nmos w=2u l=0.5u ng=1 m=1
XXD5_XN3_MN2 XD5_XN3_mid1 P5 XD5_XN3_mid2 VSS sg13_hv_nmos w=2u l=0.5u ng=1 m=1
XXD5_XN3_MN3 XD5_XN3_mid2 mod4 VSS VSS sg13_hv_nmos w=2u l=0.5u ng=1 m=1
XXD5_XI1_MP XD5_t1 XD5_nt VDD_DIV VDD_DIV sg13_hv_pmos w=5u l=0.5u ng=1 m=1
XXD5_XI1_MN XD5_t1 XD5_nt VSS VSS sg13_hv_nmos w=2u l=0.5u ng=1 m=1
XXD5_XNOR_MP1 XD5_XNOR_midp DIVOUT VDD_DIV VDD_DIV sg13_hv_pmos w=5u l=0.5u ng=1 m=1
XXD5_XNOR_MP2 XD5_dq XD5_t1 XD5_XNOR_midp VDD_DIV sg13_hv_pmos w=5u l=0.5u ng=1 m=1
XXD5_XNOR_MN1 XD5_dq DIVOUT VSS VSS sg13_hv_nmos w=2u l=0.5u ng=1 m=1
XXD5_XNOR_MN2 XD5_dq XD5_t1 VSS VSS sg13_hv_nmos w=2u l=0.5u ng=1 m=1
XXD5_XDFFQ_XICLK_MP XD5_XDFFQ_CLKB ck5 VDD_DIV VDD_DIV sg13_hv_pmos w=5u l=0.5u ng=1 m=1
XXD5_XDFFQ_XICLK_MN XD5_XDFFQ_CLKB ck5 VSS VSS sg13_hv_nmos w=2u l=0.5u ng=1 m=1
XXD5_XDFFQ_XICKBB_MP XD5_XDFFQ_CKBB XD5_XDFFQ_CLKB VDD_DIV VDD_DIV sg13_hv_pmos w=5u l=0.5u ng=1 m=1
XXD5_XDFFQ_XICKBB_MN XD5_XDFFQ_CKBB XD5_XDFFQ_CLKB VSS VSS sg13_hv_nmos w=2u l=0.5u ng=1 m=1
XXD5_XDFFQ_XTG1_MN XD5_dq XD5_XDFFQ_CLKB XD5_XDFFQ_M VSS sg13_hv_nmos w=2u l=0.5u ng=1 m=1
XXD5_XDFFQ_XTG1_MP XD5_XDFFQ_M XD5_XDFFQ_CKBB XD5_dq VDD_DIV sg13_hv_pmos w=5u l=0.5u ng=1 m=1
XXD5_XDFFQ_XIM_MP XD5_XDFFQ_MB XD5_XDFFQ_M VDD_DIV VDD_DIV sg13_hv_pmos w=5u l=0.5u ng=1 m=1
XXD5_XDFFQ_XIM_MN XD5_XDFFQ_MB XD5_XDFFQ_M VSS VSS sg13_hv_nmos w=2u l=0.5u ng=1 m=1
XXD5_XDFFQ_XIMF_MP XD5_XDFFQ_MFB XD5_XDFFQ_MB VDD_DIV VDD_DIV sg13_hv_pmos w=5u l=0.5u ng=1 m=1
XXD5_XDFFQ_XIMF_MN XD5_XDFFQ_MFB XD5_XDFFQ_MB VSS VSS sg13_hv_nmos w=2u l=0.5u ng=1 m=1
XXD5_XDFFQ_XTGFBM_MN XD5_XDFFQ_MFB XD5_XDFFQ_CKBB XD5_XDFFQ_M VSS sg13_hv_nmos w=2u l=0.5u ng=1 m=1
XXD5_XDFFQ_XTGFBM_MP XD5_XDFFQ_M XD5_XDFFQ_CLKB XD5_XDFFQ_MFB VDD_DIV sg13_hv_pmos w=5u l=0.5u ng=1 m=1
XXD5_XDFFQ_XTG2_MN XD5_XDFFQ_M XD5_XDFFQ_CKBB XD5_XDFFQ_S VSS sg13_hv_nmos w=2u l=0.5u ng=1 m=1
XXD5_XDFFQ_XTG2_MP XD5_XDFFQ_S XD5_XDFFQ_CLKB XD5_XDFFQ_M VDD_DIV sg13_hv_pmos w=5u l=0.5u ng=1 m=1
XXD5_XDFFQ_XIS_MP XD5_XDFFQ_SB XD5_XDFFQ_S VDD_DIV VDD_DIV sg13_hv_pmos w=5u l=0.5u ng=1 m=1
XXD5_XDFFQ_XIS_MN XD5_XDFFQ_SB XD5_XDFFQ_S VSS VSS sg13_hv_nmos w=2u l=0.5u ng=1 m=1
XXD5_XDFFQ_XISF_MP XD5_XDFFQ_SFB XD5_XDFFQ_SB VDD_DIV VDD_DIV sg13_hv_pmos w=5u l=0.5u ng=1 m=1
XXD5_XDFFQ_XISF_MN XD5_XDFFQ_SFB XD5_XDFFQ_SB VSS VSS sg13_hv_nmos w=2u l=0.5u ng=1 m=1
XXD5_XDFFQ_XTGFBS_MN XD5_XDFFQ_SFB XD5_XDFFQ_CLKB XD5_XDFFQ_S VSS sg13_hv_nmos w=2u l=0.5u ng=1 m=1
XXD5_XDFFQ_XTGFBS_MP XD5_XDFFQ_S XD5_XDFFQ_CKBB XD5_XDFFQ_SFB VDD_DIV sg13_hv_pmos w=5u l=0.5u ng=1 m=1
XXD5_XDFFQ_XBQ_MP DIVOUT XD5_XDFFQ_SB VDD_DIV VDD_DIV sg13_hv_pmos w=5u l=0.5u ng=1 m=1
XXD5_XDFFQ_XBQ_MN DIVOUT XD5_XDFFQ_SB VSS VSS sg13_hv_nmos w=2u l=0.5u ng=1 m=1
XXD5_XN2_MP1 XD5_nm VDD_DIV VDD_DIV VDD_DIV sg13_hv_pmos w=5u l=0.5u ng=1 m=1
XXD5_XN2_MP2 XD5_nm DIVOUT VDD_DIV VDD_DIV sg13_hv_pmos w=5u l=0.5u ng=1 m=1
XXD5_XN2_MN1 XD5_nm VDD_DIV XD5_XN2_mid1 VSS sg13_hv_nmos w=2u l=0.5u ng=1 m=1
XXD5_XN2_MN2 XD5_XN2_mid1 DIVOUT VSS VSS sg13_hv_nmos w=2u l=0.5u ng=1 m=1
XXD5_XI2_MP XD5_dmodout XD5_nm VDD_DIV VDD_DIV sg13_hv_pmos w=5u l=0.5u ng=1 m=1
XXD5_XI2_MN XD5_dmodout XD5_nm VSS VSS sg13_hv_nmos w=2u l=0.5u ng=1 m=1
XXD5_XDFFM_XICLK_MP XD5_XDFFM_CLKB ck5 VDD_DIV VDD_DIV sg13_hv_pmos w=5u l=0.5u ng=1 m=1
XXD5_XDFFM_XICLK_MN XD5_XDFFM_CLKB ck5 VSS VSS sg13_hv_nmos w=2u l=0.5u ng=1 m=1
XXD5_XDFFM_XICKBB_MP XD5_XDFFM_CKBB XD5_XDFFM_CLKB VDD_DIV VDD_DIV sg13_hv_pmos w=5u l=0.5u ng=1 m=1
XXD5_XDFFM_XICKBB_MN XD5_XDFFM_CKBB XD5_XDFFM_CLKB VSS VSS sg13_hv_nmos w=2u l=0.5u ng=1 m=1
XXD5_XDFFM_XTG1_MN XD5_dmodout XD5_XDFFM_CLKB XD5_XDFFM_M VSS sg13_hv_nmos w=2u l=0.5u ng=1 m=1
XXD5_XDFFM_XTG1_MP XD5_XDFFM_M XD5_XDFFM_CKBB XD5_dmodout VDD_DIV sg13_hv_pmos w=5u l=0.5u ng=1 m=1
XXD5_XDFFM_XIM_MP XD5_XDFFM_MB XD5_XDFFM_M VDD_DIV VDD_DIV sg13_hv_pmos w=5u l=0.5u ng=1 m=1
XXD5_XDFFM_XIM_MN XD5_XDFFM_MB XD5_XDFFM_M VSS VSS sg13_hv_nmos w=2u l=0.5u ng=1 m=1
XXD5_XDFFM_XIMF_MP XD5_XDFFM_MFB XD5_XDFFM_MB VDD_DIV VDD_DIV sg13_hv_pmos w=5u l=0.5u ng=1 m=1
XXD5_XDFFM_XIMF_MN XD5_XDFFM_MFB XD5_XDFFM_MB VSS VSS sg13_hv_nmos w=2u l=0.5u ng=1 m=1
XXD5_XDFFM_XTGFBM_MN XD5_XDFFM_MFB XD5_XDFFM_CKBB XD5_XDFFM_M VSS sg13_hv_nmos w=2u l=0.5u ng=1 m=1
XXD5_XDFFM_XTGFBM_MP XD5_XDFFM_M XD5_XDFFM_CLKB XD5_XDFFM_MFB VDD_DIV sg13_hv_pmos w=5u l=0.5u ng=1 m=1
XXD5_XDFFM_XTG2_MN XD5_XDFFM_M XD5_XDFFM_CKBB XD5_XDFFM_S VSS sg13_hv_nmos w=2u l=0.5u ng=1 m=1
XXD5_XDFFM_XTG2_MP XD5_XDFFM_S XD5_XDFFM_CLKB XD5_XDFFM_M VDD_DIV sg13_hv_pmos w=5u l=0.5u ng=1 m=1
XXD5_XDFFM_XIS_MP XD5_XDFFM_SB XD5_XDFFM_S VDD_DIV VDD_DIV sg13_hv_pmos w=5u l=0.5u ng=1 m=1
XXD5_XDFFM_XIS_MN XD5_XDFFM_SB XD5_XDFFM_S VSS VSS sg13_hv_nmos w=2u l=0.5u ng=1 m=1
XXD5_XDFFM_XISF_MP XD5_XDFFM_SFB XD5_XDFFM_SB VDD_DIV VDD_DIV sg13_hv_pmos w=5u l=0.5u ng=1 m=1
XXD5_XDFFM_XISF_MN XD5_XDFFM_SFB XD5_XDFFM_SB VSS VSS sg13_hv_nmos w=2u l=0.5u ng=1 m=1
XXD5_XDFFM_XTGFBS_MN XD5_XDFFM_SFB XD5_XDFFM_CLKB XD5_XDFFM_S VSS sg13_hv_nmos w=2u l=0.5u ng=1 m=1
XXD5_XDFFM_XTGFBS_MP XD5_XDFFM_S XD5_XDFFM_CKBB XD5_XDFFM_SFB VDD_DIV sg13_hv_pmos w=5u l=0.5u ng=1 m=1
XXD5_XDFFM_XBQ_MP mod4 XD5_XDFFM_SB VDD_DIV VDD_DIV sg13_hv_pmos w=5u l=0.5u ng=1 m=1
XXD5_XDFFM_XBQ_MN mod4 XD5_XDFFM_SB VSS VSS sg13_hv_nmos w=2u l=0.5u ng=1 m=1
XXFRT_XICLK_MP XFRT_CLKB CKIN_VCO VDD_DIV VDD_DIV sg13_hv_pmos w=5u l=0.5u ng=1 m=1
XXFRT_XICLK_MN XFRT_CLKB CKIN_VCO VSS VSS sg13_hv_nmos w=2u l=0.5u ng=1 m=1
XXFRT_XICKBB_MP XFRT_CKBB XFRT_CLKB VDD_DIV VDD_DIV sg13_hv_pmos w=5u l=0.5u ng=1 m=1
XXFRT_XICKBB_MN XFRT_CKBB XFRT_CLKB VSS VSS sg13_hv_nmos w=2u l=0.5u ng=1 m=1
XXFRT_XTG1_MN DIVOUT XFRT_CLKB XFRT_M VSS sg13_hv_nmos w=2u l=0.5u ng=1 m=1
XXFRT_XTG1_MP XFRT_M XFRT_CKBB DIVOUT VDD_DIV sg13_hv_pmos w=5u l=0.5u ng=1 m=1
XXFRT_XIM_MP XFRT_MB XFRT_M VDD_DIV VDD_DIV sg13_hv_pmos w=5u l=0.5u ng=1 m=1
XXFRT_XIM_MN XFRT_MB XFRT_M VSS VSS sg13_hv_nmos w=2u l=0.5u ng=1 m=1
XXFRT_XIMF_MP XFRT_MFB XFRT_MB VDD_DIV VDD_DIV sg13_hv_pmos w=5u l=0.5u ng=1 m=1
XXFRT_XIMF_MN XFRT_MFB XFRT_MB VSS VSS sg13_hv_nmos w=2u l=0.5u ng=1 m=1
XXFRT_XTGFBM_MN XFRT_MFB XFRT_CKBB XFRT_M VSS sg13_hv_nmos w=2u l=0.5u ng=1 m=1
XXFRT_XTGFBM_MP XFRT_M XFRT_CLKB XFRT_MFB VDD_DIV sg13_hv_pmos w=5u l=0.5u ng=1 m=1
XXFRT_XTG2_MN XFRT_M XFRT_CKBB XFRT_S VSS sg13_hv_nmos w=2u l=0.5u ng=1 m=1
XXFRT_XTG2_MP XFRT_S XFRT_CLKB XFRT_M VDD_DIV sg13_hv_pmos w=5u l=0.5u ng=1 m=1
XXFRT_XIS_MP XFRT_SB XFRT_S VDD_DIV VDD_DIV sg13_hv_pmos w=5u l=0.5u ng=1 m=1
XXFRT_XIS_MN XFRT_SB XFRT_S VSS VSS sg13_hv_nmos w=2u l=0.5u ng=1 m=1
XXFRT_XISF_MP XFRT_SFB XFRT_SB VDD_DIV VDD_DIV sg13_hv_pmos w=5u l=0.5u ng=1 m=1
XXFRT_XISF_MN XFRT_SFB XFRT_SB VSS VSS sg13_hv_nmos w=2u l=0.5u ng=1 m=1
XXFRT_XTGFBS_MN XFRT_SFB XFRT_CLKB XFRT_S VSS sg13_hv_nmos w=2u l=0.5u ng=1 m=1
XXFRT_XTGFBS_MP XFRT_S XFRT_CKBB XFRT_SFB VDD_DIV sg13_hv_pmos w=5u l=0.5u ng=1 m=1
XXFRT_XBQ_MP FB XFRT_SB VDD_DIV VDD_DIV sg13_hv_pmos w=5u l=0.5u ng=1 m=1
XXFRT_XBQ_MN FB XFRT_SB VSS VSS sg13_hv_nmos w=2u l=0.5u ng=1 m=1
.ends pll_divider_chain
