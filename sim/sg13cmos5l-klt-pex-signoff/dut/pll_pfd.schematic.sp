* flattened from ../../design/sg13cmos5l/netlist/pfd.spice subckt pfd by flatten-schematic.py (device cards verbatim)
.subckt pll_pfd DN FB REF UP VDD VSS
XXED_UP_XD1_MP XED_UP_d1 REF VDD VDD sg13_hv_pmos w=5u l=0.5u ng=1 m=1
XXED_UP_XD1_MN XED_UP_d1 REF VSS VSS sg13_hv_nmos w=2u l=0.5u ng=1 m=1
XXED_UP_XD2_MP XED_UP_d2 XED_UP_d1 VDD VDD sg13_hv_pmos w=5u l=0.5u ng=1 m=1
XXED_UP_XD2_MN XED_UP_d2 XED_UP_d1 VSS VSS sg13_hv_nmos w=2u l=0.5u ng=1 m=1
XXED_UP_XD3_MP XED_UP_d3 XED_UP_d2 VDD VDD sg13_hv_pmos w=5u l=0.5u ng=1 m=1
XXED_UP_XD3_MN XED_UP_d3 XED_UP_d2 VSS VSS sg13_hv_nmos w=2u l=0.5u ng=1 m=1
XXED_UP_XD4_MP XED_UP_d4 XED_UP_d3 VDD VDD sg13_hv_pmos w=5u l=0.5u ng=1 m=1
XXED_UP_XD4_MN XED_UP_d4 XED_UP_d3 VSS VSS sg13_hv_nmos w=2u l=0.5u ng=1 m=1
XXED_UP_XD5_MP XED_UP_XD5 XED_UP_d4 VDD VDD sg13_hv_pmos w=5u l=0.5u ng=1 m=1
XXED_UP_XD5_MN XED_UP_XD5 XED_UP_d4 VSS VSS sg13_hv_nmos w=2u l=0.5u ng=1 m=1
XXED_UP_XN1_MP1 XED_UP_ntmp REF VDD VDD sg13_hv_pmos w=5u l=0.5u ng=1 m=1
XXED_UP_XN1_MP2 XED_UP_ntmp XED_UP_XD5 VDD VDD sg13_hv_pmos w=5u l=0.5u ng=1 m=1
XXED_UP_XN1_MN1 XED_UP_ntmp REF XED_UP_XN1_mid1 VSS sg13_hv_nmos w=2u l=0.5u ng=1 m=1
XXED_UP_XN1_MN2 XED_UP_XN1_mid1 XED_UP_XD5 VSS VSS sg13_hv_nmos w=2u l=0.5u ng=1 m=1
XXED_UP_XOUT_MP set_up XED_UP_ntmp VDD VDD sg13_hv_pmos w=5u l=0.5u ng=1 m=1
XXED_UP_XOUT_MN set_up XED_UP_ntmp VSS VSS sg13_hv_nmos w=2u l=0.5u ng=1 m=1
XXED_DN_XD1_MP XED_DN_d1 FB VDD VDD sg13_hv_pmos w=5u l=0.5u ng=1 m=1
XXED_DN_XD1_MN XED_DN_d1 FB VSS VSS sg13_hv_nmos w=2u l=0.5u ng=1 m=1
XXED_DN_XD2_MP XED_DN_d2 XED_DN_d1 VDD VDD sg13_hv_pmos w=5u l=0.5u ng=1 m=1
XXED_DN_XD2_MN XED_DN_d2 XED_DN_d1 VSS VSS sg13_hv_nmos w=2u l=0.5u ng=1 m=1
XXED_DN_XD3_MP XED_DN_d3 XED_DN_d2 VDD VDD sg13_hv_pmos w=5u l=0.5u ng=1 m=1
XXED_DN_XD3_MN XED_DN_d3 XED_DN_d2 VSS VSS sg13_hv_nmos w=2u l=0.5u ng=1 m=1
XXED_DN_XD4_MP XED_DN_d4 XED_DN_d3 VDD VDD sg13_hv_pmos w=5u l=0.5u ng=1 m=1
XXED_DN_XD4_MN XED_DN_d4 XED_DN_d3 VSS VSS sg13_hv_nmos w=2u l=0.5u ng=1 m=1
XXED_DN_XD5_MP XED_DN_XD5 XED_DN_d4 VDD VDD sg13_hv_pmos w=5u l=0.5u ng=1 m=1
XXED_DN_XD5_MN XED_DN_XD5 XED_DN_d4 VSS VSS sg13_hv_nmos w=2u l=0.5u ng=1 m=1
XXED_DN_XN1_MP1 XED_DN_ntmp FB VDD VDD sg13_hv_pmos w=5u l=0.5u ng=1 m=1
XXED_DN_XN1_MP2 XED_DN_ntmp XED_DN_XD5 VDD VDD sg13_hv_pmos w=5u l=0.5u ng=1 m=1
XXED_DN_XN1_MN1 XED_DN_ntmp FB XED_DN_XN1_mid1 VSS sg13_hv_nmos w=2u l=0.5u ng=1 m=1
XXED_DN_XN1_MN2 XED_DN_XN1_mid1 XED_DN_XD5 VSS VSS sg13_hv_nmos w=2u l=0.5u ng=1 m=1
XXED_DN_XOUT_MP set_dn XED_DN_ntmp VDD VDD sg13_hv_pmos w=5u l=0.5u ng=1 m=1
XXED_DN_XOUT_MN set_dn XED_DN_ntmp VSS VSS sg13_hv_nmos w=2u l=0.5u ng=1 m=1
XXLU_XIS_MP XLU_SB set_up VDD VDD sg13_hv_pmos w=5u l=0.5u ng=1 m=1
XXLU_XIS_MN XLU_SB set_up VSS VSS sg13_hv_nmos w=2u l=0.5u ng=1 m=1
XXLU_XIR_MP XLU_RB reset VDD VDD sg13_hv_pmos w=5u l=0.5u ng=1 m=1
XXLU_XIR_MN XLU_RB reset VSS VSS sg13_hv_nmos w=2u l=0.5u ng=1 m=1
XXLU_XNQ_MP1 UP XLU_SB VDD VDD sg13_hv_pmos w=5u l=0.5u ng=1 m=1
XXLU_XNQ_MP2 UP net1 VDD VDD sg13_hv_pmos w=5u l=0.5u ng=1 m=1
XXLU_XNQ_MN1 UP XLU_SB XLU_XNQ_mid1 VSS sg13_hv_nmos w=2u l=0.5u ng=1 m=1
XXLU_XNQ_MN2 XLU_XNQ_mid1 net1 VSS VSS sg13_hv_nmos w=2u l=0.5u ng=1 m=1
XXLU_XNQB_MP1 net1 XLU_RB VDD VDD sg13_hv_pmos w=5u l=0.5u ng=1 m=1
XXLU_XNQB_MP2 net1 UP VDD VDD sg13_hv_pmos w=5u l=0.5u ng=1 m=1
XXLU_XNQB_MN1 net1 XLU_RB XLU_XNQB_mid1 VSS sg13_hv_nmos w=2u l=0.5u ng=1 m=1
XXLU_XNQB_MN2 XLU_XNQB_mid1 UP VSS VSS sg13_hv_nmos w=2u l=0.5u ng=1 m=1
XXLD_XIS_MP XLD_SB set_dn VDD VDD sg13_hv_pmos w=5u l=0.5u ng=1 m=1
XXLD_XIS_MN XLD_SB set_dn VSS VSS sg13_hv_nmos w=2u l=0.5u ng=1 m=1
XXLD_XIR_MP XLD_RB reset VDD VDD sg13_hv_pmos w=5u l=0.5u ng=1 m=1
XXLD_XIR_MN XLD_RB reset VSS VSS sg13_hv_nmos w=2u l=0.5u ng=1 m=1
XXLD_XNQ_MP1 DN XLD_SB VDD VDD sg13_hv_pmos w=5u l=0.5u ng=1 m=1
XXLD_XNQ_MP2 DN net2 VDD VDD sg13_hv_pmos w=5u l=0.5u ng=1 m=1
XXLD_XNQ_MN1 DN XLD_SB XLD_XNQ_mid1 VSS sg13_hv_nmos w=2u l=0.5u ng=1 m=1
XXLD_XNQ_MN2 XLD_XNQ_mid1 net2 VSS VSS sg13_hv_nmos w=2u l=0.5u ng=1 m=1
XXLD_XNQB_MP1 net2 XLD_RB VDD VDD sg13_hv_pmos w=5u l=0.5u ng=1 m=1
XXLD_XNQB_MP2 net2 DN VDD VDD sg13_hv_pmos w=5u l=0.5u ng=1 m=1
XXLD_XNQB_MN1 net2 XLD_RB XLD_XNQB_mid1 VSS sg13_hv_nmos w=2u l=0.5u ng=1 m=1
XXLD_XNQB_MN2 XLD_XNQB_mid1 DN VSS VSS sg13_hv_nmos w=2u l=0.5u ng=1 m=1
XXNR_MP1 reset_raw UP VDD VDD sg13_hv_pmos w=5u l=0.5u ng=1 m=1
XXNR_MP2 reset_raw DN VDD VDD sg13_hv_pmos w=5u l=0.5u ng=1 m=1
XXNR_MN1 reset_raw UP XNR_mid1 VSS sg13_hv_nmos w=2u l=0.5u ng=1 m=1
XXNR_MN2 XNR_mid1 DN VSS VSS sg13_hv_nmos w=2u l=0.5u ng=1 m=1
XXI1_MP reset_d1 reset_raw VDD VDD sg13_hv_pmos w=5u l=0.5u ng=1 m=1
XXI1_MN reset_d1 reset_raw VSS VSS sg13_hv_nmos w=2u l=0.5u ng=1 m=1
XXI1B_MP reset_d2 reset_d1 VDD VDD sg13_hv_pmos w=5u l=0.5u ng=1 m=1
XXI1B_MN reset_d2 reset_d1 VSS VSS sg13_hv_nmos w=2u l=0.5u ng=1 m=1
XXI2_MP reset reset_d2 VDD VDD sg13_hv_pmos w=10u l=0.5u ng=1 m=1
XXI2_MN reset reset_d2 VSS VSS sg13_hv_nmos w=4u l=0.5u ng=1 m=1
.ends pll_pfd
