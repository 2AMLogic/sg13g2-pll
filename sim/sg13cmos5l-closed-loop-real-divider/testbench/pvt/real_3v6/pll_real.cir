* sg13g2-pll :: sim/sg13cmos5l-closed-loop-real-divider (issue #159, Part of #16)
* NOMINAL-CORNER, PRE-LAYOUT closed-loop deck, two arms from ONE template.
*
*   ARM=control : feedback = unchanged behavioural XSPICE divide-by-64
*                 (same d_dff toggle chain as RECORD-003/005's decks).
*   ARM=real    : feedback = committed transistor-level `divider_chain`
*                 (repaired, #112/#121), P5..P0 = 000000 (N = 64).
*
* Everything outside the arm block marker is byte-identical between arms
* (run.sh renders both from this file): rails, reference, supplies, bias
* currents, loop filter, VCO word, .ic on vctrl / ring1, solver options,
* TSTOP/TPRINT/TMAX. The real arm additionally needs latch .ic statements on
* the divider's 13 flops (the block has no reset; see RECORD-001) -- those
* are the only arm-specific initial conditions and are declared in the arm
* block. `vdd_div` exists in BOTH arms (unloaded in the control arm).
*
* Substitutions vs the production composition (all disclosed in RECORD-001):
*   S1 loop_filter XC1/XC2 (cap_cmomi) -> ideal caps at campaign values.
*   S2 vco XCDECAP stripped (same precedent as the campaign decks).
*   S3 cp IBP/ICP/IBN/ICN driven by ideal 10u current sources.
*   S4 b0/b1 held at rails by ideal sources; REF is an ideal pulse source.
*   S5 lock_detector NOT instantiated.
*   S6 control arm only: ideal behavioural divider.
*   S7 real arm only: latch .ic symmetry break on divider flops.

.option scale=1 reltol=1e-3 vntol=1e-4 abstol=1e-9 trtol=7
.global sub!

* Netlist provenance snapshot -- sim/README.md convention
* Frozen verbatim (body unmodified) from design/sg13cmos5l/netlist/pfd.spice at commit 3da79b6 (origin/main)
* Simulated by sim/sg13cmos5l-closed-loop-real-divider/ (issue #159, Part of #16)
*
* sg13g2-pll :: pfd (SG13CMOS5L) -- generated by design/sg13cmos5l/netlist.sh from pfd.sch
* xschem XSCHEM V3.4.7; do not edit by hand.
** sch_path: design/sg13cmos5l/pfd.sch
.subckt pfd REF FB UP DN VDD VSS
*.ipin REF
*.ipin FB
*.opin UP
*.opin DN
*.iopin VDD
*.iopin VSS
XED_UP REF set_up VDD VSS edgedet
XED_DN FB set_dn VDD VSS edgedet
XLU set_up reset UP net1 VDD VSS srlatch
XLD set_dn reset DN net2 VDD VSS srlatch
XNR UP DN reset_raw VDD VSS nand2_hv
XI1 reset_raw reset_d1 VDD VSS inv_hv
XI1B reset_d1 reset_d2 VDD VSS inv_hv
XI2 reset_d2 reset VDD VSS inv2x_hv
.ends

* expanding   symbol:  edgedet.sym # of pins=4
** sym_path: design/sg13cmos5l/edgedet.sym
** sch_path: design/sg13cmos5l/edgedet.sch
.subckt edgedet X OUT VDD VSS
*.ipin X
*.opin OUT
*.iopin VDD
*.iopin VSS
XD1 X d1 VDD VSS inv_hv
XD2 d1 d2 VDD VSS inv_hv
XD3 d2 d3 VDD VSS inv_hv
XD4 d3 d4 VDD VSS inv_hv
XD5 d4 XD5 VDD VSS inv_hv
XN1 X XD5 ntmp VDD VSS nand2_hv
XOUT ntmp OUT VDD VSS inv_hv
.ends

* expanding   symbol:  srlatch.sym # of pins=6
** sym_path: design/sg13cmos5l/srlatch.sym
** sch_path: design/sg13cmos5l/srlatch.sch
.subckt srlatch S R Q QB VDD VSS
*.ipin S
*.ipin R
*.opin Q
*.opin QB
*.iopin VDD
*.iopin VSS
XIS S SB VDD VSS inv_hv
XIR R RB VDD VSS inv_hv
XNQ SB QB Q VDD VSS nand2_hv
XNQB RB Q QB VDD VSS nand2_hv
.ends

* expanding   symbol:  nand2_hv.sym # of pins=5
** sym_path: design/sg13cmos5l/nand2_hv.sym
** sch_path: design/sg13cmos5l/nand2_hv.sch
.subckt nand2_hv A1 A2 Y VDD VSS
*.opin Y
*.ipin A1
*.ipin A2
*.iopin VDD
*.iopin VSS
XMP1 Y A1 VDD VDD sg13_hv_pmos w=5u l=0.5u ng=1 m=1
XMP2 Y A2 VDD VDD sg13_hv_pmos w=5u l=0.5u ng=1 m=1
XMN1 Y A1 mid1 VSS sg13_hv_nmos w=2u l=0.5u ng=1 m=1
XMN2 mid1 A2 VSS VSS sg13_hv_nmos w=2u l=0.5u ng=1 m=1
.ends

* expanding   symbol:  inv_hv.sym # of pins=4
** sym_path: design/sg13cmos5l/inv_hv.sym
** sch_path: design/sg13cmos5l/inv_hv.sch
.subckt inv_hv A Y VDD VSS
*.ipin A
*.opin Y
*.iopin VDD
*.iopin VSS
XMP Y A VDD VDD sg13_hv_pmos w=5u l=0.5u ng=1 m=1
XMN Y A VSS VSS sg13_hv_nmos w=2u l=0.5u ng=1 m=1
.ends

* expanding   symbol:  inv2x_hv.sym # of pins=4
** sym_path: design/sg13cmos5l/inv2x_hv.sym
** sch_path: design/sg13cmos5l/inv2x_hv.sch
.subckt inv2x_hv A Y VDD VSS
*.ipin A
*.opin Y
*.iopin VDD
*.iopin VSS
XMP Y A VDD VDD sg13_hv_pmos w=10u l=0.5u ng=1 m=1
XMN Y A VSS VSS sg13_hv_nmos w=4u l=0.5u ng=1 m=1
.ends

* Netlist provenance snapshot -- sim/README.md convention
* Frozen verbatim (body unmodified) from design/sg13cmos5l/netlist/cp.spice at commit ab6e9f1 (origin/main)
* Simulated by sim/sg13cmos5l-closed-loop-real-divider/ (issue #401; DR-010 complementary dump buffer, replaces RECORD-001's pre-DR-010 cp.spice)
*
* sg13g2-pll :: cp (SG13CMOS5L) -- generated by design/sg13cmos5l/netlist.sh from cp.sch
* xschem XSCHEM V3.4.7; do not edit by hand.
** sch_path: design/sg13cmos5l/cp.sch
.subckt cp UP DN IBP ICP IBN ICN VOUT VDD VSS
*.ipin UP
*.ipin DN
*.iopin IBP
*.iopin ICP
*.iopin IBN
*.iopin ICN
*.opin VOUT
*.iopin VDD
*.iopin VSS
XIUP UP UPB VDD VSS inv_hv
XIDN DN DNB VDD VSS inv_hv
XLEGP IBP ICP UP UPB VOUT VDUMP VDD cp_leg_p
XLEGN IBN ICN DN DNB VOUT VDUMP VSS cp_leg_n
XBUF VOUT IBN IBP VDUMP VDD VSS cp_dumpbuf
XMBP nxp IBP VDD VDD sg13_hv_pmos w=24u l=1u ng=1 m=1
XMBPC IBP ICP nxp VDD sg13_hv_pmos w=24u l=1u ng=1 m=1
XMCP ICP ICP VDD VDD sg13_hv_pmos w=6u l=3u ng=1 m=1
XMBN nxn IBN VSS VSS sg13_hv_nmos w=8u l=1u ng=1 m=1
XMBNC IBN ICN nxn VSS sg13_hv_nmos w=8u l=1u ng=1 m=1
XMCN ICN ICN VSS VSS sg13_hv_nmos w=2u l=3u ng=1 m=1
.ends

* expanding   symbol:  inv_hv.sym # of pins=4
** sym_path: design/sg13cmos5l/inv_hv.sym
** sch_path: design/sg13cmos5l/inv_hv.sch
.subckt inv_hv A Y VDD VSS
*.ipin A
*.opin Y
*.iopin VDD
*.iopin VSS
XMP Y A VDD VDD sg13_hv_pmos w=5u l=0.5u ng=1 m=1
XMN Y A VSS VSS sg13_hv_nmos w=2u l=0.5u ng=1 m=1
.ends

* expanding   symbol:  cp_leg_p.sym # of pins=7
** sym_path: design/sg13cmos5l/cp_leg_p.sym
** sch_path: design/sg13cmos5l/cp_leg_p.sch
.subckt cp_leg_p IBP ICP UP UPB VOUT VDUMP VDD
*.ipin IBP
*.ipin ICP
*.ipin UP
*.ipin UPB
*.opin VOUT
*.opin VDUMP
*.iopin VDD
XM1 tail IBP VDD VDD sg13_hv_pmos w=24u l=1u ng=1 m=1
XM2 sw ICP tail VDD sg13_hv_pmos w=24u l=1u ng=1 m=1
XSWO VOUT UPB sw VDD sg13_hv_pmos w=6u l=0.3u ng=1 m=1
XSWD VDUMP UP sw VDD sg13_hv_pmos w=6u l=0.3u ng=1 m=1
.ends

* expanding   symbol:  cp_leg_n.sym # of pins=7
** sym_path: design/sg13cmos5l/cp_leg_n.sym
** sch_path: design/sg13cmos5l/cp_leg_n.sch
.subckt cp_leg_n IBN ICN DN DNB VOUT VDUMP VSS
*.ipin IBN
*.ipin ICN
*.ipin DNB
*.ipin DN
*.opin VOUT
*.opin VDUMP
*.iopin VSS
XM1 tail IBN VSS VSS sg13_hv_nmos w=8u l=1u ng=1 m=1
XM2 sw ICN tail VSS sg13_hv_nmos w=8u l=1u ng=1 m=1
XSWO VOUT DN sw VSS sg13_hv_nmos w=6u l=0.3u ng=1 m=1
XSWD VDUMP DNB sw VSS sg13_hv_nmos w=6u l=0.3u ng=1 m=1
.ends

* expanding   symbol:  cp_dumpbuf.sym # of pins=6
** sym_path: design/sg13cmos5l/cp_dumpbuf.sym
** sch_path: design/sg13cmos5l/cp_dumpbuf.sch
.subckt cp_dumpbuf VOUT IBN IBP VDUMP VDD VSS
*.ipin VOUT
*.ipin IBN
*.ipin IBP
*.opin VDUMP
*.iopin VDD
*.iopin VSS
XMTN NSRC IBN VSS VSS sg13_hv_nmos w=12u l=1u ng=1 m=1
XMN1 NDA VOUT NSRC VSS sg13_hv_nmos w=2u l=1u ng=1 m=1
XMN2 VDUMP VDUMP NSRC VSS sg13_hv_nmos w=2u l=1u ng=1 m=1
XMN3 NDA NDA VDD VDD sg13_hv_pmos w=24u l=1u ng=1 m=1
XMN4 VDUMP NDA VDD VDD sg13_hv_pmos w=24u l=1u ng=1 m=1
XMTP PSRC IBP VDD VDD sg13_hv_pmos w=36u l=1u ng=1 m=1
XMP1 PDA VOUT PSRC PSRC sg13_hv_pmos w=6u l=0.5u ng=1 m=1
XMP2 VDUMP VDUMP PSRC PSRC sg13_hv_pmos w=6u l=0.5u ng=1 m=1
XMP3 PDA PDA VSS VSS sg13_hv_nmos w=16u l=1u ng=1 m=1
XMP4 VDUMP PDA VSS VSS sg13_hv_nmos w=16u l=1u ng=1 m=1
.ends

* Netlist provenance snapshot -- sim/README.md convention
* Frozen verbatim (body unmodified) from design/sg13cmos5l/netlist/loop_filter.spice at commit 3da79b6 (origin/main)
* Simulated by sim/sg13cmos5l-closed-loop-real-divider/ (issue #159, Part of #16)
*
* sg13g2-pll :: loop_filter (SG13CMOS5L) -- generated by design/sg13cmos5l/netlist.sh from loop_filter.sch
* xschem XSCHEM V3.4.7; do not edit by hand.
** sch_path: design/sg13cmos5l/loop_filter.sch
.subckt loop_filter VCTRL VSS
*.iopin VCTRL
*.iopin VSS
XR1 VCTRL NZ sub! rppd w=0.6u l=810u m=1 b=0
CC1 NZ VSS 1.691196e-12
CC2 VCTRL VSS 1.001529e-13
.ends

* Netlist provenance snapshot -- sim/README.md convention
* Frozen verbatim (body unmodified) from design/sg13cmos5l/netlist/vco.spice at commit 3da79b6 (origin/main)
* Simulated by sim/sg13cmos5l-closed-loop-real-divider/ (issue #159, Part of #16)
*
* sg13g2-pll :: vco (SG13CMOS5L) -- generated by design/sg13cmos5l/netlist.sh from vco.sch
* xschem XSCHEM V3.4.7; do not edit by hand.
** sch_path: design/sg13cmos5l/vco.sch
.subckt vco VCTRL B0 B1 CLK VDD_VCO GND_VCO
*.ipin VCTRL
*.ipin B0
*.ipin B1
*.opin CLK
*.iopin VDD_VCO
*.iopin GND_VCO
XBIAS VCTRL B0 B1 VBP VBN VDD_VCO GND_VCO vco_bias
XS1 ring5 VBP VBN ring1 VDD_VCO GND_VCO vco_stage
XS2 ring1 VBP VBN ring2 VDD_VCO GND_VCO vco_stage
XS3 ring2 VBP VBN ring3 VDD_VCO GND_VCO vco_stage
XS4 ring3 VBP VBN ring4 VDD_VCO GND_VCO vco_stage
XS5 ring4 VBP VBN ring5 VDD_VCO GND_VCO vco_stage
XBUF1 ring1 bufmid VDD_VCO GND_VCO inv2x_hv
XBUF2 bufmid CLK VDD_VCO GND_VCO inv2x_hv
*XCDECAP VDD_VCO GND_VCO cap_cmomi w=70u l=70u mmin=1 mmax=4 feed=double subblock=0 m=1 mm_ok=1
.ends

* expanding   symbol:  vco_bias.sym # of pins=7
** sym_path: design/sg13cmos5l/vco_bias.sym
** sch_path: design/sg13cmos5l/vco_bias.sch
.subckt vco_bias VCTRL B0 B1 VBP VBN VDD VSS
*.ipin VCTRL
*.ipin B0
*.ipin B1
*.opin VBP
*.opin VBN
*.iopin VDD
*.iopin VSS
XP1 vb1 vb1 VDD VDD sg13_hv_pmos w=6u l=1u ng=1 m=1
XP2 vb2 vb1 VDD VDD sg13_hv_pmos w=6u l=1u ng=1 m=1
XN1 vb1 vb2 VSS VSS sg13_hv_nmos w=2u l=1u ng=1 m=1
XN2 vb2 vb2 n2s VSS sg13_hv_nmos w=8u l=1u ng=1 m=1
XRS n2s VSS VSS rppd w=1u l=30u m=1 b=0
XRSTART VDD vb2 VSS rhigh w=0.5u l=8u m=1 b=0
XP5 VFIX vb1 VDD VDD sg13_hv_pmos w=3u l=1u ng=1 m=1
XN5 VFIX VFIX vfixmid VSS sg13_hv_nmos w=2u l=1u ng=1 m=1
XN6 vfixmid vfixmid VSS VSS sg13_hv_nmos w=2u l=1u ng=1 m=1
XM6 VBP VBP VDD VDD sg13_hv_pmos w=10u l=1u ng=1 m=1
XM7 VBP VFIX dega VSS sg13_hv_nmos w=4u l=1u ng=1 m=1
XRDEGA dega VSS VSS rppd w=1u l=60u m=1 b=0
XM8 VBP VCTRL degb VSS sg13_hv_nmos w=4u l=1u ng=1 m=1
XRDEGB0 degb VSS VSS rppd w=1u l=60u m=1 b=0
XSWB0 degb B0 nb0 VSS sg13_hv_nmos w=4u l=0.3u ng=1 m=1
XRDEGB1 nb0 VSS VSS rppd w=1u l=60u m=1 b=0
XSWB1 degb B1 nb1 VSS sg13_hv_nmos w=4u l=0.3u ng=1 m=1
XRDEGB2 nb1 VSS VSS rppd w=1u l=30u m=1 b=0
XM11 VBN VBP VDD VDD sg13_hv_pmos w=10u l=1u ng=1 m=1
XM10 VBN VBN VSS VSS sg13_hv_nmos w=4u l=1u ng=1 m=1
.ends

* expanding   symbol:  vco_stage.sym # of pins=6
** sym_path: design/sg13cmos5l/vco_stage.sym
** sch_path: design/sg13cmos5l/vco_stage.sch
.subckt vco_stage IN VBP VBN OUT VDDV GNDV
*.ipin IN
*.opin OUT
*.ipin VBP
*.ipin VBN
*.iopin VDDV
*.iopin GNDV
XMPH nh VBP VDDV VDDV sg13_hv_pmos w=10u l=0.5u ng=1 m=1
XMP OUT IN nh VDDV sg13_hv_pmos w=5u l=0.28u ng=1 m=1
XMN OUT IN nt GNDV sg13_hv_nmos w=2u l=0.28u ng=1 m=1
XMNT nt VBN GNDV GNDV sg13_hv_nmos w=4u l=0.5u ng=1 m=1
.ends

* expanding   symbol:  inv2x_hv.sym # of pins=4
** sym_path: design/sg13cmos5l/inv2x_hv.sym
** sch_path: design/sg13cmos5l/inv2x_hv.sch
.subckt inv2x_hv A Y VDD VSS
*.ipin A
*.opin Y
*.iopin VDD
*.iopin VSS
XMP Y A VDD VDD sg13_hv_pmos w=10u l=0.5u ng=1 m=1
XMN Y A VSS VSS sg13_hv_nmos w=4u l=0.5u ng=1 m=1
.ends

* Netlist provenance snapshot -- sim/README.md convention
* Frozen verbatim (body unmodified) from design/sg13cmos5l/netlist/divider_chain.spice at commit 3da79b6 (origin/main)
* Simulated by sim/sg13cmos5l-closed-loop-real-divider/ (issue #159, Part of #16)
*
* sg13g2-pll :: divider_chain (SG13CMOS5L) -- generated by design/sg13cmos5l/netlist.sh from divider_chain.sch
* xschem XSCHEM V3.4.7; do not edit by hand.
** sch_path: design/sg13cmos5l/divider_chain.sch
.subckt divider_chain CKIN CKIN_VCO P0 P1 P2 P3 P4 P5 FB DIVOUT VDD_DIV VSS
*.ipin CKIN
*.ipin CKIN_VCO
*.ipin P0
*.ipin P1
*.ipin P2
*.ipin P3
*.ipin P4
*.ipin P5
*.opin FB
*.opin DIVOUT
*.iopin VDD_DIV
*.iopin VSS
XD0 mod0 P0 CKIN ck1 net1 VDD_DIV VSS div23_cell
XD1 mod1 P1 ck1 ck2 mod0 VDD_DIV VSS div23_cell
XD2 mod2 P2 ck2 ck3 mod1 VDD_DIV VSS div23_cell
XD3 mod3 P3 ck3 ck4 mod2 VDD_DIV VSS div23_cell
XD4 mod4 P4 ck4 ck5 mod3 VDD_DIV VSS div23_cell
XD5 VDD_DIV P5 ck5 DIVOUT mod4 VDD_DIV VSS div23_cell
XFRT DIVOUT CKIN_VCO FB VDD_DIV VSS dff_tg_hv
.ends

* expanding   symbol:  div23_cell.sym # of pins=7
** sym_path: design/sg13cmos5l/div23_cell.sym
** sch_path: design/sg13cmos5l/div23_cell.sch
.subckt div23_cell MODIN P CKIN Q MODOUT VDD VSS
*.ipin MODIN
*.ipin P
*.ipin CKIN
*.opin Q
*.opin MODOUT
*.iopin VDD
*.iopin VSS
XN3 MODIN P MODOUT nt VDD VSS nand3_hv
XI1 nt t1 VDD VSS inv_hv
XNOR Q t1 dq VDD VSS nor2_hv
XDFFQ dq CKIN Q VDD VSS dff_tg_hv
XN2 MODIN Q nm VDD VSS nand2_hv
XI2 nm dmodout VDD VSS inv_hv
XDFFM dmodout CKIN MODOUT VDD VSS dff_tg_hv
.ends

* expanding   symbol:  dff_tg_hv.sym # of pins=5
** sym_path: design/sg13cmos5l/dff_tg_hv.sym
** sch_path: design/sg13cmos5l/dff_tg_hv.sch
.subckt dff_tg_hv D CLK Q VDD VSS
*.ipin D
*.ipin CLK
*.opin Q
*.iopin VDD
*.iopin VSS
XICLK CLK CLKB VDD VSS inv_hv
XICKBB CLKB CKBB VDD VSS inv_hv
XTG1 D CLKB CKBB M VDD VSS tgate_hv
XIM M MB VDD VSS inv_hv
XIMF MB MFB VDD VSS inv_hv
XTGFBM MFB CKBB CLKB M VDD VSS tgate_hv
XTG2 M CKBB CLKB S VDD VSS tgate_hv
XIS S SB VDD VSS inv_hv
XISF SB SFB VDD VSS inv_hv
XTGFBS SFB CLKB CKBB S VDD VSS tgate_hv
XBQ SB Q VDD VSS inv_hv
.ends

* expanding   symbol:  nand3_hv.sym # of pins=6
** sym_path: design/sg13cmos5l/nand3_hv.sym
** sch_path: design/sg13cmos5l/nand3_hv.sch
.subckt nand3_hv A1 A2 A3 Y VDD VSS
*.opin Y
*.ipin A1
*.ipin A2
*.ipin A3
*.iopin VDD
*.iopin VSS
XMP1 Y A1 VDD VDD sg13_hv_pmos w=5u l=0.5u ng=1 m=1
XMP2 Y A2 VDD VDD sg13_hv_pmos w=5u l=0.5u ng=1 m=1
XMP3 Y A3 VDD VDD sg13_hv_pmos w=5u l=0.5u ng=1 m=1
XMN1 Y A1 mid1 VSS sg13_hv_nmos w=2u l=0.5u ng=1 m=1
XMN2 mid1 A2 mid2 VSS sg13_hv_nmos w=2u l=0.5u ng=1 m=1
XMN3 mid2 A3 VSS VSS sg13_hv_nmos w=2u l=0.5u ng=1 m=1
.ends

* expanding   symbol:  inv_hv.sym # of pins=4
** sym_path: design/sg13cmos5l/inv_hv.sym
** sch_path: design/sg13cmos5l/inv_hv.sch
.subckt inv_hv A Y VDD VSS
*.ipin A
*.opin Y
*.iopin VDD
*.iopin VSS
XMP Y A VDD VDD sg13_hv_pmos w=5u l=0.5u ng=1 m=1
XMN Y A VSS VSS sg13_hv_nmos w=2u l=0.5u ng=1 m=1
.ends

* expanding   symbol:  nor2_hv.sym # of pins=5
** sym_path: design/sg13cmos5l/nor2_hv.sym
** sch_path: design/sg13cmos5l/nor2_hv.sch
.subckt nor2_hv A B Y VDD VSS
*.ipin A
*.ipin B
*.opin Y
*.iopin VDD
*.iopin VSS
XMP1 midp A VDD VDD sg13_hv_pmos w=5u l=0.5u ng=1 m=1
XMP2 Y B midp VDD sg13_hv_pmos w=5u l=0.5u ng=1 m=1
XMN1 Y A VSS VSS sg13_hv_nmos w=2u l=0.5u ng=1 m=1
XMN2 Y B VSS VSS sg13_hv_nmos w=2u l=0.5u ng=1 m=1
.ends

* expanding   symbol:  nand2_hv.sym # of pins=5
** sym_path: design/sg13cmos5l/nand2_hv.sym
** sch_path: design/sg13cmos5l/nand2_hv.sch
.subckt nand2_hv A1 A2 Y VDD VSS
*.opin Y
*.ipin A1
*.ipin A2
*.iopin VDD
*.iopin VSS
XMP1 Y A1 VDD VDD sg13_hv_pmos w=5u l=0.5u ng=1 m=1
XMP2 Y A2 VDD VDD sg13_hv_pmos w=5u l=0.5u ng=1 m=1
XMN1 Y A1 mid1 VSS sg13_hv_nmos w=2u l=0.5u ng=1 m=1
XMN2 mid1 A2 VSS VSS sg13_hv_nmos w=2u l=0.5u ng=1 m=1
.ends

* expanding   symbol:  tgate_hv.sym # of pins=6
** sym_path: design/sg13cmos5l/tgate_hv.sym
** sch_path: design/sg13cmos5l/tgate_hv.sch
.subckt tgate_hv A NG PG Y VDD VSS
*.ipin A
*.opin Y
*.ipin NG
*.ipin PG
*.iopin VDD
*.iopin VSS
XMN A NG Y VSS sg13_hv_nmos w=2u l=0.5u ng=1 m=1
XMP Y PG A VDD sg13_hv_pmos w=5u l=0.5u ng=1 m=1
.ends

Vsub sub! 0 dc 0

Vdd_pfd vdd_pfd 0 dc 3.6
Vdd_cp  vdd_cp  0 dc 3.6
Vdd_vco vdd_vco 0 dc 3.6
Vdd_div vdd_div 0 dc 3.6

Vref ref 0 pulse(0 3.6 0 100p 100p 5.323333e-08 1.066667e-07)
Vb0 b0 0 dc 0
Vb1 b1 0 dc 0

Irefbp ibp 0 dc 10u
Irefcp icp 0 dc 10u
Irefbn 0 ibn dc 10u
Irefcn 0 icn dc 10u

XPFD ref fb up dn vdd_pfd 0 pfd
XCP up dn ibp icp ibn icn vctrl vdd_cp 0 cp
XLF vctrl 0 loop_filter
XVCO vctrl b0 b1 clk vdd_vco 0 vco

* ---- arm block begin ----
Vp0 p0 0 dc 0
Vp1 p1 0 dc 0
Vp2 p2 0 dc 0
Vp3 p3 0 dc 0
Vp4 p4 0 dc 0
Vp5 p5 0 dc 0
XDIV clk clk p0 p1 p2 p3 p4 p5 fb divout vdd_div 0 divider_chain
.ic v(xdiv.xd0.xdffq.m)=0 v(xdiv.xd0.xdffq.s)=0 v(xdiv.xd0.xdffm.m)=0 v(xdiv.xd0.xdffm.s)=0
.ic v(xdiv.xd1.xdffq.m)=0 v(xdiv.xd1.xdffq.s)=0 v(xdiv.xd1.xdffm.m)=0 v(xdiv.xd1.xdffm.s)=0
.ic v(xdiv.xd2.xdffq.m)=0 v(xdiv.xd2.xdffq.s)=0 v(xdiv.xd2.xdffm.m)=0 v(xdiv.xd2.xdffm.s)=0
.ic v(xdiv.xd3.xdffq.m)=0 v(xdiv.xd3.xdffq.s)=0 v(xdiv.xd3.xdffm.m)=0 v(xdiv.xd3.xdffm.s)=0
.ic v(xdiv.xd4.xdffq.m)=0 v(xdiv.xd4.xdffq.s)=0 v(xdiv.xd4.xdffm.m)=0 v(xdiv.xd4.xdffm.s)=0
.ic v(xdiv.xd5.xdffq.m)=0 v(xdiv.xd5.xdffq.s)=0 v(xdiv.xd5.xdffm.m)=0 v(xdiv.xd5.xdffm.s)=0
.ic v(xdiv.xfrt.m)=0 v(xdiv.xfrt.s)=0

* ---- arm block end ----

.ic v(vctrl)=1.23
.ic v(xvco.ring1)=0.5

* Save only what the measurements and extraction need: with default save-all the
* real arm exhausts ngspice memory (see RECORD-001, attempt 1). Identical in both arms.
