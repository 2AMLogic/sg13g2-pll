* sg13g2-pll :: sim/sg13cmos5l-divider-max-frequency (issue #402)
* `divider_chain` maximum-input-frequency deck: the committed (repaired)
* divider_chain alone, ideal pulse clock at one frequency, one corner,
* one programming word. Counts -- via ngspice `.meas ... when rise=k` --
* the FIRST `1.815` crossing time of every rising edge of the clock (CKIN)
* and of the feedback clock (FB) within `6.704600e-07`; the collector
* (../testbench/collect_maxfreq.py) buckets the CKIN edges per FB period and
* scores each period against the programmed ratio N. Wave units
* ( non-empty) additionally dump the internal stage nodes
* ck1..ck5 (plus CKIN/FB/DIVOUT) as text for the failing-stage isolation
* (AC 3); the collector gzips that dump into ../corners/.
*
* The deck is rendered per unit by ../testbench/gen_maxfreq_requests.py,
* which substitutes the corner (mos_tt), temperature (27), supply
* (3.63, with the 50 % crossing threshold 1.815 -- the supply corners
* make a hard-coded 1.65 V wrong), the clock period (6.402049e-10) and high time
* (2.401024e-10 = 6.402049e-10/2 - 80 p: 80 ps edges and ~50 % duty, the SAME drive shape
* tb_div_speed.sp.tmpl used for the 640 MHz / 1.28 GHz bracket this
* campaign anchors against), timestep, stop time, reltol, the programming
* word, the saved-node list, an optional waveform-dump control block and
* the emitted per-edge .meas lines.
*
* PDK provenance: the deck names the PINNED model files relative to itself
* (`models/`, `osdi/`). `klt sim`'s deck-list preservation contract stages
* those files from the submitting host -- the pinned
* `ihp-sg13cmos5l 607e18d4...` checkout's bytes (staged by the generator,
* which refuses to run without `--pinned-pdk`) -- so neither this deck nor
* the record may cite `$PDK_ROOT` (that resolves on the worker to the
* newer, unpinned fleet image). See ../records/RECORD-001.
*
* Both clock inputs of `divider_chain` are driven from the same source
* (`CKIN` = `CKIN_VCO` = `ck`): in the closed loop they are the same net,
* exactly as in tb_div_func.sp.tmpl. Driving them separately would invent
* a skew the design does not have.
*
* `divider_chain` has NO reset pin: its 13 `dff_tg_hv` state elements have
* no defined power-up state, so the DC operating point is indeterminate and
* ngspice's gmin/source stepping cannot resolve it. These `.ic` statements
* are the minimum symmetry break that makes an OP exist -- a TESTBENCH
* workaround for a DESIGN gap (Finding 1 of
* sim/sg13cmos5l-divider-nrange-retiming/records/RECORD-001), not a
* property of the block.
*
* The `.control` block deliberately contains NO `run`: with a `.control`
* present, the deck-level `.tran` runs exactly once and `run` would execute
* it a second time (measured: the anchor's first cut ran the whole transient
* twice). `pre_osdi` needs to precede only the model resolution, which the
* control block satisfies.

.lib models/cornerMOShv.lib mos_tt
.option scale=1 temp=27
.options reltol=0.001 vntol=1e-4 abstol=1e-9 trtol=7
.global sub!

.include divider_chain.spice

Vdd vdd 0 dc 3.63
Vsub sub! 0 dc 0
Vck ck 0 pulse(0 3.63 0 80p 80p 2.401024e-10 6.402049e-10)
Vp0 p0 0 dc 3.63
Vp1 p1 0 dc 3.63
Vp2 p2 0 dc 3.63
Vp3 p3 0 dc 3.63
Vp4 p4 0 dc 3.63
Vp5 p5 0 dc 3.63

Xdiv ck ck p0 p1 p2 p3 p4 p5 fb divout vdd 0 divider_chain

.ic v(xdiv.xd0.xdffq.m)=0 v(xdiv.xd0.xdffq.s)=0 v(xdiv.xd0.xdffm.m)=0 v(xdiv.xd0.xdffm.s)=0
.ic v(xdiv.xd1.xdffq.m)=0 v(xdiv.xd1.xdffq.s)=0 v(xdiv.xd1.xdffm.m)=0 v(xdiv.xd1.xdffm.s)=0
.ic v(xdiv.xd2.xdffq.m)=0 v(xdiv.xd2.xdffq.s)=0 v(xdiv.xd2.xdffm.m)=0 v(xdiv.xd2.xdffm.s)=0
.ic v(xdiv.xd3.xdffq.m)=0 v(xdiv.xd3.xdffq.s)=0 v(xdiv.xd3.xdffm.m)=0 v(xdiv.xd3.xdffm.s)=0
.ic v(xdiv.xd4.xdffq.m)=0 v(xdiv.xd4.xdffq.s)=0 v(xdiv.xd4.xdffm.m)=0 v(xdiv.xd4.xdffm.s)=0
.ic v(xdiv.xd5.xdffq.m)=0 v(xdiv.xd5.xdffq.s)=0 v(xdiv.xd5.xdffm.m)=0 v(xdiv.xd5.xdffm.s)=0
.ic v(xdiv.xfrt.m)=0 v(xdiv.xfrt.s)=0

.save v(ck) v(fb)
.tran 2.000000e-11 6.704600e-07 0 2.000000e-11

.control
pre_osdi osdi/psp103.osdi
pre_osdi osdi/psp103_nqs.osdi
pre_osdi osdi/mosvar.osdi
set num_threads=2

.endc
.meas tran tck_1 when v(ck)=1.815 rise=1
.meas tran tck_2 when v(ck)=1.815 rise=2
.meas tran tck_3 when v(ck)=1.815 rise=3
.meas tran tck_4 when v(ck)=1.815 rise=4
.meas tran tck_5 when v(ck)=1.815 rise=5
.meas tran tck_6 when v(ck)=1.815 rise=6
.meas tran tck_7 when v(ck)=1.815 rise=7
.meas tran tck_8 when v(ck)=1.815 rise=8
.meas tran tck_9 when v(ck)=1.815 rise=9
.meas tran tck_10 when v(ck)=1.815 rise=10
.meas tran tck_11 when v(ck)=1.815 rise=11
.meas tran tck_12 when v(ck)=1.815 rise=12
.meas tran tck_13 when v(ck)=1.815 rise=13
.meas tran tck_14 when v(ck)=1.815 rise=14
.meas tran tck_15 when v(ck)=1.815 rise=15
.meas tran tck_16 when v(ck)=1.815 rise=16
.meas tran tck_17 when v(ck)=1.815 rise=17
.meas tran tck_18 when v(ck)=1.815 rise=18
.meas tran tck_19 when v(ck)=1.815 rise=19
.meas tran tck_20 when v(ck)=1.815 rise=20
.meas tran tck_21 when v(ck)=1.815 rise=21
.meas tran tck_22 when v(ck)=1.815 rise=22
.meas tran tck_23 when v(ck)=1.815 rise=23
.meas tran tck_24 when v(ck)=1.815 rise=24
.meas tran tck_25 when v(ck)=1.815 rise=25
.meas tran tck_26 when v(ck)=1.815 rise=26
.meas tran tck_27 when v(ck)=1.815 rise=27
.meas tran tck_28 when v(ck)=1.815 rise=28
.meas tran tck_29 when v(ck)=1.815 rise=29
.meas tran tck_30 when v(ck)=1.815 rise=30
.meas tran tck_31 when v(ck)=1.815 rise=31
.meas tran tck_32 when v(ck)=1.815 rise=32
.meas tran tck_33 when v(ck)=1.815 rise=33
.meas tran tck_34 when v(ck)=1.815 rise=34
.meas tran tck_35 when v(ck)=1.815 rise=35
.meas tran tck_36 when v(ck)=1.815 rise=36
.meas tran tck_37 when v(ck)=1.815 rise=37
.meas tran tck_38 when v(ck)=1.815 rise=38
.meas tran tck_39 when v(ck)=1.815 rise=39
.meas tran tck_40 when v(ck)=1.815 rise=40
.meas tran tck_41 when v(ck)=1.815 rise=41
.meas tran tck_42 when v(ck)=1.815 rise=42
.meas tran tck_43 when v(ck)=1.815 rise=43
.meas tran tck_44 when v(ck)=1.815 rise=44
.meas tran tck_45 when v(ck)=1.815 rise=45
.meas tran tck_46 when v(ck)=1.815 rise=46
.meas tran tck_47 when v(ck)=1.815 rise=47
.meas tran tck_48 when v(ck)=1.815 rise=48
.meas tran tck_49 when v(ck)=1.815 rise=49
.meas tran tck_50 when v(ck)=1.815 rise=50
.meas tran tck_51 when v(ck)=1.815 rise=51
.meas tran tck_52 when v(ck)=1.815 rise=52
.meas tran tck_53 when v(ck)=1.815 rise=53
.meas tran tck_54 when v(ck)=1.815 rise=54
.meas tran tck_55 when v(ck)=1.815 rise=55
.meas tran tck_56 when v(ck)=1.815 rise=56
.meas tran tck_57 when v(ck)=1.815 rise=57
.meas tran tck_58 when v(ck)=1.815 rise=58
.meas tran tck_59 when v(ck)=1.815 rise=59
.meas tran tck_60 when v(ck)=1.815 rise=60
.meas tran tck_61 when v(ck)=1.815 rise=61
.meas tran tck_62 when v(ck)=1.815 rise=62
.meas tran tck_63 when v(ck)=1.815 rise=63
.meas tran tck_64 when v(ck)=1.815 rise=64
.meas tran tck_65 when v(ck)=1.815 rise=65
.meas tran tck_66 when v(ck)=1.815 rise=66
.meas tran tck_67 when v(ck)=1.815 rise=67
.meas tran tck_68 when v(ck)=1.815 rise=68
.meas tran tck_69 when v(ck)=1.815 rise=69
.meas tran tck_70 when v(ck)=1.815 rise=70
.meas tran tck_71 when v(ck)=1.815 rise=71
.meas tran tck_72 when v(ck)=1.815 rise=72
.meas tran tck_73 when v(ck)=1.815 rise=73
.meas tran tck_74 when v(ck)=1.815 rise=74
.meas tran tck_75 when v(ck)=1.815 rise=75
.meas tran tck_76 when v(ck)=1.815 rise=76
.meas tran tck_77 when v(ck)=1.815 rise=77
.meas tran tck_78 when v(ck)=1.815 rise=78
.meas tran tck_79 when v(ck)=1.815 rise=79
.meas tran tck_80 when v(ck)=1.815 rise=80
.meas tran tck_81 when v(ck)=1.815 rise=81
.meas tran tck_82 when v(ck)=1.815 rise=82
.meas tran tck_83 when v(ck)=1.815 rise=83
.meas tran tck_84 when v(ck)=1.815 rise=84
.meas tran tck_85 when v(ck)=1.815 rise=85
.meas tran tck_86 when v(ck)=1.815 rise=86
.meas tran tck_87 when v(ck)=1.815 rise=87
.meas tran tck_88 when v(ck)=1.815 rise=88
.meas tran tck_89 when v(ck)=1.815 rise=89
.meas tran tck_90 when v(ck)=1.815 rise=90
.meas tran tck_91 when v(ck)=1.815 rise=91
.meas tran tck_92 when v(ck)=1.815 rise=92
.meas tran tck_93 when v(ck)=1.815 rise=93
.meas tran tck_94 when v(ck)=1.815 rise=94
.meas tran tck_95 when v(ck)=1.815 rise=95
.meas tran tck_96 when v(ck)=1.815 rise=96
.meas tran tck_97 when v(ck)=1.815 rise=97
.meas tran tck_98 when v(ck)=1.815 rise=98
.meas tran tck_99 when v(ck)=1.815 rise=99
.meas tran tck_100 when v(ck)=1.815 rise=100
.meas tran tck_101 when v(ck)=1.815 rise=101
.meas tran tck_102 when v(ck)=1.815 rise=102
.meas tran tck_103 when v(ck)=1.815 rise=103
.meas tran tck_104 when v(ck)=1.815 rise=104
.meas tran tck_105 when v(ck)=1.815 rise=105
.meas tran tck_106 when v(ck)=1.815 rise=106
.meas tran tck_107 when v(ck)=1.815 rise=107
.meas tran tck_108 when v(ck)=1.815 rise=108
.meas tran tck_109 when v(ck)=1.815 rise=109
.meas tran tck_110 when v(ck)=1.815 rise=110
.meas tran tck_111 when v(ck)=1.815 rise=111
.meas tran tck_112 when v(ck)=1.815 rise=112
.meas tran tck_113 when v(ck)=1.815 rise=113
.meas tran tck_114 when v(ck)=1.815 rise=114
.meas tran tck_115 when v(ck)=1.815 rise=115
.meas tran tck_116 when v(ck)=1.815 rise=116
.meas tran tck_117 when v(ck)=1.815 rise=117
.meas tran tck_118 when v(ck)=1.815 rise=118
.meas tran tck_119 when v(ck)=1.815 rise=119
.meas tran tck_120 when v(ck)=1.815 rise=120
.meas tran tck_121 when v(ck)=1.815 rise=121
.meas tran tck_122 when v(ck)=1.815 rise=122
.meas tran tck_123 when v(ck)=1.815 rise=123
.meas tran tck_124 when v(ck)=1.815 rise=124
.meas tran tck_125 when v(ck)=1.815 rise=125
.meas tran tck_126 when v(ck)=1.815 rise=126
.meas tran tck_127 when v(ck)=1.815 rise=127
.meas tran tck_128 when v(ck)=1.815 rise=128
.meas tran tck_129 when v(ck)=1.815 rise=129
.meas tran tck_130 when v(ck)=1.815 rise=130
.meas tran tck_131 when v(ck)=1.815 rise=131
.meas tran tck_132 when v(ck)=1.815 rise=132
.meas tran tck_133 when v(ck)=1.815 rise=133
.meas tran tck_134 when v(ck)=1.815 rise=134
.meas tran tck_135 when v(ck)=1.815 rise=135
.meas tran tck_136 when v(ck)=1.815 rise=136
.meas tran tck_137 when v(ck)=1.815 rise=137
.meas tran tck_138 when v(ck)=1.815 rise=138
.meas tran tck_139 when v(ck)=1.815 rise=139
.meas tran tck_140 when v(ck)=1.815 rise=140
.meas tran tck_141 when v(ck)=1.815 rise=141
.meas tran tck_142 when v(ck)=1.815 rise=142
.meas tran tck_143 when v(ck)=1.815 rise=143
.meas tran tck_144 when v(ck)=1.815 rise=144
.meas tran tck_145 when v(ck)=1.815 rise=145
.meas tran tck_146 when v(ck)=1.815 rise=146
.meas tran tck_147 when v(ck)=1.815 rise=147
.meas tran tck_148 when v(ck)=1.815 rise=148
.meas tran tck_149 when v(ck)=1.815 rise=149
.meas tran tck_150 when v(ck)=1.815 rise=150
.meas tran tck_151 when v(ck)=1.815 rise=151
.meas tran tck_152 when v(ck)=1.815 rise=152
.meas tran tck_153 when v(ck)=1.815 rise=153
.meas tran tck_154 when v(ck)=1.815 rise=154
.meas tran tck_155 when v(ck)=1.815 rise=155
.meas tran tck_156 when v(ck)=1.815 rise=156
.meas tran tck_157 when v(ck)=1.815 rise=157
.meas tran tck_158 when v(ck)=1.815 rise=158
.meas tran tck_159 when v(ck)=1.815 rise=159
.meas tran tck_160 when v(ck)=1.815 rise=160
.meas tran tck_161 when v(ck)=1.815 rise=161
.meas tran tck_162 when v(ck)=1.815 rise=162
.meas tran tck_163 when v(ck)=1.815 rise=163
.meas tran tck_164 when v(ck)=1.815 rise=164
.meas tran tck_165 when v(ck)=1.815 rise=165
.meas tran tck_166 when v(ck)=1.815 rise=166
.meas tran tck_167 when v(ck)=1.815 rise=167
.meas tran tck_168 when v(ck)=1.815 rise=168
.meas tran tck_169 when v(ck)=1.815 rise=169
.meas tran tck_170 when v(ck)=1.815 rise=170
.meas tran tck_171 when v(ck)=1.815 rise=171
.meas tran tck_172 when v(ck)=1.815 rise=172
.meas tran tck_173 when v(ck)=1.815 rise=173
.meas tran tck_174 when v(ck)=1.815 rise=174
.meas tran tck_175 when v(ck)=1.815 rise=175
.meas tran tck_176 when v(ck)=1.815 rise=176
.meas tran tck_177 when v(ck)=1.815 rise=177
.meas tran tck_178 when v(ck)=1.815 rise=178
.meas tran tck_179 when v(ck)=1.815 rise=179
.meas tran tck_180 when v(ck)=1.815 rise=180
.meas tran tck_181 when v(ck)=1.815 rise=181
.meas tran tck_182 when v(ck)=1.815 rise=182
.meas tran tck_183 when v(ck)=1.815 rise=183
.meas tran tck_184 when v(ck)=1.815 rise=184
.meas tran tck_185 when v(ck)=1.815 rise=185
.meas tran tck_186 when v(ck)=1.815 rise=186
.meas tran tck_187 when v(ck)=1.815 rise=187
.meas tran tck_188 when v(ck)=1.815 rise=188
.meas tran tck_189 when v(ck)=1.815 rise=189
.meas tran tck_190 when v(ck)=1.815 rise=190
.meas tran tck_191 when v(ck)=1.815 rise=191
.meas tran tck_192 when v(ck)=1.815 rise=192
.meas tran tck_193 when v(ck)=1.815 rise=193
.meas tran tck_194 when v(ck)=1.815 rise=194
.meas tran tck_195 when v(ck)=1.815 rise=195
.meas tran tck_196 when v(ck)=1.815 rise=196
.meas tran tck_197 when v(ck)=1.815 rise=197
.meas tran tck_198 when v(ck)=1.815 rise=198
.meas tran tck_199 when v(ck)=1.815 rise=199
.meas tran tck_200 when v(ck)=1.815 rise=200
.meas tran tck_201 when v(ck)=1.815 rise=201
.meas tran tck_202 when v(ck)=1.815 rise=202
.meas tran tck_203 when v(ck)=1.815 rise=203
.meas tran tck_204 when v(ck)=1.815 rise=204
.meas tran tck_205 when v(ck)=1.815 rise=205
.meas tran tck_206 when v(ck)=1.815 rise=206
.meas tran tck_207 when v(ck)=1.815 rise=207
.meas tran tck_208 when v(ck)=1.815 rise=208
.meas tran tck_209 when v(ck)=1.815 rise=209
.meas tran tck_210 when v(ck)=1.815 rise=210
.meas tran tck_211 when v(ck)=1.815 rise=211
.meas tran tck_212 when v(ck)=1.815 rise=212
.meas tran tck_213 when v(ck)=1.815 rise=213
.meas tran tck_214 when v(ck)=1.815 rise=214
.meas tran tck_215 when v(ck)=1.815 rise=215
.meas tran tck_216 when v(ck)=1.815 rise=216
.meas tran tck_217 when v(ck)=1.815 rise=217
.meas tran tck_218 when v(ck)=1.815 rise=218
.meas tran tck_219 when v(ck)=1.815 rise=219
.meas tran tck_220 when v(ck)=1.815 rise=220
.meas tran tck_221 when v(ck)=1.815 rise=221
.meas tran tck_222 when v(ck)=1.815 rise=222
.meas tran tck_223 when v(ck)=1.815 rise=223
.meas tran tck_224 when v(ck)=1.815 rise=224
.meas tran tck_225 when v(ck)=1.815 rise=225
.meas tran tck_226 when v(ck)=1.815 rise=226
.meas tran tck_227 when v(ck)=1.815 rise=227
.meas tran tck_228 when v(ck)=1.815 rise=228
.meas tran tck_229 when v(ck)=1.815 rise=229
.meas tran tck_230 when v(ck)=1.815 rise=230
.meas tran tck_231 when v(ck)=1.815 rise=231
.meas tran tck_232 when v(ck)=1.815 rise=232
.meas tran tck_233 when v(ck)=1.815 rise=233
.meas tran tck_234 when v(ck)=1.815 rise=234
.meas tran tck_235 when v(ck)=1.815 rise=235
.meas tran tck_236 when v(ck)=1.815 rise=236
.meas tran tck_237 when v(ck)=1.815 rise=237
.meas tran tck_238 when v(ck)=1.815 rise=238
.meas tran tck_239 when v(ck)=1.815 rise=239
.meas tran tck_240 when v(ck)=1.815 rise=240
.meas tran tck_241 when v(ck)=1.815 rise=241
.meas tran tck_242 when v(ck)=1.815 rise=242
.meas tran tck_243 when v(ck)=1.815 rise=243
.meas tran tck_244 when v(ck)=1.815 rise=244
.meas tran tck_245 when v(ck)=1.815 rise=245
.meas tran tck_246 when v(ck)=1.815 rise=246
.meas tran tck_247 when v(ck)=1.815 rise=247
.meas tran tck_248 when v(ck)=1.815 rise=248
.meas tran tck_249 when v(ck)=1.815 rise=249
.meas tran tck_250 when v(ck)=1.815 rise=250
.meas tran tck_251 when v(ck)=1.815 rise=251
.meas tran tck_252 when v(ck)=1.815 rise=252
.meas tran tck_253 when v(ck)=1.815 rise=253
.meas tran tck_254 when v(ck)=1.815 rise=254
.meas tran tck_255 when v(ck)=1.815 rise=255
.meas tran tck_256 when v(ck)=1.815 rise=256
.meas tran tck_257 when v(ck)=1.815 rise=257
.meas tran tck_258 when v(ck)=1.815 rise=258
.meas tran tck_259 when v(ck)=1.815 rise=259
.meas tran tck_260 when v(ck)=1.815 rise=260
.meas tran tck_261 when v(ck)=1.815 rise=261
.meas tran tck_262 when v(ck)=1.815 rise=262
.meas tran tck_263 when v(ck)=1.815 rise=263
.meas tran tck_264 when v(ck)=1.815 rise=264
.meas tran tck_265 when v(ck)=1.815 rise=265
.meas tran tck_266 when v(ck)=1.815 rise=266
.meas tran tck_267 when v(ck)=1.815 rise=267
.meas tran tck_268 when v(ck)=1.815 rise=268
.meas tran tck_269 when v(ck)=1.815 rise=269
.meas tran tck_270 when v(ck)=1.815 rise=270
.meas tran tck_271 when v(ck)=1.815 rise=271
.meas tran tck_272 when v(ck)=1.815 rise=272
.meas tran tck_273 when v(ck)=1.815 rise=273
.meas tran tck_274 when v(ck)=1.815 rise=274
.meas tran tck_275 when v(ck)=1.815 rise=275
.meas tran tck_276 when v(ck)=1.815 rise=276
.meas tran tck_277 when v(ck)=1.815 rise=277
.meas tran tck_278 when v(ck)=1.815 rise=278
.meas tran tck_279 when v(ck)=1.815 rise=279
.meas tran tck_280 when v(ck)=1.815 rise=280
.meas tran tck_281 when v(ck)=1.815 rise=281
.meas tran tck_282 when v(ck)=1.815 rise=282
.meas tran tck_283 when v(ck)=1.815 rise=283
.meas tran tck_284 when v(ck)=1.815 rise=284
.meas tran tck_285 when v(ck)=1.815 rise=285
.meas tran tck_286 when v(ck)=1.815 rise=286
.meas tran tck_287 when v(ck)=1.815 rise=287
.meas tran tck_288 when v(ck)=1.815 rise=288
.meas tran tck_289 when v(ck)=1.815 rise=289
.meas tran tck_290 when v(ck)=1.815 rise=290
.meas tran tck_291 when v(ck)=1.815 rise=291
.meas tran tck_292 when v(ck)=1.815 rise=292
.meas tran tck_293 when v(ck)=1.815 rise=293
.meas tran tck_294 when v(ck)=1.815 rise=294
.meas tran tck_295 when v(ck)=1.815 rise=295
.meas tran tck_296 when v(ck)=1.815 rise=296
.meas tran tck_297 when v(ck)=1.815 rise=297
.meas tran tck_298 when v(ck)=1.815 rise=298
.meas tran tck_299 when v(ck)=1.815 rise=299
.meas tran tck_300 when v(ck)=1.815 rise=300
.meas tran tck_301 when v(ck)=1.815 rise=301
.meas tran tck_302 when v(ck)=1.815 rise=302
.meas tran tck_303 when v(ck)=1.815 rise=303
.meas tran tck_304 when v(ck)=1.815 rise=304
.meas tran tck_305 when v(ck)=1.815 rise=305
.meas tran tck_306 when v(ck)=1.815 rise=306
.meas tran tck_307 when v(ck)=1.815 rise=307
.meas tran tck_308 when v(ck)=1.815 rise=308
.meas tran tck_309 when v(ck)=1.815 rise=309
.meas tran tck_310 when v(ck)=1.815 rise=310
.meas tran tck_311 when v(ck)=1.815 rise=311
.meas tran tck_312 when v(ck)=1.815 rise=312
.meas tran tck_313 when v(ck)=1.815 rise=313
.meas tran tck_314 when v(ck)=1.815 rise=314
.meas tran tck_315 when v(ck)=1.815 rise=315
.meas tran tck_316 when v(ck)=1.815 rise=316
.meas tran tck_317 when v(ck)=1.815 rise=317
.meas tran tck_318 when v(ck)=1.815 rise=318
.meas tran tck_319 when v(ck)=1.815 rise=319
.meas tran tck_320 when v(ck)=1.815 rise=320
.meas tran tck_321 when v(ck)=1.815 rise=321
.meas tran tck_322 when v(ck)=1.815 rise=322
.meas tran tck_323 when v(ck)=1.815 rise=323
.meas tran tck_324 when v(ck)=1.815 rise=324
.meas tran tck_325 when v(ck)=1.815 rise=325
.meas tran tck_326 when v(ck)=1.815 rise=326
.meas tran tck_327 when v(ck)=1.815 rise=327
.meas tran tck_328 when v(ck)=1.815 rise=328
.meas tran tck_329 when v(ck)=1.815 rise=329
.meas tran tck_330 when v(ck)=1.815 rise=330
.meas tran tck_331 when v(ck)=1.815 rise=331
.meas tran tck_332 when v(ck)=1.815 rise=332
.meas tran tck_333 when v(ck)=1.815 rise=333
.meas tran tck_334 when v(ck)=1.815 rise=334
.meas tran tck_335 when v(ck)=1.815 rise=335
.meas tran tck_336 when v(ck)=1.815 rise=336
.meas tran tck_337 when v(ck)=1.815 rise=337
.meas tran tck_338 when v(ck)=1.815 rise=338
.meas tran tck_339 when v(ck)=1.815 rise=339
.meas tran tck_340 when v(ck)=1.815 rise=340
.meas tran tck_341 when v(ck)=1.815 rise=341
.meas tran tck_342 when v(ck)=1.815 rise=342
.meas tran tck_343 when v(ck)=1.815 rise=343
.meas tran tck_344 when v(ck)=1.815 rise=344
.meas tran tck_345 when v(ck)=1.815 rise=345
.meas tran tck_346 when v(ck)=1.815 rise=346
.meas tran tck_347 when v(ck)=1.815 rise=347
.meas tran tck_348 when v(ck)=1.815 rise=348
.meas tran tck_349 when v(ck)=1.815 rise=349
.meas tran tck_350 when v(ck)=1.815 rise=350
.meas tran tck_351 when v(ck)=1.815 rise=351
.meas tran tck_352 when v(ck)=1.815 rise=352
.meas tran tck_353 when v(ck)=1.815 rise=353
.meas tran tck_354 when v(ck)=1.815 rise=354
.meas tran tck_355 when v(ck)=1.815 rise=355
.meas tran tck_356 when v(ck)=1.815 rise=356
.meas tran tck_357 when v(ck)=1.815 rise=357
.meas tran tck_358 when v(ck)=1.815 rise=358
.meas tran tck_359 when v(ck)=1.815 rise=359
.meas tran tck_360 when v(ck)=1.815 rise=360
.meas tran tck_361 when v(ck)=1.815 rise=361
.meas tran tck_362 when v(ck)=1.815 rise=362
.meas tran tck_363 when v(ck)=1.815 rise=363
.meas tran tck_364 when v(ck)=1.815 rise=364
.meas tran tck_365 when v(ck)=1.815 rise=365
.meas tran tck_366 when v(ck)=1.815 rise=366
.meas tran tck_367 when v(ck)=1.815 rise=367
.meas tran tck_368 when v(ck)=1.815 rise=368
.meas tran tck_369 when v(ck)=1.815 rise=369
.meas tran tck_370 when v(ck)=1.815 rise=370
.meas tran tck_371 when v(ck)=1.815 rise=371
.meas tran tck_372 when v(ck)=1.815 rise=372
.meas tran tck_373 when v(ck)=1.815 rise=373
.meas tran tck_374 when v(ck)=1.815 rise=374
.meas tran tck_375 when v(ck)=1.815 rise=375
.meas tran tck_376 when v(ck)=1.815 rise=376
.meas tran tck_377 when v(ck)=1.815 rise=377
.meas tran tck_378 when v(ck)=1.815 rise=378
.meas tran tck_379 when v(ck)=1.815 rise=379
.meas tran tck_380 when v(ck)=1.815 rise=380
.meas tran tck_381 when v(ck)=1.815 rise=381
.meas tran tck_382 when v(ck)=1.815 rise=382
.meas tran tck_383 when v(ck)=1.815 rise=383
.meas tran tck_384 when v(ck)=1.815 rise=384
.meas tran tck_385 when v(ck)=1.815 rise=385
.meas tran tck_386 when v(ck)=1.815 rise=386
.meas tran tck_387 when v(ck)=1.815 rise=387
.meas tran tck_388 when v(ck)=1.815 rise=388
.meas tran tck_389 when v(ck)=1.815 rise=389
.meas tran tck_390 when v(ck)=1.815 rise=390
.meas tran tck_391 when v(ck)=1.815 rise=391
.meas tran tck_392 when v(ck)=1.815 rise=392
.meas tran tck_393 when v(ck)=1.815 rise=393
.meas tran tck_394 when v(ck)=1.815 rise=394
.meas tran tck_395 when v(ck)=1.815 rise=395
.meas tran tck_396 when v(ck)=1.815 rise=396
.meas tran tck_397 when v(ck)=1.815 rise=397
.meas tran tck_398 when v(ck)=1.815 rise=398
.meas tran tck_399 when v(ck)=1.815 rise=399
.meas tran tck_400 when v(ck)=1.815 rise=400
.meas tran tck_401 when v(ck)=1.815 rise=401
.meas tran tck_402 when v(ck)=1.815 rise=402
.meas tran tck_403 when v(ck)=1.815 rise=403
.meas tran tck_404 when v(ck)=1.815 rise=404
.meas tran tck_405 when v(ck)=1.815 rise=405
.meas tran tck_406 when v(ck)=1.815 rise=406
.meas tran tck_407 when v(ck)=1.815 rise=407
.meas tran tck_408 when v(ck)=1.815 rise=408
.meas tran tck_409 when v(ck)=1.815 rise=409
.meas tran tck_410 when v(ck)=1.815 rise=410
.meas tran tck_411 when v(ck)=1.815 rise=411
.meas tran tck_412 when v(ck)=1.815 rise=412
.meas tran tck_413 when v(ck)=1.815 rise=413
.meas tran tck_414 when v(ck)=1.815 rise=414
.meas tran tck_415 when v(ck)=1.815 rise=415
.meas tran tck_416 when v(ck)=1.815 rise=416
.meas tran tck_417 when v(ck)=1.815 rise=417
.meas tran tck_418 when v(ck)=1.815 rise=418
.meas tran tck_419 when v(ck)=1.815 rise=419
.meas tran tck_420 when v(ck)=1.815 rise=420
.meas tran tck_421 when v(ck)=1.815 rise=421
.meas tran tck_422 when v(ck)=1.815 rise=422
.meas tran tck_423 when v(ck)=1.815 rise=423
.meas tran tck_424 when v(ck)=1.815 rise=424
.meas tran tck_425 when v(ck)=1.815 rise=425
.meas tran tck_426 when v(ck)=1.815 rise=426
.meas tran tck_427 when v(ck)=1.815 rise=427
.meas tran tck_428 when v(ck)=1.815 rise=428
.meas tran tck_429 when v(ck)=1.815 rise=429
.meas tran tck_430 when v(ck)=1.815 rise=430
.meas tran tck_431 when v(ck)=1.815 rise=431
.meas tran tck_432 when v(ck)=1.815 rise=432
.meas tran tck_433 when v(ck)=1.815 rise=433
.meas tran tck_434 when v(ck)=1.815 rise=434
.meas tran tck_435 when v(ck)=1.815 rise=435
.meas tran tck_436 when v(ck)=1.815 rise=436
.meas tran tck_437 when v(ck)=1.815 rise=437
.meas tran tck_438 when v(ck)=1.815 rise=438
.meas tran tck_439 when v(ck)=1.815 rise=439
.meas tran tck_440 when v(ck)=1.815 rise=440
.meas tran tck_441 when v(ck)=1.815 rise=441
.meas tran tck_442 when v(ck)=1.815 rise=442
.meas tran tck_443 when v(ck)=1.815 rise=443
.meas tran tck_444 when v(ck)=1.815 rise=444
.meas tran tck_445 when v(ck)=1.815 rise=445
.meas tran tck_446 when v(ck)=1.815 rise=446
.meas tran tck_447 when v(ck)=1.815 rise=447
.meas tran tck_448 when v(ck)=1.815 rise=448
.meas tran tck_449 when v(ck)=1.815 rise=449
.meas tran tck_450 when v(ck)=1.815 rise=450
.meas tran tck_451 when v(ck)=1.815 rise=451
.meas tran tck_452 when v(ck)=1.815 rise=452
.meas tran tck_453 when v(ck)=1.815 rise=453
.meas tran tck_454 when v(ck)=1.815 rise=454
.meas tran tck_455 when v(ck)=1.815 rise=455
.meas tran tck_456 when v(ck)=1.815 rise=456
.meas tran tck_457 when v(ck)=1.815 rise=457
.meas tran tck_458 when v(ck)=1.815 rise=458
.meas tran tck_459 when v(ck)=1.815 rise=459
.meas tran tck_460 when v(ck)=1.815 rise=460
.meas tran tck_461 when v(ck)=1.815 rise=461
.meas tran tck_462 when v(ck)=1.815 rise=462
.meas tran tck_463 when v(ck)=1.815 rise=463
.meas tran tck_464 when v(ck)=1.815 rise=464
.meas tran tck_465 when v(ck)=1.815 rise=465
.meas tran tck_466 when v(ck)=1.815 rise=466
.meas tran tck_467 when v(ck)=1.815 rise=467
.meas tran tck_468 when v(ck)=1.815 rise=468
.meas tran tck_469 when v(ck)=1.815 rise=469
.meas tran tck_470 when v(ck)=1.815 rise=470
.meas tran tck_471 when v(ck)=1.815 rise=471
.meas tran tck_472 when v(ck)=1.815 rise=472
.meas tran tck_473 when v(ck)=1.815 rise=473
.meas tran tck_474 when v(ck)=1.815 rise=474
.meas tran tck_475 when v(ck)=1.815 rise=475
.meas tran tck_476 when v(ck)=1.815 rise=476
.meas tran tck_477 when v(ck)=1.815 rise=477
.meas tran tck_478 when v(ck)=1.815 rise=478
.meas tran tck_479 when v(ck)=1.815 rise=479
.meas tran tck_480 when v(ck)=1.815 rise=480
.meas tran tck_481 when v(ck)=1.815 rise=481
.meas tran tck_482 when v(ck)=1.815 rise=482
.meas tran tck_483 when v(ck)=1.815 rise=483
.meas tran tck_484 when v(ck)=1.815 rise=484
.meas tran tck_485 when v(ck)=1.815 rise=485
.meas tran tck_486 when v(ck)=1.815 rise=486
.meas tran tck_487 when v(ck)=1.815 rise=487
.meas tran tck_488 when v(ck)=1.815 rise=488
.meas tran tck_489 when v(ck)=1.815 rise=489
.meas tran tck_490 when v(ck)=1.815 rise=490
.meas tran tck_491 when v(ck)=1.815 rise=491
.meas tran tck_492 when v(ck)=1.815 rise=492
.meas tran tck_493 when v(ck)=1.815 rise=493
.meas tran tck_494 when v(ck)=1.815 rise=494
.meas tran tck_495 when v(ck)=1.815 rise=495
.meas tran tck_496 when v(ck)=1.815 rise=496
.meas tran tck_497 when v(ck)=1.815 rise=497
.meas tran tck_498 when v(ck)=1.815 rise=498
.meas tran tck_499 when v(ck)=1.815 rise=499
.meas tran tck_500 when v(ck)=1.815 rise=500
.meas tran tck_501 when v(ck)=1.815 rise=501
.meas tran tck_502 when v(ck)=1.815 rise=502
.meas tran tck_503 when v(ck)=1.815 rise=503
.meas tran tck_504 when v(ck)=1.815 rise=504
.meas tran tck_505 when v(ck)=1.815 rise=505
.meas tran tck_506 when v(ck)=1.815 rise=506
.meas tran tck_507 when v(ck)=1.815 rise=507
.meas tran tck_508 when v(ck)=1.815 rise=508
.meas tran tck_509 when v(ck)=1.815 rise=509
.meas tran tck_510 when v(ck)=1.815 rise=510
.meas tran tck_511 when v(ck)=1.815 rise=511
.meas tran tck_512 when v(ck)=1.815 rise=512
.meas tran tck_513 when v(ck)=1.815 rise=513
.meas tran tck_514 when v(ck)=1.815 rise=514
.meas tran tck_515 when v(ck)=1.815 rise=515
.meas tran tck_516 when v(ck)=1.815 rise=516
.meas tran tck_517 when v(ck)=1.815 rise=517
.meas tran tck_518 when v(ck)=1.815 rise=518
.meas tran tck_519 when v(ck)=1.815 rise=519
.meas tran tck_520 when v(ck)=1.815 rise=520
.meas tran tck_521 when v(ck)=1.815 rise=521
.meas tran tck_522 when v(ck)=1.815 rise=522
.meas tran tck_523 when v(ck)=1.815 rise=523
.meas tran tck_524 when v(ck)=1.815 rise=524
.meas tran tck_525 when v(ck)=1.815 rise=525
.meas tran tck_526 when v(ck)=1.815 rise=526
.meas tran tck_527 when v(ck)=1.815 rise=527
.meas tran tck_528 when v(ck)=1.815 rise=528
.meas tran tck_529 when v(ck)=1.815 rise=529
.meas tran tck_530 when v(ck)=1.815 rise=530
.meas tran tck_531 when v(ck)=1.815 rise=531
.meas tran tck_532 when v(ck)=1.815 rise=532
.meas tran tck_533 when v(ck)=1.815 rise=533
.meas tran tck_534 when v(ck)=1.815 rise=534
.meas tran tck_535 when v(ck)=1.815 rise=535
.meas tran tck_536 when v(ck)=1.815 rise=536
.meas tran tck_537 when v(ck)=1.815 rise=537
.meas tran tck_538 when v(ck)=1.815 rise=538
.meas tran tck_539 when v(ck)=1.815 rise=539
.meas tran tck_540 when v(ck)=1.815 rise=540
.meas tran tck_541 when v(ck)=1.815 rise=541
.meas tran tck_542 when v(ck)=1.815 rise=542
.meas tran tck_543 when v(ck)=1.815 rise=543
.meas tran tck_544 when v(ck)=1.815 rise=544
.meas tran tck_545 when v(ck)=1.815 rise=545
.meas tran tck_546 when v(ck)=1.815 rise=546
.meas tran tck_547 when v(ck)=1.815 rise=547
.meas tran tck_548 when v(ck)=1.815 rise=548
.meas tran tck_549 when v(ck)=1.815 rise=549
.meas tran tck_550 when v(ck)=1.815 rise=550
.meas tran tck_551 when v(ck)=1.815 rise=551
.meas tran tck_552 when v(ck)=1.815 rise=552
.meas tran tck_553 when v(ck)=1.815 rise=553
.meas tran tck_554 when v(ck)=1.815 rise=554
.meas tran tck_555 when v(ck)=1.815 rise=555
.meas tran tck_556 when v(ck)=1.815 rise=556
.meas tran tck_557 when v(ck)=1.815 rise=557
.meas tran tck_558 when v(ck)=1.815 rise=558
.meas tran tck_559 when v(ck)=1.815 rise=559
.meas tran tck_560 when v(ck)=1.815 rise=560
.meas tran tck_561 when v(ck)=1.815 rise=561
.meas tran tck_562 when v(ck)=1.815 rise=562
.meas tran tck_563 when v(ck)=1.815 rise=563
.meas tran tck_564 when v(ck)=1.815 rise=564
.meas tran tck_565 when v(ck)=1.815 rise=565
.meas tran tck_566 when v(ck)=1.815 rise=566
.meas tran tck_567 when v(ck)=1.815 rise=567
.meas tran tck_568 when v(ck)=1.815 rise=568
.meas tran tck_569 when v(ck)=1.815 rise=569
.meas tran tck_570 when v(ck)=1.815 rise=570
.meas tran tck_571 when v(ck)=1.815 rise=571
.meas tran tck_572 when v(ck)=1.815 rise=572
.meas tran tck_573 when v(ck)=1.815 rise=573
.meas tran tck_574 when v(ck)=1.815 rise=574
.meas tran tck_575 when v(ck)=1.815 rise=575
.meas tran tck_576 when v(ck)=1.815 rise=576
.meas tran tck_577 when v(ck)=1.815 rise=577
.meas tran tck_578 when v(ck)=1.815 rise=578
.meas tran tck_579 when v(ck)=1.815 rise=579
.meas tran tck_580 when v(ck)=1.815 rise=580
.meas tran tck_581 when v(ck)=1.815 rise=581
.meas tran tck_582 when v(ck)=1.815 rise=582
.meas tran tck_583 when v(ck)=1.815 rise=583
.meas tran tck_584 when v(ck)=1.815 rise=584
.meas tran tck_585 when v(ck)=1.815 rise=585
.meas tran tck_586 when v(ck)=1.815 rise=586
.meas tran tck_587 when v(ck)=1.815 rise=587
.meas tran tck_588 when v(ck)=1.815 rise=588
.meas tran tck_589 when v(ck)=1.815 rise=589
.meas tran tck_590 when v(ck)=1.815 rise=590
.meas tran tck_591 when v(ck)=1.815 rise=591
.meas tran tck_592 when v(ck)=1.815 rise=592
.meas tran tck_593 when v(ck)=1.815 rise=593
.meas tran tck_594 when v(ck)=1.815 rise=594
.meas tran tck_595 when v(ck)=1.815 rise=595
.meas tran tck_596 when v(ck)=1.815 rise=596
.meas tran tck_597 when v(ck)=1.815 rise=597
.meas tran tck_598 when v(ck)=1.815 rise=598
.meas tran tck_599 when v(ck)=1.815 rise=599
.meas tran tck_600 when v(ck)=1.815 rise=600
.meas tran tck_601 when v(ck)=1.815 rise=601
.meas tran tck_602 when v(ck)=1.815 rise=602
.meas tran tck_603 when v(ck)=1.815 rise=603
.meas tran tck_604 when v(ck)=1.815 rise=604
.meas tran tck_605 when v(ck)=1.815 rise=605
.meas tran tck_606 when v(ck)=1.815 rise=606
.meas tran tck_607 when v(ck)=1.815 rise=607
.meas tran tck_608 when v(ck)=1.815 rise=608
.meas tran tck_609 when v(ck)=1.815 rise=609
.meas tran tck_610 when v(ck)=1.815 rise=610
.meas tran tck_611 when v(ck)=1.815 rise=611
.meas tran tck_612 when v(ck)=1.815 rise=612
.meas tran tck_613 when v(ck)=1.815 rise=613
.meas tran tck_614 when v(ck)=1.815 rise=614
.meas tran tck_615 when v(ck)=1.815 rise=615
.meas tran tck_616 when v(ck)=1.815 rise=616
.meas tran tck_617 when v(ck)=1.815 rise=617
.meas tran tck_618 when v(ck)=1.815 rise=618
.meas tran tck_619 when v(ck)=1.815 rise=619
.meas tran tck_620 when v(ck)=1.815 rise=620
.meas tran tck_621 when v(ck)=1.815 rise=621
.meas tran tck_622 when v(ck)=1.815 rise=622
.meas tran tck_623 when v(ck)=1.815 rise=623
.meas tran tck_624 when v(ck)=1.815 rise=624
.meas tran tck_625 when v(ck)=1.815 rise=625
.meas tran tck_626 when v(ck)=1.815 rise=626
.meas tran tck_627 when v(ck)=1.815 rise=627
.meas tran tck_628 when v(ck)=1.815 rise=628
.meas tran tck_629 when v(ck)=1.815 rise=629
.meas tran tck_630 when v(ck)=1.815 rise=630
.meas tran tck_631 when v(ck)=1.815 rise=631
.meas tran tck_632 when v(ck)=1.815 rise=632
.meas tran tck_633 when v(ck)=1.815 rise=633
.meas tran tck_634 when v(ck)=1.815 rise=634
.meas tran tck_635 when v(ck)=1.815 rise=635
.meas tran tck_636 when v(ck)=1.815 rise=636
.meas tran tck_637 when v(ck)=1.815 rise=637
.meas tran tck_638 when v(ck)=1.815 rise=638
.meas tran tck_639 when v(ck)=1.815 rise=639
.meas tran tck_640 when v(ck)=1.815 rise=640
.meas tran tck_641 when v(ck)=1.815 rise=641
.meas tran tck_642 when v(ck)=1.815 rise=642
.meas tran tck_643 when v(ck)=1.815 rise=643
.meas tran tck_644 when v(ck)=1.815 rise=644
.meas tran tck_645 when v(ck)=1.815 rise=645
.meas tran tck_646 when v(ck)=1.815 rise=646
.meas tran tck_647 when v(ck)=1.815 rise=647
.meas tran tck_648 when v(ck)=1.815 rise=648
.meas tran tck_649 when v(ck)=1.815 rise=649
.meas tran tck_650 when v(ck)=1.815 rise=650
.meas tran tck_651 when v(ck)=1.815 rise=651
.meas tran tck_652 when v(ck)=1.815 rise=652
.meas tran tck_653 when v(ck)=1.815 rise=653
.meas tran tck_654 when v(ck)=1.815 rise=654
.meas tran tck_655 when v(ck)=1.815 rise=655
.meas tran tck_656 when v(ck)=1.815 rise=656
.meas tran tck_657 when v(ck)=1.815 rise=657
.meas tran tck_658 when v(ck)=1.815 rise=658
.meas tran tck_659 when v(ck)=1.815 rise=659
.meas tran tck_660 when v(ck)=1.815 rise=660
.meas tran tck_661 when v(ck)=1.815 rise=661
.meas tran tck_662 when v(ck)=1.815 rise=662
.meas tran tck_663 when v(ck)=1.815 rise=663
.meas tran tck_664 when v(ck)=1.815 rise=664
.meas tran tck_665 when v(ck)=1.815 rise=665
.meas tran tck_666 when v(ck)=1.815 rise=666
.meas tran tck_667 when v(ck)=1.815 rise=667
.meas tran tck_668 when v(ck)=1.815 rise=668
.meas tran tck_669 when v(ck)=1.815 rise=669
.meas tran tck_670 when v(ck)=1.815 rise=670
.meas tran tck_671 when v(ck)=1.815 rise=671
.meas tran tck_672 when v(ck)=1.815 rise=672
.meas tran tck_673 when v(ck)=1.815 rise=673
.meas tran tck_674 when v(ck)=1.815 rise=674
.meas tran tck_675 when v(ck)=1.815 rise=675
.meas tran tck_676 when v(ck)=1.815 rise=676
.meas tran tck_677 when v(ck)=1.815 rise=677
.meas tran tck_678 when v(ck)=1.815 rise=678
.meas tran tck_679 when v(ck)=1.815 rise=679
.meas tran tck_680 when v(ck)=1.815 rise=680
.meas tran tck_681 when v(ck)=1.815 rise=681
.meas tran tck_682 when v(ck)=1.815 rise=682
.meas tran tck_683 when v(ck)=1.815 rise=683
.meas tran tck_684 when v(ck)=1.815 rise=684
.meas tran tck_685 when v(ck)=1.815 rise=685
.meas tran tck_686 when v(ck)=1.815 rise=686
.meas tran tck_687 when v(ck)=1.815 rise=687
.meas tran tck_688 when v(ck)=1.815 rise=688
.meas tran tck_689 when v(ck)=1.815 rise=689
.meas tran tck_690 when v(ck)=1.815 rise=690
.meas tran tck_691 when v(ck)=1.815 rise=691
.meas tran tck_692 when v(ck)=1.815 rise=692
.meas tran tck_693 when v(ck)=1.815 rise=693
.meas tran tck_694 when v(ck)=1.815 rise=694
.meas tran tck_695 when v(ck)=1.815 rise=695
.meas tran tck_696 when v(ck)=1.815 rise=696
.meas tran tck_697 when v(ck)=1.815 rise=697
.meas tran tck_698 when v(ck)=1.815 rise=698
.meas tran tck_699 when v(ck)=1.815 rise=699
.meas tran tck_700 when v(ck)=1.815 rise=700
.meas tran tck_701 when v(ck)=1.815 rise=701
.meas tran tck_702 when v(ck)=1.815 rise=702
.meas tran tck_703 when v(ck)=1.815 rise=703
.meas tran tck_704 when v(ck)=1.815 rise=704
.meas tran tck_705 when v(ck)=1.815 rise=705
.meas tran tck_706 when v(ck)=1.815 rise=706
.meas tran tck_707 when v(ck)=1.815 rise=707
.meas tran tck_708 when v(ck)=1.815 rise=708
.meas tran tck_709 when v(ck)=1.815 rise=709
.meas tran tck_710 when v(ck)=1.815 rise=710
.meas tran tck_711 when v(ck)=1.815 rise=711
.meas tran tck_712 when v(ck)=1.815 rise=712
.meas tran tck_713 when v(ck)=1.815 rise=713
.meas tran tck_714 when v(ck)=1.815 rise=714
.meas tran tck_715 when v(ck)=1.815 rise=715
.meas tran tck_716 when v(ck)=1.815 rise=716
.meas tran tck_717 when v(ck)=1.815 rise=717
.meas tran tck_718 when v(ck)=1.815 rise=718
.meas tran tck_719 when v(ck)=1.815 rise=719
.meas tran tck_720 when v(ck)=1.815 rise=720
.meas tran tck_721 when v(ck)=1.815 rise=721
.meas tran tck_722 when v(ck)=1.815 rise=722
.meas tran tck_723 when v(ck)=1.815 rise=723
.meas tran tck_724 when v(ck)=1.815 rise=724
.meas tran tck_725 when v(ck)=1.815 rise=725
.meas tran tck_726 when v(ck)=1.815 rise=726
.meas tran tck_727 when v(ck)=1.815 rise=727
.meas tran tck_728 when v(ck)=1.815 rise=728
.meas tran tck_729 when v(ck)=1.815 rise=729
.meas tran tck_730 when v(ck)=1.815 rise=730
.meas tran tck_731 when v(ck)=1.815 rise=731
.meas tran tck_732 when v(ck)=1.815 rise=732
.meas tran tck_733 when v(ck)=1.815 rise=733
.meas tran tck_734 when v(ck)=1.815 rise=734
.meas tran tck_735 when v(ck)=1.815 rise=735
.meas tran tck_736 when v(ck)=1.815 rise=736
.meas tran tck_737 when v(ck)=1.815 rise=737
.meas tran tck_738 when v(ck)=1.815 rise=738
.meas tran tck_739 when v(ck)=1.815 rise=739
.meas tran tck_740 when v(ck)=1.815 rise=740
.meas tran tck_741 when v(ck)=1.815 rise=741
.meas tran tck_742 when v(ck)=1.815 rise=742
.meas tran tck_743 when v(ck)=1.815 rise=743
.meas tran tck_744 when v(ck)=1.815 rise=744
.meas tran tck_745 when v(ck)=1.815 rise=745
.meas tran tck_746 when v(ck)=1.815 rise=746
.meas tran tck_747 when v(ck)=1.815 rise=747
.meas tran tck_748 when v(ck)=1.815 rise=748
.meas tran tck_749 when v(ck)=1.815 rise=749
.meas tran tck_750 when v(ck)=1.815 rise=750
.meas tran tck_751 when v(ck)=1.815 rise=751
.meas tran tck_752 when v(ck)=1.815 rise=752
.meas tran tck_753 when v(ck)=1.815 rise=753
.meas tran tck_754 when v(ck)=1.815 rise=754
.meas tran tck_755 when v(ck)=1.815 rise=755
.meas tran tck_756 when v(ck)=1.815 rise=756
.meas tran tck_757 when v(ck)=1.815 rise=757
.meas tran tck_758 when v(ck)=1.815 rise=758
.meas tran tck_759 when v(ck)=1.815 rise=759
.meas tran tck_760 when v(ck)=1.815 rise=760
.meas tran tck_761 when v(ck)=1.815 rise=761
.meas tran tck_762 when v(ck)=1.815 rise=762
.meas tran tck_763 when v(ck)=1.815 rise=763
.meas tran tck_764 when v(ck)=1.815 rise=764
.meas tran tck_765 when v(ck)=1.815 rise=765
.meas tran tck_766 when v(ck)=1.815 rise=766
.meas tran tck_767 when v(ck)=1.815 rise=767
.meas tran tck_768 when v(ck)=1.815 rise=768
.meas tran tck_769 when v(ck)=1.815 rise=769
.meas tran tck_770 when v(ck)=1.815 rise=770
.meas tran tck_771 when v(ck)=1.815 rise=771
.meas tran tck_772 when v(ck)=1.815 rise=772
.meas tran tck_773 when v(ck)=1.815 rise=773
.meas tran tck_774 when v(ck)=1.815 rise=774
.meas tran tck_775 when v(ck)=1.815 rise=775
.meas tran tck_776 when v(ck)=1.815 rise=776
.meas tran tck_777 when v(ck)=1.815 rise=777
.meas tran tck_778 when v(ck)=1.815 rise=778
.meas tran tck_779 when v(ck)=1.815 rise=779
.meas tran tck_780 when v(ck)=1.815 rise=780
.meas tran tck_781 when v(ck)=1.815 rise=781
.meas tran tck_782 when v(ck)=1.815 rise=782
.meas tran tck_783 when v(ck)=1.815 rise=783
.meas tran tck_784 when v(ck)=1.815 rise=784
.meas tran tck_785 when v(ck)=1.815 rise=785
.meas tran tck_786 when v(ck)=1.815 rise=786
.meas tran tck_787 when v(ck)=1.815 rise=787
.meas tran tck_788 when v(ck)=1.815 rise=788
.meas tran tck_789 when v(ck)=1.815 rise=789
.meas tran tck_790 when v(ck)=1.815 rise=790
.meas tran tck_791 when v(ck)=1.815 rise=791
.meas tran tck_792 when v(ck)=1.815 rise=792
.meas tran tck_793 when v(ck)=1.815 rise=793
.meas tran tck_794 when v(ck)=1.815 rise=794
.meas tran tck_795 when v(ck)=1.815 rise=795
.meas tran tck_796 when v(ck)=1.815 rise=796
.meas tran tck_797 when v(ck)=1.815 rise=797
.meas tran tck_798 when v(ck)=1.815 rise=798
.meas tran tck_799 when v(ck)=1.815 rise=799
.meas tran tck_800 when v(ck)=1.815 rise=800
.meas tran tck_801 when v(ck)=1.815 rise=801
.meas tran tck_802 when v(ck)=1.815 rise=802
.meas tran tck_803 when v(ck)=1.815 rise=803
.meas tran tck_804 when v(ck)=1.815 rise=804
.meas tran tck_805 when v(ck)=1.815 rise=805
.meas tran tck_806 when v(ck)=1.815 rise=806
.meas tran tck_807 when v(ck)=1.815 rise=807
.meas tran tck_808 when v(ck)=1.815 rise=808
.meas tran tck_809 when v(ck)=1.815 rise=809
.meas tran tck_810 when v(ck)=1.815 rise=810
.meas tran tck_811 when v(ck)=1.815 rise=811
.meas tran tck_812 when v(ck)=1.815 rise=812
.meas tran tck_813 when v(ck)=1.815 rise=813
.meas tran tck_814 when v(ck)=1.815 rise=814
.meas tran tck_815 when v(ck)=1.815 rise=815
.meas tran tck_816 when v(ck)=1.815 rise=816
.meas tran tck_817 when v(ck)=1.815 rise=817
.meas tran tck_818 when v(ck)=1.815 rise=818
.meas tran tck_819 when v(ck)=1.815 rise=819
.meas tran tck_820 when v(ck)=1.815 rise=820
.meas tran tck_821 when v(ck)=1.815 rise=821
.meas tran tck_822 when v(ck)=1.815 rise=822
.meas tran tck_823 when v(ck)=1.815 rise=823
.meas tran tck_824 when v(ck)=1.815 rise=824
.meas tran tck_825 when v(ck)=1.815 rise=825
.meas tran tck_826 when v(ck)=1.815 rise=826
.meas tran tck_827 when v(ck)=1.815 rise=827
.meas tran tck_828 when v(ck)=1.815 rise=828
.meas tran tck_829 when v(ck)=1.815 rise=829
.meas tran tck_830 when v(ck)=1.815 rise=830
.meas tran tck_831 when v(ck)=1.815 rise=831
.meas tran tck_832 when v(ck)=1.815 rise=832
.meas tran tck_833 when v(ck)=1.815 rise=833
.meas tran tck_834 when v(ck)=1.815 rise=834
.meas tran tck_835 when v(ck)=1.815 rise=835
.meas tran tck_836 when v(ck)=1.815 rise=836
.meas tran tck_837 when v(ck)=1.815 rise=837
.meas tran tck_838 when v(ck)=1.815 rise=838
.meas tran tck_839 when v(ck)=1.815 rise=839
.meas tran tck_840 when v(ck)=1.815 rise=840
.meas tran tck_841 when v(ck)=1.815 rise=841
.meas tran tck_842 when v(ck)=1.815 rise=842
.meas tran tck_843 when v(ck)=1.815 rise=843
.meas tran tck_844 when v(ck)=1.815 rise=844
.meas tran tck_845 when v(ck)=1.815 rise=845
.meas tran tck_846 when v(ck)=1.815 rise=846
.meas tran tck_847 when v(ck)=1.815 rise=847
.meas tran tck_848 when v(ck)=1.815 rise=848
.meas tran tck_849 when v(ck)=1.815 rise=849
.meas tran tck_850 when v(ck)=1.815 rise=850
.meas tran tck_851 when v(ck)=1.815 rise=851
.meas tran tck_852 when v(ck)=1.815 rise=852
.meas tran tck_853 when v(ck)=1.815 rise=853
.meas tran tck_854 when v(ck)=1.815 rise=854
.meas tran tck_855 when v(ck)=1.815 rise=855
.meas tran tck_856 when v(ck)=1.815 rise=856
.meas tran tck_857 when v(ck)=1.815 rise=857
.meas tran tck_858 when v(ck)=1.815 rise=858
.meas tran tck_859 when v(ck)=1.815 rise=859
.meas tran tck_860 when v(ck)=1.815 rise=860
.meas tran tck_861 when v(ck)=1.815 rise=861
.meas tran tck_862 when v(ck)=1.815 rise=862
.meas tran tck_863 when v(ck)=1.815 rise=863
.meas tran tck_864 when v(ck)=1.815 rise=864
.meas tran tck_865 when v(ck)=1.815 rise=865
.meas tran tck_866 when v(ck)=1.815 rise=866
.meas tran tck_867 when v(ck)=1.815 rise=867
.meas tran tck_868 when v(ck)=1.815 rise=868
.meas tran tck_869 when v(ck)=1.815 rise=869
.meas tran tck_870 when v(ck)=1.815 rise=870
.meas tran tck_871 when v(ck)=1.815 rise=871
.meas tran tck_872 when v(ck)=1.815 rise=872
.meas tran tck_873 when v(ck)=1.815 rise=873
.meas tran tck_874 when v(ck)=1.815 rise=874
.meas tran tck_875 when v(ck)=1.815 rise=875
.meas tran tck_876 when v(ck)=1.815 rise=876
.meas tran tck_877 when v(ck)=1.815 rise=877
.meas tran tck_878 when v(ck)=1.815 rise=878
.meas tran tck_879 when v(ck)=1.815 rise=879
.meas tran tck_880 when v(ck)=1.815 rise=880
.meas tran tck_881 when v(ck)=1.815 rise=881
.meas tran tck_882 when v(ck)=1.815 rise=882
.meas tran tck_883 when v(ck)=1.815 rise=883
.meas tran tck_884 when v(ck)=1.815 rise=884
.meas tran tck_885 when v(ck)=1.815 rise=885
.meas tran tck_886 when v(ck)=1.815 rise=886
.meas tran tck_887 when v(ck)=1.815 rise=887
.meas tran tck_888 when v(ck)=1.815 rise=888
.meas tran tck_889 when v(ck)=1.815 rise=889
.meas tran tck_890 when v(ck)=1.815 rise=890
.meas tran tck_891 when v(ck)=1.815 rise=891
.meas tran tck_892 when v(ck)=1.815 rise=892
.meas tran tck_893 when v(ck)=1.815 rise=893
.meas tran tck_894 when v(ck)=1.815 rise=894
.meas tran tck_895 when v(ck)=1.815 rise=895
.meas tran tck_896 when v(ck)=1.815 rise=896
.meas tran tck_897 when v(ck)=1.815 rise=897
.meas tran tck_898 when v(ck)=1.815 rise=898
.meas tran tck_899 when v(ck)=1.815 rise=899
.meas tran tck_900 when v(ck)=1.815 rise=900
.meas tran tck_901 when v(ck)=1.815 rise=901
.meas tran tck_902 when v(ck)=1.815 rise=902
.meas tran tck_903 when v(ck)=1.815 rise=903
.meas tran tck_904 when v(ck)=1.815 rise=904
.meas tran tck_905 when v(ck)=1.815 rise=905
.meas tran tck_906 when v(ck)=1.815 rise=906
.meas tran tck_907 when v(ck)=1.815 rise=907
.meas tran tck_908 when v(ck)=1.815 rise=908
.meas tran tck_909 when v(ck)=1.815 rise=909
.meas tran tck_910 when v(ck)=1.815 rise=910
.meas tran tck_911 when v(ck)=1.815 rise=911
.meas tran tck_912 when v(ck)=1.815 rise=912
.meas tran tck_913 when v(ck)=1.815 rise=913
.meas tran tck_914 when v(ck)=1.815 rise=914
.meas tran tck_915 when v(ck)=1.815 rise=915
.meas tran tck_916 when v(ck)=1.815 rise=916
.meas tran tck_917 when v(ck)=1.815 rise=917
.meas tran tck_918 when v(ck)=1.815 rise=918
.meas tran tck_919 when v(ck)=1.815 rise=919
.meas tran tck_920 when v(ck)=1.815 rise=920
.meas tran tck_921 when v(ck)=1.815 rise=921
.meas tran tck_922 when v(ck)=1.815 rise=922
.meas tran tck_923 when v(ck)=1.815 rise=923
.meas tran tck_924 when v(ck)=1.815 rise=924
.meas tran tck_925 when v(ck)=1.815 rise=925
.meas tran tck_926 when v(ck)=1.815 rise=926
.meas tran tck_927 when v(ck)=1.815 rise=927
.meas tran tck_928 when v(ck)=1.815 rise=928
.meas tran tck_929 when v(ck)=1.815 rise=929
.meas tran tck_930 when v(ck)=1.815 rise=930
.meas tran tck_931 when v(ck)=1.815 rise=931
.meas tran tck_932 when v(ck)=1.815 rise=932
.meas tran tck_933 when v(ck)=1.815 rise=933
.meas tran tck_934 when v(ck)=1.815 rise=934
.meas tran tck_935 when v(ck)=1.815 rise=935
.meas tran tck_936 when v(ck)=1.815 rise=936
.meas tran tck_937 when v(ck)=1.815 rise=937
.meas tran tck_938 when v(ck)=1.815 rise=938
.meas tran tck_939 when v(ck)=1.815 rise=939
.meas tran tck_940 when v(ck)=1.815 rise=940
.meas tran tck_941 when v(ck)=1.815 rise=941
.meas tran tck_942 when v(ck)=1.815 rise=942
.meas tran tck_943 when v(ck)=1.815 rise=943
.meas tran tck_944 when v(ck)=1.815 rise=944
.meas tran tck_945 when v(ck)=1.815 rise=945
.meas tran tck_946 when v(ck)=1.815 rise=946
.meas tran tck_947 when v(ck)=1.815 rise=947
.meas tran tck_948 when v(ck)=1.815 rise=948
.meas tran tck_949 when v(ck)=1.815 rise=949
.meas tran tck_950 when v(ck)=1.815 rise=950
.meas tran tck_951 when v(ck)=1.815 rise=951
.meas tran tck_952 when v(ck)=1.815 rise=952
.meas tran tck_953 when v(ck)=1.815 rise=953
.meas tran tck_954 when v(ck)=1.815 rise=954
.meas tran tck_955 when v(ck)=1.815 rise=955
.meas tran tck_956 when v(ck)=1.815 rise=956
.meas tran tck_957 when v(ck)=1.815 rise=957
.meas tran tck_958 when v(ck)=1.815 rise=958
.meas tran tck_959 when v(ck)=1.815 rise=959
.meas tran tck_960 when v(ck)=1.815 rise=960
.meas tran tck_961 when v(ck)=1.815 rise=961
.meas tran tck_962 when v(ck)=1.815 rise=962
.meas tran tck_963 when v(ck)=1.815 rise=963
.meas tran tck_964 when v(ck)=1.815 rise=964
.meas tran tck_965 when v(ck)=1.815 rise=965
.meas tran tck_966 when v(ck)=1.815 rise=966
.meas tran tck_967 when v(ck)=1.815 rise=967
.meas tran tck_968 when v(ck)=1.815 rise=968
.meas tran tck_969 when v(ck)=1.815 rise=969
.meas tran tck_970 when v(ck)=1.815 rise=970
.meas tran tck_971 when v(ck)=1.815 rise=971
.meas tran tck_972 when v(ck)=1.815 rise=972
.meas tran tck_973 when v(ck)=1.815 rise=973
.meas tran tck_974 when v(ck)=1.815 rise=974
.meas tran tck_975 when v(ck)=1.815 rise=975
.meas tran tck_976 when v(ck)=1.815 rise=976
.meas tran tck_977 when v(ck)=1.815 rise=977
.meas tran tck_978 when v(ck)=1.815 rise=978
.meas tran tck_979 when v(ck)=1.815 rise=979
.meas tran tck_980 when v(ck)=1.815 rise=980
.meas tran tck_981 when v(ck)=1.815 rise=981
.meas tran tck_982 when v(ck)=1.815 rise=982
.meas tran tck_983 when v(ck)=1.815 rise=983
.meas tran tck_984 when v(ck)=1.815 rise=984
.meas tran tck_985 when v(ck)=1.815 rise=985
.meas tran tck_986 when v(ck)=1.815 rise=986
.meas tran tck_987 when v(ck)=1.815 rise=987
.meas tran tck_988 when v(ck)=1.815 rise=988
.meas tran tck_989 when v(ck)=1.815 rise=989
.meas tran tck_990 when v(ck)=1.815 rise=990
.meas tran tck_991 when v(ck)=1.815 rise=991
.meas tran tck_992 when v(ck)=1.815 rise=992
.meas tran tck_993 when v(ck)=1.815 rise=993
.meas tran tck_994 when v(ck)=1.815 rise=994
.meas tran tck_995 when v(ck)=1.815 rise=995
.meas tran tck_996 when v(ck)=1.815 rise=996
.meas tran tck_997 when v(ck)=1.815 rise=997
.meas tran tck_998 when v(ck)=1.815 rise=998
.meas tran tck_999 when v(ck)=1.815 rise=999
.meas tran tck_1000 when v(ck)=1.815 rise=1000
.meas tran tck_1001 when v(ck)=1.815 rise=1001
.meas tran tck_1002 when v(ck)=1.815 rise=1002
.meas tran tck_1003 when v(ck)=1.815 rise=1003
.meas tran tck_1004 when v(ck)=1.815 rise=1004
.meas tran tck_1005 when v(ck)=1.815 rise=1005
.meas tran tck_1006 when v(ck)=1.815 rise=1006
.meas tran tck_1007 when v(ck)=1.815 rise=1007
.meas tran tck_1008 when v(ck)=1.815 rise=1008
.meas tran tck_1009 when v(ck)=1.815 rise=1009
.meas tran tck_1010 when v(ck)=1.815 rise=1010
.meas tran tck_1011 when v(ck)=1.815 rise=1011
.meas tran tck_1012 when v(ck)=1.815 rise=1012
.meas tran tck_1013 when v(ck)=1.815 rise=1013
.meas tran tck_1014 when v(ck)=1.815 rise=1014
.meas tran tck_1015 when v(ck)=1.815 rise=1015
.meas tran tck_1016 when v(ck)=1.815 rise=1016
.meas tran tck_1017 when v(ck)=1.815 rise=1017
.meas tran tck_1018 when v(ck)=1.815 rise=1018
.meas tran tck_1019 when v(ck)=1.815 rise=1019
.meas tran tck_1020 when v(ck)=1.815 rise=1020
.meas tran tck_1021 when v(ck)=1.815 rise=1021
.meas tran tck_1022 when v(ck)=1.815 rise=1022
.meas tran tck_1023 when v(ck)=1.815 rise=1023
.meas tran tck_1024 when v(ck)=1.815 rise=1024
.meas tran tck_1025 when v(ck)=1.815 rise=1025
.meas tran tck_1026 when v(ck)=1.815 rise=1026
.meas tran tck_1027 when v(ck)=1.815 rise=1027
.meas tran tck_1028 when v(ck)=1.815 rise=1028
.meas tran tck_1029 when v(ck)=1.815 rise=1029
.meas tran tck_1030 when v(ck)=1.815 rise=1030
.meas tran tck_1031 when v(ck)=1.815 rise=1031
.meas tran tck_1032 when v(ck)=1.815 rise=1032
.meas tran tck_1033 when v(ck)=1.815 rise=1033
.meas tran tck_1034 when v(ck)=1.815 rise=1034
.meas tran tck_1035 when v(ck)=1.815 rise=1035
.meas tran tck_1036 when v(ck)=1.815 rise=1036
.meas tran tck_1037 when v(ck)=1.815 rise=1037
.meas tran tck_1038 when v(ck)=1.815 rise=1038
.meas tran tck_1039 when v(ck)=1.815 rise=1039
.meas tran tck_1040 when v(ck)=1.815 rise=1040
.meas tran tck_1041 when v(ck)=1.815 rise=1041
.meas tran tck_1042 when v(ck)=1.815 rise=1042
.meas tran tck_1043 when v(ck)=1.815 rise=1043
.meas tran tck_1044 when v(ck)=1.815 rise=1044
.meas tran tck_1045 when v(ck)=1.815 rise=1045
.meas tran tck_1046 when v(ck)=1.815 rise=1046
.meas tran tck_1047 when v(ck)=1.815 rise=1047
.meas tran tck_1048 when v(ck)=1.815 rise=1048
.meas tran tfb_1 when v(fb)=1.815 rise=1
.meas tran tfb_2 when v(fb)=1.815 rise=2
.meas tran tfb_3 when v(fb)=1.815 rise=3
.meas tran tfb_4 when v(fb)=1.815 rise=4
.meas tran tfb_5 when v(fb)=1.815 rise=5
.meas tran tfb_6 when v(fb)=1.815 rise=6
.meas tran tfb_7 when v(fb)=1.815 rise=7
.meas tran tfb_8 when v(fb)=1.815 rise=8
.meas tran tfb_9 when v(fb)=1.815 rise=9
.meas tran tfb_10 when v(fb)=1.815 rise=10
.meas tran tfb_11 when v(fb)=1.815 rise=11
.end
