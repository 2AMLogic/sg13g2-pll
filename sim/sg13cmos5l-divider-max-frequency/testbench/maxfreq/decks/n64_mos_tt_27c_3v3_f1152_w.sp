* sg13g2-pll :: sim/sg13cmos5l-divider-max-frequency (issue #402)
* `divider_chain` maximum-input-frequency deck: the committed (repaired)
* divider_chain alone, ideal pulse clock at one frequency, one corner,
* one programming word. Counts -- via ngspice `.meas ... when rise=k` --
* the FIRST `1.65` crossing time of every rising edge of the clock (CKIN)
* and of the feedback clock (FB) within `4.644600e-07`; the collector
* (../testbench/collect_maxfreq.py) buckets the CKIN edges per FB period and
* scores each period against the programmed ratio N. Wave units
* (the generator's "waves" flag) additionally dump the internal stage nodes
* ck1..ck5 (plus CKIN/FB/DIVOUT) as text for the failing-stage isolation
* (AC 3); the collector gzips that dump into ../corners/.
*
* The deck is rendered per unit by ../testbench/gen_maxfreq_requests.py,
* which substitutes the corner (mos_tt), temperature (27), supply
* (3.3, with the 50 % crossing threshold 1.65 -- the supply corners
* make a hard-coded 1.65 V wrong), the clock period (8.680556e-10) and high time
* (3.540278e-10 = 8.680556e-10/2 - 80 p: 80 ps edges and ~50 % duty, the SAME drive shape
* tb_div_speed.sp.tmpl used for the 640 MHz / 1.28 GHz bracket this
* campaign anchors against), timestep, stop time, reltol, the programming
* word, the saved-node list, an optional waveform-dump control block and
* the emitted per-edge .meas lines.
*
* PDK provenance: the deck names the PINNED model files relative to itself
* (`models/`, `osdi/`). `klt sim`'s deck-list preservation contract stages
* those files from the submitting host -- the pinned
* `ihp-sg13cmos5l 607e18d4...` checkout's bytes (staged by the generator,
* which refuses to run without `--pinned-pdk`) -- so neither this deck nor
* the record may cite `$PDK_ROOT` (that resolves on the worker to the
* newer, unpinned fleet image). See ../records/RECORD-001.
*
* Both clock inputs of `divider_chain` are driven from the same source
* (`CKIN` = `CKIN_VCO` = `ck`): in the closed loop they are the same net,
* exactly as in tb_div_func.sp.tmpl. Driving them separately would invent
* a skew the design does not have.
*
* `divider_chain` has NO reset pin: its 13 `dff_tg_hv` state elements have
* no defined power-up state, so the DC operating point is indeterminate and
* ngspice's gmin/source stepping cannot resolve it. These `.ic` statements
* are the minimum symmetry break that makes an OP exist -- a TESTBENCH
* workaround for a DESIGN gap (Finding 1 of
* sim/sg13cmos5l-divider-nrange-retiming/records/RECORD-001), not a
* property of the block.
*
* The `.control` block deliberately contains NO `run`. With a `.control`
* present, ngspice executes the control block BEFORE the deck-level analyses
* (that is why `pre_osdi` works from here -- it must precede model
* resolution), so a bare `wrdata` in the control block would run before the
* transient's vectors exist. Wave units therefore render the POST block as a
* control-block `tran` command + `linearize` + `wrdata`: the analysis is
* started from the control block itself (the deck-level TRAN line is
* rendered empty for wave units), `linearize`/`wrdata` then see the
* transient vectors, and the deck-level `.meas` cards still evaluate (they
* hook the analysis regardless of how it was started; measured 2026-11-15:
* single transient, waves.txt written, .meas values identical to the
* deck-level-.tran form). Every non-wave unit keeps the deck-level TRAN.

.lib models/cornerMOShv.lib mos_tt
.option scale=1 temp=27
.options reltol=0.001 vntol=1e-4 abstol=1e-9 trtol=7
.global sub!

.include divider_chain.spice

Vdd vdd 0 dc 3.3
Vsub sub! 0 dc 0
Vck ck 0 pulse(0 3.3 0 80p 80p 3.540278e-10 8.680556e-10)
Vp0 p0 0 dc 0
Vp1 p1 0 dc 0
Vp2 p2 0 dc 0
Vp3 p3 0 dc 0
Vp4 p4 0 dc 0
Vp5 p5 0 dc 0

Xdiv ck ck p0 p1 p2 p3 p4 p5 fb divout vdd 0 divider_chain

.ic v(xdiv.xd0.xdffq.m)=0 v(xdiv.xd0.xdffq.s)=0 v(xdiv.xd0.xdffm.m)=0 v(xdiv.xd0.xdffm.s)=0
.ic v(xdiv.xd1.xdffq.m)=0 v(xdiv.xd1.xdffq.s)=0 v(xdiv.xd1.xdffm.m)=0 v(xdiv.xd1.xdffm.s)=0
.ic v(xdiv.xd2.xdffq.m)=0 v(xdiv.xd2.xdffq.s)=0 v(xdiv.xd2.xdffm.m)=0 v(xdiv.xd2.xdffm.s)=0
.ic v(xdiv.xd3.xdffq.m)=0 v(xdiv.xd3.xdffq.s)=0 v(xdiv.xd3.xdffm.m)=0 v(xdiv.xd3.xdffm.s)=0
.ic v(xdiv.xd4.xdffq.m)=0 v(xdiv.xd4.xdffq.s)=0 v(xdiv.xd4.xdffm.m)=0 v(xdiv.xd4.xdffm.s)=0
.ic v(xdiv.xd5.xdffq.m)=0 v(xdiv.xd5.xdffq.s)=0 v(xdiv.xd5.xdffm.m)=0 v(xdiv.xd5.xdffm.s)=0
.ic v(xdiv.xfrt.m)=0 v(xdiv.xfrt.s)=0

.save v(ck) v(xdiv.ck1) v(xdiv.ck2) v(xdiv.ck3) v(xdiv.ck4) v(xdiv.ck5) v(fb) v(divout)

.control
pre_osdi osdi/psp103.osdi
pre_osdi osdi/psp103_nqs.osdi
pre_osdi osdi/mosvar.osdi
set num_threads=2
tran 2.000000e-11 4.644600e-07 0 2.000000e-11
linearize v(ck) v(xdiv.ck1) v(xdiv.ck2) v(xdiv.ck3) v(xdiv.ck4) v(xdiv.ck5) v(fb) v(divout)
wrdata waves.txt v(ck) v(xdiv.ck1) v(xdiv.ck2) v(xdiv.ck3) v(xdiv.ck4) v(xdiv.ck5) v(fb) v(divout)
.endc
.meas tran tck_1 when v(ck)=1.65 rise=1
.meas tran tck_2 when v(ck)=1.65 rise=2
.meas tran tck_3 when v(ck)=1.65 rise=3
.meas tran tck_4 when v(ck)=1.65 rise=4
.meas tran tck_5 when v(ck)=1.65 rise=5
.meas tran tck_6 when v(ck)=1.65 rise=6
.meas tran tck_7 when v(ck)=1.65 rise=7
.meas tran tck_8 when v(ck)=1.65 rise=8
.meas tran tck_9 when v(ck)=1.65 rise=9
.meas tran tck_10 when v(ck)=1.65 rise=10
.meas tran tck_11 when v(ck)=1.65 rise=11
.meas tran tck_12 when v(ck)=1.65 rise=12
.meas tran tck_13 when v(ck)=1.65 rise=13
.meas tran tck_14 when v(ck)=1.65 rise=14
.meas tran tck_15 when v(ck)=1.65 rise=15
.meas tran tck_16 when v(ck)=1.65 rise=16
.meas tran tck_17 when v(ck)=1.65 rise=17
.meas tran tck_18 when v(ck)=1.65 rise=18
.meas tran tck_19 when v(ck)=1.65 rise=19
.meas tran tck_20 when v(ck)=1.65 rise=20
.meas tran tck_21 when v(ck)=1.65 rise=21
.meas tran tck_22 when v(ck)=1.65 rise=22
.meas tran tck_23 when v(ck)=1.65 rise=23
.meas tran tck_24 when v(ck)=1.65 rise=24
.meas tran tck_25 when v(ck)=1.65 rise=25
.meas tran tck_26 when v(ck)=1.65 rise=26
.meas tran tck_27 when v(ck)=1.65 rise=27
.meas tran tck_28 when v(ck)=1.65 rise=28
.meas tran tck_29 when v(ck)=1.65 rise=29
.meas tran tck_30 when v(ck)=1.65 rise=30
.meas tran tck_31 when v(ck)=1.65 rise=31
.meas tran tck_32 when v(ck)=1.65 rise=32
.meas tran tck_33 when v(ck)=1.65 rise=33
.meas tran tck_34 when v(ck)=1.65 rise=34
.meas tran tck_35 when v(ck)=1.65 rise=35
.meas tran tck_36 when v(ck)=1.65 rise=36
.meas tran tck_37 when v(ck)=1.65 rise=37
.meas tran tck_38 when v(ck)=1.65 rise=38
.meas tran tck_39 when v(ck)=1.65 rise=39
.meas tran tck_40 when v(ck)=1.65 rise=40
.meas tran tck_41 when v(ck)=1.65 rise=41
.meas tran tck_42 when v(ck)=1.65 rise=42
.meas tran tck_43 when v(ck)=1.65 rise=43
.meas tran tck_44 when v(ck)=1.65 rise=44
.meas tran tck_45 when v(ck)=1.65 rise=45
.meas tran tck_46 when v(ck)=1.65 rise=46
.meas tran tck_47 when v(ck)=1.65 rise=47
.meas tran tck_48 when v(ck)=1.65 rise=48
.meas tran tck_49 when v(ck)=1.65 rise=49
.meas tran tck_50 when v(ck)=1.65 rise=50
.meas tran tck_51 when v(ck)=1.65 rise=51
.meas tran tck_52 when v(ck)=1.65 rise=52
.meas tran tck_53 when v(ck)=1.65 rise=53
.meas tran tck_54 when v(ck)=1.65 rise=54
.meas tran tck_55 when v(ck)=1.65 rise=55
.meas tran tck_56 when v(ck)=1.65 rise=56
.meas tran tck_57 when v(ck)=1.65 rise=57
.meas tran tck_58 when v(ck)=1.65 rise=58
.meas tran tck_59 when v(ck)=1.65 rise=59
.meas tran tck_60 when v(ck)=1.65 rise=60
.meas tran tck_61 when v(ck)=1.65 rise=61
.meas tran tck_62 when v(ck)=1.65 rise=62
.meas tran tck_63 when v(ck)=1.65 rise=63
.meas tran tck_64 when v(ck)=1.65 rise=64
.meas tran tck_65 when v(ck)=1.65 rise=65
.meas tran tck_66 when v(ck)=1.65 rise=66
.meas tran tck_67 when v(ck)=1.65 rise=67
.meas tran tck_68 when v(ck)=1.65 rise=68
.meas tran tck_69 when v(ck)=1.65 rise=69
.meas tran tck_70 when v(ck)=1.65 rise=70
.meas tran tck_71 when v(ck)=1.65 rise=71
.meas tran tck_72 when v(ck)=1.65 rise=72
.meas tran tck_73 when v(ck)=1.65 rise=73
.meas tran tck_74 when v(ck)=1.65 rise=74
.meas tran tck_75 when v(ck)=1.65 rise=75
.meas tran tck_76 when v(ck)=1.65 rise=76
.meas tran tck_77 when v(ck)=1.65 rise=77
.meas tran tck_78 when v(ck)=1.65 rise=78
.meas tran tck_79 when v(ck)=1.65 rise=79
.meas tran tck_80 when v(ck)=1.65 rise=80
.meas tran tck_81 when v(ck)=1.65 rise=81
.meas tran tck_82 when v(ck)=1.65 rise=82
.meas tran tck_83 when v(ck)=1.65 rise=83
.meas tran tck_84 when v(ck)=1.65 rise=84
.meas tran tck_85 when v(ck)=1.65 rise=85
.meas tran tck_86 when v(ck)=1.65 rise=86
.meas tran tck_87 when v(ck)=1.65 rise=87
.meas tran tck_88 when v(ck)=1.65 rise=88
.meas tran tck_89 when v(ck)=1.65 rise=89
.meas tran tck_90 when v(ck)=1.65 rise=90
.meas tran tck_91 when v(ck)=1.65 rise=91
.meas tran tck_92 when v(ck)=1.65 rise=92
.meas tran tck_93 when v(ck)=1.65 rise=93
.meas tran tck_94 when v(ck)=1.65 rise=94
.meas tran tck_95 when v(ck)=1.65 rise=95
.meas tran tck_96 when v(ck)=1.65 rise=96
.meas tran tck_97 when v(ck)=1.65 rise=97
.meas tran tck_98 when v(ck)=1.65 rise=98
.meas tran tck_99 when v(ck)=1.65 rise=99
.meas tran tck_100 when v(ck)=1.65 rise=100
.meas tran tck_101 when v(ck)=1.65 rise=101
.meas tran tck_102 when v(ck)=1.65 rise=102
.meas tran tck_103 when v(ck)=1.65 rise=103
.meas tran tck_104 when v(ck)=1.65 rise=104
.meas tran tck_105 when v(ck)=1.65 rise=105
.meas tran tck_106 when v(ck)=1.65 rise=106
.meas tran tck_107 when v(ck)=1.65 rise=107
.meas tran tck_108 when v(ck)=1.65 rise=108
.meas tran tck_109 when v(ck)=1.65 rise=109
.meas tran tck_110 when v(ck)=1.65 rise=110
.meas tran tck_111 when v(ck)=1.65 rise=111
.meas tran tck_112 when v(ck)=1.65 rise=112
.meas tran tck_113 when v(ck)=1.65 rise=113
.meas tran tck_114 when v(ck)=1.65 rise=114
.meas tran tck_115 when v(ck)=1.65 rise=115
.meas tran tck_116 when v(ck)=1.65 rise=116
.meas tran tck_117 when v(ck)=1.65 rise=117
.meas tran tck_118 when v(ck)=1.65 rise=118
.meas tran tck_119 when v(ck)=1.65 rise=119
.meas tran tck_120 when v(ck)=1.65 rise=120
.meas tran tck_121 when v(ck)=1.65 rise=121
.meas tran tck_122 when v(ck)=1.65 rise=122
.meas tran tck_123 when v(ck)=1.65 rise=123
.meas tran tck_124 when v(ck)=1.65 rise=124
.meas tran tck_125 when v(ck)=1.65 rise=125
.meas tran tck_126 when v(ck)=1.65 rise=126
.meas tran tck_127 when v(ck)=1.65 rise=127
.meas tran tck_128 when v(ck)=1.65 rise=128
.meas tran tck_129 when v(ck)=1.65 rise=129
.meas tran tck_130 when v(ck)=1.65 rise=130
.meas tran tck_131 when v(ck)=1.65 rise=131
.meas tran tck_132 when v(ck)=1.65 rise=132
.meas tran tck_133 when v(ck)=1.65 rise=133
.meas tran tck_134 when v(ck)=1.65 rise=134
.meas tran tck_135 when v(ck)=1.65 rise=135
.meas tran tck_136 when v(ck)=1.65 rise=136
.meas tran tck_137 when v(ck)=1.65 rise=137
.meas tran tck_138 when v(ck)=1.65 rise=138
.meas tran tck_139 when v(ck)=1.65 rise=139
.meas tran tck_140 when v(ck)=1.65 rise=140
.meas tran tck_141 when v(ck)=1.65 rise=141
.meas tran tck_142 when v(ck)=1.65 rise=142
.meas tran tck_143 when v(ck)=1.65 rise=143
.meas tran tck_144 when v(ck)=1.65 rise=144
.meas tran tck_145 when v(ck)=1.65 rise=145
.meas tran tck_146 when v(ck)=1.65 rise=146
.meas tran tck_147 when v(ck)=1.65 rise=147
.meas tran tck_148 when v(ck)=1.65 rise=148
.meas tran tck_149 when v(ck)=1.65 rise=149
.meas tran tck_150 when v(ck)=1.65 rise=150
.meas tran tck_151 when v(ck)=1.65 rise=151
.meas tran tck_152 when v(ck)=1.65 rise=152
.meas tran tck_153 when v(ck)=1.65 rise=153
.meas tran tck_154 when v(ck)=1.65 rise=154
.meas tran tck_155 when v(ck)=1.65 rise=155
.meas tran tck_156 when v(ck)=1.65 rise=156
.meas tran tck_157 when v(ck)=1.65 rise=157
.meas tran tck_158 when v(ck)=1.65 rise=158
.meas tran tck_159 when v(ck)=1.65 rise=159
.meas tran tck_160 when v(ck)=1.65 rise=160
.meas tran tck_161 when v(ck)=1.65 rise=161
.meas tran tck_162 when v(ck)=1.65 rise=162
.meas tran tck_163 when v(ck)=1.65 rise=163
.meas tran tck_164 when v(ck)=1.65 rise=164
.meas tran tck_165 when v(ck)=1.65 rise=165
.meas tran tck_166 when v(ck)=1.65 rise=166
.meas tran tck_167 when v(ck)=1.65 rise=167
.meas tran tck_168 when v(ck)=1.65 rise=168
.meas tran tck_169 when v(ck)=1.65 rise=169
.meas tran tck_170 when v(ck)=1.65 rise=170
.meas tran tck_171 when v(ck)=1.65 rise=171
.meas tran tck_172 when v(ck)=1.65 rise=172
.meas tran tck_173 when v(ck)=1.65 rise=173
.meas tran tck_174 when v(ck)=1.65 rise=174
.meas tran tck_175 when v(ck)=1.65 rise=175
.meas tran tck_176 when v(ck)=1.65 rise=176
.meas tran tck_177 when v(ck)=1.65 rise=177
.meas tran tck_178 when v(ck)=1.65 rise=178
.meas tran tck_179 when v(ck)=1.65 rise=179
.meas tran tck_180 when v(ck)=1.65 rise=180
.meas tran tck_181 when v(ck)=1.65 rise=181
.meas tran tck_182 when v(ck)=1.65 rise=182
.meas tran tck_183 when v(ck)=1.65 rise=183
.meas tran tck_184 when v(ck)=1.65 rise=184
.meas tran tck_185 when v(ck)=1.65 rise=185
.meas tran tck_186 when v(ck)=1.65 rise=186
.meas tran tck_187 when v(ck)=1.65 rise=187
.meas tran tck_188 when v(ck)=1.65 rise=188
.meas tran tck_189 when v(ck)=1.65 rise=189
.meas tran tck_190 when v(ck)=1.65 rise=190
.meas tran tck_191 when v(ck)=1.65 rise=191
.meas tran tck_192 when v(ck)=1.65 rise=192
.meas tran tck_193 when v(ck)=1.65 rise=193
.meas tran tck_194 when v(ck)=1.65 rise=194
.meas tran tck_195 when v(ck)=1.65 rise=195
.meas tran tck_196 when v(ck)=1.65 rise=196
.meas tran tck_197 when v(ck)=1.65 rise=197
.meas tran tck_198 when v(ck)=1.65 rise=198
.meas tran tck_199 when v(ck)=1.65 rise=199
.meas tran tck_200 when v(ck)=1.65 rise=200
.meas tran tck_201 when v(ck)=1.65 rise=201
.meas tran tck_202 when v(ck)=1.65 rise=202
.meas tran tck_203 when v(ck)=1.65 rise=203
.meas tran tck_204 when v(ck)=1.65 rise=204
.meas tran tck_205 when v(ck)=1.65 rise=205
.meas tran tck_206 when v(ck)=1.65 rise=206
.meas tran tck_207 when v(ck)=1.65 rise=207
.meas tran tck_208 when v(ck)=1.65 rise=208
.meas tran tck_209 when v(ck)=1.65 rise=209
.meas tran tck_210 when v(ck)=1.65 rise=210
.meas tran tck_211 when v(ck)=1.65 rise=211
.meas tran tck_212 when v(ck)=1.65 rise=212
.meas tran tck_213 when v(ck)=1.65 rise=213
.meas tran tck_214 when v(ck)=1.65 rise=214
.meas tran tck_215 when v(ck)=1.65 rise=215
.meas tran tck_216 when v(ck)=1.65 rise=216
.meas tran tck_217 when v(ck)=1.65 rise=217
.meas tran tck_218 when v(ck)=1.65 rise=218
.meas tran tck_219 when v(ck)=1.65 rise=219
.meas tran tck_220 when v(ck)=1.65 rise=220
.meas tran tck_221 when v(ck)=1.65 rise=221
.meas tran tck_222 when v(ck)=1.65 rise=222
.meas tran tck_223 when v(ck)=1.65 rise=223
.meas tran tck_224 when v(ck)=1.65 rise=224
.meas tran tck_225 when v(ck)=1.65 rise=225
.meas tran tck_226 when v(ck)=1.65 rise=226
.meas tran tck_227 when v(ck)=1.65 rise=227
.meas tran tck_228 when v(ck)=1.65 rise=228
.meas tran tck_229 when v(ck)=1.65 rise=229
.meas tran tck_230 when v(ck)=1.65 rise=230
.meas tran tck_231 when v(ck)=1.65 rise=231
.meas tran tck_232 when v(ck)=1.65 rise=232
.meas tran tck_233 when v(ck)=1.65 rise=233
.meas tran tck_234 when v(ck)=1.65 rise=234
.meas tran tck_235 when v(ck)=1.65 rise=235
.meas tran tck_236 when v(ck)=1.65 rise=236
.meas tran tck_237 when v(ck)=1.65 rise=237
.meas tran tck_238 when v(ck)=1.65 rise=238
.meas tran tck_239 when v(ck)=1.65 rise=239
.meas tran tck_240 when v(ck)=1.65 rise=240
.meas tran tck_241 when v(ck)=1.65 rise=241
.meas tran tck_242 when v(ck)=1.65 rise=242
.meas tran tck_243 when v(ck)=1.65 rise=243
.meas tran tck_244 when v(ck)=1.65 rise=244
.meas tran tck_245 when v(ck)=1.65 rise=245
.meas tran tck_246 when v(ck)=1.65 rise=246
.meas tran tck_247 when v(ck)=1.65 rise=247
.meas tran tck_248 when v(ck)=1.65 rise=248
.meas tran tck_249 when v(ck)=1.65 rise=249
.meas tran tck_250 when v(ck)=1.65 rise=250
.meas tran tck_251 when v(ck)=1.65 rise=251
.meas tran tck_252 when v(ck)=1.65 rise=252
.meas tran tck_253 when v(ck)=1.65 rise=253
.meas tran tck_254 when v(ck)=1.65 rise=254
.meas tran tck_255 when v(ck)=1.65 rise=255
.meas tran tck_256 when v(ck)=1.65 rise=256
.meas tran tck_257 when v(ck)=1.65 rise=257
.meas tran tck_258 when v(ck)=1.65 rise=258
.meas tran tck_259 when v(ck)=1.65 rise=259
.meas tran tck_260 when v(ck)=1.65 rise=260
.meas tran tck_261 when v(ck)=1.65 rise=261
.meas tran tck_262 when v(ck)=1.65 rise=262
.meas tran tck_263 when v(ck)=1.65 rise=263
.meas tran tck_264 when v(ck)=1.65 rise=264
.meas tran tck_265 when v(ck)=1.65 rise=265
.meas tran tck_266 when v(ck)=1.65 rise=266
.meas tran tck_267 when v(ck)=1.65 rise=267
.meas tran tck_268 when v(ck)=1.65 rise=268
.meas tran tck_269 when v(ck)=1.65 rise=269
.meas tran tck_270 when v(ck)=1.65 rise=270
.meas tran tck_271 when v(ck)=1.65 rise=271
.meas tran tck_272 when v(ck)=1.65 rise=272
.meas tran tck_273 when v(ck)=1.65 rise=273
.meas tran tck_274 when v(ck)=1.65 rise=274
.meas tran tck_275 when v(ck)=1.65 rise=275
.meas tran tck_276 when v(ck)=1.65 rise=276
.meas tran tck_277 when v(ck)=1.65 rise=277
.meas tran tck_278 when v(ck)=1.65 rise=278
.meas tran tck_279 when v(ck)=1.65 rise=279
.meas tran tck_280 when v(ck)=1.65 rise=280
.meas tran tck_281 when v(ck)=1.65 rise=281
.meas tran tck_282 when v(ck)=1.65 rise=282
.meas tran tck_283 when v(ck)=1.65 rise=283
.meas tran tck_284 when v(ck)=1.65 rise=284
.meas tran tck_285 when v(ck)=1.65 rise=285
.meas tran tck_286 when v(ck)=1.65 rise=286
.meas tran tck_287 when v(ck)=1.65 rise=287
.meas tran tck_288 when v(ck)=1.65 rise=288
.meas tran tck_289 when v(ck)=1.65 rise=289
.meas tran tck_290 when v(ck)=1.65 rise=290
.meas tran tck_291 when v(ck)=1.65 rise=291
.meas tran tck_292 when v(ck)=1.65 rise=292
.meas tran tck_293 when v(ck)=1.65 rise=293
.meas tran tck_294 when v(ck)=1.65 rise=294
.meas tran tck_295 when v(ck)=1.65 rise=295
.meas tran tck_296 when v(ck)=1.65 rise=296
.meas tran tck_297 when v(ck)=1.65 rise=297
.meas tran tck_298 when v(ck)=1.65 rise=298
.meas tran tck_299 when v(ck)=1.65 rise=299
.meas tran tck_300 when v(ck)=1.65 rise=300
.meas tran tck_301 when v(ck)=1.65 rise=301
.meas tran tck_302 when v(ck)=1.65 rise=302
.meas tran tck_303 when v(ck)=1.65 rise=303
.meas tran tck_304 when v(ck)=1.65 rise=304
.meas tran tck_305 when v(ck)=1.65 rise=305
.meas tran tck_306 when v(ck)=1.65 rise=306
.meas tran tck_307 when v(ck)=1.65 rise=307
.meas tran tck_308 when v(ck)=1.65 rise=308
.meas tran tck_309 when v(ck)=1.65 rise=309
.meas tran tck_310 when v(ck)=1.65 rise=310
.meas tran tck_311 when v(ck)=1.65 rise=311
.meas tran tck_312 when v(ck)=1.65 rise=312
.meas tran tck_313 when v(ck)=1.65 rise=313
.meas tran tck_314 when v(ck)=1.65 rise=314
.meas tran tck_315 when v(ck)=1.65 rise=315
.meas tran tck_316 when v(ck)=1.65 rise=316
.meas tran tck_317 when v(ck)=1.65 rise=317
.meas tran tck_318 when v(ck)=1.65 rise=318
.meas tran tck_319 when v(ck)=1.65 rise=319
.meas tran tck_320 when v(ck)=1.65 rise=320
.meas tran tck_321 when v(ck)=1.65 rise=321
.meas tran tck_322 when v(ck)=1.65 rise=322
.meas tran tck_323 when v(ck)=1.65 rise=323
.meas tran tck_324 when v(ck)=1.65 rise=324
.meas tran tck_325 when v(ck)=1.65 rise=325
.meas tran tck_326 when v(ck)=1.65 rise=326
.meas tran tck_327 when v(ck)=1.65 rise=327
.meas tran tck_328 when v(ck)=1.65 rise=328
.meas tran tck_329 when v(ck)=1.65 rise=329
.meas tran tck_330 when v(ck)=1.65 rise=330
.meas tran tck_331 when v(ck)=1.65 rise=331
.meas tran tck_332 when v(ck)=1.65 rise=332
.meas tran tck_333 when v(ck)=1.65 rise=333
.meas tran tck_334 when v(ck)=1.65 rise=334
.meas tran tck_335 when v(ck)=1.65 rise=335
.meas tran tck_336 when v(ck)=1.65 rise=336
.meas tran tck_337 when v(ck)=1.65 rise=337
.meas tran tck_338 when v(ck)=1.65 rise=338
.meas tran tck_339 when v(ck)=1.65 rise=339
.meas tran tck_340 when v(ck)=1.65 rise=340
.meas tran tck_341 when v(ck)=1.65 rise=341
.meas tran tck_342 when v(ck)=1.65 rise=342
.meas tran tck_343 when v(ck)=1.65 rise=343
.meas tran tck_344 when v(ck)=1.65 rise=344
.meas tran tck_345 when v(ck)=1.65 rise=345
.meas tran tck_346 when v(ck)=1.65 rise=346
.meas tran tck_347 when v(ck)=1.65 rise=347
.meas tran tck_348 when v(ck)=1.65 rise=348
.meas tran tck_349 when v(ck)=1.65 rise=349
.meas tran tck_350 when v(ck)=1.65 rise=350
.meas tran tck_351 when v(ck)=1.65 rise=351
.meas tran tck_352 when v(ck)=1.65 rise=352
.meas tran tck_353 when v(ck)=1.65 rise=353
.meas tran tck_354 when v(ck)=1.65 rise=354
.meas tran tck_355 when v(ck)=1.65 rise=355
.meas tran tck_356 when v(ck)=1.65 rise=356
.meas tran tck_357 when v(ck)=1.65 rise=357
.meas tran tck_358 when v(ck)=1.65 rise=358
.meas tran tck_359 when v(ck)=1.65 rise=359
.meas tran tck_360 when v(ck)=1.65 rise=360
.meas tran tck_361 when v(ck)=1.65 rise=361
.meas tran tck_362 when v(ck)=1.65 rise=362
.meas tran tck_363 when v(ck)=1.65 rise=363
.meas tran tck_364 when v(ck)=1.65 rise=364
.meas tran tck_365 when v(ck)=1.65 rise=365
.meas tran tck_366 when v(ck)=1.65 rise=366
.meas tran tck_367 when v(ck)=1.65 rise=367
.meas tran tck_368 when v(ck)=1.65 rise=368
.meas tran tck_369 when v(ck)=1.65 rise=369
.meas tran tck_370 when v(ck)=1.65 rise=370
.meas tran tck_371 when v(ck)=1.65 rise=371
.meas tran tck_372 when v(ck)=1.65 rise=372
.meas tran tck_373 when v(ck)=1.65 rise=373
.meas tran tck_374 when v(ck)=1.65 rise=374
.meas tran tck_375 when v(ck)=1.65 rise=375
.meas tran tck_376 when v(ck)=1.65 rise=376
.meas tran tck_377 when v(ck)=1.65 rise=377
.meas tran tck_378 when v(ck)=1.65 rise=378
.meas tran tck_379 when v(ck)=1.65 rise=379
.meas tran tck_380 when v(ck)=1.65 rise=380
.meas tran tck_381 when v(ck)=1.65 rise=381
.meas tran tck_382 when v(ck)=1.65 rise=382
.meas tran tck_383 when v(ck)=1.65 rise=383
.meas tran tck_384 when v(ck)=1.65 rise=384
.meas tran tck_385 when v(ck)=1.65 rise=385
.meas tran tck_386 when v(ck)=1.65 rise=386
.meas tran tck_387 when v(ck)=1.65 rise=387
.meas tran tck_388 when v(ck)=1.65 rise=388
.meas tran tck_389 when v(ck)=1.65 rise=389
.meas tran tck_390 when v(ck)=1.65 rise=390
.meas tran tck_391 when v(ck)=1.65 rise=391
.meas tran tck_392 when v(ck)=1.65 rise=392
.meas tran tck_393 when v(ck)=1.65 rise=393
.meas tran tck_394 when v(ck)=1.65 rise=394
.meas tran tck_395 when v(ck)=1.65 rise=395
.meas tran tck_396 when v(ck)=1.65 rise=396
.meas tran tck_397 when v(ck)=1.65 rise=397
.meas tran tck_398 when v(ck)=1.65 rise=398
.meas tran tck_399 when v(ck)=1.65 rise=399
.meas tran tck_400 when v(ck)=1.65 rise=400
.meas tran tck_401 when v(ck)=1.65 rise=401
.meas tran tck_402 when v(ck)=1.65 rise=402
.meas tran tck_403 when v(ck)=1.65 rise=403
.meas tran tck_404 when v(ck)=1.65 rise=404
.meas tran tck_405 when v(ck)=1.65 rise=405
.meas tran tck_406 when v(ck)=1.65 rise=406
.meas tran tck_407 when v(ck)=1.65 rise=407
.meas tran tck_408 when v(ck)=1.65 rise=408
.meas tran tck_409 when v(ck)=1.65 rise=409
.meas tran tck_410 when v(ck)=1.65 rise=410
.meas tran tck_411 when v(ck)=1.65 rise=411
.meas tran tck_412 when v(ck)=1.65 rise=412
.meas tran tck_413 when v(ck)=1.65 rise=413
.meas tran tck_414 when v(ck)=1.65 rise=414
.meas tran tck_415 when v(ck)=1.65 rise=415
.meas tran tck_416 when v(ck)=1.65 rise=416
.meas tran tck_417 when v(ck)=1.65 rise=417
.meas tran tck_418 when v(ck)=1.65 rise=418
.meas tran tck_419 when v(ck)=1.65 rise=419
.meas tran tck_420 when v(ck)=1.65 rise=420
.meas tran tck_421 when v(ck)=1.65 rise=421
.meas tran tck_422 when v(ck)=1.65 rise=422
.meas tran tck_423 when v(ck)=1.65 rise=423
.meas tran tck_424 when v(ck)=1.65 rise=424
.meas tran tck_425 when v(ck)=1.65 rise=425
.meas tran tck_426 when v(ck)=1.65 rise=426
.meas tran tck_427 when v(ck)=1.65 rise=427
.meas tran tck_428 when v(ck)=1.65 rise=428
.meas tran tck_429 when v(ck)=1.65 rise=429
.meas tran tck_430 when v(ck)=1.65 rise=430
.meas tran tck_431 when v(ck)=1.65 rise=431
.meas tran tck_432 when v(ck)=1.65 rise=432
.meas tran tck_433 when v(ck)=1.65 rise=433
.meas tran tck_434 when v(ck)=1.65 rise=434
.meas tran tck_435 when v(ck)=1.65 rise=435
.meas tran tck_436 when v(ck)=1.65 rise=436
.meas tran tck_437 when v(ck)=1.65 rise=437
.meas tran tck_438 when v(ck)=1.65 rise=438
.meas tran tck_439 when v(ck)=1.65 rise=439
.meas tran tck_440 when v(ck)=1.65 rise=440
.meas tran tck_441 when v(ck)=1.65 rise=441
.meas tran tck_442 when v(ck)=1.65 rise=442
.meas tran tck_443 when v(ck)=1.65 rise=443
.meas tran tck_444 when v(ck)=1.65 rise=444
.meas tran tck_445 when v(ck)=1.65 rise=445
.meas tran tck_446 when v(ck)=1.65 rise=446
.meas tran tck_447 when v(ck)=1.65 rise=447
.meas tran tck_448 when v(ck)=1.65 rise=448
.meas tran tck_449 when v(ck)=1.65 rise=449
.meas tran tck_450 when v(ck)=1.65 rise=450
.meas tran tck_451 when v(ck)=1.65 rise=451
.meas tran tck_452 when v(ck)=1.65 rise=452
.meas tran tck_453 when v(ck)=1.65 rise=453
.meas tran tck_454 when v(ck)=1.65 rise=454
.meas tran tck_455 when v(ck)=1.65 rise=455
.meas tran tck_456 when v(ck)=1.65 rise=456
.meas tran tck_457 when v(ck)=1.65 rise=457
.meas tran tck_458 when v(ck)=1.65 rise=458
.meas tran tck_459 when v(ck)=1.65 rise=459
.meas tran tck_460 when v(ck)=1.65 rise=460
.meas tran tck_461 when v(ck)=1.65 rise=461
.meas tran tck_462 when v(ck)=1.65 rise=462
.meas tran tck_463 when v(ck)=1.65 rise=463
.meas tran tck_464 when v(ck)=1.65 rise=464
.meas tran tck_465 when v(ck)=1.65 rise=465
.meas tran tck_466 when v(ck)=1.65 rise=466
.meas tran tck_467 when v(ck)=1.65 rise=467
.meas tran tck_468 when v(ck)=1.65 rise=468
.meas tran tck_469 when v(ck)=1.65 rise=469
.meas tran tck_470 when v(ck)=1.65 rise=470
.meas tran tck_471 when v(ck)=1.65 rise=471
.meas tran tck_472 when v(ck)=1.65 rise=472
.meas tran tck_473 when v(ck)=1.65 rise=473
.meas tran tck_474 when v(ck)=1.65 rise=474
.meas tran tck_475 when v(ck)=1.65 rise=475
.meas tran tck_476 when v(ck)=1.65 rise=476
.meas tran tck_477 when v(ck)=1.65 rise=477
.meas tran tck_478 when v(ck)=1.65 rise=478
.meas tran tck_479 when v(ck)=1.65 rise=479
.meas tran tck_480 when v(ck)=1.65 rise=480
.meas tran tck_481 when v(ck)=1.65 rise=481
.meas tran tck_482 when v(ck)=1.65 rise=482
.meas tran tck_483 when v(ck)=1.65 rise=483
.meas tran tck_484 when v(ck)=1.65 rise=484
.meas tran tck_485 when v(ck)=1.65 rise=485
.meas tran tck_486 when v(ck)=1.65 rise=486
.meas tran tck_487 when v(ck)=1.65 rise=487
.meas tran tck_488 when v(ck)=1.65 rise=488
.meas tran tck_489 when v(ck)=1.65 rise=489
.meas tran tck_490 when v(ck)=1.65 rise=490
.meas tran tck_491 when v(ck)=1.65 rise=491
.meas tran tck_492 when v(ck)=1.65 rise=492
.meas tran tck_493 when v(ck)=1.65 rise=493
.meas tran tck_494 when v(ck)=1.65 rise=494
.meas tran tck_495 when v(ck)=1.65 rise=495
.meas tran tck_496 when v(ck)=1.65 rise=496
.meas tran tck_497 when v(ck)=1.65 rise=497
.meas tran tck_498 when v(ck)=1.65 rise=498
.meas tran tck_499 when v(ck)=1.65 rise=499
.meas tran tck_500 when v(ck)=1.65 rise=500
.meas tran tck_501 when v(ck)=1.65 rise=501
.meas tran tck_502 when v(ck)=1.65 rise=502
.meas tran tck_503 when v(ck)=1.65 rise=503
.meas tran tck_504 when v(ck)=1.65 rise=504
.meas tran tck_505 when v(ck)=1.65 rise=505
.meas tran tck_506 when v(ck)=1.65 rise=506
.meas tran tck_507 when v(ck)=1.65 rise=507
.meas tran tck_508 when v(ck)=1.65 rise=508
.meas tran tck_509 when v(ck)=1.65 rise=509
.meas tran tck_510 when v(ck)=1.65 rise=510
.meas tran tck_511 when v(ck)=1.65 rise=511
.meas tran tck_512 when v(ck)=1.65 rise=512
.meas tran tck_513 when v(ck)=1.65 rise=513
.meas tran tck_514 when v(ck)=1.65 rise=514
.meas tran tck_515 when v(ck)=1.65 rise=515
.meas tran tck_516 when v(ck)=1.65 rise=516
.meas tran tck_517 when v(ck)=1.65 rise=517
.meas tran tck_518 when v(ck)=1.65 rise=518
.meas tran tck_519 when v(ck)=1.65 rise=519
.meas tran tck_520 when v(ck)=1.65 rise=520
.meas tran tck_521 when v(ck)=1.65 rise=521
.meas tran tck_522 when v(ck)=1.65 rise=522
.meas tran tck_523 when v(ck)=1.65 rise=523
.meas tran tck_524 when v(ck)=1.65 rise=524
.meas tran tck_525 when v(ck)=1.65 rise=525
.meas tran tck_526 when v(ck)=1.65 rise=526
.meas tran tck_527 when v(ck)=1.65 rise=527
.meas tran tck_528 when v(ck)=1.65 rise=528
.meas tran tck_529 when v(ck)=1.65 rise=529
.meas tran tck_530 when v(ck)=1.65 rise=530
.meas tran tck_531 when v(ck)=1.65 rise=531
.meas tran tck_532 when v(ck)=1.65 rise=532
.meas tran tck_533 when v(ck)=1.65 rise=533
.meas tran tck_534 when v(ck)=1.65 rise=534
.meas tran tck_535 when v(ck)=1.65 rise=535
.meas tran tck_536 when v(ck)=1.65 rise=536
.meas tran tck1_1 when v(xdiv.ck1)=1.65 rise=1
.meas tran tck1_2 when v(xdiv.ck1)=1.65 rise=2
.meas tran tck1_3 when v(xdiv.ck1)=1.65 rise=3
.meas tran tck1_4 when v(xdiv.ck1)=1.65 rise=4
.meas tran tck1_5 when v(xdiv.ck1)=1.65 rise=5
.meas tran tck1_6 when v(xdiv.ck1)=1.65 rise=6
.meas tran tck1_7 when v(xdiv.ck1)=1.65 rise=7
.meas tran tck1_8 when v(xdiv.ck1)=1.65 rise=8
.meas tran tck1_9 when v(xdiv.ck1)=1.65 rise=9
.meas tran tck1_10 when v(xdiv.ck1)=1.65 rise=10
.meas tran tck1_11 when v(xdiv.ck1)=1.65 rise=11
.meas tran tck1_12 when v(xdiv.ck1)=1.65 rise=12
.meas tran tck1_13 when v(xdiv.ck1)=1.65 rise=13
.meas tran tck1_14 when v(xdiv.ck1)=1.65 rise=14
.meas tran tck1_15 when v(xdiv.ck1)=1.65 rise=15
.meas tran tck1_16 when v(xdiv.ck1)=1.65 rise=16
.meas tran tck1_17 when v(xdiv.ck1)=1.65 rise=17
.meas tran tck1_18 when v(xdiv.ck1)=1.65 rise=18
.meas tran tck1_19 when v(xdiv.ck1)=1.65 rise=19
.meas tran tck1_20 when v(xdiv.ck1)=1.65 rise=20
.meas tran tck1_21 when v(xdiv.ck1)=1.65 rise=21
.meas tran tck1_22 when v(xdiv.ck1)=1.65 rise=22
.meas tran tck1_23 when v(xdiv.ck1)=1.65 rise=23
.meas tran tck1_24 when v(xdiv.ck1)=1.65 rise=24
.meas tran tck1_25 when v(xdiv.ck1)=1.65 rise=25
.meas tran tck1_26 when v(xdiv.ck1)=1.65 rise=26
.meas tran tck1_27 when v(xdiv.ck1)=1.65 rise=27
.meas tran tck1_28 when v(xdiv.ck1)=1.65 rise=28
.meas tran tck1_29 when v(xdiv.ck1)=1.65 rise=29
.meas tran tck1_30 when v(xdiv.ck1)=1.65 rise=30
.meas tran tck1_31 when v(xdiv.ck1)=1.65 rise=31
.meas tran tck1_32 when v(xdiv.ck1)=1.65 rise=32
.meas tran tck1_33 when v(xdiv.ck1)=1.65 rise=33
.meas tran tck1_34 when v(xdiv.ck1)=1.65 rise=34
.meas tran tck1_35 when v(xdiv.ck1)=1.65 rise=35
.meas tran tck1_36 when v(xdiv.ck1)=1.65 rise=36
.meas tran tck1_37 when v(xdiv.ck1)=1.65 rise=37
.meas tran tck1_38 when v(xdiv.ck1)=1.65 rise=38
.meas tran tck1_39 when v(xdiv.ck1)=1.65 rise=39
.meas tran tck1_40 when v(xdiv.ck1)=1.65 rise=40
.meas tran tck1_41 when v(xdiv.ck1)=1.65 rise=41
.meas tran tck1_42 when v(xdiv.ck1)=1.65 rise=42
.meas tran tck1_43 when v(xdiv.ck1)=1.65 rise=43
.meas tran tck1_44 when v(xdiv.ck1)=1.65 rise=44
.meas tran tck1_45 when v(xdiv.ck1)=1.65 rise=45
.meas tran tck1_46 when v(xdiv.ck1)=1.65 rise=46
.meas tran tck1_47 when v(xdiv.ck1)=1.65 rise=47
.meas tran tck1_48 when v(xdiv.ck1)=1.65 rise=48
.meas tran tck1_49 when v(xdiv.ck1)=1.65 rise=49
.meas tran tck1_50 when v(xdiv.ck1)=1.65 rise=50
.meas tran tck1_51 when v(xdiv.ck1)=1.65 rise=51
.meas tran tck1_52 when v(xdiv.ck1)=1.65 rise=52
.meas tran tck1_53 when v(xdiv.ck1)=1.65 rise=53
.meas tran tck1_54 when v(xdiv.ck1)=1.65 rise=54
.meas tran tck1_55 when v(xdiv.ck1)=1.65 rise=55
.meas tran tck1_56 when v(xdiv.ck1)=1.65 rise=56
.meas tran tck1_57 when v(xdiv.ck1)=1.65 rise=57
.meas tran tck1_58 when v(xdiv.ck1)=1.65 rise=58
.meas tran tck1_59 when v(xdiv.ck1)=1.65 rise=59
.meas tran tck1_60 when v(xdiv.ck1)=1.65 rise=60
.meas tran tck1_61 when v(xdiv.ck1)=1.65 rise=61
.meas tran tck1_62 when v(xdiv.ck1)=1.65 rise=62
.meas tran tck1_63 when v(xdiv.ck1)=1.65 rise=63
.meas tran tck1_64 when v(xdiv.ck1)=1.65 rise=64
.meas tran tck1_65 when v(xdiv.ck1)=1.65 rise=65
.meas tran tck1_66 when v(xdiv.ck1)=1.65 rise=66
.meas tran tck1_67 when v(xdiv.ck1)=1.65 rise=67
.meas tran tck1_68 when v(xdiv.ck1)=1.65 rise=68
.meas tran tck1_69 when v(xdiv.ck1)=1.65 rise=69
.meas tran tck1_70 when v(xdiv.ck1)=1.65 rise=70
.meas tran tck1_71 when v(xdiv.ck1)=1.65 rise=71
.meas tran tck1_72 when v(xdiv.ck1)=1.65 rise=72
.meas tran tck1_73 when v(xdiv.ck1)=1.65 rise=73
.meas tran tck1_74 when v(xdiv.ck1)=1.65 rise=74
.meas tran tck1_75 when v(xdiv.ck1)=1.65 rise=75
.meas tran tck1_76 when v(xdiv.ck1)=1.65 rise=76
.meas tran tck1_77 when v(xdiv.ck1)=1.65 rise=77
.meas tran tck1_78 when v(xdiv.ck1)=1.65 rise=78
.meas tran tck1_79 when v(xdiv.ck1)=1.65 rise=79
.meas tran tck1_80 when v(xdiv.ck1)=1.65 rise=80
.meas tran tck1_81 when v(xdiv.ck1)=1.65 rise=81
.meas tran tck1_82 when v(xdiv.ck1)=1.65 rise=82
.meas tran tck1_83 when v(xdiv.ck1)=1.65 rise=83
.meas tran tck1_84 when v(xdiv.ck1)=1.65 rise=84
.meas tran tck1_85 when v(xdiv.ck1)=1.65 rise=85
.meas tran tck1_86 when v(xdiv.ck1)=1.65 rise=86
.meas tran tck1_87 when v(xdiv.ck1)=1.65 rise=87
.meas tran tck1_88 when v(xdiv.ck1)=1.65 rise=88
.meas tran tck1_89 when v(xdiv.ck1)=1.65 rise=89
.meas tran tck1_90 when v(xdiv.ck1)=1.65 rise=90
.meas tran tck1_91 when v(xdiv.ck1)=1.65 rise=91
.meas tran tck1_92 when v(xdiv.ck1)=1.65 rise=92
.meas tran tck1_93 when v(xdiv.ck1)=1.65 rise=93
.meas tran tck1_94 when v(xdiv.ck1)=1.65 rise=94
.meas tran tck1_95 when v(xdiv.ck1)=1.65 rise=95
.meas tran tck1_96 when v(xdiv.ck1)=1.65 rise=96
.meas tran tck1_97 when v(xdiv.ck1)=1.65 rise=97
.meas tran tck1_98 when v(xdiv.ck1)=1.65 rise=98
.meas tran tck1_99 when v(xdiv.ck1)=1.65 rise=99
.meas tran tck1_100 when v(xdiv.ck1)=1.65 rise=100
.meas tran tck1_101 when v(xdiv.ck1)=1.65 rise=101
.meas tran tck1_102 when v(xdiv.ck1)=1.65 rise=102
.meas tran tck1_103 when v(xdiv.ck1)=1.65 rise=103
.meas tran tck1_104 when v(xdiv.ck1)=1.65 rise=104
.meas tran tck1_105 when v(xdiv.ck1)=1.65 rise=105
.meas tran tck1_106 when v(xdiv.ck1)=1.65 rise=106
.meas tran tck1_107 when v(xdiv.ck1)=1.65 rise=107
.meas tran tck1_108 when v(xdiv.ck1)=1.65 rise=108
.meas tran tck1_109 when v(xdiv.ck1)=1.65 rise=109
.meas tran tck1_110 when v(xdiv.ck1)=1.65 rise=110
.meas tran tck1_111 when v(xdiv.ck1)=1.65 rise=111
.meas tran tck1_112 when v(xdiv.ck1)=1.65 rise=112
.meas tran tck1_113 when v(xdiv.ck1)=1.65 rise=113
.meas tran tck1_114 when v(xdiv.ck1)=1.65 rise=114
.meas tran tck1_115 when v(xdiv.ck1)=1.65 rise=115
.meas tran tck1_116 when v(xdiv.ck1)=1.65 rise=116
.meas tran tck1_117 when v(xdiv.ck1)=1.65 rise=117
.meas tran tck1_118 when v(xdiv.ck1)=1.65 rise=118
.meas tran tck1_119 when v(xdiv.ck1)=1.65 rise=119
.meas tran tck1_120 when v(xdiv.ck1)=1.65 rise=120
.meas tran tck1_121 when v(xdiv.ck1)=1.65 rise=121
.meas tran tck1_122 when v(xdiv.ck1)=1.65 rise=122
.meas tran tck1_123 when v(xdiv.ck1)=1.65 rise=123
.meas tran tck1_124 when v(xdiv.ck1)=1.65 rise=124
.meas tran tck1_125 when v(xdiv.ck1)=1.65 rise=125
.meas tran tck1_126 when v(xdiv.ck1)=1.65 rise=126
.meas tran tck1_127 when v(xdiv.ck1)=1.65 rise=127
.meas tran tck1_128 when v(xdiv.ck1)=1.65 rise=128
.meas tran tck1_129 when v(xdiv.ck1)=1.65 rise=129
.meas tran tck1_130 when v(xdiv.ck1)=1.65 rise=130
.meas tran tck1_131 when v(xdiv.ck1)=1.65 rise=131
.meas tran tck1_132 when v(xdiv.ck1)=1.65 rise=132
.meas tran tck1_133 when v(xdiv.ck1)=1.65 rise=133
.meas tran tck1_134 when v(xdiv.ck1)=1.65 rise=134
.meas tran tck1_135 when v(xdiv.ck1)=1.65 rise=135
.meas tran tck1_136 when v(xdiv.ck1)=1.65 rise=136
.meas tran tck1_137 when v(xdiv.ck1)=1.65 rise=137
.meas tran tck1_138 when v(xdiv.ck1)=1.65 rise=138
.meas tran tck1_139 when v(xdiv.ck1)=1.65 rise=139
.meas tran tck1_140 when v(xdiv.ck1)=1.65 rise=140
.meas tran tck1_141 when v(xdiv.ck1)=1.65 rise=141
.meas tran tck1_142 when v(xdiv.ck1)=1.65 rise=142
.meas tran tck1_143 when v(xdiv.ck1)=1.65 rise=143
.meas tran tck1_144 when v(xdiv.ck1)=1.65 rise=144
.meas tran tck1_145 when v(xdiv.ck1)=1.65 rise=145
.meas tran tck1_146 when v(xdiv.ck1)=1.65 rise=146
.meas tran tck1_147 when v(xdiv.ck1)=1.65 rise=147
.meas tran tck1_148 when v(xdiv.ck1)=1.65 rise=148
.meas tran tck1_149 when v(xdiv.ck1)=1.65 rise=149
.meas tran tck1_150 when v(xdiv.ck1)=1.65 rise=150
.meas tran tck1_151 when v(xdiv.ck1)=1.65 rise=151
.meas tran tck1_152 when v(xdiv.ck1)=1.65 rise=152
.meas tran tck1_153 when v(xdiv.ck1)=1.65 rise=153
.meas tran tck1_154 when v(xdiv.ck1)=1.65 rise=154
.meas tran tck1_155 when v(xdiv.ck1)=1.65 rise=155
.meas tran tck1_156 when v(xdiv.ck1)=1.65 rise=156
.meas tran tck1_157 when v(xdiv.ck1)=1.65 rise=157
.meas tran tck1_158 when v(xdiv.ck1)=1.65 rise=158
.meas tran tck1_159 when v(xdiv.ck1)=1.65 rise=159
.meas tran tck1_160 when v(xdiv.ck1)=1.65 rise=160
.meas tran tck1_161 when v(xdiv.ck1)=1.65 rise=161
.meas tran tck1_162 when v(xdiv.ck1)=1.65 rise=162
.meas tran tck1_163 when v(xdiv.ck1)=1.65 rise=163
.meas tran tck1_164 when v(xdiv.ck1)=1.65 rise=164
.meas tran tck1_165 when v(xdiv.ck1)=1.65 rise=165
.meas tran tck1_166 when v(xdiv.ck1)=1.65 rise=166
.meas tran tck1_167 when v(xdiv.ck1)=1.65 rise=167
.meas tran tck1_168 when v(xdiv.ck1)=1.65 rise=168
.meas tran tck1_169 when v(xdiv.ck1)=1.65 rise=169
.meas tran tck1_170 when v(xdiv.ck1)=1.65 rise=170
.meas tran tck1_171 when v(xdiv.ck1)=1.65 rise=171
.meas tran tck1_172 when v(xdiv.ck1)=1.65 rise=172
.meas tran tck1_173 when v(xdiv.ck1)=1.65 rise=173
.meas tran tck1_174 when v(xdiv.ck1)=1.65 rise=174
.meas tran tck1_175 when v(xdiv.ck1)=1.65 rise=175
.meas tran tck1_176 when v(xdiv.ck1)=1.65 rise=176
.meas tran tck1_177 when v(xdiv.ck1)=1.65 rise=177
.meas tran tck1_178 when v(xdiv.ck1)=1.65 rise=178
.meas tran tck1_179 when v(xdiv.ck1)=1.65 rise=179
.meas tran tck1_180 when v(xdiv.ck1)=1.65 rise=180
.meas tran tck1_181 when v(xdiv.ck1)=1.65 rise=181
.meas tran tck1_182 when v(xdiv.ck1)=1.65 rise=182
.meas tran tck1_183 when v(xdiv.ck1)=1.65 rise=183
.meas tran tck1_184 when v(xdiv.ck1)=1.65 rise=184
.meas tran tck1_185 when v(xdiv.ck1)=1.65 rise=185
.meas tran tck1_186 when v(xdiv.ck1)=1.65 rise=186
.meas tran tck1_187 when v(xdiv.ck1)=1.65 rise=187
.meas tran tck1_188 when v(xdiv.ck1)=1.65 rise=188
.meas tran tck1_189 when v(xdiv.ck1)=1.65 rise=189
.meas tran tck1_190 when v(xdiv.ck1)=1.65 rise=190
.meas tran tck1_191 when v(xdiv.ck1)=1.65 rise=191
.meas tran tck1_192 when v(xdiv.ck1)=1.65 rise=192
.meas tran tck1_193 when v(xdiv.ck1)=1.65 rise=193
.meas tran tck1_194 when v(xdiv.ck1)=1.65 rise=194
.meas tran tck1_195 when v(xdiv.ck1)=1.65 rise=195
.meas tran tck1_196 when v(xdiv.ck1)=1.65 rise=196
.meas tran tck1_197 when v(xdiv.ck1)=1.65 rise=197
.meas tran tck1_198 when v(xdiv.ck1)=1.65 rise=198
.meas tran tck1_199 when v(xdiv.ck1)=1.65 rise=199
.meas tran tck1_200 when v(xdiv.ck1)=1.65 rise=200
.meas tran tck1_201 when v(xdiv.ck1)=1.65 rise=201
.meas tran tck1_202 when v(xdiv.ck1)=1.65 rise=202
.meas tran tck1_203 when v(xdiv.ck1)=1.65 rise=203
.meas tran tck1_204 when v(xdiv.ck1)=1.65 rise=204
.meas tran tck1_205 when v(xdiv.ck1)=1.65 rise=205
.meas tran tck1_206 when v(xdiv.ck1)=1.65 rise=206
.meas tran tck1_207 when v(xdiv.ck1)=1.65 rise=207
.meas tran tck1_208 when v(xdiv.ck1)=1.65 rise=208
.meas tran tck1_209 when v(xdiv.ck1)=1.65 rise=209
.meas tran tck1_210 when v(xdiv.ck1)=1.65 rise=210
.meas tran tck1_211 when v(xdiv.ck1)=1.65 rise=211
.meas tran tck1_212 when v(xdiv.ck1)=1.65 rise=212
.meas tran tck1_213 when v(xdiv.ck1)=1.65 rise=213
.meas tran tck1_214 when v(xdiv.ck1)=1.65 rise=214
.meas tran tck1_215 when v(xdiv.ck1)=1.65 rise=215
.meas tran tck1_216 when v(xdiv.ck1)=1.65 rise=216
.meas tran tck1_217 when v(xdiv.ck1)=1.65 rise=217
.meas tran tck1_218 when v(xdiv.ck1)=1.65 rise=218
.meas tran tck1_219 when v(xdiv.ck1)=1.65 rise=219
.meas tran tck1_220 when v(xdiv.ck1)=1.65 rise=220
.meas tran tck1_221 when v(xdiv.ck1)=1.65 rise=221
.meas tran tck1_222 when v(xdiv.ck1)=1.65 rise=222
.meas tran tck1_223 when v(xdiv.ck1)=1.65 rise=223
.meas tran tck1_224 when v(xdiv.ck1)=1.65 rise=224
.meas tran tck1_225 when v(xdiv.ck1)=1.65 rise=225
.meas tran tck1_226 when v(xdiv.ck1)=1.65 rise=226
.meas tran tck1_227 when v(xdiv.ck1)=1.65 rise=227
.meas tran tck1_228 when v(xdiv.ck1)=1.65 rise=228
.meas tran tck1_229 when v(xdiv.ck1)=1.65 rise=229
.meas tran tck1_230 when v(xdiv.ck1)=1.65 rise=230
.meas tran tck1_231 when v(xdiv.ck1)=1.65 rise=231
.meas tran tck1_232 when v(xdiv.ck1)=1.65 rise=232
.meas tran tck1_233 when v(xdiv.ck1)=1.65 rise=233
.meas tran tck1_234 when v(xdiv.ck1)=1.65 rise=234
.meas tran tck1_235 when v(xdiv.ck1)=1.65 rise=235
.meas tran tck1_236 when v(xdiv.ck1)=1.65 rise=236
.meas tran tck1_237 when v(xdiv.ck1)=1.65 rise=237
.meas tran tck1_238 when v(xdiv.ck1)=1.65 rise=238
.meas tran tck1_239 when v(xdiv.ck1)=1.65 rise=239
.meas tran tck1_240 when v(xdiv.ck1)=1.65 rise=240
.meas tran tck1_241 when v(xdiv.ck1)=1.65 rise=241
.meas tran tck1_242 when v(xdiv.ck1)=1.65 rise=242
.meas tran tck1_243 when v(xdiv.ck1)=1.65 rise=243
.meas tran tck1_244 when v(xdiv.ck1)=1.65 rise=244
.meas tran tck1_245 when v(xdiv.ck1)=1.65 rise=245
.meas tran tck1_246 when v(xdiv.ck1)=1.65 rise=246
.meas tran tck1_247 when v(xdiv.ck1)=1.65 rise=247
.meas tran tck1_248 when v(xdiv.ck1)=1.65 rise=248
.meas tran tck1_249 when v(xdiv.ck1)=1.65 rise=249
.meas tran tck1_250 when v(xdiv.ck1)=1.65 rise=250
.meas tran tck1_251 when v(xdiv.ck1)=1.65 rise=251
.meas tran tck1_252 when v(xdiv.ck1)=1.65 rise=252
.meas tran tck1_253 when v(xdiv.ck1)=1.65 rise=253
.meas tran tck1_254 when v(xdiv.ck1)=1.65 rise=254
.meas tran tck1_255 when v(xdiv.ck1)=1.65 rise=255
.meas tran tck1_256 when v(xdiv.ck1)=1.65 rise=256
.meas tran tck1_257 when v(xdiv.ck1)=1.65 rise=257
.meas tran tck1_258 when v(xdiv.ck1)=1.65 rise=258
.meas tran tck1_259 when v(xdiv.ck1)=1.65 rise=259
.meas tran tck1_260 when v(xdiv.ck1)=1.65 rise=260
.meas tran tck1_261 when v(xdiv.ck1)=1.65 rise=261
.meas tran tck1_262 when v(xdiv.ck1)=1.65 rise=262
.meas tran tck1_263 when v(xdiv.ck1)=1.65 rise=263
.meas tran tck1_264 when v(xdiv.ck1)=1.65 rise=264
.meas tran tck1_265 when v(xdiv.ck1)=1.65 rise=265
.meas tran tck1_266 when v(xdiv.ck1)=1.65 rise=266
.meas tran tck1_267 when v(xdiv.ck1)=1.65 rise=267
.meas tran tck1_268 when v(xdiv.ck1)=1.65 rise=268
.meas tran tck1_269 when v(xdiv.ck1)=1.65 rise=269
.meas tran tck1_270 when v(xdiv.ck1)=1.65 rise=270
.meas tran tck1_271 when v(xdiv.ck1)=1.65 rise=271
.meas tran tck1_272 when v(xdiv.ck1)=1.65 rise=272
.meas tran tck1_273 when v(xdiv.ck1)=1.65 rise=273
.meas tran tck1_274 when v(xdiv.ck1)=1.65 rise=274
.meas tran tck1_275 when v(xdiv.ck1)=1.65 rise=275
.meas tran tck1_276 when v(xdiv.ck1)=1.65 rise=276
.meas tran tck1_277 when v(xdiv.ck1)=1.65 rise=277
.meas tran tck1_278 when v(xdiv.ck1)=1.65 rise=278
.meas tran tck1_279 when v(xdiv.ck1)=1.65 rise=279
.meas tran tck1_280 when v(xdiv.ck1)=1.65 rise=280
.meas tran tck1_281 when v(xdiv.ck1)=1.65 rise=281
.meas tran tck1_282 when v(xdiv.ck1)=1.65 rise=282
.meas tran tck1_283 when v(xdiv.ck1)=1.65 rise=283
.meas tran tck1_284 when v(xdiv.ck1)=1.65 rise=284
.meas tran tck1_285 when v(xdiv.ck1)=1.65 rise=285
.meas tran tck1_286 when v(xdiv.ck1)=1.65 rise=286
.meas tran tck1_287 when v(xdiv.ck1)=1.65 rise=287
.meas tran tck1_288 when v(xdiv.ck1)=1.65 rise=288
.meas tran tck1_289 when v(xdiv.ck1)=1.65 rise=289
.meas tran tck1_290 when v(xdiv.ck1)=1.65 rise=290
.meas tran tck1_291 when v(xdiv.ck1)=1.65 rise=291
.meas tran tck1_292 when v(xdiv.ck1)=1.65 rise=292
.meas tran tck1_293 when v(xdiv.ck1)=1.65 rise=293
.meas tran tck1_294 when v(xdiv.ck1)=1.65 rise=294
.meas tran tck1_295 when v(xdiv.ck1)=1.65 rise=295
.meas tran tck1_296 when v(xdiv.ck1)=1.65 rise=296
.meas tran tck1_297 when v(xdiv.ck1)=1.65 rise=297
.meas tran tck1_298 when v(xdiv.ck1)=1.65 rise=298
.meas tran tck1_299 when v(xdiv.ck1)=1.65 rise=299
.meas tran tck1_300 when v(xdiv.ck1)=1.65 rise=300
.meas tran tck1_301 when v(xdiv.ck1)=1.65 rise=301
.meas tran tck1_302 when v(xdiv.ck1)=1.65 rise=302
.meas tran tck1_303 when v(xdiv.ck1)=1.65 rise=303
.meas tran tck1_304 when v(xdiv.ck1)=1.65 rise=304
.meas tran tck1_305 when v(xdiv.ck1)=1.65 rise=305
.meas tran tck1_306 when v(xdiv.ck1)=1.65 rise=306
.meas tran tck1_307 when v(xdiv.ck1)=1.65 rise=307
.meas tran tck1_308 when v(xdiv.ck1)=1.65 rise=308
.meas tran tck1_309 when v(xdiv.ck1)=1.65 rise=309
.meas tran tck1_310 when v(xdiv.ck1)=1.65 rise=310
.meas tran tck1_311 when v(xdiv.ck1)=1.65 rise=311
.meas tran tck1_312 when v(xdiv.ck1)=1.65 rise=312
.meas tran tck1_313 when v(xdiv.ck1)=1.65 rise=313
.meas tran tck1_314 when v(xdiv.ck1)=1.65 rise=314
.meas tran tck1_315 when v(xdiv.ck1)=1.65 rise=315
.meas tran tck1_316 when v(xdiv.ck1)=1.65 rise=316
.meas tran tck1_317 when v(xdiv.ck1)=1.65 rise=317
.meas tran tck1_318 when v(xdiv.ck1)=1.65 rise=318
.meas tran tck1_319 when v(xdiv.ck1)=1.65 rise=319
.meas tran tck1_320 when v(xdiv.ck1)=1.65 rise=320
.meas tran tck1_321 when v(xdiv.ck1)=1.65 rise=321
.meas tran tck1_322 when v(xdiv.ck1)=1.65 rise=322
.meas tran tck1_323 when v(xdiv.ck1)=1.65 rise=323
.meas tran tck1_324 when v(xdiv.ck1)=1.65 rise=324
.meas tran tck1_325 when v(xdiv.ck1)=1.65 rise=325
.meas tran tck1_326 when v(xdiv.ck1)=1.65 rise=326
.meas tran tck1_327 when v(xdiv.ck1)=1.65 rise=327
.meas tran tck1_328 when v(xdiv.ck1)=1.65 rise=328
.meas tran tck1_329 when v(xdiv.ck1)=1.65 rise=329
.meas tran tck1_330 when v(xdiv.ck1)=1.65 rise=330
.meas tran tck1_331 when v(xdiv.ck1)=1.65 rise=331
.meas tran tck1_332 when v(xdiv.ck1)=1.65 rise=332
.meas tran tck1_333 when v(xdiv.ck1)=1.65 rise=333
.meas tran tck1_334 when v(xdiv.ck1)=1.65 rise=334
.meas tran tck1_335 when v(xdiv.ck1)=1.65 rise=335
.meas tran tck1_336 when v(xdiv.ck1)=1.65 rise=336
.meas tran tck1_337 when v(xdiv.ck1)=1.65 rise=337
.meas tran tck1_338 when v(xdiv.ck1)=1.65 rise=338
.meas tran tck1_339 when v(xdiv.ck1)=1.65 rise=339
.meas tran tck1_340 when v(xdiv.ck1)=1.65 rise=340
.meas tran tck1_341 when v(xdiv.ck1)=1.65 rise=341
.meas tran tck1_342 when v(xdiv.ck1)=1.65 rise=342
.meas tran tck1_343 when v(xdiv.ck1)=1.65 rise=343
.meas tran tck1_344 when v(xdiv.ck1)=1.65 rise=344
.meas tran tck1_345 when v(xdiv.ck1)=1.65 rise=345
.meas tran tck1_346 when v(xdiv.ck1)=1.65 rise=346
.meas tran tck1_347 when v(xdiv.ck1)=1.65 rise=347
.meas tran tck1_348 when v(xdiv.ck1)=1.65 rise=348
.meas tran tck1_349 when v(xdiv.ck1)=1.65 rise=349
.meas tran tck1_350 when v(xdiv.ck1)=1.65 rise=350
.meas tran tck1_351 when v(xdiv.ck1)=1.65 rise=351
.meas tran tck1_352 when v(xdiv.ck1)=1.65 rise=352
.meas tran tck1_353 when v(xdiv.ck1)=1.65 rise=353
.meas tran tck1_354 when v(xdiv.ck1)=1.65 rise=354
.meas tran tck1_355 when v(xdiv.ck1)=1.65 rise=355
.meas tran tck1_356 when v(xdiv.ck1)=1.65 rise=356
.meas tran tck1_357 when v(xdiv.ck1)=1.65 rise=357
.meas tran tck1_358 when v(xdiv.ck1)=1.65 rise=358
.meas tran tck1_359 when v(xdiv.ck1)=1.65 rise=359
.meas tran tck1_360 when v(xdiv.ck1)=1.65 rise=360
.meas tran tck1_361 when v(xdiv.ck1)=1.65 rise=361
.meas tran tck1_362 when v(xdiv.ck1)=1.65 rise=362
.meas tran tck1_363 when v(xdiv.ck1)=1.65 rise=363
.meas tran tck1_364 when v(xdiv.ck1)=1.65 rise=364
.meas tran tck1_365 when v(xdiv.ck1)=1.65 rise=365
.meas tran tck1_366 when v(xdiv.ck1)=1.65 rise=366
.meas tran tck1_367 when v(xdiv.ck1)=1.65 rise=367
.meas tran tck1_368 when v(xdiv.ck1)=1.65 rise=368
.meas tran tck1_369 when v(xdiv.ck1)=1.65 rise=369
.meas tran tck1_370 when v(xdiv.ck1)=1.65 rise=370
.meas tran tck1_371 when v(xdiv.ck1)=1.65 rise=371
.meas tran tck1_372 when v(xdiv.ck1)=1.65 rise=372
.meas tran tck1_373 when v(xdiv.ck1)=1.65 rise=373
.meas tran tck1_374 when v(xdiv.ck1)=1.65 rise=374
.meas tran tck1_375 when v(xdiv.ck1)=1.65 rise=375
.meas tran tck1_376 when v(xdiv.ck1)=1.65 rise=376
.meas tran tck1_377 when v(xdiv.ck1)=1.65 rise=377
.meas tran tck1_378 when v(xdiv.ck1)=1.65 rise=378
.meas tran tck1_379 when v(xdiv.ck1)=1.65 rise=379
.meas tran tck1_380 when v(xdiv.ck1)=1.65 rise=380
.meas tran tck1_381 when v(xdiv.ck1)=1.65 rise=381
.meas tran tck1_382 when v(xdiv.ck1)=1.65 rise=382
.meas tran tck1_383 when v(xdiv.ck1)=1.65 rise=383
.meas tran tck1_384 when v(xdiv.ck1)=1.65 rise=384
.meas tran tck1_385 when v(xdiv.ck1)=1.65 rise=385
.meas tran tck1_386 when v(xdiv.ck1)=1.65 rise=386
.meas tran tck1_387 when v(xdiv.ck1)=1.65 rise=387
.meas tran tck1_388 when v(xdiv.ck1)=1.65 rise=388
.meas tran tck1_389 when v(xdiv.ck1)=1.65 rise=389
.meas tran tck1_390 when v(xdiv.ck1)=1.65 rise=390
.meas tran tck1_391 when v(xdiv.ck1)=1.65 rise=391
.meas tran tck1_392 when v(xdiv.ck1)=1.65 rise=392
.meas tran tck1_393 when v(xdiv.ck1)=1.65 rise=393
.meas tran tck1_394 when v(xdiv.ck1)=1.65 rise=394
.meas tran tck1_395 when v(xdiv.ck1)=1.65 rise=395
.meas tran tck1_396 when v(xdiv.ck1)=1.65 rise=396
.meas tran tck1_397 when v(xdiv.ck1)=1.65 rise=397
.meas tran tck1_398 when v(xdiv.ck1)=1.65 rise=398
.meas tran tck1_399 when v(xdiv.ck1)=1.65 rise=399
.meas tran tck1_400 when v(xdiv.ck1)=1.65 rise=400
.meas tran tck1_401 when v(xdiv.ck1)=1.65 rise=401
.meas tran tck1_402 when v(xdiv.ck1)=1.65 rise=402
.meas tran tck1_403 when v(xdiv.ck1)=1.65 rise=403
.meas tran tck1_404 when v(xdiv.ck1)=1.65 rise=404
.meas tran tck1_405 when v(xdiv.ck1)=1.65 rise=405
.meas tran tck1_406 when v(xdiv.ck1)=1.65 rise=406
.meas tran tck1_407 when v(xdiv.ck1)=1.65 rise=407
.meas tran tck1_408 when v(xdiv.ck1)=1.65 rise=408
.meas tran tck1_409 when v(xdiv.ck1)=1.65 rise=409
.meas tran tck1_410 when v(xdiv.ck1)=1.65 rise=410
.meas tran tck1_411 when v(xdiv.ck1)=1.65 rise=411
.meas tran tck1_412 when v(xdiv.ck1)=1.65 rise=412
.meas tran tck1_413 when v(xdiv.ck1)=1.65 rise=413
.meas tran tck1_414 when v(xdiv.ck1)=1.65 rise=414
.meas tran tck1_415 when v(xdiv.ck1)=1.65 rise=415
.meas tran tck1_416 when v(xdiv.ck1)=1.65 rise=416
.meas tran tck1_417 when v(xdiv.ck1)=1.65 rise=417
.meas tran tck1_418 when v(xdiv.ck1)=1.65 rise=418
.meas tran tck1_419 when v(xdiv.ck1)=1.65 rise=419
.meas tran tck1_420 when v(xdiv.ck1)=1.65 rise=420
.meas tran tck1_421 when v(xdiv.ck1)=1.65 rise=421
.meas tran tck1_422 when v(xdiv.ck1)=1.65 rise=422
.meas tran tck1_423 when v(xdiv.ck1)=1.65 rise=423
.meas tran tck1_424 when v(xdiv.ck1)=1.65 rise=424
.meas tran tck1_425 when v(xdiv.ck1)=1.65 rise=425
.meas tran tck1_426 when v(xdiv.ck1)=1.65 rise=426
.meas tran tck1_427 when v(xdiv.ck1)=1.65 rise=427
.meas tran tck1_428 when v(xdiv.ck1)=1.65 rise=428
.meas tran tck1_429 when v(xdiv.ck1)=1.65 rise=429
.meas tran tck1_430 when v(xdiv.ck1)=1.65 rise=430
.meas tran tck1_431 when v(xdiv.ck1)=1.65 rise=431
.meas tran tck1_432 when v(xdiv.ck1)=1.65 rise=432
.meas tran tck1_433 when v(xdiv.ck1)=1.65 rise=433
.meas tran tck1_434 when v(xdiv.ck1)=1.65 rise=434
.meas tran tck1_435 when v(xdiv.ck1)=1.65 rise=435
.meas tran tck1_436 when v(xdiv.ck1)=1.65 rise=436
.meas tran tck1_437 when v(xdiv.ck1)=1.65 rise=437
.meas tran tck1_438 when v(xdiv.ck1)=1.65 rise=438
.meas tran tck1_439 when v(xdiv.ck1)=1.65 rise=439
.meas tran tck1_440 when v(xdiv.ck1)=1.65 rise=440
.meas tran tck1_441 when v(xdiv.ck1)=1.65 rise=441
.meas tran tck1_442 when v(xdiv.ck1)=1.65 rise=442
.meas tran tck1_443 when v(xdiv.ck1)=1.65 rise=443
.meas tran tck1_444 when v(xdiv.ck1)=1.65 rise=444
.meas tran tck1_445 when v(xdiv.ck1)=1.65 rise=445
.meas tran tck1_446 when v(xdiv.ck1)=1.65 rise=446
.meas tran tck1_447 when v(xdiv.ck1)=1.65 rise=447
.meas tran tck1_448 when v(xdiv.ck1)=1.65 rise=448
.meas tran tck1_449 when v(xdiv.ck1)=1.65 rise=449
.meas tran tck1_450 when v(xdiv.ck1)=1.65 rise=450
.meas tran tck1_451 when v(xdiv.ck1)=1.65 rise=451
.meas tran tck1_452 when v(xdiv.ck1)=1.65 rise=452
.meas tran tck1_453 when v(xdiv.ck1)=1.65 rise=453
.meas tran tck1_454 when v(xdiv.ck1)=1.65 rise=454
.meas tran tck1_455 when v(xdiv.ck1)=1.65 rise=455
.meas tran tck1_456 when v(xdiv.ck1)=1.65 rise=456
.meas tran tck1_457 when v(xdiv.ck1)=1.65 rise=457
.meas tran tck1_458 when v(xdiv.ck1)=1.65 rise=458
.meas tran tck1_459 when v(xdiv.ck1)=1.65 rise=459
.meas tran tck1_460 when v(xdiv.ck1)=1.65 rise=460
.meas tran tck1_461 when v(xdiv.ck1)=1.65 rise=461
.meas tran tck1_462 when v(xdiv.ck1)=1.65 rise=462
.meas tran tck1_463 when v(xdiv.ck1)=1.65 rise=463
.meas tran tck1_464 when v(xdiv.ck1)=1.65 rise=464
.meas tran tck1_465 when v(xdiv.ck1)=1.65 rise=465
.meas tran tck1_466 when v(xdiv.ck1)=1.65 rise=466
.meas tran tck1_467 when v(xdiv.ck1)=1.65 rise=467
.meas tran tck1_468 when v(xdiv.ck1)=1.65 rise=468
.meas tran tck1_469 when v(xdiv.ck1)=1.65 rise=469
.meas tran tck1_470 when v(xdiv.ck1)=1.65 rise=470
.meas tran tck1_471 when v(xdiv.ck1)=1.65 rise=471
.meas tran tck1_472 when v(xdiv.ck1)=1.65 rise=472
.meas tran tck1_473 when v(xdiv.ck1)=1.65 rise=473
.meas tran tck1_474 when v(xdiv.ck1)=1.65 rise=474
.meas tran tck1_475 when v(xdiv.ck1)=1.65 rise=475
.meas tran tck1_476 when v(xdiv.ck1)=1.65 rise=476
.meas tran tck1_477 when v(xdiv.ck1)=1.65 rise=477
.meas tran tck1_478 when v(xdiv.ck1)=1.65 rise=478
.meas tran tck1_479 when v(xdiv.ck1)=1.65 rise=479
.meas tran tck1_480 when v(xdiv.ck1)=1.65 rise=480
.meas tran tck1_481 when v(xdiv.ck1)=1.65 rise=481
.meas tran tck1_482 when v(xdiv.ck1)=1.65 rise=482
.meas tran tck1_483 when v(xdiv.ck1)=1.65 rise=483
.meas tran tck1_484 when v(xdiv.ck1)=1.65 rise=484
.meas tran tck1_485 when v(xdiv.ck1)=1.65 rise=485
.meas tran tck1_486 when v(xdiv.ck1)=1.65 rise=486
.meas tran tck1_487 when v(xdiv.ck1)=1.65 rise=487
.meas tran tck1_488 when v(xdiv.ck1)=1.65 rise=488
.meas tran tck1_489 when v(xdiv.ck1)=1.65 rise=489
.meas tran tck1_490 when v(xdiv.ck1)=1.65 rise=490
.meas tran tck1_491 when v(xdiv.ck1)=1.65 rise=491
.meas tran tck1_492 when v(xdiv.ck1)=1.65 rise=492
.meas tran tck1_493 when v(xdiv.ck1)=1.65 rise=493
.meas tran tck1_494 when v(xdiv.ck1)=1.65 rise=494
.meas tran tck1_495 when v(xdiv.ck1)=1.65 rise=495
.meas tran tck1_496 when v(xdiv.ck1)=1.65 rise=496
.meas tran tck1_497 when v(xdiv.ck1)=1.65 rise=497
.meas tran tck1_498 when v(xdiv.ck1)=1.65 rise=498
.meas tran tck1_499 when v(xdiv.ck1)=1.65 rise=499
.meas tran tck1_500 when v(xdiv.ck1)=1.65 rise=500
.meas tran tck1_501 when v(xdiv.ck1)=1.65 rise=501
.meas tran tck1_502 when v(xdiv.ck1)=1.65 rise=502
.meas tran tck1_503 when v(xdiv.ck1)=1.65 rise=503
.meas tran tck1_504 when v(xdiv.ck1)=1.65 rise=504
.meas tran tck1_505 when v(xdiv.ck1)=1.65 rise=505
.meas tran tck1_506 when v(xdiv.ck1)=1.65 rise=506
.meas tran tck1_507 when v(xdiv.ck1)=1.65 rise=507
.meas tran tck1_508 when v(xdiv.ck1)=1.65 rise=508
.meas tran tck1_509 when v(xdiv.ck1)=1.65 rise=509
.meas tran tck1_510 when v(xdiv.ck1)=1.65 rise=510
.meas tran tck1_511 when v(xdiv.ck1)=1.65 rise=511
.meas tran tck1_512 when v(xdiv.ck1)=1.65 rise=512
.meas tran tck1_513 when v(xdiv.ck1)=1.65 rise=513
.meas tran tck1_514 when v(xdiv.ck1)=1.65 rise=514
.meas tran tck1_515 when v(xdiv.ck1)=1.65 rise=515
.meas tran tck1_516 when v(xdiv.ck1)=1.65 rise=516
.meas tran tck1_517 when v(xdiv.ck1)=1.65 rise=517
.meas tran tck1_518 when v(xdiv.ck1)=1.65 rise=518
.meas tran tck1_519 when v(xdiv.ck1)=1.65 rise=519
.meas tran tck1_520 when v(xdiv.ck1)=1.65 rise=520
.meas tran tck1_521 when v(xdiv.ck1)=1.65 rise=521
.meas tran tck1_522 when v(xdiv.ck1)=1.65 rise=522
.meas tran tck1_523 when v(xdiv.ck1)=1.65 rise=523
.meas tran tck1_524 when v(xdiv.ck1)=1.65 rise=524
.meas tran tck1_525 when v(xdiv.ck1)=1.65 rise=525
.meas tran tck1_526 when v(xdiv.ck1)=1.65 rise=526
.meas tran tck1_527 when v(xdiv.ck1)=1.65 rise=527
.meas tran tck1_528 when v(xdiv.ck1)=1.65 rise=528
.meas tran tck1_529 when v(xdiv.ck1)=1.65 rise=529
.meas tran tck1_530 when v(xdiv.ck1)=1.65 rise=530
.meas tran tck1_531 when v(xdiv.ck1)=1.65 rise=531
.meas tran tck1_532 when v(xdiv.ck1)=1.65 rise=532
.meas tran tck1_533 when v(xdiv.ck1)=1.65 rise=533
.meas tran tck1_534 when v(xdiv.ck1)=1.65 rise=534
.meas tran tck1_535 when v(xdiv.ck1)=1.65 rise=535
.meas tran tck1_536 when v(xdiv.ck1)=1.65 rise=536
.meas tran tck2_1 when v(xdiv.ck2)=1.65 rise=1
.meas tran tck2_2 when v(xdiv.ck2)=1.65 rise=2
.meas tran tck2_3 when v(xdiv.ck2)=1.65 rise=3
.meas tran tck2_4 when v(xdiv.ck2)=1.65 rise=4
.meas tran tck2_5 when v(xdiv.ck2)=1.65 rise=5
.meas tran tck2_6 when v(xdiv.ck2)=1.65 rise=6
.meas tran tck2_7 when v(xdiv.ck2)=1.65 rise=7
.meas tran tck2_8 when v(xdiv.ck2)=1.65 rise=8
.meas tran tck2_9 when v(xdiv.ck2)=1.65 rise=9
.meas tran tck2_10 when v(xdiv.ck2)=1.65 rise=10
.meas tran tck2_11 when v(xdiv.ck2)=1.65 rise=11
.meas tran tck2_12 when v(xdiv.ck2)=1.65 rise=12
.meas tran tck2_13 when v(xdiv.ck2)=1.65 rise=13
.meas tran tck2_14 when v(xdiv.ck2)=1.65 rise=14
.meas tran tck2_15 when v(xdiv.ck2)=1.65 rise=15
.meas tran tck2_16 when v(xdiv.ck2)=1.65 rise=16
.meas tran tck2_17 when v(xdiv.ck2)=1.65 rise=17
.meas tran tck2_18 when v(xdiv.ck2)=1.65 rise=18
.meas tran tck2_19 when v(xdiv.ck2)=1.65 rise=19
.meas tran tck2_20 when v(xdiv.ck2)=1.65 rise=20
.meas tran tck2_21 when v(xdiv.ck2)=1.65 rise=21
.meas tran tck2_22 when v(xdiv.ck2)=1.65 rise=22
.meas tran tck2_23 when v(xdiv.ck2)=1.65 rise=23
.meas tran tck2_24 when v(xdiv.ck2)=1.65 rise=24
.meas tran tck2_25 when v(xdiv.ck2)=1.65 rise=25
.meas tran tck2_26 when v(xdiv.ck2)=1.65 rise=26
.meas tran tck2_27 when v(xdiv.ck2)=1.65 rise=27
.meas tran tck2_28 when v(xdiv.ck2)=1.65 rise=28
.meas tran tck2_29 when v(xdiv.ck2)=1.65 rise=29
.meas tran tck2_30 when v(xdiv.ck2)=1.65 rise=30
.meas tran tck2_31 when v(xdiv.ck2)=1.65 rise=31
.meas tran tck2_32 when v(xdiv.ck2)=1.65 rise=32
.meas tran tck2_33 when v(xdiv.ck2)=1.65 rise=33
.meas tran tck2_34 when v(xdiv.ck2)=1.65 rise=34
.meas tran tck2_35 when v(xdiv.ck2)=1.65 rise=35
.meas tran tck2_36 when v(xdiv.ck2)=1.65 rise=36
.meas tran tck2_37 when v(xdiv.ck2)=1.65 rise=37
.meas tran tck2_38 when v(xdiv.ck2)=1.65 rise=38
.meas tran tck2_39 when v(xdiv.ck2)=1.65 rise=39
.meas tran tck2_40 when v(xdiv.ck2)=1.65 rise=40
.meas tran tck2_41 when v(xdiv.ck2)=1.65 rise=41
.meas tran tck2_42 when v(xdiv.ck2)=1.65 rise=42
.meas tran tck2_43 when v(xdiv.ck2)=1.65 rise=43
.meas tran tck2_44 when v(xdiv.ck2)=1.65 rise=44
.meas tran tck2_45 when v(xdiv.ck2)=1.65 rise=45
.meas tran tck2_46 when v(xdiv.ck2)=1.65 rise=46
.meas tran tck2_47 when v(xdiv.ck2)=1.65 rise=47
.meas tran tck2_48 when v(xdiv.ck2)=1.65 rise=48
.meas tran tck2_49 when v(xdiv.ck2)=1.65 rise=49
.meas tran tck2_50 when v(xdiv.ck2)=1.65 rise=50
.meas tran tck2_51 when v(xdiv.ck2)=1.65 rise=51
.meas tran tck2_52 when v(xdiv.ck2)=1.65 rise=52
.meas tran tck2_53 when v(xdiv.ck2)=1.65 rise=53
.meas tran tck2_54 when v(xdiv.ck2)=1.65 rise=54
.meas tran tck2_55 when v(xdiv.ck2)=1.65 rise=55
.meas tran tck2_56 when v(xdiv.ck2)=1.65 rise=56
.meas tran tck2_57 when v(xdiv.ck2)=1.65 rise=57
.meas tran tck2_58 when v(xdiv.ck2)=1.65 rise=58
.meas tran tck2_59 when v(xdiv.ck2)=1.65 rise=59
.meas tran tck2_60 when v(xdiv.ck2)=1.65 rise=60
.meas tran tck2_61 when v(xdiv.ck2)=1.65 rise=61
.meas tran tck2_62 when v(xdiv.ck2)=1.65 rise=62
.meas tran tck2_63 when v(xdiv.ck2)=1.65 rise=63
.meas tran tck2_64 when v(xdiv.ck2)=1.65 rise=64
.meas tran tck2_65 when v(xdiv.ck2)=1.65 rise=65
.meas tran tck2_66 when v(xdiv.ck2)=1.65 rise=66
.meas tran tck2_67 when v(xdiv.ck2)=1.65 rise=67
.meas tran tck2_68 when v(xdiv.ck2)=1.65 rise=68
.meas tran tck2_69 when v(xdiv.ck2)=1.65 rise=69
.meas tran tck2_70 when v(xdiv.ck2)=1.65 rise=70
.meas tran tck2_71 when v(xdiv.ck2)=1.65 rise=71
.meas tran tck2_72 when v(xdiv.ck2)=1.65 rise=72
.meas tran tck2_73 when v(xdiv.ck2)=1.65 rise=73
.meas tran tck2_74 when v(xdiv.ck2)=1.65 rise=74
.meas tran tck2_75 when v(xdiv.ck2)=1.65 rise=75
.meas tran tck2_76 when v(xdiv.ck2)=1.65 rise=76
.meas tran tck2_77 when v(xdiv.ck2)=1.65 rise=77
.meas tran tck2_78 when v(xdiv.ck2)=1.65 rise=78
.meas tran tck2_79 when v(xdiv.ck2)=1.65 rise=79
.meas tran tck2_80 when v(xdiv.ck2)=1.65 rise=80
.meas tran tck2_81 when v(xdiv.ck2)=1.65 rise=81
.meas tran tck2_82 when v(xdiv.ck2)=1.65 rise=82
.meas tran tck2_83 when v(xdiv.ck2)=1.65 rise=83
.meas tran tck2_84 when v(xdiv.ck2)=1.65 rise=84
.meas tran tck2_85 when v(xdiv.ck2)=1.65 rise=85
.meas tran tck2_86 when v(xdiv.ck2)=1.65 rise=86
.meas tran tck2_87 when v(xdiv.ck2)=1.65 rise=87
.meas tran tck2_88 when v(xdiv.ck2)=1.65 rise=88
.meas tran tck2_89 when v(xdiv.ck2)=1.65 rise=89
.meas tran tck2_90 when v(xdiv.ck2)=1.65 rise=90
.meas tran tck2_91 when v(xdiv.ck2)=1.65 rise=91
.meas tran tck2_92 when v(xdiv.ck2)=1.65 rise=92
.meas tran tck2_93 when v(xdiv.ck2)=1.65 rise=93
.meas tran tck2_94 when v(xdiv.ck2)=1.65 rise=94
.meas tran tck2_95 when v(xdiv.ck2)=1.65 rise=95
.meas tran tck2_96 when v(xdiv.ck2)=1.65 rise=96
.meas tran tck2_97 when v(xdiv.ck2)=1.65 rise=97
.meas tran tck2_98 when v(xdiv.ck2)=1.65 rise=98
.meas tran tck2_99 when v(xdiv.ck2)=1.65 rise=99
.meas tran tck2_100 when v(xdiv.ck2)=1.65 rise=100
.meas tran tck2_101 when v(xdiv.ck2)=1.65 rise=101
.meas tran tck2_102 when v(xdiv.ck2)=1.65 rise=102
.meas tran tck2_103 when v(xdiv.ck2)=1.65 rise=103
.meas tran tck2_104 when v(xdiv.ck2)=1.65 rise=104
.meas tran tck2_105 when v(xdiv.ck2)=1.65 rise=105
.meas tran tck2_106 when v(xdiv.ck2)=1.65 rise=106
.meas tran tck2_107 when v(xdiv.ck2)=1.65 rise=107
.meas tran tck2_108 when v(xdiv.ck2)=1.65 rise=108
.meas tran tck2_109 when v(xdiv.ck2)=1.65 rise=109
.meas tran tck2_110 when v(xdiv.ck2)=1.65 rise=110
.meas tran tck2_111 when v(xdiv.ck2)=1.65 rise=111
.meas tran tck2_112 when v(xdiv.ck2)=1.65 rise=112
.meas tran tck2_113 when v(xdiv.ck2)=1.65 rise=113
.meas tran tck2_114 when v(xdiv.ck2)=1.65 rise=114
.meas tran tck2_115 when v(xdiv.ck2)=1.65 rise=115
.meas tran tck2_116 when v(xdiv.ck2)=1.65 rise=116
.meas tran tck2_117 when v(xdiv.ck2)=1.65 rise=117
.meas tran tck2_118 when v(xdiv.ck2)=1.65 rise=118
.meas tran tck2_119 when v(xdiv.ck2)=1.65 rise=119
.meas tran tck2_120 when v(xdiv.ck2)=1.65 rise=120
.meas tran tck2_121 when v(xdiv.ck2)=1.65 rise=121
.meas tran tck2_122 when v(xdiv.ck2)=1.65 rise=122
.meas tran tck2_123 when v(xdiv.ck2)=1.65 rise=123
.meas tran tck2_124 when v(xdiv.ck2)=1.65 rise=124
.meas tran tck2_125 when v(xdiv.ck2)=1.65 rise=125
.meas tran tck2_126 when v(xdiv.ck2)=1.65 rise=126
.meas tran tck2_127 when v(xdiv.ck2)=1.65 rise=127
.meas tran tck2_128 when v(xdiv.ck2)=1.65 rise=128
.meas tran tck2_129 when v(xdiv.ck2)=1.65 rise=129
.meas tran tck2_130 when v(xdiv.ck2)=1.65 rise=130
.meas tran tck2_131 when v(xdiv.ck2)=1.65 rise=131
.meas tran tck2_132 when v(xdiv.ck2)=1.65 rise=132
.meas tran tck2_133 when v(xdiv.ck2)=1.65 rise=133
.meas tran tck2_134 when v(xdiv.ck2)=1.65 rise=134
.meas tran tck2_135 when v(xdiv.ck2)=1.65 rise=135
.meas tran tck2_136 when v(xdiv.ck2)=1.65 rise=136
.meas tran tck2_137 when v(xdiv.ck2)=1.65 rise=137
.meas tran tck2_138 when v(xdiv.ck2)=1.65 rise=138
.meas tran tck2_139 when v(xdiv.ck2)=1.65 rise=139
.meas tran tck2_140 when v(xdiv.ck2)=1.65 rise=140
.meas tran tck2_141 when v(xdiv.ck2)=1.65 rise=141
.meas tran tck2_142 when v(xdiv.ck2)=1.65 rise=142
.meas tran tck2_143 when v(xdiv.ck2)=1.65 rise=143
.meas tran tck2_144 when v(xdiv.ck2)=1.65 rise=144
.meas tran tck2_145 when v(xdiv.ck2)=1.65 rise=145
.meas tran tck2_146 when v(xdiv.ck2)=1.65 rise=146
.meas tran tck2_147 when v(xdiv.ck2)=1.65 rise=147
.meas tran tck2_148 when v(xdiv.ck2)=1.65 rise=148
.meas tran tck2_149 when v(xdiv.ck2)=1.65 rise=149
.meas tran tck2_150 when v(xdiv.ck2)=1.65 rise=150
.meas tran tck2_151 when v(xdiv.ck2)=1.65 rise=151
.meas tran tck2_152 when v(xdiv.ck2)=1.65 rise=152
.meas tran tck2_153 when v(xdiv.ck2)=1.65 rise=153
.meas tran tck2_154 when v(xdiv.ck2)=1.65 rise=154
.meas tran tck2_155 when v(xdiv.ck2)=1.65 rise=155
.meas tran tck2_156 when v(xdiv.ck2)=1.65 rise=156
.meas tran tck2_157 when v(xdiv.ck2)=1.65 rise=157
.meas tran tck2_158 when v(xdiv.ck2)=1.65 rise=158
.meas tran tck2_159 when v(xdiv.ck2)=1.65 rise=159
.meas tran tck2_160 when v(xdiv.ck2)=1.65 rise=160
.meas tran tck2_161 when v(xdiv.ck2)=1.65 rise=161
.meas tran tck2_162 when v(xdiv.ck2)=1.65 rise=162
.meas tran tck2_163 when v(xdiv.ck2)=1.65 rise=163
.meas tran tck2_164 when v(xdiv.ck2)=1.65 rise=164
.meas tran tck2_165 when v(xdiv.ck2)=1.65 rise=165
.meas tran tck2_166 when v(xdiv.ck2)=1.65 rise=166
.meas tran tck2_167 when v(xdiv.ck2)=1.65 rise=167
.meas tran tck2_168 when v(xdiv.ck2)=1.65 rise=168
.meas tran tck2_169 when v(xdiv.ck2)=1.65 rise=169
.meas tran tck2_170 when v(xdiv.ck2)=1.65 rise=170
.meas tran tck2_171 when v(xdiv.ck2)=1.65 rise=171
.meas tran tck2_172 when v(xdiv.ck2)=1.65 rise=172
.meas tran tck2_173 when v(xdiv.ck2)=1.65 rise=173
.meas tran tck2_174 when v(xdiv.ck2)=1.65 rise=174
.meas tran tck2_175 when v(xdiv.ck2)=1.65 rise=175
.meas tran tck2_176 when v(xdiv.ck2)=1.65 rise=176
.meas tran tck2_177 when v(xdiv.ck2)=1.65 rise=177
.meas tran tck2_178 when v(xdiv.ck2)=1.65 rise=178
.meas tran tck2_179 when v(xdiv.ck2)=1.65 rise=179
.meas tran tck2_180 when v(xdiv.ck2)=1.65 rise=180
.meas tran tck2_181 when v(xdiv.ck2)=1.65 rise=181
.meas tran tck2_182 when v(xdiv.ck2)=1.65 rise=182
.meas tran tck2_183 when v(xdiv.ck2)=1.65 rise=183
.meas tran tck2_184 when v(xdiv.ck2)=1.65 rise=184
.meas tran tck2_185 when v(xdiv.ck2)=1.65 rise=185
.meas tran tck2_186 when v(xdiv.ck2)=1.65 rise=186
.meas tran tck2_187 when v(xdiv.ck2)=1.65 rise=187
.meas tran tck2_188 when v(xdiv.ck2)=1.65 rise=188
.meas tran tck2_189 when v(xdiv.ck2)=1.65 rise=189
.meas tran tck2_190 when v(xdiv.ck2)=1.65 rise=190
.meas tran tck2_191 when v(xdiv.ck2)=1.65 rise=191
.meas tran tck2_192 when v(xdiv.ck2)=1.65 rise=192
.meas tran tck2_193 when v(xdiv.ck2)=1.65 rise=193
.meas tran tck2_194 when v(xdiv.ck2)=1.65 rise=194
.meas tran tck2_195 when v(xdiv.ck2)=1.65 rise=195
.meas tran tck2_196 when v(xdiv.ck2)=1.65 rise=196
.meas tran tck2_197 when v(xdiv.ck2)=1.65 rise=197
.meas tran tck2_198 when v(xdiv.ck2)=1.65 rise=198
.meas tran tck2_199 when v(xdiv.ck2)=1.65 rise=199
.meas tran tck2_200 when v(xdiv.ck2)=1.65 rise=200
.meas tran tck2_201 when v(xdiv.ck2)=1.65 rise=201
.meas tran tck2_202 when v(xdiv.ck2)=1.65 rise=202
.meas tran tck2_203 when v(xdiv.ck2)=1.65 rise=203
.meas tran tck2_204 when v(xdiv.ck2)=1.65 rise=204
.meas tran tck2_205 when v(xdiv.ck2)=1.65 rise=205
.meas tran tck2_206 when v(xdiv.ck2)=1.65 rise=206
.meas tran tck2_207 when v(xdiv.ck2)=1.65 rise=207
.meas tran tck2_208 when v(xdiv.ck2)=1.65 rise=208
.meas tran tck2_209 when v(xdiv.ck2)=1.65 rise=209
.meas tran tck2_210 when v(xdiv.ck2)=1.65 rise=210
.meas tran tck2_211 when v(xdiv.ck2)=1.65 rise=211
.meas tran tck2_212 when v(xdiv.ck2)=1.65 rise=212
.meas tran tck2_213 when v(xdiv.ck2)=1.65 rise=213
.meas tran tck2_214 when v(xdiv.ck2)=1.65 rise=214
.meas tran tck2_215 when v(xdiv.ck2)=1.65 rise=215
.meas tran tck2_216 when v(xdiv.ck2)=1.65 rise=216
.meas tran tck2_217 when v(xdiv.ck2)=1.65 rise=217
.meas tran tck2_218 when v(xdiv.ck2)=1.65 rise=218
.meas tran tck2_219 when v(xdiv.ck2)=1.65 rise=219
.meas tran tck2_220 when v(xdiv.ck2)=1.65 rise=220
.meas tran tck2_221 when v(xdiv.ck2)=1.65 rise=221
.meas tran tck2_222 when v(xdiv.ck2)=1.65 rise=222
.meas tran tck2_223 when v(xdiv.ck2)=1.65 rise=223
.meas tran tck2_224 when v(xdiv.ck2)=1.65 rise=224
.meas tran tck2_225 when v(xdiv.ck2)=1.65 rise=225
.meas tran tck2_226 when v(xdiv.ck2)=1.65 rise=226
.meas tran tck2_227 when v(xdiv.ck2)=1.65 rise=227
.meas tran tck2_228 when v(xdiv.ck2)=1.65 rise=228
.meas tran tck2_229 when v(xdiv.ck2)=1.65 rise=229
.meas tran tck2_230 when v(xdiv.ck2)=1.65 rise=230
.meas tran tck2_231 when v(xdiv.ck2)=1.65 rise=231
.meas tran tck2_232 when v(xdiv.ck2)=1.65 rise=232
.meas tran tck2_233 when v(xdiv.ck2)=1.65 rise=233
.meas tran tck2_234 when v(xdiv.ck2)=1.65 rise=234
.meas tran tck2_235 when v(xdiv.ck2)=1.65 rise=235
.meas tran tck2_236 when v(xdiv.ck2)=1.65 rise=236
.meas tran tck2_237 when v(xdiv.ck2)=1.65 rise=237
.meas tran tck2_238 when v(xdiv.ck2)=1.65 rise=238
.meas tran tck2_239 when v(xdiv.ck2)=1.65 rise=239
.meas tran tck2_240 when v(xdiv.ck2)=1.65 rise=240
.meas tran tck2_241 when v(xdiv.ck2)=1.65 rise=241
.meas tran tck2_242 when v(xdiv.ck2)=1.65 rise=242
.meas tran tck2_243 when v(xdiv.ck2)=1.65 rise=243
.meas tran tck2_244 when v(xdiv.ck2)=1.65 rise=244
.meas tran tck2_245 when v(xdiv.ck2)=1.65 rise=245
.meas tran tck2_246 when v(xdiv.ck2)=1.65 rise=246
.meas tran tck2_247 when v(xdiv.ck2)=1.65 rise=247
.meas tran tck2_248 when v(xdiv.ck2)=1.65 rise=248
.meas tran tck2_249 when v(xdiv.ck2)=1.65 rise=249
.meas tran tck2_250 when v(xdiv.ck2)=1.65 rise=250
.meas tran tck2_251 when v(xdiv.ck2)=1.65 rise=251
.meas tran tck2_252 when v(xdiv.ck2)=1.65 rise=252
.meas tran tck2_253 when v(xdiv.ck2)=1.65 rise=253
.meas tran tck2_254 when v(xdiv.ck2)=1.65 rise=254
.meas tran tck2_255 when v(xdiv.ck2)=1.65 rise=255
.meas tran tck2_256 when v(xdiv.ck2)=1.65 rise=256
.meas tran tck2_257 when v(xdiv.ck2)=1.65 rise=257
.meas tran tck2_258 when v(xdiv.ck2)=1.65 rise=258
.meas tran tck2_259 when v(xdiv.ck2)=1.65 rise=259
.meas tran tck2_260 when v(xdiv.ck2)=1.65 rise=260
.meas tran tck2_261 when v(xdiv.ck2)=1.65 rise=261
.meas tran tck2_262 when v(xdiv.ck2)=1.65 rise=262
.meas tran tck2_263 when v(xdiv.ck2)=1.65 rise=263
.meas tran tck2_264 when v(xdiv.ck2)=1.65 rise=264
.meas tran tck2_265 when v(xdiv.ck2)=1.65 rise=265
.meas tran tck2_266 when v(xdiv.ck2)=1.65 rise=266
.meas tran tck2_267 when v(xdiv.ck2)=1.65 rise=267
.meas tran tck2_268 when v(xdiv.ck2)=1.65 rise=268
.meas tran tck2_269 when v(xdiv.ck2)=1.65 rise=269
.meas tran tck2_270 when v(xdiv.ck2)=1.65 rise=270
.meas tran tck2_271 when v(xdiv.ck2)=1.65 rise=271
.meas tran tck2_272 when v(xdiv.ck2)=1.65 rise=272
.meas tran tck2_273 when v(xdiv.ck2)=1.65 rise=273
.meas tran tck2_274 when v(xdiv.ck2)=1.65 rise=274
.meas tran tck2_275 when v(xdiv.ck2)=1.65 rise=275
.meas tran tck2_276 when v(xdiv.ck2)=1.65 rise=276
.meas tran tck2_277 when v(xdiv.ck2)=1.65 rise=277
.meas tran tck2_278 when v(xdiv.ck2)=1.65 rise=278
.meas tran tck2_279 when v(xdiv.ck2)=1.65 rise=279
.meas tran tck2_280 when v(xdiv.ck2)=1.65 rise=280
.meas tran tck2_281 when v(xdiv.ck2)=1.65 rise=281
.meas tran tck2_282 when v(xdiv.ck2)=1.65 rise=282
.meas tran tck2_283 when v(xdiv.ck2)=1.65 rise=283
.meas tran tck2_284 when v(xdiv.ck2)=1.65 rise=284
.meas tran tck2_285 when v(xdiv.ck2)=1.65 rise=285
.meas tran tck2_286 when v(xdiv.ck2)=1.65 rise=286
.meas tran tck2_287 when v(xdiv.ck2)=1.65 rise=287
.meas tran tck2_288 when v(xdiv.ck2)=1.65 rise=288
.meas tran tck2_289 when v(xdiv.ck2)=1.65 rise=289
.meas tran tck2_290 when v(xdiv.ck2)=1.65 rise=290
.meas tran tck2_291 when v(xdiv.ck2)=1.65 rise=291
.meas tran tck2_292 when v(xdiv.ck2)=1.65 rise=292
.meas tran tck2_293 when v(xdiv.ck2)=1.65 rise=293
.meas tran tck2_294 when v(xdiv.ck2)=1.65 rise=294
.meas tran tck2_295 when v(xdiv.ck2)=1.65 rise=295
.meas tran tck2_296 when v(xdiv.ck2)=1.65 rise=296
.meas tran tck2_297 when v(xdiv.ck2)=1.65 rise=297
.meas tran tck2_298 when v(xdiv.ck2)=1.65 rise=298
.meas tran tck2_299 when v(xdiv.ck2)=1.65 rise=299
.meas tran tck2_300 when v(xdiv.ck2)=1.65 rise=300
.meas tran tck2_301 when v(xdiv.ck2)=1.65 rise=301
.meas tran tck2_302 when v(xdiv.ck2)=1.65 rise=302
.meas tran tck2_303 when v(xdiv.ck2)=1.65 rise=303
.meas tran tck2_304 when v(xdiv.ck2)=1.65 rise=304
.meas tran tck2_305 when v(xdiv.ck2)=1.65 rise=305
.meas tran tck2_306 when v(xdiv.ck2)=1.65 rise=306
.meas tran tck2_307 when v(xdiv.ck2)=1.65 rise=307
.meas tran tck2_308 when v(xdiv.ck2)=1.65 rise=308
.meas tran tck2_309 when v(xdiv.ck2)=1.65 rise=309
.meas tran tck2_310 when v(xdiv.ck2)=1.65 rise=310
.meas tran tck2_311 when v(xdiv.ck2)=1.65 rise=311
.meas tran tck2_312 when v(xdiv.ck2)=1.65 rise=312
.meas tran tck2_313 when v(xdiv.ck2)=1.65 rise=313
.meas tran tck2_314 when v(xdiv.ck2)=1.65 rise=314
.meas tran tck2_315 when v(xdiv.ck2)=1.65 rise=315
.meas tran tck2_316 when v(xdiv.ck2)=1.65 rise=316
.meas tran tck2_317 when v(xdiv.ck2)=1.65 rise=317
.meas tran tck2_318 when v(xdiv.ck2)=1.65 rise=318
.meas tran tck2_319 when v(xdiv.ck2)=1.65 rise=319
.meas tran tck2_320 when v(xdiv.ck2)=1.65 rise=320
.meas tran tck2_321 when v(xdiv.ck2)=1.65 rise=321
.meas tran tck2_322 when v(xdiv.ck2)=1.65 rise=322
.meas tran tck2_323 when v(xdiv.ck2)=1.65 rise=323
.meas tran tck2_324 when v(xdiv.ck2)=1.65 rise=324
.meas tran tck2_325 when v(xdiv.ck2)=1.65 rise=325
.meas tran tck2_326 when v(xdiv.ck2)=1.65 rise=326
.meas tran tck2_327 when v(xdiv.ck2)=1.65 rise=327
.meas tran tck2_328 when v(xdiv.ck2)=1.65 rise=328
.meas tran tck2_329 when v(xdiv.ck2)=1.65 rise=329
.meas tran tck2_330 when v(xdiv.ck2)=1.65 rise=330
.meas tran tck2_331 when v(xdiv.ck2)=1.65 rise=331
.meas tran tck2_332 when v(xdiv.ck2)=1.65 rise=332
.meas tran tck2_333 when v(xdiv.ck2)=1.65 rise=333
.meas tran tck2_334 when v(xdiv.ck2)=1.65 rise=334
.meas tran tck2_335 when v(xdiv.ck2)=1.65 rise=335
.meas tran tck2_336 when v(xdiv.ck2)=1.65 rise=336
.meas tran tck2_337 when v(xdiv.ck2)=1.65 rise=337
.meas tran tck2_338 when v(xdiv.ck2)=1.65 rise=338
.meas tran tck2_339 when v(xdiv.ck2)=1.65 rise=339
.meas tran tck2_340 when v(xdiv.ck2)=1.65 rise=340
.meas tran tck2_341 when v(xdiv.ck2)=1.65 rise=341
.meas tran tck2_342 when v(xdiv.ck2)=1.65 rise=342
.meas tran tck2_343 when v(xdiv.ck2)=1.65 rise=343
.meas tran tck2_344 when v(xdiv.ck2)=1.65 rise=344
.meas tran tck2_345 when v(xdiv.ck2)=1.65 rise=345
.meas tran tck2_346 when v(xdiv.ck2)=1.65 rise=346
.meas tran tck2_347 when v(xdiv.ck2)=1.65 rise=347
.meas tran tck2_348 when v(xdiv.ck2)=1.65 rise=348
.meas tran tck2_349 when v(xdiv.ck2)=1.65 rise=349
.meas tran tck2_350 when v(xdiv.ck2)=1.65 rise=350
.meas tran tck2_351 when v(xdiv.ck2)=1.65 rise=351
.meas tran tck2_352 when v(xdiv.ck2)=1.65 rise=352
.meas tran tck2_353 when v(xdiv.ck2)=1.65 rise=353
.meas tran tck2_354 when v(xdiv.ck2)=1.65 rise=354
.meas tran tck2_355 when v(xdiv.ck2)=1.65 rise=355
.meas tran tck2_356 when v(xdiv.ck2)=1.65 rise=356
.meas tran tck2_357 when v(xdiv.ck2)=1.65 rise=357
.meas tran tck2_358 when v(xdiv.ck2)=1.65 rise=358
.meas tran tck2_359 when v(xdiv.ck2)=1.65 rise=359
.meas tran tck2_360 when v(xdiv.ck2)=1.65 rise=360
.meas tran tck2_361 when v(xdiv.ck2)=1.65 rise=361
.meas tran tck2_362 when v(xdiv.ck2)=1.65 rise=362
.meas tran tck2_363 when v(xdiv.ck2)=1.65 rise=363
.meas tran tck2_364 when v(xdiv.ck2)=1.65 rise=364
.meas tran tck2_365 when v(xdiv.ck2)=1.65 rise=365
.meas tran tck2_366 when v(xdiv.ck2)=1.65 rise=366
.meas tran tck2_367 when v(xdiv.ck2)=1.65 rise=367
.meas tran tck2_368 when v(xdiv.ck2)=1.65 rise=368
.meas tran tck2_369 when v(xdiv.ck2)=1.65 rise=369
.meas tran tck2_370 when v(xdiv.ck2)=1.65 rise=370
.meas tran tck2_371 when v(xdiv.ck2)=1.65 rise=371
.meas tran tck2_372 when v(xdiv.ck2)=1.65 rise=372
.meas tran tck2_373 when v(xdiv.ck2)=1.65 rise=373
.meas tran tck2_374 when v(xdiv.ck2)=1.65 rise=374
.meas tran tck2_375 when v(xdiv.ck2)=1.65 rise=375
.meas tran tck2_376 when v(xdiv.ck2)=1.65 rise=376
.meas tran tck2_377 when v(xdiv.ck2)=1.65 rise=377
.meas tran tck2_378 when v(xdiv.ck2)=1.65 rise=378
.meas tran tck2_379 when v(xdiv.ck2)=1.65 rise=379
.meas tran tck2_380 when v(xdiv.ck2)=1.65 rise=380
.meas tran tck2_381 when v(xdiv.ck2)=1.65 rise=381
.meas tran tck2_382 when v(xdiv.ck2)=1.65 rise=382
.meas tran tck2_383 when v(xdiv.ck2)=1.65 rise=383
.meas tran tck2_384 when v(xdiv.ck2)=1.65 rise=384
.meas tran tck2_385 when v(xdiv.ck2)=1.65 rise=385
.meas tran tck2_386 when v(xdiv.ck2)=1.65 rise=386
.meas tran tck2_387 when v(xdiv.ck2)=1.65 rise=387
.meas tran tck2_388 when v(xdiv.ck2)=1.65 rise=388
.meas tran tck2_389 when v(xdiv.ck2)=1.65 rise=389
.meas tran tck2_390 when v(xdiv.ck2)=1.65 rise=390
.meas tran tck2_391 when v(xdiv.ck2)=1.65 rise=391
.meas tran tck2_392 when v(xdiv.ck2)=1.65 rise=392
.meas tran tck2_393 when v(xdiv.ck2)=1.65 rise=393
.meas tran tck2_394 when v(xdiv.ck2)=1.65 rise=394
.meas tran tck2_395 when v(xdiv.ck2)=1.65 rise=395
.meas tran tck2_396 when v(xdiv.ck2)=1.65 rise=396
.meas tran tck2_397 when v(xdiv.ck2)=1.65 rise=397
.meas tran tck2_398 when v(xdiv.ck2)=1.65 rise=398
.meas tran tck2_399 when v(xdiv.ck2)=1.65 rise=399
.meas tran tck2_400 when v(xdiv.ck2)=1.65 rise=400
.meas tran tck2_401 when v(xdiv.ck2)=1.65 rise=401
.meas tran tck2_402 when v(xdiv.ck2)=1.65 rise=402
.meas tran tck2_403 when v(xdiv.ck2)=1.65 rise=403
.meas tran tck2_404 when v(xdiv.ck2)=1.65 rise=404
.meas tran tck2_405 when v(xdiv.ck2)=1.65 rise=405
.meas tran tck2_406 when v(xdiv.ck2)=1.65 rise=406
.meas tran tck2_407 when v(xdiv.ck2)=1.65 rise=407
.meas tran tck2_408 when v(xdiv.ck2)=1.65 rise=408
.meas tran tck2_409 when v(xdiv.ck2)=1.65 rise=409
.meas tran tck2_410 when v(xdiv.ck2)=1.65 rise=410
.meas tran tck2_411 when v(xdiv.ck2)=1.65 rise=411
.meas tran tck2_412 when v(xdiv.ck2)=1.65 rise=412
.meas tran tck2_413 when v(xdiv.ck2)=1.65 rise=413
.meas tran tck2_414 when v(xdiv.ck2)=1.65 rise=414
.meas tran tck2_415 when v(xdiv.ck2)=1.65 rise=415
.meas tran tck2_416 when v(xdiv.ck2)=1.65 rise=416
.meas tran tck2_417 when v(xdiv.ck2)=1.65 rise=417
.meas tran tck2_418 when v(xdiv.ck2)=1.65 rise=418
.meas tran tck2_419 when v(xdiv.ck2)=1.65 rise=419
.meas tran tck2_420 when v(xdiv.ck2)=1.65 rise=420
.meas tran tck2_421 when v(xdiv.ck2)=1.65 rise=421
.meas tran tck2_422 when v(xdiv.ck2)=1.65 rise=422
.meas tran tck2_423 when v(xdiv.ck2)=1.65 rise=423
.meas tran tck2_424 when v(xdiv.ck2)=1.65 rise=424
.meas tran tck2_425 when v(xdiv.ck2)=1.65 rise=425
.meas tran tck2_426 when v(xdiv.ck2)=1.65 rise=426
.meas tran tck2_427 when v(xdiv.ck2)=1.65 rise=427
.meas tran tck2_428 when v(xdiv.ck2)=1.65 rise=428
.meas tran tck2_429 when v(xdiv.ck2)=1.65 rise=429
.meas tran tck2_430 when v(xdiv.ck2)=1.65 rise=430
.meas tran tck2_431 when v(xdiv.ck2)=1.65 rise=431
.meas tran tck2_432 when v(xdiv.ck2)=1.65 rise=432
.meas tran tck2_433 when v(xdiv.ck2)=1.65 rise=433
.meas tran tck2_434 when v(xdiv.ck2)=1.65 rise=434
.meas tran tck2_435 when v(xdiv.ck2)=1.65 rise=435
.meas tran tck2_436 when v(xdiv.ck2)=1.65 rise=436
.meas tran tck2_437 when v(xdiv.ck2)=1.65 rise=437
.meas tran tck2_438 when v(xdiv.ck2)=1.65 rise=438
.meas tran tck2_439 when v(xdiv.ck2)=1.65 rise=439
.meas tran tck2_440 when v(xdiv.ck2)=1.65 rise=440
.meas tran tck2_441 when v(xdiv.ck2)=1.65 rise=441
.meas tran tck2_442 when v(xdiv.ck2)=1.65 rise=442
.meas tran tck2_443 when v(xdiv.ck2)=1.65 rise=443
.meas tran tck2_444 when v(xdiv.ck2)=1.65 rise=444
.meas tran tck2_445 when v(xdiv.ck2)=1.65 rise=445
.meas tran tck2_446 when v(xdiv.ck2)=1.65 rise=446
.meas tran tck2_447 when v(xdiv.ck2)=1.65 rise=447
.meas tran tck2_448 when v(xdiv.ck2)=1.65 rise=448
.meas tran tck2_449 when v(xdiv.ck2)=1.65 rise=449
.meas tran tck2_450 when v(xdiv.ck2)=1.65 rise=450
.meas tran tck2_451 when v(xdiv.ck2)=1.65 rise=451
.meas tran tck2_452 when v(xdiv.ck2)=1.65 rise=452
.meas tran tck2_453 when v(xdiv.ck2)=1.65 rise=453
.meas tran tck2_454 when v(xdiv.ck2)=1.65 rise=454
.meas tran tck2_455 when v(xdiv.ck2)=1.65 rise=455
.meas tran tck2_456 when v(xdiv.ck2)=1.65 rise=456
.meas tran tck2_457 when v(xdiv.ck2)=1.65 rise=457
.meas tran tck2_458 when v(xdiv.ck2)=1.65 rise=458
.meas tran tck2_459 when v(xdiv.ck2)=1.65 rise=459
.meas tran tck2_460 when v(xdiv.ck2)=1.65 rise=460
.meas tran tck2_461 when v(xdiv.ck2)=1.65 rise=461
.meas tran tck2_462 when v(xdiv.ck2)=1.65 rise=462
.meas tran tck2_463 when v(xdiv.ck2)=1.65 rise=463
.meas tran tck2_464 when v(xdiv.ck2)=1.65 rise=464
.meas tran tck2_465 when v(xdiv.ck2)=1.65 rise=465
.meas tran tck2_466 when v(xdiv.ck2)=1.65 rise=466
.meas tran tck2_467 when v(xdiv.ck2)=1.65 rise=467
.meas tran tck2_468 when v(xdiv.ck2)=1.65 rise=468
.meas tran tck2_469 when v(xdiv.ck2)=1.65 rise=469
.meas tran tck2_470 when v(xdiv.ck2)=1.65 rise=470
.meas tran tck2_471 when v(xdiv.ck2)=1.65 rise=471
.meas tran tck2_472 when v(xdiv.ck2)=1.65 rise=472
.meas tran tck2_473 when v(xdiv.ck2)=1.65 rise=473
.meas tran tck2_474 when v(xdiv.ck2)=1.65 rise=474
.meas tran tck2_475 when v(xdiv.ck2)=1.65 rise=475
.meas tran tck2_476 when v(xdiv.ck2)=1.65 rise=476
.meas tran tck2_477 when v(xdiv.ck2)=1.65 rise=477
.meas tran tck2_478 when v(xdiv.ck2)=1.65 rise=478
.meas tran tck2_479 when v(xdiv.ck2)=1.65 rise=479
.meas tran tck2_480 when v(xdiv.ck2)=1.65 rise=480
.meas tran tck2_481 when v(xdiv.ck2)=1.65 rise=481
.meas tran tck2_482 when v(xdiv.ck2)=1.65 rise=482
.meas tran tck2_483 when v(xdiv.ck2)=1.65 rise=483
.meas tran tck2_484 when v(xdiv.ck2)=1.65 rise=484
.meas tran tck2_485 when v(xdiv.ck2)=1.65 rise=485
.meas tran tck2_486 when v(xdiv.ck2)=1.65 rise=486
.meas tran tck2_487 when v(xdiv.ck2)=1.65 rise=487
.meas tran tck2_488 when v(xdiv.ck2)=1.65 rise=488
.meas tran tck2_489 when v(xdiv.ck2)=1.65 rise=489
.meas tran tck2_490 when v(xdiv.ck2)=1.65 rise=490
.meas tran tck2_491 when v(xdiv.ck2)=1.65 rise=491
.meas tran tck2_492 when v(xdiv.ck2)=1.65 rise=492
.meas tran tck2_493 when v(xdiv.ck2)=1.65 rise=493
.meas tran tck2_494 when v(xdiv.ck2)=1.65 rise=494
.meas tran tck2_495 when v(xdiv.ck2)=1.65 rise=495
.meas tran tck2_496 when v(xdiv.ck2)=1.65 rise=496
.meas tran tck2_497 when v(xdiv.ck2)=1.65 rise=497
.meas tran tck2_498 when v(xdiv.ck2)=1.65 rise=498
.meas tran tck2_499 when v(xdiv.ck2)=1.65 rise=499
.meas tran tck2_500 when v(xdiv.ck2)=1.65 rise=500
.meas tran tck2_501 when v(xdiv.ck2)=1.65 rise=501
.meas tran tck2_502 when v(xdiv.ck2)=1.65 rise=502
.meas tran tck2_503 when v(xdiv.ck2)=1.65 rise=503
.meas tran tck2_504 when v(xdiv.ck2)=1.65 rise=504
.meas tran tck2_505 when v(xdiv.ck2)=1.65 rise=505
.meas tran tck2_506 when v(xdiv.ck2)=1.65 rise=506
.meas tran tck2_507 when v(xdiv.ck2)=1.65 rise=507
.meas tran tck2_508 when v(xdiv.ck2)=1.65 rise=508
.meas tran tck2_509 when v(xdiv.ck2)=1.65 rise=509
.meas tran tck2_510 when v(xdiv.ck2)=1.65 rise=510
.meas tran tck2_511 when v(xdiv.ck2)=1.65 rise=511
.meas tran tck2_512 when v(xdiv.ck2)=1.65 rise=512
.meas tran tck2_513 when v(xdiv.ck2)=1.65 rise=513
.meas tran tck2_514 when v(xdiv.ck2)=1.65 rise=514
.meas tran tck2_515 when v(xdiv.ck2)=1.65 rise=515
.meas tran tck2_516 when v(xdiv.ck2)=1.65 rise=516
.meas tran tck2_517 when v(xdiv.ck2)=1.65 rise=517
.meas tran tck2_518 when v(xdiv.ck2)=1.65 rise=518
.meas tran tck2_519 when v(xdiv.ck2)=1.65 rise=519
.meas tran tck2_520 when v(xdiv.ck2)=1.65 rise=520
.meas tran tck2_521 when v(xdiv.ck2)=1.65 rise=521
.meas tran tck2_522 when v(xdiv.ck2)=1.65 rise=522
.meas tran tck2_523 when v(xdiv.ck2)=1.65 rise=523
.meas tran tck2_524 when v(xdiv.ck2)=1.65 rise=524
.meas tran tck2_525 when v(xdiv.ck2)=1.65 rise=525
.meas tran tck2_526 when v(xdiv.ck2)=1.65 rise=526
.meas tran tck2_527 when v(xdiv.ck2)=1.65 rise=527
.meas tran tck2_528 when v(xdiv.ck2)=1.65 rise=528
.meas tran tck2_529 when v(xdiv.ck2)=1.65 rise=529
.meas tran tck2_530 when v(xdiv.ck2)=1.65 rise=530
.meas tran tck2_531 when v(xdiv.ck2)=1.65 rise=531
.meas tran tck2_532 when v(xdiv.ck2)=1.65 rise=532
.meas tran tck2_533 when v(xdiv.ck2)=1.65 rise=533
.meas tran tck2_534 when v(xdiv.ck2)=1.65 rise=534
.meas tran tck2_535 when v(xdiv.ck2)=1.65 rise=535
.meas tran tck2_536 when v(xdiv.ck2)=1.65 rise=536
.meas tran tck3_1 when v(xdiv.ck3)=1.65 rise=1
.meas tran tck3_2 when v(xdiv.ck3)=1.65 rise=2
.meas tran tck3_3 when v(xdiv.ck3)=1.65 rise=3
.meas tran tck3_4 when v(xdiv.ck3)=1.65 rise=4
.meas tran tck3_5 when v(xdiv.ck3)=1.65 rise=5
.meas tran tck3_6 when v(xdiv.ck3)=1.65 rise=6
.meas tran tck3_7 when v(xdiv.ck3)=1.65 rise=7
.meas tran tck3_8 when v(xdiv.ck3)=1.65 rise=8
.meas tran tck3_9 when v(xdiv.ck3)=1.65 rise=9
.meas tran tck3_10 when v(xdiv.ck3)=1.65 rise=10
.meas tran tck3_11 when v(xdiv.ck3)=1.65 rise=11
.meas tran tck3_12 when v(xdiv.ck3)=1.65 rise=12
.meas tran tck3_13 when v(xdiv.ck3)=1.65 rise=13
.meas tran tck3_14 when v(xdiv.ck3)=1.65 rise=14
.meas tran tck3_15 when v(xdiv.ck3)=1.65 rise=15
.meas tran tck3_16 when v(xdiv.ck3)=1.65 rise=16
.meas tran tck3_17 when v(xdiv.ck3)=1.65 rise=17
.meas tran tck3_18 when v(xdiv.ck3)=1.65 rise=18
.meas tran tck3_19 when v(xdiv.ck3)=1.65 rise=19
.meas tran tck3_20 when v(xdiv.ck3)=1.65 rise=20
.meas tran tck3_21 when v(xdiv.ck3)=1.65 rise=21
.meas tran tck3_22 when v(xdiv.ck3)=1.65 rise=22
.meas tran tck3_23 when v(xdiv.ck3)=1.65 rise=23
.meas tran tck3_24 when v(xdiv.ck3)=1.65 rise=24
.meas tran tck3_25 when v(xdiv.ck3)=1.65 rise=25
.meas tran tck3_26 when v(xdiv.ck3)=1.65 rise=26
.meas tran tck3_27 when v(xdiv.ck3)=1.65 rise=27
.meas tran tck3_28 when v(xdiv.ck3)=1.65 rise=28
.meas tran tck3_29 when v(xdiv.ck3)=1.65 rise=29
.meas tran tck3_30 when v(xdiv.ck3)=1.65 rise=30
.meas tran tck3_31 when v(xdiv.ck3)=1.65 rise=31
.meas tran tck3_32 when v(xdiv.ck3)=1.65 rise=32
.meas tran tck3_33 when v(xdiv.ck3)=1.65 rise=33
.meas tran tck3_34 when v(xdiv.ck3)=1.65 rise=34
.meas tran tck3_35 when v(xdiv.ck3)=1.65 rise=35
.meas tran tck3_36 when v(xdiv.ck3)=1.65 rise=36
.meas tran tck3_37 when v(xdiv.ck3)=1.65 rise=37
.meas tran tck3_38 when v(xdiv.ck3)=1.65 rise=38
.meas tran tck3_39 when v(xdiv.ck3)=1.65 rise=39
.meas tran tck3_40 when v(xdiv.ck3)=1.65 rise=40
.meas tran tck3_41 when v(xdiv.ck3)=1.65 rise=41
.meas tran tck3_42 when v(xdiv.ck3)=1.65 rise=42
.meas tran tck3_43 when v(xdiv.ck3)=1.65 rise=43
.meas tran tck3_44 when v(xdiv.ck3)=1.65 rise=44
.meas tran tck3_45 when v(xdiv.ck3)=1.65 rise=45
.meas tran tck3_46 when v(xdiv.ck3)=1.65 rise=46
.meas tran tck3_47 when v(xdiv.ck3)=1.65 rise=47
.meas tran tck3_48 when v(xdiv.ck3)=1.65 rise=48
.meas tran tck3_49 when v(xdiv.ck3)=1.65 rise=49
.meas tran tck3_50 when v(xdiv.ck3)=1.65 rise=50
.meas tran tck3_51 when v(xdiv.ck3)=1.65 rise=51
.meas tran tck3_52 when v(xdiv.ck3)=1.65 rise=52
.meas tran tck3_53 when v(xdiv.ck3)=1.65 rise=53
.meas tran tck3_54 when v(xdiv.ck3)=1.65 rise=54
.meas tran tck3_55 when v(xdiv.ck3)=1.65 rise=55
.meas tran tck3_56 when v(xdiv.ck3)=1.65 rise=56
.meas tran tck3_57 when v(xdiv.ck3)=1.65 rise=57
.meas tran tck3_58 when v(xdiv.ck3)=1.65 rise=58
.meas tran tck3_59 when v(xdiv.ck3)=1.65 rise=59
.meas tran tck3_60 when v(xdiv.ck3)=1.65 rise=60
.meas tran tck3_61 when v(xdiv.ck3)=1.65 rise=61
.meas tran tck3_62 when v(xdiv.ck3)=1.65 rise=62
.meas tran tck3_63 when v(xdiv.ck3)=1.65 rise=63
.meas tran tck3_64 when v(xdiv.ck3)=1.65 rise=64
.meas tran tck3_65 when v(xdiv.ck3)=1.65 rise=65
.meas tran tck3_66 when v(xdiv.ck3)=1.65 rise=66
.meas tran tck3_67 when v(xdiv.ck3)=1.65 rise=67
.meas tran tck3_68 when v(xdiv.ck3)=1.65 rise=68
.meas tran tck3_69 when v(xdiv.ck3)=1.65 rise=69
.meas tran tck3_70 when v(xdiv.ck3)=1.65 rise=70
.meas tran tck3_71 when v(xdiv.ck3)=1.65 rise=71
.meas tran tck3_72 when v(xdiv.ck3)=1.65 rise=72
.meas tran tck3_73 when v(xdiv.ck3)=1.65 rise=73
.meas tran tck3_74 when v(xdiv.ck3)=1.65 rise=74
.meas tran tck3_75 when v(xdiv.ck3)=1.65 rise=75
.meas tran tck3_76 when v(xdiv.ck3)=1.65 rise=76
.meas tran tck3_77 when v(xdiv.ck3)=1.65 rise=77
.meas tran tck3_78 when v(xdiv.ck3)=1.65 rise=78
.meas tran tck3_79 when v(xdiv.ck3)=1.65 rise=79
.meas tran tck3_80 when v(xdiv.ck3)=1.65 rise=80
.meas tran tck3_81 when v(xdiv.ck3)=1.65 rise=81
.meas tran tck3_82 when v(xdiv.ck3)=1.65 rise=82
.meas tran tck3_83 when v(xdiv.ck3)=1.65 rise=83
.meas tran tck3_84 when v(xdiv.ck3)=1.65 rise=84
.meas tran tck3_85 when v(xdiv.ck3)=1.65 rise=85
.meas tran tck3_86 when v(xdiv.ck3)=1.65 rise=86
.meas tran tck3_87 when v(xdiv.ck3)=1.65 rise=87
.meas tran tck3_88 when v(xdiv.ck3)=1.65 rise=88
.meas tran tck3_89 when v(xdiv.ck3)=1.65 rise=89
.meas tran tck3_90 when v(xdiv.ck3)=1.65 rise=90
.meas tran tck3_91 when v(xdiv.ck3)=1.65 rise=91
.meas tran tck3_92 when v(xdiv.ck3)=1.65 rise=92
.meas tran tck3_93 when v(xdiv.ck3)=1.65 rise=93
.meas tran tck3_94 when v(xdiv.ck3)=1.65 rise=94
.meas tran tck3_95 when v(xdiv.ck3)=1.65 rise=95
.meas tran tck3_96 when v(xdiv.ck3)=1.65 rise=96
.meas tran tck3_97 when v(xdiv.ck3)=1.65 rise=97
.meas tran tck3_98 when v(xdiv.ck3)=1.65 rise=98
.meas tran tck3_99 when v(xdiv.ck3)=1.65 rise=99
.meas tran tck3_100 when v(xdiv.ck3)=1.65 rise=100
.meas tran tck3_101 when v(xdiv.ck3)=1.65 rise=101
.meas tran tck3_102 when v(xdiv.ck3)=1.65 rise=102
.meas tran tck3_103 when v(xdiv.ck3)=1.65 rise=103
.meas tran tck3_104 when v(xdiv.ck3)=1.65 rise=104
.meas tran tck3_105 when v(xdiv.ck3)=1.65 rise=105
.meas tran tck3_106 when v(xdiv.ck3)=1.65 rise=106
.meas tran tck3_107 when v(xdiv.ck3)=1.65 rise=107
.meas tran tck3_108 when v(xdiv.ck3)=1.65 rise=108
.meas tran tck3_109 when v(xdiv.ck3)=1.65 rise=109
.meas tran tck3_110 when v(xdiv.ck3)=1.65 rise=110
.meas tran tck3_111 when v(xdiv.ck3)=1.65 rise=111
.meas tran tck3_112 when v(xdiv.ck3)=1.65 rise=112
.meas tran tck3_113 when v(xdiv.ck3)=1.65 rise=113
.meas tran tck3_114 when v(xdiv.ck3)=1.65 rise=114
.meas tran tck3_115 when v(xdiv.ck3)=1.65 rise=115
.meas tran tck3_116 when v(xdiv.ck3)=1.65 rise=116
.meas tran tck3_117 when v(xdiv.ck3)=1.65 rise=117
.meas tran tck3_118 when v(xdiv.ck3)=1.65 rise=118
.meas tran tck3_119 when v(xdiv.ck3)=1.65 rise=119
.meas tran tck3_120 when v(xdiv.ck3)=1.65 rise=120
.meas tran tck3_121 when v(xdiv.ck3)=1.65 rise=121
.meas tran tck3_122 when v(xdiv.ck3)=1.65 rise=122
.meas tran tck3_123 when v(xdiv.ck3)=1.65 rise=123
.meas tran tck3_124 when v(xdiv.ck3)=1.65 rise=124
.meas tran tck3_125 when v(xdiv.ck3)=1.65 rise=125
.meas tran tck3_126 when v(xdiv.ck3)=1.65 rise=126
.meas tran tck3_127 when v(xdiv.ck3)=1.65 rise=127
.meas tran tck3_128 when v(xdiv.ck3)=1.65 rise=128
.meas tran tck3_129 when v(xdiv.ck3)=1.65 rise=129
.meas tran tck3_130 when v(xdiv.ck3)=1.65 rise=130
.meas tran tck3_131 when v(xdiv.ck3)=1.65 rise=131
.meas tran tck3_132 when v(xdiv.ck3)=1.65 rise=132
.meas tran tck3_133 when v(xdiv.ck3)=1.65 rise=133
.meas tran tck3_134 when v(xdiv.ck3)=1.65 rise=134
.meas tran tck3_135 when v(xdiv.ck3)=1.65 rise=135
.meas tran tck3_136 when v(xdiv.ck3)=1.65 rise=136
.meas tran tck3_137 when v(xdiv.ck3)=1.65 rise=137
.meas tran tck3_138 when v(xdiv.ck3)=1.65 rise=138
.meas tran tck3_139 when v(xdiv.ck3)=1.65 rise=139
.meas tran tck3_140 when v(xdiv.ck3)=1.65 rise=140
.meas tran tck3_141 when v(xdiv.ck3)=1.65 rise=141
.meas tran tck3_142 when v(xdiv.ck3)=1.65 rise=142
.meas tran tck3_143 when v(xdiv.ck3)=1.65 rise=143
.meas tran tck3_144 when v(xdiv.ck3)=1.65 rise=144
.meas tran tck3_145 when v(xdiv.ck3)=1.65 rise=145
.meas tran tck3_146 when v(xdiv.ck3)=1.65 rise=146
.meas tran tck3_147 when v(xdiv.ck3)=1.65 rise=147
.meas tran tck3_148 when v(xdiv.ck3)=1.65 rise=148
.meas tran tck3_149 when v(xdiv.ck3)=1.65 rise=149
.meas tran tck3_150 when v(xdiv.ck3)=1.65 rise=150
.meas tran tck3_151 when v(xdiv.ck3)=1.65 rise=151
.meas tran tck3_152 when v(xdiv.ck3)=1.65 rise=152
.meas tran tck3_153 when v(xdiv.ck3)=1.65 rise=153
.meas tran tck3_154 when v(xdiv.ck3)=1.65 rise=154
.meas tran tck3_155 when v(xdiv.ck3)=1.65 rise=155
.meas tran tck3_156 when v(xdiv.ck3)=1.65 rise=156
.meas tran tck3_157 when v(xdiv.ck3)=1.65 rise=157
.meas tran tck3_158 when v(xdiv.ck3)=1.65 rise=158
.meas tran tck3_159 when v(xdiv.ck3)=1.65 rise=159
.meas tran tck3_160 when v(xdiv.ck3)=1.65 rise=160
.meas tran tck3_161 when v(xdiv.ck3)=1.65 rise=161
.meas tran tck3_162 when v(xdiv.ck3)=1.65 rise=162
.meas tran tck3_163 when v(xdiv.ck3)=1.65 rise=163
.meas tran tck3_164 when v(xdiv.ck3)=1.65 rise=164
.meas tran tck3_165 when v(xdiv.ck3)=1.65 rise=165
.meas tran tck3_166 when v(xdiv.ck3)=1.65 rise=166
.meas tran tck3_167 when v(xdiv.ck3)=1.65 rise=167
.meas tran tck3_168 when v(xdiv.ck3)=1.65 rise=168
.meas tran tck3_169 when v(xdiv.ck3)=1.65 rise=169
.meas tran tck3_170 when v(xdiv.ck3)=1.65 rise=170
.meas tran tck3_171 when v(xdiv.ck3)=1.65 rise=171
.meas tran tck3_172 when v(xdiv.ck3)=1.65 rise=172
.meas tran tck3_173 when v(xdiv.ck3)=1.65 rise=173
.meas tran tck3_174 when v(xdiv.ck3)=1.65 rise=174
.meas tran tck3_175 when v(xdiv.ck3)=1.65 rise=175
.meas tran tck3_176 when v(xdiv.ck3)=1.65 rise=176
.meas tran tck3_177 when v(xdiv.ck3)=1.65 rise=177
.meas tran tck3_178 when v(xdiv.ck3)=1.65 rise=178
.meas tran tck3_179 when v(xdiv.ck3)=1.65 rise=179
.meas tran tck3_180 when v(xdiv.ck3)=1.65 rise=180
.meas tran tck3_181 when v(xdiv.ck3)=1.65 rise=181
.meas tran tck3_182 when v(xdiv.ck3)=1.65 rise=182
.meas tran tck3_183 when v(xdiv.ck3)=1.65 rise=183
.meas tran tck3_184 when v(xdiv.ck3)=1.65 rise=184
.meas tran tck3_185 when v(xdiv.ck3)=1.65 rise=185
.meas tran tck3_186 when v(xdiv.ck3)=1.65 rise=186
.meas tran tck3_187 when v(xdiv.ck3)=1.65 rise=187
.meas tran tck3_188 when v(xdiv.ck3)=1.65 rise=188
.meas tran tck3_189 when v(xdiv.ck3)=1.65 rise=189
.meas tran tck3_190 when v(xdiv.ck3)=1.65 rise=190
.meas tran tck3_191 when v(xdiv.ck3)=1.65 rise=191
.meas tran tck3_192 when v(xdiv.ck3)=1.65 rise=192
.meas tran tck3_193 when v(xdiv.ck3)=1.65 rise=193
.meas tran tck3_194 when v(xdiv.ck3)=1.65 rise=194
.meas tran tck3_195 when v(xdiv.ck3)=1.65 rise=195
.meas tran tck3_196 when v(xdiv.ck3)=1.65 rise=196
.meas tran tck3_197 when v(xdiv.ck3)=1.65 rise=197
.meas tran tck3_198 when v(xdiv.ck3)=1.65 rise=198
.meas tran tck3_199 when v(xdiv.ck3)=1.65 rise=199
.meas tran tck3_200 when v(xdiv.ck3)=1.65 rise=200
.meas tran tck3_201 when v(xdiv.ck3)=1.65 rise=201
.meas tran tck3_202 when v(xdiv.ck3)=1.65 rise=202
.meas tran tck3_203 when v(xdiv.ck3)=1.65 rise=203
.meas tran tck3_204 when v(xdiv.ck3)=1.65 rise=204
.meas tran tck3_205 when v(xdiv.ck3)=1.65 rise=205
.meas tran tck3_206 when v(xdiv.ck3)=1.65 rise=206
.meas tran tck3_207 when v(xdiv.ck3)=1.65 rise=207
.meas tran tck3_208 when v(xdiv.ck3)=1.65 rise=208
.meas tran tck3_209 when v(xdiv.ck3)=1.65 rise=209
.meas tran tck3_210 when v(xdiv.ck3)=1.65 rise=210
.meas tran tck3_211 when v(xdiv.ck3)=1.65 rise=211
.meas tran tck3_212 when v(xdiv.ck3)=1.65 rise=212
.meas tran tck3_213 when v(xdiv.ck3)=1.65 rise=213
.meas tran tck3_214 when v(xdiv.ck3)=1.65 rise=214
.meas tran tck3_215 when v(xdiv.ck3)=1.65 rise=215
.meas tran tck3_216 when v(xdiv.ck3)=1.65 rise=216
.meas tran tck3_217 when v(xdiv.ck3)=1.65 rise=217
.meas tran tck3_218 when v(xdiv.ck3)=1.65 rise=218
.meas tran tck3_219 when v(xdiv.ck3)=1.65 rise=219
.meas tran tck3_220 when v(xdiv.ck3)=1.65 rise=220
.meas tran tck3_221 when v(xdiv.ck3)=1.65 rise=221
.meas tran tck3_222 when v(xdiv.ck3)=1.65 rise=222
.meas tran tck3_223 when v(xdiv.ck3)=1.65 rise=223
.meas tran tck3_224 when v(xdiv.ck3)=1.65 rise=224
.meas tran tck3_225 when v(xdiv.ck3)=1.65 rise=225
.meas tran tck3_226 when v(xdiv.ck3)=1.65 rise=226
.meas tran tck3_227 when v(xdiv.ck3)=1.65 rise=227
.meas tran tck3_228 when v(xdiv.ck3)=1.65 rise=228
.meas tran tck3_229 when v(xdiv.ck3)=1.65 rise=229
.meas tran tck3_230 when v(xdiv.ck3)=1.65 rise=230
.meas tran tck3_231 when v(xdiv.ck3)=1.65 rise=231
.meas tran tck3_232 when v(xdiv.ck3)=1.65 rise=232
.meas tran tck3_233 when v(xdiv.ck3)=1.65 rise=233
.meas tran tck3_234 when v(xdiv.ck3)=1.65 rise=234
.meas tran tck3_235 when v(xdiv.ck3)=1.65 rise=235
.meas tran tck3_236 when v(xdiv.ck3)=1.65 rise=236
.meas tran tck3_237 when v(xdiv.ck3)=1.65 rise=237
.meas tran tck3_238 when v(xdiv.ck3)=1.65 rise=238
.meas tran tck3_239 when v(xdiv.ck3)=1.65 rise=239
.meas tran tck3_240 when v(xdiv.ck3)=1.65 rise=240
.meas tran tck3_241 when v(xdiv.ck3)=1.65 rise=241
.meas tran tck3_242 when v(xdiv.ck3)=1.65 rise=242
.meas tran tck3_243 when v(xdiv.ck3)=1.65 rise=243
.meas tran tck3_244 when v(xdiv.ck3)=1.65 rise=244
.meas tran tck3_245 when v(xdiv.ck3)=1.65 rise=245
.meas tran tck3_246 when v(xdiv.ck3)=1.65 rise=246
.meas tran tck3_247 when v(xdiv.ck3)=1.65 rise=247
.meas tran tck3_248 when v(xdiv.ck3)=1.65 rise=248
.meas tran tck3_249 when v(xdiv.ck3)=1.65 rise=249
.meas tran tck3_250 when v(xdiv.ck3)=1.65 rise=250
.meas tran tck3_251 when v(xdiv.ck3)=1.65 rise=251
.meas tran tck3_252 when v(xdiv.ck3)=1.65 rise=252
.meas tran tck3_253 when v(xdiv.ck3)=1.65 rise=253
.meas tran tck3_254 when v(xdiv.ck3)=1.65 rise=254
.meas tran tck3_255 when v(xdiv.ck3)=1.65 rise=255
.meas tran tck3_256 when v(xdiv.ck3)=1.65 rise=256
.meas tran tck3_257 when v(xdiv.ck3)=1.65 rise=257
.meas tran tck3_258 when v(xdiv.ck3)=1.65 rise=258
.meas tran tck3_259 when v(xdiv.ck3)=1.65 rise=259
.meas tran tck3_260 when v(xdiv.ck3)=1.65 rise=260
.meas tran tck3_261 when v(xdiv.ck3)=1.65 rise=261
.meas tran tck3_262 when v(xdiv.ck3)=1.65 rise=262
.meas tran tck3_263 when v(xdiv.ck3)=1.65 rise=263
.meas tran tck3_264 when v(xdiv.ck3)=1.65 rise=264
.meas tran tck3_265 when v(xdiv.ck3)=1.65 rise=265
.meas tran tck3_266 when v(xdiv.ck3)=1.65 rise=266
.meas tran tck3_267 when v(xdiv.ck3)=1.65 rise=267
.meas tran tck3_268 when v(xdiv.ck3)=1.65 rise=268
.meas tran tck3_269 when v(xdiv.ck3)=1.65 rise=269
.meas tran tck3_270 when v(xdiv.ck3)=1.65 rise=270
.meas tran tck3_271 when v(xdiv.ck3)=1.65 rise=271
.meas tran tck3_272 when v(xdiv.ck3)=1.65 rise=272
.meas tran tck3_273 when v(xdiv.ck3)=1.65 rise=273
.meas tran tck3_274 when v(xdiv.ck3)=1.65 rise=274
.meas tran tck3_275 when v(xdiv.ck3)=1.65 rise=275
.meas tran tck3_276 when v(xdiv.ck3)=1.65 rise=276
.meas tran tck3_277 when v(xdiv.ck3)=1.65 rise=277
.meas tran tck3_278 when v(xdiv.ck3)=1.65 rise=278
.meas tran tck3_279 when v(xdiv.ck3)=1.65 rise=279
.meas tran tck3_280 when v(xdiv.ck3)=1.65 rise=280
.meas tran tck3_281 when v(xdiv.ck3)=1.65 rise=281
.meas tran tck3_282 when v(xdiv.ck3)=1.65 rise=282
.meas tran tck3_283 when v(xdiv.ck3)=1.65 rise=283
.meas tran tck3_284 when v(xdiv.ck3)=1.65 rise=284
.meas tran tck3_285 when v(xdiv.ck3)=1.65 rise=285
.meas tran tck3_286 when v(xdiv.ck3)=1.65 rise=286
.meas tran tck3_287 when v(xdiv.ck3)=1.65 rise=287
.meas tran tck3_288 when v(xdiv.ck3)=1.65 rise=288
.meas tran tck3_289 when v(xdiv.ck3)=1.65 rise=289
.meas tran tck3_290 when v(xdiv.ck3)=1.65 rise=290
.meas tran tck3_291 when v(xdiv.ck3)=1.65 rise=291
.meas tran tck3_292 when v(xdiv.ck3)=1.65 rise=292
.meas tran tck3_293 when v(xdiv.ck3)=1.65 rise=293
.meas tran tck3_294 when v(xdiv.ck3)=1.65 rise=294
.meas tran tck3_295 when v(xdiv.ck3)=1.65 rise=295
.meas tran tck3_296 when v(xdiv.ck3)=1.65 rise=296
.meas tran tck3_297 when v(xdiv.ck3)=1.65 rise=297
.meas tran tck3_298 when v(xdiv.ck3)=1.65 rise=298
.meas tran tck3_299 when v(xdiv.ck3)=1.65 rise=299
.meas tran tck3_300 when v(xdiv.ck3)=1.65 rise=300
.meas tran tck3_301 when v(xdiv.ck3)=1.65 rise=301
.meas tran tck3_302 when v(xdiv.ck3)=1.65 rise=302
.meas tran tck3_303 when v(xdiv.ck3)=1.65 rise=303
.meas tran tck3_304 when v(xdiv.ck3)=1.65 rise=304
.meas tran tck3_305 when v(xdiv.ck3)=1.65 rise=305
.meas tran tck3_306 when v(xdiv.ck3)=1.65 rise=306
.meas tran tck3_307 when v(xdiv.ck3)=1.65 rise=307
.meas tran tck3_308 when v(xdiv.ck3)=1.65 rise=308
.meas tran tck3_309 when v(xdiv.ck3)=1.65 rise=309
.meas tran tck3_310 when v(xdiv.ck3)=1.65 rise=310
.meas tran tck3_311 when v(xdiv.ck3)=1.65 rise=311
.meas tran tck3_312 when v(xdiv.ck3)=1.65 rise=312
.meas tran tck3_313 when v(xdiv.ck3)=1.65 rise=313
.meas tran tck3_314 when v(xdiv.ck3)=1.65 rise=314
.meas tran tck3_315 when v(xdiv.ck3)=1.65 rise=315
.meas tran tck3_316 when v(xdiv.ck3)=1.65 rise=316
.meas tran tck3_317 when v(xdiv.ck3)=1.65 rise=317
.meas tran tck3_318 when v(xdiv.ck3)=1.65 rise=318
.meas tran tck3_319 when v(xdiv.ck3)=1.65 rise=319
.meas tran tck3_320 when v(xdiv.ck3)=1.65 rise=320
.meas tran tck3_321 when v(xdiv.ck3)=1.65 rise=321
.meas tran tck3_322 when v(xdiv.ck3)=1.65 rise=322
.meas tran tck3_323 when v(xdiv.ck3)=1.65 rise=323
.meas tran tck3_324 when v(xdiv.ck3)=1.65 rise=324
.meas tran tck3_325 when v(xdiv.ck3)=1.65 rise=325
.meas tran tck3_326 when v(xdiv.ck3)=1.65 rise=326
.meas tran tck3_327 when v(xdiv.ck3)=1.65 rise=327
.meas tran tck3_328 when v(xdiv.ck3)=1.65 rise=328
.meas tran tck3_329 when v(xdiv.ck3)=1.65 rise=329
.meas tran tck3_330 when v(xdiv.ck3)=1.65 rise=330
.meas tran tck3_331 when v(xdiv.ck3)=1.65 rise=331
.meas tran tck3_332 when v(xdiv.ck3)=1.65 rise=332
.meas tran tck3_333 when v(xdiv.ck3)=1.65 rise=333
.meas tran tck3_334 when v(xdiv.ck3)=1.65 rise=334
.meas tran tck3_335 when v(xdiv.ck3)=1.65 rise=335
.meas tran tck3_336 when v(xdiv.ck3)=1.65 rise=336
.meas tran tck3_337 when v(xdiv.ck3)=1.65 rise=337
.meas tran tck3_338 when v(xdiv.ck3)=1.65 rise=338
.meas tran tck3_339 when v(xdiv.ck3)=1.65 rise=339
.meas tran tck3_340 when v(xdiv.ck3)=1.65 rise=340
.meas tran tck3_341 when v(xdiv.ck3)=1.65 rise=341
.meas tran tck3_342 when v(xdiv.ck3)=1.65 rise=342
.meas tran tck3_343 when v(xdiv.ck3)=1.65 rise=343
.meas tran tck3_344 when v(xdiv.ck3)=1.65 rise=344
.meas tran tck3_345 when v(xdiv.ck3)=1.65 rise=345
.meas tran tck3_346 when v(xdiv.ck3)=1.65 rise=346
.meas tran tck3_347 when v(xdiv.ck3)=1.65 rise=347
.meas tran tck3_348 when v(xdiv.ck3)=1.65 rise=348
.meas tran tck3_349 when v(xdiv.ck3)=1.65 rise=349
.meas tran tck3_350 when v(xdiv.ck3)=1.65 rise=350
.meas tran tck3_351 when v(xdiv.ck3)=1.65 rise=351
.meas tran tck3_352 when v(xdiv.ck3)=1.65 rise=352
.meas tran tck3_353 when v(xdiv.ck3)=1.65 rise=353
.meas tran tck3_354 when v(xdiv.ck3)=1.65 rise=354
.meas tran tck3_355 when v(xdiv.ck3)=1.65 rise=355
.meas tran tck3_356 when v(xdiv.ck3)=1.65 rise=356
.meas tran tck3_357 when v(xdiv.ck3)=1.65 rise=357
.meas tran tck3_358 when v(xdiv.ck3)=1.65 rise=358
.meas tran tck3_359 when v(xdiv.ck3)=1.65 rise=359
.meas tran tck3_360 when v(xdiv.ck3)=1.65 rise=360
.meas tran tck3_361 when v(xdiv.ck3)=1.65 rise=361
.meas tran tck3_362 when v(xdiv.ck3)=1.65 rise=362
.meas tran tck3_363 when v(xdiv.ck3)=1.65 rise=363
.meas tran tck3_364 when v(xdiv.ck3)=1.65 rise=364
.meas tran tck3_365 when v(xdiv.ck3)=1.65 rise=365
.meas tran tck3_366 when v(xdiv.ck3)=1.65 rise=366
.meas tran tck3_367 when v(xdiv.ck3)=1.65 rise=367
.meas tran tck3_368 when v(xdiv.ck3)=1.65 rise=368
.meas tran tck3_369 when v(xdiv.ck3)=1.65 rise=369
.meas tran tck3_370 when v(xdiv.ck3)=1.65 rise=370
.meas tran tck3_371 when v(xdiv.ck3)=1.65 rise=371
.meas tran tck3_372 when v(xdiv.ck3)=1.65 rise=372
.meas tran tck3_373 when v(xdiv.ck3)=1.65 rise=373
.meas tran tck3_374 when v(xdiv.ck3)=1.65 rise=374
.meas tran tck3_375 when v(xdiv.ck3)=1.65 rise=375
.meas tran tck3_376 when v(xdiv.ck3)=1.65 rise=376
.meas tran tck3_377 when v(xdiv.ck3)=1.65 rise=377
.meas tran tck3_378 when v(xdiv.ck3)=1.65 rise=378
.meas tran tck3_379 when v(xdiv.ck3)=1.65 rise=379
.meas tran tck3_380 when v(xdiv.ck3)=1.65 rise=380
.meas tran tck3_381 when v(xdiv.ck3)=1.65 rise=381
.meas tran tck3_382 when v(xdiv.ck3)=1.65 rise=382
.meas tran tck3_383 when v(xdiv.ck3)=1.65 rise=383
.meas tran tck3_384 when v(xdiv.ck3)=1.65 rise=384
.meas tran tck3_385 when v(xdiv.ck3)=1.65 rise=385
.meas tran tck3_386 when v(xdiv.ck3)=1.65 rise=386
.meas tran tck3_387 when v(xdiv.ck3)=1.65 rise=387
.meas tran tck3_388 when v(xdiv.ck3)=1.65 rise=388
.meas tran tck3_389 when v(xdiv.ck3)=1.65 rise=389
.meas tran tck3_390 when v(xdiv.ck3)=1.65 rise=390
.meas tran tck3_391 when v(xdiv.ck3)=1.65 rise=391
.meas tran tck3_392 when v(xdiv.ck3)=1.65 rise=392
.meas tran tck3_393 when v(xdiv.ck3)=1.65 rise=393
.meas tran tck3_394 when v(xdiv.ck3)=1.65 rise=394
.meas tran tck3_395 when v(xdiv.ck3)=1.65 rise=395
.meas tran tck3_396 when v(xdiv.ck3)=1.65 rise=396
.meas tran tck3_397 when v(xdiv.ck3)=1.65 rise=397
.meas tran tck3_398 when v(xdiv.ck3)=1.65 rise=398
.meas tran tck3_399 when v(xdiv.ck3)=1.65 rise=399
.meas tran tck3_400 when v(xdiv.ck3)=1.65 rise=400
.meas tran tck3_401 when v(xdiv.ck3)=1.65 rise=401
.meas tran tck3_402 when v(xdiv.ck3)=1.65 rise=402
.meas tran tck3_403 when v(xdiv.ck3)=1.65 rise=403
.meas tran tck3_404 when v(xdiv.ck3)=1.65 rise=404
.meas tran tck3_405 when v(xdiv.ck3)=1.65 rise=405
.meas tran tck3_406 when v(xdiv.ck3)=1.65 rise=406
.meas tran tck3_407 when v(xdiv.ck3)=1.65 rise=407
.meas tran tck3_408 when v(xdiv.ck3)=1.65 rise=408
.meas tran tck3_409 when v(xdiv.ck3)=1.65 rise=409
.meas tran tck3_410 when v(xdiv.ck3)=1.65 rise=410
.meas tran tck3_411 when v(xdiv.ck3)=1.65 rise=411
.meas tran tck3_412 when v(xdiv.ck3)=1.65 rise=412
.meas tran tck3_413 when v(xdiv.ck3)=1.65 rise=413
.meas tran tck3_414 when v(xdiv.ck3)=1.65 rise=414
.meas tran tck3_415 when v(xdiv.ck3)=1.65 rise=415
.meas tran tck3_416 when v(xdiv.ck3)=1.65 rise=416
.meas tran tck3_417 when v(xdiv.ck3)=1.65 rise=417
.meas tran tck3_418 when v(xdiv.ck3)=1.65 rise=418
.meas tran tck3_419 when v(xdiv.ck3)=1.65 rise=419
.meas tran tck3_420 when v(xdiv.ck3)=1.65 rise=420
.meas tran tck3_421 when v(xdiv.ck3)=1.65 rise=421
.meas tran tck3_422 when v(xdiv.ck3)=1.65 rise=422
.meas tran tck3_423 when v(xdiv.ck3)=1.65 rise=423
.meas tran tck3_424 when v(xdiv.ck3)=1.65 rise=424
.meas tran tck3_425 when v(xdiv.ck3)=1.65 rise=425
.meas tran tck3_426 when v(xdiv.ck3)=1.65 rise=426
.meas tran tck3_427 when v(xdiv.ck3)=1.65 rise=427
.meas tran tck3_428 when v(xdiv.ck3)=1.65 rise=428
.meas tran tck3_429 when v(xdiv.ck3)=1.65 rise=429
.meas tran tck3_430 when v(xdiv.ck3)=1.65 rise=430
.meas tran tck3_431 when v(xdiv.ck3)=1.65 rise=431
.meas tran tck3_432 when v(xdiv.ck3)=1.65 rise=432
.meas tran tck3_433 when v(xdiv.ck3)=1.65 rise=433
.meas tran tck3_434 when v(xdiv.ck3)=1.65 rise=434
.meas tran tck3_435 when v(xdiv.ck3)=1.65 rise=435
.meas tran tck3_436 when v(xdiv.ck3)=1.65 rise=436
.meas tran tck3_437 when v(xdiv.ck3)=1.65 rise=437
.meas tran tck3_438 when v(xdiv.ck3)=1.65 rise=438
.meas tran tck3_439 when v(xdiv.ck3)=1.65 rise=439
.meas tran tck3_440 when v(xdiv.ck3)=1.65 rise=440
.meas tran tck3_441 when v(xdiv.ck3)=1.65 rise=441
.meas tran tck3_442 when v(xdiv.ck3)=1.65 rise=442
.meas tran tck3_443 when v(xdiv.ck3)=1.65 rise=443
.meas tran tck3_444 when v(xdiv.ck3)=1.65 rise=444
.meas tran tck3_445 when v(xdiv.ck3)=1.65 rise=445
.meas tran tck3_446 when v(xdiv.ck3)=1.65 rise=446
.meas tran tck3_447 when v(xdiv.ck3)=1.65 rise=447
.meas tran tck3_448 when v(xdiv.ck3)=1.65 rise=448
.meas tran tck3_449 when v(xdiv.ck3)=1.65 rise=449
.meas tran tck3_450 when v(xdiv.ck3)=1.65 rise=450
.meas tran tck3_451 when v(xdiv.ck3)=1.65 rise=451
.meas tran tck3_452 when v(xdiv.ck3)=1.65 rise=452
.meas tran tck3_453 when v(xdiv.ck3)=1.65 rise=453
.meas tran tck3_454 when v(xdiv.ck3)=1.65 rise=454
.meas tran tck3_455 when v(xdiv.ck3)=1.65 rise=455
.meas tran tck3_456 when v(xdiv.ck3)=1.65 rise=456
.meas tran tck3_457 when v(xdiv.ck3)=1.65 rise=457
.meas tran tck3_458 when v(xdiv.ck3)=1.65 rise=458
.meas tran tck3_459 when v(xdiv.ck3)=1.65 rise=459
.meas tran tck3_460 when v(xdiv.ck3)=1.65 rise=460
.meas tran tck3_461 when v(xdiv.ck3)=1.65 rise=461
.meas tran tck3_462 when v(xdiv.ck3)=1.65 rise=462
.meas tran tck3_463 when v(xdiv.ck3)=1.65 rise=463
.meas tran tck3_464 when v(xdiv.ck3)=1.65 rise=464
.meas tran tck3_465 when v(xdiv.ck3)=1.65 rise=465
.meas tran tck3_466 when v(xdiv.ck3)=1.65 rise=466
.meas tran tck3_467 when v(xdiv.ck3)=1.65 rise=467
.meas tran tck3_468 when v(xdiv.ck3)=1.65 rise=468
.meas tran tck3_469 when v(xdiv.ck3)=1.65 rise=469
.meas tran tck3_470 when v(xdiv.ck3)=1.65 rise=470
.meas tran tck3_471 when v(xdiv.ck3)=1.65 rise=471
.meas tran tck3_472 when v(xdiv.ck3)=1.65 rise=472
.meas tran tck3_473 when v(xdiv.ck3)=1.65 rise=473
.meas tran tck3_474 when v(xdiv.ck3)=1.65 rise=474
.meas tran tck3_475 when v(xdiv.ck3)=1.65 rise=475
.meas tran tck3_476 when v(xdiv.ck3)=1.65 rise=476
.meas tran tck3_477 when v(xdiv.ck3)=1.65 rise=477
.meas tran tck3_478 when v(xdiv.ck3)=1.65 rise=478
.meas tran tck3_479 when v(xdiv.ck3)=1.65 rise=479
.meas tran tck3_480 when v(xdiv.ck3)=1.65 rise=480
.meas tran tck3_481 when v(xdiv.ck3)=1.65 rise=481
.meas tran tck3_482 when v(xdiv.ck3)=1.65 rise=482
.meas tran tck3_483 when v(xdiv.ck3)=1.65 rise=483
.meas tran tck3_484 when v(xdiv.ck3)=1.65 rise=484
.meas tran tck3_485 when v(xdiv.ck3)=1.65 rise=485
.meas tran tck3_486 when v(xdiv.ck3)=1.65 rise=486
.meas tran tck3_487 when v(xdiv.ck3)=1.65 rise=487
.meas tran tck3_488 when v(xdiv.ck3)=1.65 rise=488
.meas tran tck3_489 when v(xdiv.ck3)=1.65 rise=489
.meas tran tck3_490 when v(xdiv.ck3)=1.65 rise=490
.meas tran tck3_491 when v(xdiv.ck3)=1.65 rise=491
.meas tran tck3_492 when v(xdiv.ck3)=1.65 rise=492
.meas tran tck3_493 when v(xdiv.ck3)=1.65 rise=493
.meas tran tck3_494 when v(xdiv.ck3)=1.65 rise=494
.meas tran tck3_495 when v(xdiv.ck3)=1.65 rise=495
.meas tran tck3_496 when v(xdiv.ck3)=1.65 rise=496
.meas tran tck3_497 when v(xdiv.ck3)=1.65 rise=497
.meas tran tck3_498 when v(xdiv.ck3)=1.65 rise=498
.meas tran tck3_499 when v(xdiv.ck3)=1.65 rise=499
.meas tran tck3_500 when v(xdiv.ck3)=1.65 rise=500
.meas tran tck3_501 when v(xdiv.ck3)=1.65 rise=501
.meas tran tck3_502 when v(xdiv.ck3)=1.65 rise=502
.meas tran tck3_503 when v(xdiv.ck3)=1.65 rise=503
.meas tran tck3_504 when v(xdiv.ck3)=1.65 rise=504
.meas tran tck3_505 when v(xdiv.ck3)=1.65 rise=505
.meas tran tck3_506 when v(xdiv.ck3)=1.65 rise=506
.meas tran tck3_507 when v(xdiv.ck3)=1.65 rise=507
.meas tran tck3_508 when v(xdiv.ck3)=1.65 rise=508
.meas tran tck3_509 when v(xdiv.ck3)=1.65 rise=509
.meas tran tck3_510 when v(xdiv.ck3)=1.65 rise=510
.meas tran tck3_511 when v(xdiv.ck3)=1.65 rise=511
.meas tran tck3_512 when v(xdiv.ck3)=1.65 rise=512
.meas tran tck3_513 when v(xdiv.ck3)=1.65 rise=513
.meas tran tck3_514 when v(xdiv.ck3)=1.65 rise=514
.meas tran tck3_515 when v(xdiv.ck3)=1.65 rise=515
.meas tran tck3_516 when v(xdiv.ck3)=1.65 rise=516
.meas tran tck3_517 when v(xdiv.ck3)=1.65 rise=517
.meas tran tck3_518 when v(xdiv.ck3)=1.65 rise=518
.meas tran tck3_519 when v(xdiv.ck3)=1.65 rise=519
.meas tran tck3_520 when v(xdiv.ck3)=1.65 rise=520
.meas tran tck3_521 when v(xdiv.ck3)=1.65 rise=521
.meas tran tck3_522 when v(xdiv.ck3)=1.65 rise=522
.meas tran tck3_523 when v(xdiv.ck3)=1.65 rise=523
.meas tran tck3_524 when v(xdiv.ck3)=1.65 rise=524
.meas tran tck3_525 when v(xdiv.ck3)=1.65 rise=525
.meas tran tck3_526 when v(xdiv.ck3)=1.65 rise=526
.meas tran tck3_527 when v(xdiv.ck3)=1.65 rise=527
.meas tran tck3_528 when v(xdiv.ck3)=1.65 rise=528
.meas tran tck3_529 when v(xdiv.ck3)=1.65 rise=529
.meas tran tck3_530 when v(xdiv.ck3)=1.65 rise=530
.meas tran tck3_531 when v(xdiv.ck3)=1.65 rise=531
.meas tran tck3_532 when v(xdiv.ck3)=1.65 rise=532
.meas tran tck3_533 when v(xdiv.ck3)=1.65 rise=533
.meas tran tck3_534 when v(xdiv.ck3)=1.65 rise=534
.meas tran tck3_535 when v(xdiv.ck3)=1.65 rise=535
.meas tran tck3_536 when v(xdiv.ck3)=1.65 rise=536
.meas tran tck4_1 when v(xdiv.ck4)=1.65 rise=1
.meas tran tck4_2 when v(xdiv.ck4)=1.65 rise=2
.meas tran tck4_3 when v(xdiv.ck4)=1.65 rise=3
.meas tran tck4_4 when v(xdiv.ck4)=1.65 rise=4
.meas tran tck4_5 when v(xdiv.ck4)=1.65 rise=5
.meas tran tck4_6 when v(xdiv.ck4)=1.65 rise=6
.meas tran tck4_7 when v(xdiv.ck4)=1.65 rise=7
.meas tran tck4_8 when v(xdiv.ck4)=1.65 rise=8
.meas tran tck4_9 when v(xdiv.ck4)=1.65 rise=9
.meas tran tck4_10 when v(xdiv.ck4)=1.65 rise=10
.meas tran tck4_11 when v(xdiv.ck4)=1.65 rise=11
.meas tran tck4_12 when v(xdiv.ck4)=1.65 rise=12
.meas tran tck4_13 when v(xdiv.ck4)=1.65 rise=13
.meas tran tck4_14 when v(xdiv.ck4)=1.65 rise=14
.meas tran tck4_15 when v(xdiv.ck4)=1.65 rise=15
.meas tran tck4_16 when v(xdiv.ck4)=1.65 rise=16
.meas tran tck4_17 when v(xdiv.ck4)=1.65 rise=17
.meas tran tck4_18 when v(xdiv.ck4)=1.65 rise=18
.meas tran tck4_19 when v(xdiv.ck4)=1.65 rise=19
.meas tran tck4_20 when v(xdiv.ck4)=1.65 rise=20
.meas tran tck4_21 when v(xdiv.ck4)=1.65 rise=21
.meas tran tck4_22 when v(xdiv.ck4)=1.65 rise=22
.meas tran tck4_23 when v(xdiv.ck4)=1.65 rise=23
.meas tran tck4_24 when v(xdiv.ck4)=1.65 rise=24
.meas tran tck4_25 when v(xdiv.ck4)=1.65 rise=25
.meas tran tck4_26 when v(xdiv.ck4)=1.65 rise=26
.meas tran tck4_27 when v(xdiv.ck4)=1.65 rise=27
.meas tran tck4_28 when v(xdiv.ck4)=1.65 rise=28
.meas tran tck4_29 when v(xdiv.ck4)=1.65 rise=29
.meas tran tck4_30 when v(xdiv.ck4)=1.65 rise=30
.meas tran tck4_31 when v(xdiv.ck4)=1.65 rise=31
.meas tran tck4_32 when v(xdiv.ck4)=1.65 rise=32
.meas tran tck4_33 when v(xdiv.ck4)=1.65 rise=33
.meas tran tck4_34 when v(xdiv.ck4)=1.65 rise=34
.meas tran tck4_35 when v(xdiv.ck4)=1.65 rise=35
.meas tran tck4_36 when v(xdiv.ck4)=1.65 rise=36
.meas tran tck4_37 when v(xdiv.ck4)=1.65 rise=37
.meas tran tck4_38 when v(xdiv.ck4)=1.65 rise=38
.meas tran tck4_39 when v(xdiv.ck4)=1.65 rise=39
.meas tran tck4_40 when v(xdiv.ck4)=1.65 rise=40
.meas tran tck4_41 when v(xdiv.ck4)=1.65 rise=41
.meas tran tck4_42 when v(xdiv.ck4)=1.65 rise=42
.meas tran tck4_43 when v(xdiv.ck4)=1.65 rise=43
.meas tran tck4_44 when v(xdiv.ck4)=1.65 rise=44
.meas tran tck4_45 when v(xdiv.ck4)=1.65 rise=45
.meas tran tck4_46 when v(xdiv.ck4)=1.65 rise=46
.meas tran tck4_47 when v(xdiv.ck4)=1.65 rise=47
.meas tran tck4_48 when v(xdiv.ck4)=1.65 rise=48
.meas tran tck4_49 when v(xdiv.ck4)=1.65 rise=49
.meas tran tck4_50 when v(xdiv.ck4)=1.65 rise=50
.meas tran tck4_51 when v(xdiv.ck4)=1.65 rise=51
.meas tran tck4_52 when v(xdiv.ck4)=1.65 rise=52
.meas tran tck4_53 when v(xdiv.ck4)=1.65 rise=53
.meas tran tck4_54 when v(xdiv.ck4)=1.65 rise=54
.meas tran tck4_55 when v(xdiv.ck4)=1.65 rise=55
.meas tran tck4_56 when v(xdiv.ck4)=1.65 rise=56
.meas tran tck4_57 when v(xdiv.ck4)=1.65 rise=57
.meas tran tck4_58 when v(xdiv.ck4)=1.65 rise=58
.meas tran tck4_59 when v(xdiv.ck4)=1.65 rise=59
.meas tran tck4_60 when v(xdiv.ck4)=1.65 rise=60
.meas tran tck4_61 when v(xdiv.ck4)=1.65 rise=61
.meas tran tck4_62 when v(xdiv.ck4)=1.65 rise=62
.meas tran tck4_63 when v(xdiv.ck4)=1.65 rise=63
.meas tran tck4_64 when v(xdiv.ck4)=1.65 rise=64
.meas tran tck4_65 when v(xdiv.ck4)=1.65 rise=65
.meas tran tck4_66 when v(xdiv.ck4)=1.65 rise=66
.meas tran tck4_67 when v(xdiv.ck4)=1.65 rise=67
.meas tran tck4_68 when v(xdiv.ck4)=1.65 rise=68
.meas tran tck4_69 when v(xdiv.ck4)=1.65 rise=69
.meas tran tck4_70 when v(xdiv.ck4)=1.65 rise=70
.meas tran tck4_71 when v(xdiv.ck4)=1.65 rise=71
.meas tran tck4_72 when v(xdiv.ck4)=1.65 rise=72
.meas tran tck4_73 when v(xdiv.ck4)=1.65 rise=73
.meas tran tck4_74 when v(xdiv.ck4)=1.65 rise=74
.meas tran tck4_75 when v(xdiv.ck4)=1.65 rise=75
.meas tran tck4_76 when v(xdiv.ck4)=1.65 rise=76
.meas tran tck4_77 when v(xdiv.ck4)=1.65 rise=77
.meas tran tck4_78 when v(xdiv.ck4)=1.65 rise=78
.meas tran tck4_79 when v(xdiv.ck4)=1.65 rise=79
.meas tran tck4_80 when v(xdiv.ck4)=1.65 rise=80
.meas tran tck4_81 when v(xdiv.ck4)=1.65 rise=81
.meas tran tck4_82 when v(xdiv.ck4)=1.65 rise=82
.meas tran tck4_83 when v(xdiv.ck4)=1.65 rise=83
.meas tran tck4_84 when v(xdiv.ck4)=1.65 rise=84
.meas tran tck4_85 when v(xdiv.ck4)=1.65 rise=85
.meas tran tck4_86 when v(xdiv.ck4)=1.65 rise=86
.meas tran tck4_87 when v(xdiv.ck4)=1.65 rise=87
.meas tran tck4_88 when v(xdiv.ck4)=1.65 rise=88
.meas tran tck4_89 when v(xdiv.ck4)=1.65 rise=89
.meas tran tck4_90 when v(xdiv.ck4)=1.65 rise=90
.meas tran tck4_91 when v(xdiv.ck4)=1.65 rise=91
.meas tran tck4_92 when v(xdiv.ck4)=1.65 rise=92
.meas tran tck4_93 when v(xdiv.ck4)=1.65 rise=93
.meas tran tck4_94 when v(xdiv.ck4)=1.65 rise=94
.meas tran tck4_95 when v(xdiv.ck4)=1.65 rise=95
.meas tran tck4_96 when v(xdiv.ck4)=1.65 rise=96
.meas tran tck4_97 when v(xdiv.ck4)=1.65 rise=97
.meas tran tck4_98 when v(xdiv.ck4)=1.65 rise=98
.meas tran tck4_99 when v(xdiv.ck4)=1.65 rise=99
.meas tran tck4_100 when v(xdiv.ck4)=1.65 rise=100
.meas tran tck4_101 when v(xdiv.ck4)=1.65 rise=101
.meas tran tck4_102 when v(xdiv.ck4)=1.65 rise=102
.meas tran tck4_103 when v(xdiv.ck4)=1.65 rise=103
.meas tran tck4_104 when v(xdiv.ck4)=1.65 rise=104
.meas tran tck4_105 when v(xdiv.ck4)=1.65 rise=105
.meas tran tck4_106 when v(xdiv.ck4)=1.65 rise=106
.meas tran tck4_107 when v(xdiv.ck4)=1.65 rise=107
.meas tran tck4_108 when v(xdiv.ck4)=1.65 rise=108
.meas tran tck4_109 when v(xdiv.ck4)=1.65 rise=109
.meas tran tck4_110 when v(xdiv.ck4)=1.65 rise=110
.meas tran tck4_111 when v(xdiv.ck4)=1.65 rise=111
.meas tran tck4_112 when v(xdiv.ck4)=1.65 rise=112
.meas tran tck4_113 when v(xdiv.ck4)=1.65 rise=113
.meas tran tck4_114 when v(xdiv.ck4)=1.65 rise=114
.meas tran tck4_115 when v(xdiv.ck4)=1.65 rise=115
.meas tran tck4_116 when v(xdiv.ck4)=1.65 rise=116
.meas tran tck4_117 when v(xdiv.ck4)=1.65 rise=117
.meas tran tck4_118 when v(xdiv.ck4)=1.65 rise=118
.meas tran tck4_119 when v(xdiv.ck4)=1.65 rise=119
.meas tran tck4_120 when v(xdiv.ck4)=1.65 rise=120
.meas tran tck4_121 when v(xdiv.ck4)=1.65 rise=121
.meas tran tck4_122 when v(xdiv.ck4)=1.65 rise=122
.meas tran tck4_123 when v(xdiv.ck4)=1.65 rise=123
.meas tran tck4_124 when v(xdiv.ck4)=1.65 rise=124
.meas tran tck4_125 when v(xdiv.ck4)=1.65 rise=125
.meas tran tck4_126 when v(xdiv.ck4)=1.65 rise=126
.meas tran tck4_127 when v(xdiv.ck4)=1.65 rise=127
.meas tran tck4_128 when v(xdiv.ck4)=1.65 rise=128
.meas tran tck4_129 when v(xdiv.ck4)=1.65 rise=129
.meas tran tck4_130 when v(xdiv.ck4)=1.65 rise=130
.meas tran tck4_131 when v(xdiv.ck4)=1.65 rise=131
.meas tran tck4_132 when v(xdiv.ck4)=1.65 rise=132
.meas tran tck4_133 when v(xdiv.ck4)=1.65 rise=133
.meas tran tck4_134 when v(xdiv.ck4)=1.65 rise=134
.meas tran tck4_135 when v(xdiv.ck4)=1.65 rise=135
.meas tran tck4_136 when v(xdiv.ck4)=1.65 rise=136
.meas tran tck4_137 when v(xdiv.ck4)=1.65 rise=137
.meas tran tck4_138 when v(xdiv.ck4)=1.65 rise=138
.meas tran tck4_139 when v(xdiv.ck4)=1.65 rise=139
.meas tran tck4_140 when v(xdiv.ck4)=1.65 rise=140
.meas tran tck4_141 when v(xdiv.ck4)=1.65 rise=141
.meas tran tck4_142 when v(xdiv.ck4)=1.65 rise=142
.meas tran tck4_143 when v(xdiv.ck4)=1.65 rise=143
.meas tran tck4_144 when v(xdiv.ck4)=1.65 rise=144
.meas tran tck4_145 when v(xdiv.ck4)=1.65 rise=145
.meas tran tck4_146 when v(xdiv.ck4)=1.65 rise=146
.meas tran tck4_147 when v(xdiv.ck4)=1.65 rise=147
.meas tran tck4_148 when v(xdiv.ck4)=1.65 rise=148
.meas tran tck4_149 when v(xdiv.ck4)=1.65 rise=149
.meas tran tck4_150 when v(xdiv.ck4)=1.65 rise=150
.meas tran tck4_151 when v(xdiv.ck4)=1.65 rise=151
.meas tran tck4_152 when v(xdiv.ck4)=1.65 rise=152
.meas tran tck4_153 when v(xdiv.ck4)=1.65 rise=153
.meas tran tck4_154 when v(xdiv.ck4)=1.65 rise=154
.meas tran tck4_155 when v(xdiv.ck4)=1.65 rise=155
.meas tran tck4_156 when v(xdiv.ck4)=1.65 rise=156
.meas tran tck4_157 when v(xdiv.ck4)=1.65 rise=157
.meas tran tck4_158 when v(xdiv.ck4)=1.65 rise=158
.meas tran tck4_159 when v(xdiv.ck4)=1.65 rise=159
.meas tran tck4_160 when v(xdiv.ck4)=1.65 rise=160
.meas tran tck4_161 when v(xdiv.ck4)=1.65 rise=161
.meas tran tck4_162 when v(xdiv.ck4)=1.65 rise=162
.meas tran tck4_163 when v(xdiv.ck4)=1.65 rise=163
.meas tran tck4_164 when v(xdiv.ck4)=1.65 rise=164
.meas tran tck4_165 when v(xdiv.ck4)=1.65 rise=165
.meas tran tck4_166 when v(xdiv.ck4)=1.65 rise=166
.meas tran tck4_167 when v(xdiv.ck4)=1.65 rise=167
.meas tran tck4_168 when v(xdiv.ck4)=1.65 rise=168
.meas tran tck4_169 when v(xdiv.ck4)=1.65 rise=169
.meas tran tck4_170 when v(xdiv.ck4)=1.65 rise=170
.meas tran tck4_171 when v(xdiv.ck4)=1.65 rise=171
.meas tran tck4_172 when v(xdiv.ck4)=1.65 rise=172
.meas tran tck4_173 when v(xdiv.ck4)=1.65 rise=173
.meas tran tck4_174 when v(xdiv.ck4)=1.65 rise=174
.meas tran tck4_175 when v(xdiv.ck4)=1.65 rise=175
.meas tran tck4_176 when v(xdiv.ck4)=1.65 rise=176
.meas tran tck4_177 when v(xdiv.ck4)=1.65 rise=177
.meas tran tck4_178 when v(xdiv.ck4)=1.65 rise=178
.meas tran tck4_179 when v(xdiv.ck4)=1.65 rise=179
.meas tran tck4_180 when v(xdiv.ck4)=1.65 rise=180
.meas tran tck4_181 when v(xdiv.ck4)=1.65 rise=181
.meas tran tck4_182 when v(xdiv.ck4)=1.65 rise=182
.meas tran tck4_183 when v(xdiv.ck4)=1.65 rise=183
.meas tran tck4_184 when v(xdiv.ck4)=1.65 rise=184
.meas tran tck4_185 when v(xdiv.ck4)=1.65 rise=185
.meas tran tck4_186 when v(xdiv.ck4)=1.65 rise=186
.meas tran tck4_187 when v(xdiv.ck4)=1.65 rise=187
.meas tran tck4_188 when v(xdiv.ck4)=1.65 rise=188
.meas tran tck4_189 when v(xdiv.ck4)=1.65 rise=189
.meas tran tck4_190 when v(xdiv.ck4)=1.65 rise=190
.meas tran tck4_191 when v(xdiv.ck4)=1.65 rise=191
.meas tran tck4_192 when v(xdiv.ck4)=1.65 rise=192
.meas tran tck4_193 when v(xdiv.ck4)=1.65 rise=193
.meas tran tck4_194 when v(xdiv.ck4)=1.65 rise=194
.meas tran tck4_195 when v(xdiv.ck4)=1.65 rise=195
.meas tran tck4_196 when v(xdiv.ck4)=1.65 rise=196
.meas tran tck4_197 when v(xdiv.ck4)=1.65 rise=197
.meas tran tck4_198 when v(xdiv.ck4)=1.65 rise=198
.meas tran tck4_199 when v(xdiv.ck4)=1.65 rise=199
.meas tran tck4_200 when v(xdiv.ck4)=1.65 rise=200
.meas tran tck4_201 when v(xdiv.ck4)=1.65 rise=201
.meas tran tck4_202 when v(xdiv.ck4)=1.65 rise=202
.meas tran tck4_203 when v(xdiv.ck4)=1.65 rise=203
.meas tran tck4_204 when v(xdiv.ck4)=1.65 rise=204
.meas tran tck4_205 when v(xdiv.ck4)=1.65 rise=205
.meas tran tck4_206 when v(xdiv.ck4)=1.65 rise=206
.meas tran tck4_207 when v(xdiv.ck4)=1.65 rise=207
.meas tran tck4_208 when v(xdiv.ck4)=1.65 rise=208
.meas tran tck4_209 when v(xdiv.ck4)=1.65 rise=209
.meas tran tck4_210 when v(xdiv.ck4)=1.65 rise=210
.meas tran tck4_211 when v(xdiv.ck4)=1.65 rise=211
.meas tran tck4_212 when v(xdiv.ck4)=1.65 rise=212
.meas tran tck4_213 when v(xdiv.ck4)=1.65 rise=213
.meas tran tck4_214 when v(xdiv.ck4)=1.65 rise=214
.meas tran tck4_215 when v(xdiv.ck4)=1.65 rise=215
.meas tran tck4_216 when v(xdiv.ck4)=1.65 rise=216
.meas tran tck4_217 when v(xdiv.ck4)=1.65 rise=217
.meas tran tck4_218 when v(xdiv.ck4)=1.65 rise=218
.meas tran tck4_219 when v(xdiv.ck4)=1.65 rise=219
.meas tran tck4_220 when v(xdiv.ck4)=1.65 rise=220
.meas tran tck4_221 when v(xdiv.ck4)=1.65 rise=221
.meas tran tck4_222 when v(xdiv.ck4)=1.65 rise=222
.meas tran tck4_223 when v(xdiv.ck4)=1.65 rise=223
.meas tran tck4_224 when v(xdiv.ck4)=1.65 rise=224
.meas tran tck4_225 when v(xdiv.ck4)=1.65 rise=225
.meas tran tck4_226 when v(xdiv.ck4)=1.65 rise=226
.meas tran tck4_227 when v(xdiv.ck4)=1.65 rise=227
.meas tran tck4_228 when v(xdiv.ck4)=1.65 rise=228
.meas tran tck4_229 when v(xdiv.ck4)=1.65 rise=229
.meas tran tck4_230 when v(xdiv.ck4)=1.65 rise=230
.meas tran tck4_231 when v(xdiv.ck4)=1.65 rise=231
.meas tran tck4_232 when v(xdiv.ck4)=1.65 rise=232
.meas tran tck4_233 when v(xdiv.ck4)=1.65 rise=233
.meas tran tck4_234 when v(xdiv.ck4)=1.65 rise=234
.meas tran tck4_235 when v(xdiv.ck4)=1.65 rise=235
.meas tran tck4_236 when v(xdiv.ck4)=1.65 rise=236
.meas tran tck4_237 when v(xdiv.ck4)=1.65 rise=237
.meas tran tck4_238 when v(xdiv.ck4)=1.65 rise=238
.meas tran tck4_239 when v(xdiv.ck4)=1.65 rise=239
.meas tran tck4_240 when v(xdiv.ck4)=1.65 rise=240
.meas tran tck4_241 when v(xdiv.ck4)=1.65 rise=241
.meas tran tck4_242 when v(xdiv.ck4)=1.65 rise=242
.meas tran tck4_243 when v(xdiv.ck4)=1.65 rise=243
.meas tran tck4_244 when v(xdiv.ck4)=1.65 rise=244
.meas tran tck4_245 when v(xdiv.ck4)=1.65 rise=245
.meas tran tck4_246 when v(xdiv.ck4)=1.65 rise=246
.meas tran tck4_247 when v(xdiv.ck4)=1.65 rise=247
.meas tran tck4_248 when v(xdiv.ck4)=1.65 rise=248
.meas tran tck4_249 when v(xdiv.ck4)=1.65 rise=249
.meas tran tck4_250 when v(xdiv.ck4)=1.65 rise=250
.meas tran tck4_251 when v(xdiv.ck4)=1.65 rise=251
.meas tran tck4_252 when v(xdiv.ck4)=1.65 rise=252
.meas tran tck4_253 when v(xdiv.ck4)=1.65 rise=253
.meas tran tck4_254 when v(xdiv.ck4)=1.65 rise=254
.meas tran tck4_255 when v(xdiv.ck4)=1.65 rise=255
.meas tran tck4_256 when v(xdiv.ck4)=1.65 rise=256
.meas tran tck4_257 when v(xdiv.ck4)=1.65 rise=257
.meas tran tck4_258 when v(xdiv.ck4)=1.65 rise=258
.meas tran tck4_259 when v(xdiv.ck4)=1.65 rise=259
.meas tran tck4_260 when v(xdiv.ck4)=1.65 rise=260
.meas tran tck4_261 when v(xdiv.ck4)=1.65 rise=261
.meas tran tck4_262 when v(xdiv.ck4)=1.65 rise=262
.meas tran tck4_263 when v(xdiv.ck4)=1.65 rise=263
.meas tran tck4_264 when v(xdiv.ck4)=1.65 rise=264
.meas tran tck4_265 when v(xdiv.ck4)=1.65 rise=265
.meas tran tck4_266 when v(xdiv.ck4)=1.65 rise=266
.meas tran tck4_267 when v(xdiv.ck4)=1.65 rise=267
.meas tran tck4_268 when v(xdiv.ck4)=1.65 rise=268
.meas tran tck4_269 when v(xdiv.ck4)=1.65 rise=269
.meas tran tck4_270 when v(xdiv.ck4)=1.65 rise=270
.meas tran tck4_271 when v(xdiv.ck4)=1.65 rise=271
.meas tran tck4_272 when v(xdiv.ck4)=1.65 rise=272
.meas tran tck4_273 when v(xdiv.ck4)=1.65 rise=273
.meas tran tck4_274 when v(xdiv.ck4)=1.65 rise=274
.meas tran tck4_275 when v(xdiv.ck4)=1.65 rise=275
.meas tran tck4_276 when v(xdiv.ck4)=1.65 rise=276
.meas tran tck4_277 when v(xdiv.ck4)=1.65 rise=277
.meas tran tck4_278 when v(xdiv.ck4)=1.65 rise=278
.meas tran tck4_279 when v(xdiv.ck4)=1.65 rise=279
.meas tran tck4_280 when v(xdiv.ck4)=1.65 rise=280
.meas tran tck4_281 when v(xdiv.ck4)=1.65 rise=281
.meas tran tck4_282 when v(xdiv.ck4)=1.65 rise=282
.meas tran tck4_283 when v(xdiv.ck4)=1.65 rise=283
.meas tran tck4_284 when v(xdiv.ck4)=1.65 rise=284
.meas tran tck4_285 when v(xdiv.ck4)=1.65 rise=285
.meas tran tck4_286 when v(xdiv.ck4)=1.65 rise=286
.meas tran tck4_287 when v(xdiv.ck4)=1.65 rise=287
.meas tran tck4_288 when v(xdiv.ck4)=1.65 rise=288
.meas tran tck4_289 when v(xdiv.ck4)=1.65 rise=289
.meas tran tck4_290 when v(xdiv.ck4)=1.65 rise=290
.meas tran tck4_291 when v(xdiv.ck4)=1.65 rise=291
.meas tran tck4_292 when v(xdiv.ck4)=1.65 rise=292
.meas tran tck4_293 when v(xdiv.ck4)=1.65 rise=293
.meas tran tck4_294 when v(xdiv.ck4)=1.65 rise=294
.meas tran tck4_295 when v(xdiv.ck4)=1.65 rise=295
.meas tran tck4_296 when v(xdiv.ck4)=1.65 rise=296
.meas tran tck4_297 when v(xdiv.ck4)=1.65 rise=297
.meas tran tck4_298 when v(xdiv.ck4)=1.65 rise=298
.meas tran tck4_299 when v(xdiv.ck4)=1.65 rise=299
.meas tran tck4_300 when v(xdiv.ck4)=1.65 rise=300
.meas tran tck4_301 when v(xdiv.ck4)=1.65 rise=301
.meas tran tck4_302 when v(xdiv.ck4)=1.65 rise=302
.meas tran tck4_303 when v(xdiv.ck4)=1.65 rise=303
.meas tran tck4_304 when v(xdiv.ck4)=1.65 rise=304
.meas tran tck4_305 when v(xdiv.ck4)=1.65 rise=305
.meas tran tck4_306 when v(xdiv.ck4)=1.65 rise=306
.meas tran tck4_307 when v(xdiv.ck4)=1.65 rise=307
.meas tran tck4_308 when v(xdiv.ck4)=1.65 rise=308
.meas tran tck4_309 when v(xdiv.ck4)=1.65 rise=309
.meas tran tck4_310 when v(xdiv.ck4)=1.65 rise=310
.meas tran tck4_311 when v(xdiv.ck4)=1.65 rise=311
.meas tran tck4_312 when v(xdiv.ck4)=1.65 rise=312
.meas tran tck4_313 when v(xdiv.ck4)=1.65 rise=313
.meas tran tck4_314 when v(xdiv.ck4)=1.65 rise=314
.meas tran tck4_315 when v(xdiv.ck4)=1.65 rise=315
.meas tran tck4_316 when v(xdiv.ck4)=1.65 rise=316
.meas tran tck4_317 when v(xdiv.ck4)=1.65 rise=317
.meas tran tck4_318 when v(xdiv.ck4)=1.65 rise=318
.meas tran tck4_319 when v(xdiv.ck4)=1.65 rise=319
.meas tran tck4_320 when v(xdiv.ck4)=1.65 rise=320
.meas tran tck4_321 when v(xdiv.ck4)=1.65 rise=321
.meas tran tck4_322 when v(xdiv.ck4)=1.65 rise=322
.meas tran tck4_323 when v(xdiv.ck4)=1.65 rise=323
.meas tran tck4_324 when v(xdiv.ck4)=1.65 rise=324
.meas tran tck4_325 when v(xdiv.ck4)=1.65 rise=325
.meas tran tck4_326 when v(xdiv.ck4)=1.65 rise=326
.meas tran tck4_327 when v(xdiv.ck4)=1.65 rise=327
.meas tran tck4_328 when v(xdiv.ck4)=1.65 rise=328
.meas tran tck4_329 when v(xdiv.ck4)=1.65 rise=329
.meas tran tck4_330 when v(xdiv.ck4)=1.65 rise=330
.meas tran tck4_331 when v(xdiv.ck4)=1.65 rise=331
.meas tran tck4_332 when v(xdiv.ck4)=1.65 rise=332
.meas tran tck4_333 when v(xdiv.ck4)=1.65 rise=333
.meas tran tck4_334 when v(xdiv.ck4)=1.65 rise=334
.meas tran tck4_335 when v(xdiv.ck4)=1.65 rise=335
.meas tran tck4_336 when v(xdiv.ck4)=1.65 rise=336
.meas tran tck4_337 when v(xdiv.ck4)=1.65 rise=337
.meas tran tck4_338 when v(xdiv.ck4)=1.65 rise=338
.meas tran tck4_339 when v(xdiv.ck4)=1.65 rise=339
.meas tran tck4_340 when v(xdiv.ck4)=1.65 rise=340
.meas tran tck4_341 when v(xdiv.ck4)=1.65 rise=341
.meas tran tck4_342 when v(xdiv.ck4)=1.65 rise=342
.meas tran tck4_343 when v(xdiv.ck4)=1.65 rise=343
.meas tran tck4_344 when v(xdiv.ck4)=1.65 rise=344
.meas tran tck4_345 when v(xdiv.ck4)=1.65 rise=345
.meas tran tck4_346 when v(xdiv.ck4)=1.65 rise=346
.meas tran tck4_347 when v(xdiv.ck4)=1.65 rise=347
.meas tran tck4_348 when v(xdiv.ck4)=1.65 rise=348
.meas tran tck4_349 when v(xdiv.ck4)=1.65 rise=349
.meas tran tck4_350 when v(xdiv.ck4)=1.65 rise=350
.meas tran tck4_351 when v(xdiv.ck4)=1.65 rise=351
.meas tran tck4_352 when v(xdiv.ck4)=1.65 rise=352
.meas tran tck4_353 when v(xdiv.ck4)=1.65 rise=353
.meas tran tck4_354 when v(xdiv.ck4)=1.65 rise=354
.meas tran tck4_355 when v(xdiv.ck4)=1.65 rise=355
.meas tran tck4_356 when v(xdiv.ck4)=1.65 rise=356
.meas tran tck4_357 when v(xdiv.ck4)=1.65 rise=357
.meas tran tck4_358 when v(xdiv.ck4)=1.65 rise=358
.meas tran tck4_359 when v(xdiv.ck4)=1.65 rise=359
.meas tran tck4_360 when v(xdiv.ck4)=1.65 rise=360
.meas tran tck4_361 when v(xdiv.ck4)=1.65 rise=361
.meas tran tck4_362 when v(xdiv.ck4)=1.65 rise=362
.meas tran tck4_363 when v(xdiv.ck4)=1.65 rise=363
.meas tran tck4_364 when v(xdiv.ck4)=1.65 rise=364
.meas tran tck4_365 when v(xdiv.ck4)=1.65 rise=365
.meas tran tck4_366 when v(xdiv.ck4)=1.65 rise=366
.meas tran tck4_367 when v(xdiv.ck4)=1.65 rise=367
.meas tran tck4_368 when v(xdiv.ck4)=1.65 rise=368
.meas tran tck4_369 when v(xdiv.ck4)=1.65 rise=369
.meas tran tck4_370 when v(xdiv.ck4)=1.65 rise=370
.meas tran tck4_371 when v(xdiv.ck4)=1.65 rise=371
.meas tran tck4_372 when v(xdiv.ck4)=1.65 rise=372
.meas tran tck4_373 when v(xdiv.ck4)=1.65 rise=373
.meas tran tck4_374 when v(xdiv.ck4)=1.65 rise=374
.meas tran tck4_375 when v(xdiv.ck4)=1.65 rise=375
.meas tran tck4_376 when v(xdiv.ck4)=1.65 rise=376
.meas tran tck4_377 when v(xdiv.ck4)=1.65 rise=377
.meas tran tck4_378 when v(xdiv.ck4)=1.65 rise=378
.meas tran tck4_379 when v(xdiv.ck4)=1.65 rise=379
.meas tran tck4_380 when v(xdiv.ck4)=1.65 rise=380
.meas tran tck4_381 when v(xdiv.ck4)=1.65 rise=381
.meas tran tck4_382 when v(xdiv.ck4)=1.65 rise=382
.meas tran tck4_383 when v(xdiv.ck4)=1.65 rise=383
.meas tran tck4_384 when v(xdiv.ck4)=1.65 rise=384
.meas tran tck4_385 when v(xdiv.ck4)=1.65 rise=385
.meas tran tck4_386 when v(xdiv.ck4)=1.65 rise=386
.meas tran tck4_387 when v(xdiv.ck4)=1.65 rise=387
.meas tran tck4_388 when v(xdiv.ck4)=1.65 rise=388
.meas tran tck4_389 when v(xdiv.ck4)=1.65 rise=389
.meas tran tck4_390 when v(xdiv.ck4)=1.65 rise=390
.meas tran tck4_391 when v(xdiv.ck4)=1.65 rise=391
.meas tran tck4_392 when v(xdiv.ck4)=1.65 rise=392
.meas tran tck4_393 when v(xdiv.ck4)=1.65 rise=393
.meas tran tck4_394 when v(xdiv.ck4)=1.65 rise=394
.meas tran tck4_395 when v(xdiv.ck4)=1.65 rise=395
.meas tran tck4_396 when v(xdiv.ck4)=1.65 rise=396
.meas tran tck4_397 when v(xdiv.ck4)=1.65 rise=397
.meas tran tck4_398 when v(xdiv.ck4)=1.65 rise=398
.meas tran tck4_399 when v(xdiv.ck4)=1.65 rise=399
.meas tran tck4_400 when v(xdiv.ck4)=1.65 rise=400
.meas tran tck4_401 when v(xdiv.ck4)=1.65 rise=401
.meas tran tck4_402 when v(xdiv.ck4)=1.65 rise=402
.meas tran tck4_403 when v(xdiv.ck4)=1.65 rise=403
.meas tran tck4_404 when v(xdiv.ck4)=1.65 rise=404
.meas tran tck4_405 when v(xdiv.ck4)=1.65 rise=405
.meas tran tck4_406 when v(xdiv.ck4)=1.65 rise=406
.meas tran tck4_407 when v(xdiv.ck4)=1.65 rise=407
.meas tran tck4_408 when v(xdiv.ck4)=1.65 rise=408
.meas tran tck4_409 when v(xdiv.ck4)=1.65 rise=409
.meas tran tck4_410 when v(xdiv.ck4)=1.65 rise=410
.meas tran tck4_411 when v(xdiv.ck4)=1.65 rise=411
.meas tran tck4_412 when v(xdiv.ck4)=1.65 rise=412
.meas tran tck4_413 when v(xdiv.ck4)=1.65 rise=413
.meas tran tck4_414 when v(xdiv.ck4)=1.65 rise=414
.meas tran tck4_415 when v(xdiv.ck4)=1.65 rise=415
.meas tran tck4_416 when v(xdiv.ck4)=1.65 rise=416
.meas tran tck4_417 when v(xdiv.ck4)=1.65 rise=417
.meas tran tck4_418 when v(xdiv.ck4)=1.65 rise=418
.meas tran tck4_419 when v(xdiv.ck4)=1.65 rise=419
.meas tran tck4_420 when v(xdiv.ck4)=1.65 rise=420
.meas tran tck4_421 when v(xdiv.ck4)=1.65 rise=421
.meas tran tck4_422 when v(xdiv.ck4)=1.65 rise=422
.meas tran tck4_423 when v(xdiv.ck4)=1.65 rise=423
.meas tran tck4_424 when v(xdiv.ck4)=1.65 rise=424
.meas tran tck4_425 when v(xdiv.ck4)=1.65 rise=425
.meas tran tck4_426 when v(xdiv.ck4)=1.65 rise=426
.meas tran tck4_427 when v(xdiv.ck4)=1.65 rise=427
.meas tran tck4_428 when v(xdiv.ck4)=1.65 rise=428
.meas tran tck4_429 when v(xdiv.ck4)=1.65 rise=429
.meas tran tck4_430 when v(xdiv.ck4)=1.65 rise=430
.meas tran tck4_431 when v(xdiv.ck4)=1.65 rise=431
.meas tran tck4_432 when v(xdiv.ck4)=1.65 rise=432
.meas tran tck4_433 when v(xdiv.ck4)=1.65 rise=433
.meas tran tck4_434 when v(xdiv.ck4)=1.65 rise=434
.meas tran tck4_435 when v(xdiv.ck4)=1.65 rise=435
.meas tran tck4_436 when v(xdiv.ck4)=1.65 rise=436
.meas tran tck4_437 when v(xdiv.ck4)=1.65 rise=437
.meas tran tck4_438 when v(xdiv.ck4)=1.65 rise=438
.meas tran tck4_439 when v(xdiv.ck4)=1.65 rise=439
.meas tran tck4_440 when v(xdiv.ck4)=1.65 rise=440
.meas tran tck4_441 when v(xdiv.ck4)=1.65 rise=441
.meas tran tck4_442 when v(xdiv.ck4)=1.65 rise=442
.meas tran tck4_443 when v(xdiv.ck4)=1.65 rise=443
.meas tran tck4_444 when v(xdiv.ck4)=1.65 rise=444
.meas tran tck4_445 when v(xdiv.ck4)=1.65 rise=445
.meas tran tck4_446 when v(xdiv.ck4)=1.65 rise=446
.meas tran tck4_447 when v(xdiv.ck4)=1.65 rise=447
.meas tran tck4_448 when v(xdiv.ck4)=1.65 rise=448
.meas tran tck4_449 when v(xdiv.ck4)=1.65 rise=449
.meas tran tck4_450 when v(xdiv.ck4)=1.65 rise=450
.meas tran tck4_451 when v(xdiv.ck4)=1.65 rise=451
.meas tran tck4_452 when v(xdiv.ck4)=1.65 rise=452
.meas tran tck4_453 when v(xdiv.ck4)=1.65 rise=453
.meas tran tck4_454 when v(xdiv.ck4)=1.65 rise=454
.meas tran tck4_455 when v(xdiv.ck4)=1.65 rise=455
.meas tran tck4_456 when v(xdiv.ck4)=1.65 rise=456
.meas tran tck4_457 when v(xdiv.ck4)=1.65 rise=457
.meas tran tck4_458 when v(xdiv.ck4)=1.65 rise=458
.meas tran tck4_459 when v(xdiv.ck4)=1.65 rise=459
.meas tran tck4_460 when v(xdiv.ck4)=1.65 rise=460
.meas tran tck4_461 when v(xdiv.ck4)=1.65 rise=461
.meas tran tck4_462 when v(xdiv.ck4)=1.65 rise=462
.meas tran tck4_463 when v(xdiv.ck4)=1.65 rise=463
.meas tran tck4_464 when v(xdiv.ck4)=1.65 rise=464
.meas tran tck4_465 when v(xdiv.ck4)=1.65 rise=465
.meas tran tck4_466 when v(xdiv.ck4)=1.65 rise=466
.meas tran tck4_467 when v(xdiv.ck4)=1.65 rise=467
.meas tran tck4_468 when v(xdiv.ck4)=1.65 rise=468
.meas tran tck4_469 when v(xdiv.ck4)=1.65 rise=469
.meas tran tck4_470 when v(xdiv.ck4)=1.65 rise=470
.meas tran tck4_471 when v(xdiv.ck4)=1.65 rise=471
.meas tran tck4_472 when v(xdiv.ck4)=1.65 rise=472
.meas tran tck4_473 when v(xdiv.ck4)=1.65 rise=473
.meas tran tck4_474 when v(xdiv.ck4)=1.65 rise=474
.meas tran tck4_475 when v(xdiv.ck4)=1.65 rise=475
.meas tran tck4_476 when v(xdiv.ck4)=1.65 rise=476
.meas tran tck4_477 when v(xdiv.ck4)=1.65 rise=477
.meas tran tck4_478 when v(xdiv.ck4)=1.65 rise=478
.meas tran tck4_479 when v(xdiv.ck4)=1.65 rise=479
.meas tran tck4_480 when v(xdiv.ck4)=1.65 rise=480
.meas tran tck4_481 when v(xdiv.ck4)=1.65 rise=481
.meas tran tck4_482 when v(xdiv.ck4)=1.65 rise=482
.meas tran tck4_483 when v(xdiv.ck4)=1.65 rise=483
.meas tran tck4_484 when v(xdiv.ck4)=1.65 rise=484
.meas tran tck4_485 when v(xdiv.ck4)=1.65 rise=485
.meas tran tck4_486 when v(xdiv.ck4)=1.65 rise=486
.meas tran tck4_487 when v(xdiv.ck4)=1.65 rise=487
.meas tran tck4_488 when v(xdiv.ck4)=1.65 rise=488
.meas tran tck4_489 when v(xdiv.ck4)=1.65 rise=489
.meas tran tck4_490 when v(xdiv.ck4)=1.65 rise=490
.meas tran tck4_491 when v(xdiv.ck4)=1.65 rise=491
.meas tran tck4_492 when v(xdiv.ck4)=1.65 rise=492
.meas tran tck4_493 when v(xdiv.ck4)=1.65 rise=493
.meas tran tck4_494 when v(xdiv.ck4)=1.65 rise=494
.meas tran tck4_495 when v(xdiv.ck4)=1.65 rise=495
.meas tran tck4_496 when v(xdiv.ck4)=1.65 rise=496
.meas tran tck4_497 when v(xdiv.ck4)=1.65 rise=497
.meas tran tck4_498 when v(xdiv.ck4)=1.65 rise=498
.meas tran tck4_499 when v(xdiv.ck4)=1.65 rise=499
.meas tran tck4_500 when v(xdiv.ck4)=1.65 rise=500
.meas tran tck4_501 when v(xdiv.ck4)=1.65 rise=501
.meas tran tck4_502 when v(xdiv.ck4)=1.65 rise=502
.meas tran tck4_503 when v(xdiv.ck4)=1.65 rise=503
.meas tran tck4_504 when v(xdiv.ck4)=1.65 rise=504
.meas tran tck4_505 when v(xdiv.ck4)=1.65 rise=505
.meas tran tck4_506 when v(xdiv.ck4)=1.65 rise=506
.meas tran tck4_507 when v(xdiv.ck4)=1.65 rise=507
.meas tran tck4_508 when v(xdiv.ck4)=1.65 rise=508
.meas tran tck4_509 when v(xdiv.ck4)=1.65 rise=509
.meas tran tck4_510 when v(xdiv.ck4)=1.65 rise=510
.meas tran tck4_511 when v(xdiv.ck4)=1.65 rise=511
.meas tran tck4_512 when v(xdiv.ck4)=1.65 rise=512
.meas tran tck4_513 when v(xdiv.ck4)=1.65 rise=513
.meas tran tck4_514 when v(xdiv.ck4)=1.65 rise=514
.meas tran tck4_515 when v(xdiv.ck4)=1.65 rise=515
.meas tran tck4_516 when v(xdiv.ck4)=1.65 rise=516
.meas tran tck4_517 when v(xdiv.ck4)=1.65 rise=517
.meas tran tck4_518 when v(xdiv.ck4)=1.65 rise=518
.meas tran tck4_519 when v(xdiv.ck4)=1.65 rise=519
.meas tran tck4_520 when v(xdiv.ck4)=1.65 rise=520
.meas tran tck4_521 when v(xdiv.ck4)=1.65 rise=521
.meas tran tck4_522 when v(xdiv.ck4)=1.65 rise=522
.meas tran tck4_523 when v(xdiv.ck4)=1.65 rise=523
.meas tran tck4_524 when v(xdiv.ck4)=1.65 rise=524
.meas tran tck4_525 when v(xdiv.ck4)=1.65 rise=525
.meas tran tck4_526 when v(xdiv.ck4)=1.65 rise=526
.meas tran tck4_527 when v(xdiv.ck4)=1.65 rise=527
.meas tran tck4_528 when v(xdiv.ck4)=1.65 rise=528
.meas tran tck4_529 when v(xdiv.ck4)=1.65 rise=529
.meas tran tck4_530 when v(xdiv.ck4)=1.65 rise=530
.meas tran tck4_531 when v(xdiv.ck4)=1.65 rise=531
.meas tran tck4_532 when v(xdiv.ck4)=1.65 rise=532
.meas tran tck4_533 when v(xdiv.ck4)=1.65 rise=533
.meas tran tck4_534 when v(xdiv.ck4)=1.65 rise=534
.meas tran tck4_535 when v(xdiv.ck4)=1.65 rise=535
.meas tran tck4_536 when v(xdiv.ck4)=1.65 rise=536
.meas tran tck5_1 when v(xdiv.ck5)=1.65 rise=1
.meas tran tck5_2 when v(xdiv.ck5)=1.65 rise=2
.meas tran tck5_3 when v(xdiv.ck5)=1.65 rise=3
.meas tran tck5_4 when v(xdiv.ck5)=1.65 rise=4
.meas tran tck5_5 when v(xdiv.ck5)=1.65 rise=5
.meas tran tck5_6 when v(xdiv.ck5)=1.65 rise=6
.meas tran tck5_7 when v(xdiv.ck5)=1.65 rise=7
.meas tran tck5_8 when v(xdiv.ck5)=1.65 rise=8
.meas tran tck5_9 when v(xdiv.ck5)=1.65 rise=9
.meas tran tck5_10 when v(xdiv.ck5)=1.65 rise=10
.meas tran tck5_11 when v(xdiv.ck5)=1.65 rise=11
.meas tran tck5_12 when v(xdiv.ck5)=1.65 rise=12
.meas tran tck5_13 when v(xdiv.ck5)=1.65 rise=13
.meas tran tck5_14 when v(xdiv.ck5)=1.65 rise=14
.meas tran tck5_15 when v(xdiv.ck5)=1.65 rise=15
.meas tran tck5_16 when v(xdiv.ck5)=1.65 rise=16
.meas tran tck5_17 when v(xdiv.ck5)=1.65 rise=17
.meas tran tck5_18 when v(xdiv.ck5)=1.65 rise=18
.meas tran tck5_19 when v(xdiv.ck5)=1.65 rise=19
.meas tran tck5_20 when v(xdiv.ck5)=1.65 rise=20
.meas tran tck5_21 when v(xdiv.ck5)=1.65 rise=21
.meas tran tck5_22 when v(xdiv.ck5)=1.65 rise=22
.meas tran tck5_23 when v(xdiv.ck5)=1.65 rise=23
.meas tran tck5_24 when v(xdiv.ck5)=1.65 rise=24
.meas tran tck5_25 when v(xdiv.ck5)=1.65 rise=25
.meas tran tck5_26 when v(xdiv.ck5)=1.65 rise=26
.meas tran tck5_27 when v(xdiv.ck5)=1.65 rise=27
.meas tran tck5_28 when v(xdiv.ck5)=1.65 rise=28
.meas tran tck5_29 when v(xdiv.ck5)=1.65 rise=29
.meas tran tck5_30 when v(xdiv.ck5)=1.65 rise=30
.meas tran tck5_31 when v(xdiv.ck5)=1.65 rise=31
.meas tran tck5_32 when v(xdiv.ck5)=1.65 rise=32
.meas tran tck5_33 when v(xdiv.ck5)=1.65 rise=33
.meas tran tck5_34 when v(xdiv.ck5)=1.65 rise=34
.meas tran tck5_35 when v(xdiv.ck5)=1.65 rise=35
.meas tran tck5_36 when v(xdiv.ck5)=1.65 rise=36
.meas tran tck5_37 when v(xdiv.ck5)=1.65 rise=37
.meas tran tck5_38 when v(xdiv.ck5)=1.65 rise=38
.meas tran tck5_39 when v(xdiv.ck5)=1.65 rise=39
.meas tran tck5_40 when v(xdiv.ck5)=1.65 rise=40
.meas tran tck5_41 when v(xdiv.ck5)=1.65 rise=41
.meas tran tck5_42 when v(xdiv.ck5)=1.65 rise=42
.meas tran tck5_43 when v(xdiv.ck5)=1.65 rise=43
.meas tran tck5_44 when v(xdiv.ck5)=1.65 rise=44
.meas tran tck5_45 when v(xdiv.ck5)=1.65 rise=45
.meas tran tck5_46 when v(xdiv.ck5)=1.65 rise=46
.meas tran tck5_47 when v(xdiv.ck5)=1.65 rise=47
.meas tran tck5_48 when v(xdiv.ck5)=1.65 rise=48
.meas tran tck5_49 when v(xdiv.ck5)=1.65 rise=49
.meas tran tck5_50 when v(xdiv.ck5)=1.65 rise=50
.meas tran tck5_51 when v(xdiv.ck5)=1.65 rise=51
.meas tran tck5_52 when v(xdiv.ck5)=1.65 rise=52
.meas tran tck5_53 when v(xdiv.ck5)=1.65 rise=53
.meas tran tck5_54 when v(xdiv.ck5)=1.65 rise=54
.meas tran tck5_55 when v(xdiv.ck5)=1.65 rise=55
.meas tran tck5_56 when v(xdiv.ck5)=1.65 rise=56
.meas tran tck5_57 when v(xdiv.ck5)=1.65 rise=57
.meas tran tck5_58 when v(xdiv.ck5)=1.65 rise=58
.meas tran tck5_59 when v(xdiv.ck5)=1.65 rise=59
.meas tran tck5_60 when v(xdiv.ck5)=1.65 rise=60
.meas tran tck5_61 when v(xdiv.ck5)=1.65 rise=61
.meas tran tck5_62 when v(xdiv.ck5)=1.65 rise=62
.meas tran tck5_63 when v(xdiv.ck5)=1.65 rise=63
.meas tran tck5_64 when v(xdiv.ck5)=1.65 rise=64
.meas tran tck5_65 when v(xdiv.ck5)=1.65 rise=65
.meas tran tck5_66 when v(xdiv.ck5)=1.65 rise=66
.meas tran tck5_67 when v(xdiv.ck5)=1.65 rise=67
.meas tran tck5_68 when v(xdiv.ck5)=1.65 rise=68
.meas tran tck5_69 when v(xdiv.ck5)=1.65 rise=69
.meas tran tck5_70 when v(xdiv.ck5)=1.65 rise=70
.meas tran tck5_71 when v(xdiv.ck5)=1.65 rise=71
.meas tran tck5_72 when v(xdiv.ck5)=1.65 rise=72
.meas tran tck5_73 when v(xdiv.ck5)=1.65 rise=73
.meas tran tck5_74 when v(xdiv.ck5)=1.65 rise=74
.meas tran tck5_75 when v(xdiv.ck5)=1.65 rise=75
.meas tran tck5_76 when v(xdiv.ck5)=1.65 rise=76
.meas tran tck5_77 when v(xdiv.ck5)=1.65 rise=77
.meas tran tck5_78 when v(xdiv.ck5)=1.65 rise=78
.meas tran tck5_79 when v(xdiv.ck5)=1.65 rise=79
.meas tran tck5_80 when v(xdiv.ck5)=1.65 rise=80
.meas tran tck5_81 when v(xdiv.ck5)=1.65 rise=81
.meas tran tck5_82 when v(xdiv.ck5)=1.65 rise=82
.meas tran tck5_83 when v(xdiv.ck5)=1.65 rise=83
.meas tran tck5_84 when v(xdiv.ck5)=1.65 rise=84
.meas tran tck5_85 when v(xdiv.ck5)=1.65 rise=85
.meas tran tck5_86 when v(xdiv.ck5)=1.65 rise=86
.meas tran tck5_87 when v(xdiv.ck5)=1.65 rise=87
.meas tran tck5_88 when v(xdiv.ck5)=1.65 rise=88
.meas tran tck5_89 when v(xdiv.ck5)=1.65 rise=89
.meas tran tck5_90 when v(xdiv.ck5)=1.65 rise=90
.meas tran tck5_91 when v(xdiv.ck5)=1.65 rise=91
.meas tran tck5_92 when v(xdiv.ck5)=1.65 rise=92
.meas tran tck5_93 when v(xdiv.ck5)=1.65 rise=93
.meas tran tck5_94 when v(xdiv.ck5)=1.65 rise=94
.meas tran tck5_95 when v(xdiv.ck5)=1.65 rise=95
.meas tran tck5_96 when v(xdiv.ck5)=1.65 rise=96
.meas tran tck5_97 when v(xdiv.ck5)=1.65 rise=97
.meas tran tck5_98 when v(xdiv.ck5)=1.65 rise=98
.meas tran tck5_99 when v(xdiv.ck5)=1.65 rise=99
.meas tran tck5_100 when v(xdiv.ck5)=1.65 rise=100
.meas tran tck5_101 when v(xdiv.ck5)=1.65 rise=101
.meas tran tck5_102 when v(xdiv.ck5)=1.65 rise=102
.meas tran tck5_103 when v(xdiv.ck5)=1.65 rise=103
.meas tran tck5_104 when v(xdiv.ck5)=1.65 rise=104
.meas tran tck5_105 when v(xdiv.ck5)=1.65 rise=105
.meas tran tck5_106 when v(xdiv.ck5)=1.65 rise=106
.meas tran tck5_107 when v(xdiv.ck5)=1.65 rise=107
.meas tran tck5_108 when v(xdiv.ck5)=1.65 rise=108
.meas tran tck5_109 when v(xdiv.ck5)=1.65 rise=109
.meas tran tck5_110 when v(xdiv.ck5)=1.65 rise=110
.meas tran tck5_111 when v(xdiv.ck5)=1.65 rise=111
.meas tran tck5_112 when v(xdiv.ck5)=1.65 rise=112
.meas tran tck5_113 when v(xdiv.ck5)=1.65 rise=113
.meas tran tck5_114 when v(xdiv.ck5)=1.65 rise=114
.meas tran tck5_115 when v(xdiv.ck5)=1.65 rise=115
.meas tran tck5_116 when v(xdiv.ck5)=1.65 rise=116
.meas tran tck5_117 when v(xdiv.ck5)=1.65 rise=117
.meas tran tck5_118 when v(xdiv.ck5)=1.65 rise=118
.meas tran tck5_119 when v(xdiv.ck5)=1.65 rise=119
.meas tran tck5_120 when v(xdiv.ck5)=1.65 rise=120
.meas tran tck5_121 when v(xdiv.ck5)=1.65 rise=121
.meas tran tck5_122 when v(xdiv.ck5)=1.65 rise=122
.meas tran tck5_123 when v(xdiv.ck5)=1.65 rise=123
.meas tran tck5_124 when v(xdiv.ck5)=1.65 rise=124
.meas tran tck5_125 when v(xdiv.ck5)=1.65 rise=125
.meas tran tck5_126 when v(xdiv.ck5)=1.65 rise=126
.meas tran tck5_127 when v(xdiv.ck5)=1.65 rise=127
.meas tran tck5_128 when v(xdiv.ck5)=1.65 rise=128
.meas tran tck5_129 when v(xdiv.ck5)=1.65 rise=129
.meas tran tck5_130 when v(xdiv.ck5)=1.65 rise=130
.meas tran tck5_131 when v(xdiv.ck5)=1.65 rise=131
.meas tran tck5_132 when v(xdiv.ck5)=1.65 rise=132
.meas tran tck5_133 when v(xdiv.ck5)=1.65 rise=133
.meas tran tck5_134 when v(xdiv.ck5)=1.65 rise=134
.meas tran tck5_135 when v(xdiv.ck5)=1.65 rise=135
.meas tran tck5_136 when v(xdiv.ck5)=1.65 rise=136
.meas tran tck5_137 when v(xdiv.ck5)=1.65 rise=137
.meas tran tck5_138 when v(xdiv.ck5)=1.65 rise=138
.meas tran tck5_139 when v(xdiv.ck5)=1.65 rise=139
.meas tran tck5_140 when v(xdiv.ck5)=1.65 rise=140
.meas tran tck5_141 when v(xdiv.ck5)=1.65 rise=141
.meas tran tck5_142 when v(xdiv.ck5)=1.65 rise=142
.meas tran tck5_143 when v(xdiv.ck5)=1.65 rise=143
.meas tran tck5_144 when v(xdiv.ck5)=1.65 rise=144
.meas tran tck5_145 when v(xdiv.ck5)=1.65 rise=145
.meas tran tck5_146 when v(xdiv.ck5)=1.65 rise=146
.meas tran tck5_147 when v(xdiv.ck5)=1.65 rise=147
.meas tran tck5_148 when v(xdiv.ck5)=1.65 rise=148
.meas tran tck5_149 when v(xdiv.ck5)=1.65 rise=149
.meas tran tck5_150 when v(xdiv.ck5)=1.65 rise=150
.meas tran tck5_151 when v(xdiv.ck5)=1.65 rise=151
.meas tran tck5_152 when v(xdiv.ck5)=1.65 rise=152
.meas tran tck5_153 when v(xdiv.ck5)=1.65 rise=153
.meas tran tck5_154 when v(xdiv.ck5)=1.65 rise=154
.meas tran tck5_155 when v(xdiv.ck5)=1.65 rise=155
.meas tran tck5_156 when v(xdiv.ck5)=1.65 rise=156
.meas tran tck5_157 when v(xdiv.ck5)=1.65 rise=157
.meas tran tck5_158 when v(xdiv.ck5)=1.65 rise=158
.meas tran tck5_159 when v(xdiv.ck5)=1.65 rise=159
.meas tran tck5_160 when v(xdiv.ck5)=1.65 rise=160
.meas tran tck5_161 when v(xdiv.ck5)=1.65 rise=161
.meas tran tck5_162 when v(xdiv.ck5)=1.65 rise=162
.meas tran tck5_163 when v(xdiv.ck5)=1.65 rise=163
.meas tran tck5_164 when v(xdiv.ck5)=1.65 rise=164
.meas tran tck5_165 when v(xdiv.ck5)=1.65 rise=165
.meas tran tck5_166 when v(xdiv.ck5)=1.65 rise=166
.meas tran tck5_167 when v(xdiv.ck5)=1.65 rise=167
.meas tran tck5_168 when v(xdiv.ck5)=1.65 rise=168
.meas tran tck5_169 when v(xdiv.ck5)=1.65 rise=169
.meas tran tck5_170 when v(xdiv.ck5)=1.65 rise=170
.meas tran tck5_171 when v(xdiv.ck5)=1.65 rise=171
.meas tran tck5_172 when v(xdiv.ck5)=1.65 rise=172
.meas tran tck5_173 when v(xdiv.ck5)=1.65 rise=173
.meas tran tck5_174 when v(xdiv.ck5)=1.65 rise=174
.meas tran tck5_175 when v(xdiv.ck5)=1.65 rise=175
.meas tran tck5_176 when v(xdiv.ck5)=1.65 rise=176
.meas tran tck5_177 when v(xdiv.ck5)=1.65 rise=177
.meas tran tck5_178 when v(xdiv.ck5)=1.65 rise=178
.meas tran tck5_179 when v(xdiv.ck5)=1.65 rise=179
.meas tran tck5_180 when v(xdiv.ck5)=1.65 rise=180
.meas tran tck5_181 when v(xdiv.ck5)=1.65 rise=181
.meas tran tck5_182 when v(xdiv.ck5)=1.65 rise=182
.meas tran tck5_183 when v(xdiv.ck5)=1.65 rise=183
.meas tran tck5_184 when v(xdiv.ck5)=1.65 rise=184
.meas tran tck5_185 when v(xdiv.ck5)=1.65 rise=185
.meas tran tck5_186 when v(xdiv.ck5)=1.65 rise=186
.meas tran tck5_187 when v(xdiv.ck5)=1.65 rise=187
.meas tran tck5_188 when v(xdiv.ck5)=1.65 rise=188
.meas tran tck5_189 when v(xdiv.ck5)=1.65 rise=189
.meas tran tck5_190 when v(xdiv.ck5)=1.65 rise=190
.meas tran tck5_191 when v(xdiv.ck5)=1.65 rise=191
.meas tran tck5_192 when v(xdiv.ck5)=1.65 rise=192
.meas tran tck5_193 when v(xdiv.ck5)=1.65 rise=193
.meas tran tck5_194 when v(xdiv.ck5)=1.65 rise=194
.meas tran tck5_195 when v(xdiv.ck5)=1.65 rise=195
.meas tran tck5_196 when v(xdiv.ck5)=1.65 rise=196
.meas tran tck5_197 when v(xdiv.ck5)=1.65 rise=197
.meas tran tck5_198 when v(xdiv.ck5)=1.65 rise=198
.meas tran tck5_199 when v(xdiv.ck5)=1.65 rise=199
.meas tran tck5_200 when v(xdiv.ck5)=1.65 rise=200
.meas tran tck5_201 when v(xdiv.ck5)=1.65 rise=201
.meas tran tck5_202 when v(xdiv.ck5)=1.65 rise=202
.meas tran tck5_203 when v(xdiv.ck5)=1.65 rise=203
.meas tran tck5_204 when v(xdiv.ck5)=1.65 rise=204
.meas tran tck5_205 when v(xdiv.ck5)=1.65 rise=205
.meas tran tck5_206 when v(xdiv.ck5)=1.65 rise=206
.meas tran tck5_207 when v(xdiv.ck5)=1.65 rise=207
.meas tran tck5_208 when v(xdiv.ck5)=1.65 rise=208
.meas tran tck5_209 when v(xdiv.ck5)=1.65 rise=209
.meas tran tck5_210 when v(xdiv.ck5)=1.65 rise=210
.meas tran tck5_211 when v(xdiv.ck5)=1.65 rise=211
.meas tran tck5_212 when v(xdiv.ck5)=1.65 rise=212
.meas tran tck5_213 when v(xdiv.ck5)=1.65 rise=213
.meas tran tck5_214 when v(xdiv.ck5)=1.65 rise=214
.meas tran tck5_215 when v(xdiv.ck5)=1.65 rise=215
.meas tran tck5_216 when v(xdiv.ck5)=1.65 rise=216
.meas tran tck5_217 when v(xdiv.ck5)=1.65 rise=217
.meas tran tck5_218 when v(xdiv.ck5)=1.65 rise=218
.meas tran tck5_219 when v(xdiv.ck5)=1.65 rise=219
.meas tran tck5_220 when v(xdiv.ck5)=1.65 rise=220
.meas tran tck5_221 when v(xdiv.ck5)=1.65 rise=221
.meas tran tck5_222 when v(xdiv.ck5)=1.65 rise=222
.meas tran tck5_223 when v(xdiv.ck5)=1.65 rise=223
.meas tran tck5_224 when v(xdiv.ck5)=1.65 rise=224
.meas tran tck5_225 when v(xdiv.ck5)=1.65 rise=225
.meas tran tck5_226 when v(xdiv.ck5)=1.65 rise=226
.meas tran tck5_227 when v(xdiv.ck5)=1.65 rise=227
.meas tran tck5_228 when v(xdiv.ck5)=1.65 rise=228
.meas tran tck5_229 when v(xdiv.ck5)=1.65 rise=229
.meas tran tck5_230 when v(xdiv.ck5)=1.65 rise=230
.meas tran tck5_231 when v(xdiv.ck5)=1.65 rise=231
.meas tran tck5_232 when v(xdiv.ck5)=1.65 rise=232
.meas tran tck5_233 when v(xdiv.ck5)=1.65 rise=233
.meas tran tck5_234 when v(xdiv.ck5)=1.65 rise=234
.meas tran tck5_235 when v(xdiv.ck5)=1.65 rise=235
.meas tran tck5_236 when v(xdiv.ck5)=1.65 rise=236
.meas tran tck5_237 when v(xdiv.ck5)=1.65 rise=237
.meas tran tck5_238 when v(xdiv.ck5)=1.65 rise=238
.meas tran tck5_239 when v(xdiv.ck5)=1.65 rise=239
.meas tran tck5_240 when v(xdiv.ck5)=1.65 rise=240
.meas tran tck5_241 when v(xdiv.ck5)=1.65 rise=241
.meas tran tck5_242 when v(xdiv.ck5)=1.65 rise=242
.meas tran tck5_243 when v(xdiv.ck5)=1.65 rise=243
.meas tran tck5_244 when v(xdiv.ck5)=1.65 rise=244
.meas tran tck5_245 when v(xdiv.ck5)=1.65 rise=245
.meas tran tck5_246 when v(xdiv.ck5)=1.65 rise=246
.meas tran tck5_247 when v(xdiv.ck5)=1.65 rise=247
.meas tran tck5_248 when v(xdiv.ck5)=1.65 rise=248
.meas tran tck5_249 when v(xdiv.ck5)=1.65 rise=249
.meas tran tck5_250 when v(xdiv.ck5)=1.65 rise=250
.meas tran tck5_251 when v(xdiv.ck5)=1.65 rise=251
.meas tran tck5_252 when v(xdiv.ck5)=1.65 rise=252
.meas tran tck5_253 when v(xdiv.ck5)=1.65 rise=253
.meas tran tck5_254 when v(xdiv.ck5)=1.65 rise=254
.meas tran tck5_255 when v(xdiv.ck5)=1.65 rise=255
.meas tran tck5_256 when v(xdiv.ck5)=1.65 rise=256
.meas tran tck5_257 when v(xdiv.ck5)=1.65 rise=257
.meas tran tck5_258 when v(xdiv.ck5)=1.65 rise=258
.meas tran tck5_259 when v(xdiv.ck5)=1.65 rise=259
.meas tran tck5_260 when v(xdiv.ck5)=1.65 rise=260
.meas tran tck5_261 when v(xdiv.ck5)=1.65 rise=261
.meas tran tck5_262 when v(xdiv.ck5)=1.65 rise=262
.meas tran tck5_263 when v(xdiv.ck5)=1.65 rise=263
.meas tran tck5_264 when v(xdiv.ck5)=1.65 rise=264
.meas tran tck5_265 when v(xdiv.ck5)=1.65 rise=265
.meas tran tck5_266 when v(xdiv.ck5)=1.65 rise=266
.meas tran tck5_267 when v(xdiv.ck5)=1.65 rise=267
.meas tran tck5_268 when v(xdiv.ck5)=1.65 rise=268
.meas tran tck5_269 when v(xdiv.ck5)=1.65 rise=269
.meas tran tck5_270 when v(xdiv.ck5)=1.65 rise=270
.meas tran tck5_271 when v(xdiv.ck5)=1.65 rise=271
.meas tran tck5_272 when v(xdiv.ck5)=1.65 rise=272
.meas tran tck5_273 when v(xdiv.ck5)=1.65 rise=273
.meas tran tck5_274 when v(xdiv.ck5)=1.65 rise=274
.meas tran tck5_275 when v(xdiv.ck5)=1.65 rise=275
.meas tran tck5_276 when v(xdiv.ck5)=1.65 rise=276
.meas tran tck5_277 when v(xdiv.ck5)=1.65 rise=277
.meas tran tck5_278 when v(xdiv.ck5)=1.65 rise=278
.meas tran tck5_279 when v(xdiv.ck5)=1.65 rise=279
.meas tran tck5_280 when v(xdiv.ck5)=1.65 rise=280
.meas tran tck5_281 when v(xdiv.ck5)=1.65 rise=281
.meas tran tck5_282 when v(xdiv.ck5)=1.65 rise=282
.meas tran tck5_283 when v(xdiv.ck5)=1.65 rise=283
.meas tran tck5_284 when v(xdiv.ck5)=1.65 rise=284
.meas tran tck5_285 when v(xdiv.ck5)=1.65 rise=285
.meas tran tck5_286 when v(xdiv.ck5)=1.65 rise=286
.meas tran tck5_287 when v(xdiv.ck5)=1.65 rise=287
.meas tran tck5_288 when v(xdiv.ck5)=1.65 rise=288
.meas tran tck5_289 when v(xdiv.ck5)=1.65 rise=289
.meas tran tck5_290 when v(xdiv.ck5)=1.65 rise=290
.meas tran tck5_291 when v(xdiv.ck5)=1.65 rise=291
.meas tran tck5_292 when v(xdiv.ck5)=1.65 rise=292
.meas tran tck5_293 when v(xdiv.ck5)=1.65 rise=293
.meas tran tck5_294 when v(xdiv.ck5)=1.65 rise=294
.meas tran tck5_295 when v(xdiv.ck5)=1.65 rise=295
.meas tran tck5_296 when v(xdiv.ck5)=1.65 rise=296
.meas tran tck5_297 when v(xdiv.ck5)=1.65 rise=297
.meas tran tck5_298 when v(xdiv.ck5)=1.65 rise=298
.meas tran tck5_299 when v(xdiv.ck5)=1.65 rise=299
.meas tran tck5_300 when v(xdiv.ck5)=1.65 rise=300
.meas tran tck5_301 when v(xdiv.ck5)=1.65 rise=301
.meas tran tck5_302 when v(xdiv.ck5)=1.65 rise=302
.meas tran tck5_303 when v(xdiv.ck5)=1.65 rise=303
.meas tran tck5_304 when v(xdiv.ck5)=1.65 rise=304
.meas tran tck5_305 when v(xdiv.ck5)=1.65 rise=305
.meas tran tck5_306 when v(xdiv.ck5)=1.65 rise=306
.meas tran tck5_307 when v(xdiv.ck5)=1.65 rise=307
.meas tran tck5_308 when v(xdiv.ck5)=1.65 rise=308
.meas tran tck5_309 when v(xdiv.ck5)=1.65 rise=309
.meas tran tck5_310 when v(xdiv.ck5)=1.65 rise=310
.meas tran tck5_311 when v(xdiv.ck5)=1.65 rise=311
.meas tran tck5_312 when v(xdiv.ck5)=1.65 rise=312
.meas tran tck5_313 when v(xdiv.ck5)=1.65 rise=313
.meas tran tck5_314 when v(xdiv.ck5)=1.65 rise=314
.meas tran tck5_315 when v(xdiv.ck5)=1.65 rise=315
.meas tran tck5_316 when v(xdiv.ck5)=1.65 rise=316
.meas tran tck5_317 when v(xdiv.ck5)=1.65 rise=317
.meas tran tck5_318 when v(xdiv.ck5)=1.65 rise=318
.meas tran tck5_319 when v(xdiv.ck5)=1.65 rise=319
.meas tran tck5_320 when v(xdiv.ck5)=1.65 rise=320
.meas tran tck5_321 when v(xdiv.ck5)=1.65 rise=321
.meas tran tck5_322 when v(xdiv.ck5)=1.65 rise=322
.meas tran tck5_323 when v(xdiv.ck5)=1.65 rise=323
.meas tran tck5_324 when v(xdiv.ck5)=1.65 rise=324
.meas tran tck5_325 when v(xdiv.ck5)=1.65 rise=325
.meas tran tck5_326 when v(xdiv.ck5)=1.65 rise=326
.meas tran tck5_327 when v(xdiv.ck5)=1.65 rise=327
.meas tran tck5_328 when v(xdiv.ck5)=1.65 rise=328
.meas tran tck5_329 when v(xdiv.ck5)=1.65 rise=329
.meas tran tck5_330 when v(xdiv.ck5)=1.65 rise=330
.meas tran tck5_331 when v(xdiv.ck5)=1.65 rise=331
.meas tran tck5_332 when v(xdiv.ck5)=1.65 rise=332
.meas tran tck5_333 when v(xdiv.ck5)=1.65 rise=333
.meas tran tck5_334 when v(xdiv.ck5)=1.65 rise=334
.meas tran tck5_335 when v(xdiv.ck5)=1.65 rise=335
.meas tran tck5_336 when v(xdiv.ck5)=1.65 rise=336
.meas tran tck5_337 when v(xdiv.ck5)=1.65 rise=337
.meas tran tck5_338 when v(xdiv.ck5)=1.65 rise=338
.meas tran tck5_339 when v(xdiv.ck5)=1.65 rise=339
.meas tran tck5_340 when v(xdiv.ck5)=1.65 rise=340
.meas tran tck5_341 when v(xdiv.ck5)=1.65 rise=341
.meas tran tck5_342 when v(xdiv.ck5)=1.65 rise=342
.meas tran tck5_343 when v(xdiv.ck5)=1.65 rise=343
.meas tran tck5_344 when v(xdiv.ck5)=1.65 rise=344
.meas tran tck5_345 when v(xdiv.ck5)=1.65 rise=345
.meas tran tck5_346 when v(xdiv.ck5)=1.65 rise=346
.meas tran tck5_347 when v(xdiv.ck5)=1.65 rise=347
.meas tran tck5_348 when v(xdiv.ck5)=1.65 rise=348
.meas tran tck5_349 when v(xdiv.ck5)=1.65 rise=349
.meas tran tck5_350 when v(xdiv.ck5)=1.65 rise=350
.meas tran tck5_351 when v(xdiv.ck5)=1.65 rise=351
.meas tran tck5_352 when v(xdiv.ck5)=1.65 rise=352
.meas tran tck5_353 when v(xdiv.ck5)=1.65 rise=353
.meas tran tck5_354 when v(xdiv.ck5)=1.65 rise=354
.meas tran tck5_355 when v(xdiv.ck5)=1.65 rise=355
.meas tran tck5_356 when v(xdiv.ck5)=1.65 rise=356
.meas tran tck5_357 when v(xdiv.ck5)=1.65 rise=357
.meas tran tck5_358 when v(xdiv.ck5)=1.65 rise=358
.meas tran tck5_359 when v(xdiv.ck5)=1.65 rise=359
.meas tran tck5_360 when v(xdiv.ck5)=1.65 rise=360
.meas tran tck5_361 when v(xdiv.ck5)=1.65 rise=361
.meas tran tck5_362 when v(xdiv.ck5)=1.65 rise=362
.meas tran tck5_363 when v(xdiv.ck5)=1.65 rise=363
.meas tran tck5_364 when v(xdiv.ck5)=1.65 rise=364
.meas tran tck5_365 when v(xdiv.ck5)=1.65 rise=365
.meas tran tck5_366 when v(xdiv.ck5)=1.65 rise=366
.meas tran tck5_367 when v(xdiv.ck5)=1.65 rise=367
.meas tran tck5_368 when v(xdiv.ck5)=1.65 rise=368
.meas tran tck5_369 when v(xdiv.ck5)=1.65 rise=369
.meas tran tck5_370 when v(xdiv.ck5)=1.65 rise=370
.meas tran tck5_371 when v(xdiv.ck5)=1.65 rise=371
.meas tran tck5_372 when v(xdiv.ck5)=1.65 rise=372
.meas tran tck5_373 when v(xdiv.ck5)=1.65 rise=373
.meas tran tck5_374 when v(xdiv.ck5)=1.65 rise=374
.meas tran tck5_375 when v(xdiv.ck5)=1.65 rise=375
.meas tran tck5_376 when v(xdiv.ck5)=1.65 rise=376
.meas tran tck5_377 when v(xdiv.ck5)=1.65 rise=377
.meas tran tck5_378 when v(xdiv.ck5)=1.65 rise=378
.meas tran tck5_379 when v(xdiv.ck5)=1.65 rise=379
.meas tran tck5_380 when v(xdiv.ck5)=1.65 rise=380
.meas tran tck5_381 when v(xdiv.ck5)=1.65 rise=381
.meas tran tck5_382 when v(xdiv.ck5)=1.65 rise=382
.meas tran tck5_383 when v(xdiv.ck5)=1.65 rise=383
.meas tran tck5_384 when v(xdiv.ck5)=1.65 rise=384
.meas tran tck5_385 when v(xdiv.ck5)=1.65 rise=385
.meas tran tck5_386 when v(xdiv.ck5)=1.65 rise=386
.meas tran tck5_387 when v(xdiv.ck5)=1.65 rise=387
.meas tran tck5_388 when v(xdiv.ck5)=1.65 rise=388
.meas tran tck5_389 when v(xdiv.ck5)=1.65 rise=389
.meas tran tck5_390 when v(xdiv.ck5)=1.65 rise=390
.meas tran tck5_391 when v(xdiv.ck5)=1.65 rise=391
.meas tran tck5_392 when v(xdiv.ck5)=1.65 rise=392
.meas tran tck5_393 when v(xdiv.ck5)=1.65 rise=393
.meas tran tck5_394 when v(xdiv.ck5)=1.65 rise=394
.meas tran tck5_395 when v(xdiv.ck5)=1.65 rise=395
.meas tran tck5_396 when v(xdiv.ck5)=1.65 rise=396
.meas tran tck5_397 when v(xdiv.ck5)=1.65 rise=397
.meas tran tck5_398 when v(xdiv.ck5)=1.65 rise=398
.meas tran tck5_399 when v(xdiv.ck5)=1.65 rise=399
.meas tran tck5_400 when v(xdiv.ck5)=1.65 rise=400
.meas tran tck5_401 when v(xdiv.ck5)=1.65 rise=401
.meas tran tck5_402 when v(xdiv.ck5)=1.65 rise=402
.meas tran tck5_403 when v(xdiv.ck5)=1.65 rise=403
.meas tran tck5_404 when v(xdiv.ck5)=1.65 rise=404
.meas tran tck5_405 when v(xdiv.ck5)=1.65 rise=405
.meas tran tck5_406 when v(xdiv.ck5)=1.65 rise=406
.meas tran tck5_407 when v(xdiv.ck5)=1.65 rise=407
.meas tran tck5_408 when v(xdiv.ck5)=1.65 rise=408
.meas tran tck5_409 when v(xdiv.ck5)=1.65 rise=409
.meas tran tck5_410 when v(xdiv.ck5)=1.65 rise=410
.meas tran tck5_411 when v(xdiv.ck5)=1.65 rise=411
.meas tran tck5_412 when v(xdiv.ck5)=1.65 rise=412
.meas tran tck5_413 when v(xdiv.ck5)=1.65 rise=413
.meas tran tck5_414 when v(xdiv.ck5)=1.65 rise=414
.meas tran tck5_415 when v(xdiv.ck5)=1.65 rise=415
.meas tran tck5_416 when v(xdiv.ck5)=1.65 rise=416
.meas tran tck5_417 when v(xdiv.ck5)=1.65 rise=417
.meas tran tck5_418 when v(xdiv.ck5)=1.65 rise=418
.meas tran tck5_419 when v(xdiv.ck5)=1.65 rise=419
.meas tran tck5_420 when v(xdiv.ck5)=1.65 rise=420
.meas tran tck5_421 when v(xdiv.ck5)=1.65 rise=421
.meas tran tck5_422 when v(xdiv.ck5)=1.65 rise=422
.meas tran tck5_423 when v(xdiv.ck5)=1.65 rise=423
.meas tran tck5_424 when v(xdiv.ck5)=1.65 rise=424
.meas tran tck5_425 when v(xdiv.ck5)=1.65 rise=425
.meas tran tck5_426 when v(xdiv.ck5)=1.65 rise=426
.meas tran tck5_427 when v(xdiv.ck5)=1.65 rise=427
.meas tran tck5_428 when v(xdiv.ck5)=1.65 rise=428
.meas tran tck5_429 when v(xdiv.ck5)=1.65 rise=429
.meas tran tck5_430 when v(xdiv.ck5)=1.65 rise=430
.meas tran tck5_431 when v(xdiv.ck5)=1.65 rise=431
.meas tran tck5_432 when v(xdiv.ck5)=1.65 rise=432
.meas tran tck5_433 when v(xdiv.ck5)=1.65 rise=433
.meas tran tck5_434 when v(xdiv.ck5)=1.65 rise=434
.meas tran tck5_435 when v(xdiv.ck5)=1.65 rise=435
.meas tran tck5_436 when v(xdiv.ck5)=1.65 rise=436
.meas tran tck5_437 when v(xdiv.ck5)=1.65 rise=437
.meas tran tck5_438 when v(xdiv.ck5)=1.65 rise=438
.meas tran tck5_439 when v(xdiv.ck5)=1.65 rise=439
.meas tran tck5_440 when v(xdiv.ck5)=1.65 rise=440
.meas tran tck5_441 when v(xdiv.ck5)=1.65 rise=441
.meas tran tck5_442 when v(xdiv.ck5)=1.65 rise=442
.meas tran tck5_443 when v(xdiv.ck5)=1.65 rise=443
.meas tran tck5_444 when v(xdiv.ck5)=1.65 rise=444
.meas tran tck5_445 when v(xdiv.ck5)=1.65 rise=445
.meas tran tck5_446 when v(xdiv.ck5)=1.65 rise=446
.meas tran tck5_447 when v(xdiv.ck5)=1.65 rise=447
.meas tran tck5_448 when v(xdiv.ck5)=1.65 rise=448
.meas tran tck5_449 when v(xdiv.ck5)=1.65 rise=449
.meas tran tck5_450 when v(xdiv.ck5)=1.65 rise=450
.meas tran tck5_451 when v(xdiv.ck5)=1.65 rise=451
.meas tran tck5_452 when v(xdiv.ck5)=1.65 rise=452
.meas tran tck5_453 when v(xdiv.ck5)=1.65 rise=453
.meas tran tck5_454 when v(xdiv.ck5)=1.65 rise=454
.meas tran tck5_455 when v(xdiv.ck5)=1.65 rise=455
.meas tran tck5_456 when v(xdiv.ck5)=1.65 rise=456
.meas tran tck5_457 when v(xdiv.ck5)=1.65 rise=457
.meas tran tck5_458 when v(xdiv.ck5)=1.65 rise=458
.meas tran tck5_459 when v(xdiv.ck5)=1.65 rise=459
.meas tran tck5_460 when v(xdiv.ck5)=1.65 rise=460
.meas tran tck5_461 when v(xdiv.ck5)=1.65 rise=461
.meas tran tck5_462 when v(xdiv.ck5)=1.65 rise=462
.meas tran tck5_463 when v(xdiv.ck5)=1.65 rise=463
.meas tran tck5_464 when v(xdiv.ck5)=1.65 rise=464
.meas tran tck5_465 when v(xdiv.ck5)=1.65 rise=465
.meas tran tck5_466 when v(xdiv.ck5)=1.65 rise=466
.meas tran tck5_467 when v(xdiv.ck5)=1.65 rise=467
.meas tran tck5_468 when v(xdiv.ck5)=1.65 rise=468
.meas tran tck5_469 when v(xdiv.ck5)=1.65 rise=469
.meas tran tck5_470 when v(xdiv.ck5)=1.65 rise=470
.meas tran tck5_471 when v(xdiv.ck5)=1.65 rise=471
.meas tran tck5_472 when v(xdiv.ck5)=1.65 rise=472
.meas tran tck5_473 when v(xdiv.ck5)=1.65 rise=473
.meas tran tck5_474 when v(xdiv.ck5)=1.65 rise=474
.meas tran tck5_475 when v(xdiv.ck5)=1.65 rise=475
.meas tran tck5_476 when v(xdiv.ck5)=1.65 rise=476
.meas tran tck5_477 when v(xdiv.ck5)=1.65 rise=477
.meas tran tck5_478 when v(xdiv.ck5)=1.65 rise=478
.meas tran tck5_479 when v(xdiv.ck5)=1.65 rise=479
.meas tran tck5_480 when v(xdiv.ck5)=1.65 rise=480
.meas tran tck5_481 when v(xdiv.ck5)=1.65 rise=481
.meas tran tck5_482 when v(xdiv.ck5)=1.65 rise=482
.meas tran tck5_483 when v(xdiv.ck5)=1.65 rise=483
.meas tran tck5_484 when v(xdiv.ck5)=1.65 rise=484
.meas tran tck5_485 when v(xdiv.ck5)=1.65 rise=485
.meas tran tck5_486 when v(xdiv.ck5)=1.65 rise=486
.meas tran tck5_487 when v(xdiv.ck5)=1.65 rise=487
.meas tran tck5_488 when v(xdiv.ck5)=1.65 rise=488
.meas tran tck5_489 when v(xdiv.ck5)=1.65 rise=489
.meas tran tck5_490 when v(xdiv.ck5)=1.65 rise=490
.meas tran tck5_491 when v(xdiv.ck5)=1.65 rise=491
.meas tran tck5_492 when v(xdiv.ck5)=1.65 rise=492
.meas tran tck5_493 when v(xdiv.ck5)=1.65 rise=493
.meas tran tck5_494 when v(xdiv.ck5)=1.65 rise=494
.meas tran tck5_495 when v(xdiv.ck5)=1.65 rise=495
.meas tran tck5_496 when v(xdiv.ck5)=1.65 rise=496
.meas tran tck5_497 when v(xdiv.ck5)=1.65 rise=497
.meas tran tck5_498 when v(xdiv.ck5)=1.65 rise=498
.meas tran tck5_499 when v(xdiv.ck5)=1.65 rise=499
.meas tran tck5_500 when v(xdiv.ck5)=1.65 rise=500
.meas tran tck5_501 when v(xdiv.ck5)=1.65 rise=501
.meas tran tck5_502 when v(xdiv.ck5)=1.65 rise=502
.meas tran tck5_503 when v(xdiv.ck5)=1.65 rise=503
.meas tran tck5_504 when v(xdiv.ck5)=1.65 rise=504
.meas tran tck5_505 when v(xdiv.ck5)=1.65 rise=505
.meas tran tck5_506 when v(xdiv.ck5)=1.65 rise=506
.meas tran tck5_507 when v(xdiv.ck5)=1.65 rise=507
.meas tran tck5_508 when v(xdiv.ck5)=1.65 rise=508
.meas tran tck5_509 when v(xdiv.ck5)=1.65 rise=509
.meas tran tck5_510 when v(xdiv.ck5)=1.65 rise=510
.meas tran tck5_511 when v(xdiv.ck5)=1.65 rise=511
.meas tran tck5_512 when v(xdiv.ck5)=1.65 rise=512
.meas tran tck5_513 when v(xdiv.ck5)=1.65 rise=513
.meas tran tck5_514 when v(xdiv.ck5)=1.65 rise=514
.meas tran tck5_515 when v(xdiv.ck5)=1.65 rise=515
.meas tran tck5_516 when v(xdiv.ck5)=1.65 rise=516
.meas tran tck5_517 when v(xdiv.ck5)=1.65 rise=517
.meas tran tck5_518 when v(xdiv.ck5)=1.65 rise=518
.meas tran tck5_519 when v(xdiv.ck5)=1.65 rise=519
.meas tran tck5_520 when v(xdiv.ck5)=1.65 rise=520
.meas tran tck5_521 when v(xdiv.ck5)=1.65 rise=521
.meas tran tck5_522 when v(xdiv.ck5)=1.65 rise=522
.meas tran tck5_523 when v(xdiv.ck5)=1.65 rise=523
.meas tran tck5_524 when v(xdiv.ck5)=1.65 rise=524
.meas tran tck5_525 when v(xdiv.ck5)=1.65 rise=525
.meas tran tck5_526 when v(xdiv.ck5)=1.65 rise=526
.meas tran tck5_527 when v(xdiv.ck5)=1.65 rise=527
.meas tran tck5_528 when v(xdiv.ck5)=1.65 rise=528
.meas tran tck5_529 when v(xdiv.ck5)=1.65 rise=529
.meas tran tck5_530 when v(xdiv.ck5)=1.65 rise=530
.meas tran tck5_531 when v(xdiv.ck5)=1.65 rise=531
.meas tran tck5_532 when v(xdiv.ck5)=1.65 rise=532
.meas tran tck5_533 when v(xdiv.ck5)=1.65 rise=533
.meas tran tck5_534 when v(xdiv.ck5)=1.65 rise=534
.meas tran tck5_535 when v(xdiv.ck5)=1.65 rise=535
.meas tran tck5_536 when v(xdiv.ck5)=1.65 rise=536
.meas tran tfb_1 when v(fb)=1.65 rise=1
.meas tran tfb_2 when v(fb)=1.65 rise=2
.meas tran tfb_3 when v(fb)=1.65 rise=3
.meas tran tfb_4 when v(fb)=1.65 rise=4
.meas tran tfb_5 when v(fb)=1.65 rise=5
.meas tran tfb_6 when v(fb)=1.65 rise=6
.meas tran tfb_7 when v(fb)=1.65 rise=7
.meas tran tfb_8 when v(fb)=1.65 rise=8
.meas tran tfb_9 when v(fb)=1.65 rise=9
.meas tran tfb_10 when v(fb)=1.65 rise=10
.meas tran tfb_11 when v(fb)=1.65 rise=11
.meas tran tdvo_1 when v(divout)=1.65 rise=1
.meas tran tdvo_2 when v(divout)=1.65 rise=2
.meas tran tdvo_3 when v(divout)=1.65 rise=3
.meas tran tdvo_4 when v(divout)=1.65 rise=4
.meas tran tdvo_5 when v(divout)=1.65 rise=5
.meas tran tdvo_6 when v(divout)=1.65 rise=6
.meas tran tdvo_7 when v(divout)=1.65 rise=7
.meas tran tdvo_8 when v(divout)=1.65 rise=8
.meas tran tdvo_9 when v(divout)=1.65 rise=9
.meas tran tdvo_10 when v(divout)=1.65 rise=10
.meas tran tdvo_11 when v(divout)=1.65 rise=11
.meas tran tdvo_12 when v(divout)=1.65 rise=12
.meas tran tdvo_13 when v(divout)=1.65 rise=13
.meas tran tdvo_14 when v(divout)=1.65 rise=14
.meas tran tdvo_15 when v(divout)=1.65 rise=15
.meas tran tdvo_16 when v(divout)=1.65 rise=16
.meas tran tdvo_17 when v(divout)=1.65 rise=17
.meas tran tdvo_18 when v(divout)=1.65 rise=18
.meas tran tdvo_19 when v(divout)=1.65 rise=19
.meas tran tdvo_20 when v(divout)=1.65 rise=20
.meas tran tdvo_21 when v(divout)=1.65 rise=21
.meas tran tdvo_22 when v(divout)=1.65 rise=22
.meas tran tdvo_23 when v(divout)=1.65 rise=23
.meas tran tdvo_24 when v(divout)=1.65 rise=24
.meas tran tdvo_25 when v(divout)=1.65 rise=25
.meas tran tdvo_26 when v(divout)=1.65 rise=26
.meas tran tdvo_27 when v(divout)=1.65 rise=27
.meas tran tdvo_28 when v(divout)=1.65 rise=28
.meas tran tdvo_29 when v(divout)=1.65 rise=29
.meas tran tdvo_30 when v(divout)=1.65 rise=30
.meas tran tdvo_31 when v(divout)=1.65 rise=31
.meas tran tdvo_32 when v(divout)=1.65 rise=32
.meas tran tdvo_33 when v(divout)=1.65 rise=33
.meas tran tdvo_34 when v(divout)=1.65 rise=34
.meas tran tdvo_35 when v(divout)=1.65 rise=35
.meas tran tdvo_36 when v(divout)=1.65 rise=36
.meas tran tdvo_37 when v(divout)=1.65 rise=37
.meas tran tdvo_38 when v(divout)=1.65 rise=38
.meas tran tdvo_39 when v(divout)=1.65 rise=39
.meas tran tdvo_40 when v(divout)=1.65 rise=40
.meas tran tdvo_41 when v(divout)=1.65 rise=41
.meas tran tdvo_42 when v(divout)=1.65 rise=42
.meas tran tdvo_43 when v(divout)=1.65 rise=43
.meas tran tdvo_44 when v(divout)=1.65 rise=44
.meas tran tdvo_45 when v(divout)=1.65 rise=45
.meas tran tdvo_46 when v(divout)=1.65 rise=46
.meas tran tdvo_47 when v(divout)=1.65 rise=47
.meas tran tdvo_48 when v(divout)=1.65 rise=48
.meas tran tdvo_49 when v(divout)=1.65 rise=49
.meas tran tdvo_50 when v(divout)=1.65 rise=50
.meas tran tdvo_51 when v(divout)=1.65 rise=51
.meas tran tdvo_52 when v(divout)=1.65 rise=52
.meas tran tdvo_53 when v(divout)=1.65 rise=53
.meas tran tdvo_54 when v(divout)=1.65 rise=54
.meas tran tdvo_55 when v(divout)=1.65 rise=55
.meas tran tdvo_56 when v(divout)=1.65 rise=56
.meas tran tdvo_57 when v(divout)=1.65 rise=57
.meas tran tdvo_58 when v(divout)=1.65 rise=58
.meas tran tdvo_59 when v(divout)=1.65 rise=59
.meas tran tdvo_60 when v(divout)=1.65 rise=60
.meas tran tdvo_61 when v(divout)=1.65 rise=61
.meas tran tdvo_62 when v(divout)=1.65 rise=62
.meas tran tdvo_63 when v(divout)=1.65 rise=63
.meas tran tdvo_64 when v(divout)=1.65 rise=64
.meas tran tdvo_65 when v(divout)=1.65 rise=65
.meas tran tdvo_66 when v(divout)=1.65 rise=66
.meas tran tdvo_67 when v(divout)=1.65 rise=67
.meas tran tdvo_68 when v(divout)=1.65 rise=68
.meas tran tdvo_69 when v(divout)=1.65 rise=69
.meas tran tdvo_70 when v(divout)=1.65 rise=70
.meas tran tdvo_71 when v(divout)=1.65 rise=71
.meas tran tdvo_72 when v(divout)=1.65 rise=72
.meas tran tdvo_73 when v(divout)=1.65 rise=73
.meas tran tdvo_74 when v(divout)=1.65 rise=74
.meas tran tdvo_75 when v(divout)=1.65 rise=75
.meas tran tdvo_76 when v(divout)=1.65 rise=76
.meas tran tdvo_77 when v(divout)=1.65 rise=77
.meas tran tdvo_78 when v(divout)=1.65 rise=78
.meas tran tdvo_79 when v(divout)=1.65 rise=79
.meas tran tdvo_80 when v(divout)=1.65 rise=80
.meas tran tdvo_81 when v(divout)=1.65 rise=81
.meas tran tdvo_82 when v(divout)=1.65 rise=82
.meas tran tdvo_83 when v(divout)=1.65 rise=83
.meas tran tdvo_84 when v(divout)=1.65 rise=84
.meas tran tdvo_85 when v(divout)=1.65 rise=85
.meas tran tdvo_86 when v(divout)=1.65 rise=86
.meas tran tdvo_87 when v(divout)=1.65 rise=87
.meas tran tdvo_88 when v(divout)=1.65 rise=88
.meas tran tdvo_89 when v(divout)=1.65 rise=89
.meas tran tdvo_90 when v(divout)=1.65 rise=90
.meas tran tdvo_91 when v(divout)=1.65 rise=91
.meas tran tdvo_92 when v(divout)=1.65 rise=92
.meas tran tdvo_93 when v(divout)=1.65 rise=93
.meas tran tdvo_94 when v(divout)=1.65 rise=94
.meas tran tdvo_95 when v(divout)=1.65 rise=95
.meas tran tdvo_96 when v(divout)=1.65 rise=96
.meas tran tdvo_97 when v(divout)=1.65 rise=97
.meas tran tdvo_98 when v(divout)=1.65 rise=98
.meas tran tdvo_99 when v(divout)=1.65 rise=99
.meas tran tdvo_100 when v(divout)=1.65 rise=100
.meas tran tdvo_101 when v(divout)=1.65 rise=101
.meas tran tdvo_102 when v(divout)=1.65 rise=102
.meas tran tdvo_103 when v(divout)=1.65 rise=103
.meas tran tdvo_104 when v(divout)=1.65 rise=104
.meas tran tdvo_105 when v(divout)=1.65 rise=105
.meas tran tdvo_106 when v(divout)=1.65 rise=106
.meas tran tdvo_107 when v(divout)=1.65 rise=107
.meas tran tdvo_108 when v(divout)=1.65 rise=108
.meas tran tdvo_109 when v(divout)=1.65 rise=109
.meas tran tdvo_110 when v(divout)=1.65 rise=110
.meas tran tdvo_111 when v(divout)=1.65 rise=111
.meas tran tdvo_112 when v(divout)=1.65 rise=112
.meas tran tdvo_113 when v(divout)=1.65 rise=113
.meas tran tdvo_114 when v(divout)=1.65 rise=114
.meas tran tdvo_115 when v(divout)=1.65 rise=115
.meas tran tdvo_116 when v(divout)=1.65 rise=116
.meas tran tdvo_117 when v(divout)=1.65 rise=117
.meas tran tdvo_118 when v(divout)=1.65 rise=118
.meas tran tdvo_119 when v(divout)=1.65 rise=119
.meas tran tdvo_120 when v(divout)=1.65 rise=120
.meas tran tdvo_121 when v(divout)=1.65 rise=121
.meas tran tdvo_122 when v(divout)=1.65 rise=122
.meas tran tdvo_123 when v(divout)=1.65 rise=123
.meas tran tdvo_124 when v(divout)=1.65 rise=124
.meas tran tdvo_125 when v(divout)=1.65 rise=125
.meas tran tdvo_126 when v(divout)=1.65 rise=126
.meas tran tdvo_127 when v(divout)=1.65 rise=127
.meas tran tdvo_128 when v(divout)=1.65 rise=128
.meas tran tdvo_129 when v(divout)=1.65 rise=129
.meas tran tdvo_130 when v(divout)=1.65 rise=130
.meas tran tdvo_131 when v(divout)=1.65 rise=131
.meas tran tdvo_132 when v(divout)=1.65 rise=132
.meas tran tdvo_133 when v(divout)=1.65 rise=133
.meas tran tdvo_134 when v(divout)=1.65 rise=134
.meas tran tdvo_135 when v(divout)=1.65 rise=135
.meas tran tdvo_136 when v(divout)=1.65 rise=136
.meas tran tdvo_137 when v(divout)=1.65 rise=137
.meas tran tdvo_138 when v(divout)=1.65 rise=138
.meas tran tdvo_139 when v(divout)=1.65 rise=139
.meas tran tdvo_140 when v(divout)=1.65 rise=140
.meas tran tdvo_141 when v(divout)=1.65 rise=141
.meas tran tdvo_142 when v(divout)=1.65 rise=142
.meas tran tdvo_143 when v(divout)=1.65 rise=143
.meas tran tdvo_144 when v(divout)=1.65 rise=144
.meas tran tdvo_145 when v(divout)=1.65 rise=145
.meas tran tdvo_146 when v(divout)=1.65 rise=146
.meas tran tdvo_147 when v(divout)=1.65 rise=147
.meas tran tdvo_148 when v(divout)=1.65 rise=148
.meas tran tdvo_149 when v(divout)=1.65 rise=149
.meas tran tdvo_150 when v(divout)=1.65 rise=150
.meas tran tdvo_151 when v(divout)=1.65 rise=151
.meas tran tdvo_152 when v(divout)=1.65 rise=152
.meas tran tdvo_153 when v(divout)=1.65 rise=153
.meas tran tdvo_154 when v(divout)=1.65 rise=154
.meas tran tdvo_155 when v(divout)=1.65 rise=155
.meas tran tdvo_156 when v(divout)=1.65 rise=156
.meas tran tdvo_157 when v(divout)=1.65 rise=157
.meas tran tdvo_158 when v(divout)=1.65 rise=158
.meas tran tdvo_159 when v(divout)=1.65 rise=159
.meas tran tdvo_160 when v(divout)=1.65 rise=160
.meas tran tdvo_161 when v(divout)=1.65 rise=161
.meas tran tdvo_162 when v(divout)=1.65 rise=162
.meas tran tdvo_163 when v(divout)=1.65 rise=163
.meas tran tdvo_164 when v(divout)=1.65 rise=164
.meas tran tdvo_165 when v(divout)=1.65 rise=165
.meas tran tdvo_166 when v(divout)=1.65 rise=166
.meas tran tdvo_167 when v(divout)=1.65 rise=167
.meas tran tdvo_168 when v(divout)=1.65 rise=168
.meas tran tdvo_169 when v(divout)=1.65 rise=169
.meas tran tdvo_170 when v(divout)=1.65 rise=170
.meas tran tdvo_171 when v(divout)=1.65 rise=171
.meas tran tdvo_172 when v(divout)=1.65 rise=172
.meas tran tdvo_173 when v(divout)=1.65 rise=173
.meas tran tdvo_174 when v(divout)=1.65 rise=174
.meas tran tdvo_175 when v(divout)=1.65 rise=175
.meas tran tdvo_176 when v(divout)=1.65 rise=176
.meas tran tdvo_177 when v(divout)=1.65 rise=177
.meas tran tdvo_178 when v(divout)=1.65 rise=178
.meas tran tdvo_179 when v(divout)=1.65 rise=179
.meas tran tdvo_180 when v(divout)=1.65 rise=180
.meas tran tdvo_181 when v(divout)=1.65 rise=181
.meas tran tdvo_182 when v(divout)=1.65 rise=182
.meas tran tdvo_183 when v(divout)=1.65 rise=183
.meas tran tdvo_184 when v(divout)=1.65 rise=184
.meas tran tdvo_185 when v(divout)=1.65 rise=185
.meas tran tdvo_186 when v(divout)=1.65 rise=186
.meas tran tdvo_187 when v(divout)=1.65 rise=187
.meas tran tdvo_188 when v(divout)=1.65 rise=188
.meas tran tdvo_189 when v(divout)=1.65 rise=189
.meas tran tdvo_190 when v(divout)=1.65 rise=190
.meas tran tdvo_191 when v(divout)=1.65 rise=191
.meas tran tdvo_192 when v(divout)=1.65 rise=192
.meas tran tdvo_193 when v(divout)=1.65 rise=193
.meas tran tdvo_194 when v(divout)=1.65 rise=194
.meas tran tdvo_195 when v(divout)=1.65 rise=195
.meas tran tdvo_196 when v(divout)=1.65 rise=196
.meas tran tdvo_197 when v(divout)=1.65 rise=197
.meas tran tdvo_198 when v(divout)=1.65 rise=198
.meas tran tdvo_199 when v(divout)=1.65 rise=199
.meas tran tdvo_200 when v(divout)=1.65 rise=200
.meas tran tdvo_201 when v(divout)=1.65 rise=201
.meas tran tdvo_202 when v(divout)=1.65 rise=202
.meas tran tdvo_203 when v(divout)=1.65 rise=203
.meas tran tdvo_204 when v(divout)=1.65 rise=204
.meas tran tdvo_205 when v(divout)=1.65 rise=205
.meas tran tdvo_206 when v(divout)=1.65 rise=206
.meas tran tdvo_207 when v(divout)=1.65 rise=207
.meas tran tdvo_208 when v(divout)=1.65 rise=208
.meas tran tdvo_209 when v(divout)=1.65 rise=209
.meas tran tdvo_210 when v(divout)=1.65 rise=210
.meas tran tdvo_211 when v(divout)=1.65 rise=211
.meas tran tdvo_212 when v(divout)=1.65 rise=212
.meas tran tdvo_213 when v(divout)=1.65 rise=213
.meas tran tdvo_214 when v(divout)=1.65 rise=214
.meas tran tdvo_215 when v(divout)=1.65 rise=215
.meas tran tdvo_216 when v(divout)=1.65 rise=216
.meas tran tdvo_217 when v(divout)=1.65 rise=217
.meas tran tdvo_218 when v(divout)=1.65 rise=218
.meas tran tdvo_219 when v(divout)=1.65 rise=219
.meas tran tdvo_220 when v(divout)=1.65 rise=220
.meas tran tdvo_221 when v(divout)=1.65 rise=221
.meas tran tdvo_222 when v(divout)=1.65 rise=222
.meas tran tdvo_223 when v(divout)=1.65 rise=223
.meas tran tdvo_224 when v(divout)=1.65 rise=224
.meas tran tdvo_225 when v(divout)=1.65 rise=225
.meas tran tdvo_226 when v(divout)=1.65 rise=226
.meas tran tdvo_227 when v(divout)=1.65 rise=227
.meas tran tdvo_228 when v(divout)=1.65 rise=228
.meas tran tdvo_229 when v(divout)=1.65 rise=229
.meas tran tdvo_230 when v(divout)=1.65 rise=230
.meas tran tdvo_231 when v(divout)=1.65 rise=231
.meas tran tdvo_232 when v(divout)=1.65 rise=232
.meas tran tdvo_233 when v(divout)=1.65 rise=233
.meas tran tdvo_234 when v(divout)=1.65 rise=234
.meas tran tdvo_235 when v(divout)=1.65 rise=235
.meas tran tdvo_236 when v(divout)=1.65 rise=236
.meas tran tdvo_237 when v(divout)=1.65 rise=237
.meas tran tdvo_238 when v(divout)=1.65 rise=238
.meas tran tdvo_239 when v(divout)=1.65 rise=239
.meas tran tdvo_240 when v(divout)=1.65 rise=240
.meas tran tdvo_241 when v(divout)=1.65 rise=241
.meas tran tdvo_242 when v(divout)=1.65 rise=242
.meas tran tdvo_243 when v(divout)=1.65 rise=243
.meas tran tdvo_244 when v(divout)=1.65 rise=244
.meas tran tdvo_245 when v(divout)=1.65 rise=245
.meas tran tdvo_246 when v(divout)=1.65 rise=246
.meas tran tdvo_247 when v(divout)=1.65 rise=247
.meas tran tdvo_248 when v(divout)=1.65 rise=248
.meas tran tdvo_249 when v(divout)=1.65 rise=249
.meas tran tdvo_250 when v(divout)=1.65 rise=250
.meas tran tdvo_251 when v(divout)=1.65 rise=251
.meas tran tdvo_252 when v(divout)=1.65 rise=252
.meas tran tdvo_253 when v(divout)=1.65 rise=253
.meas tran tdvo_254 when v(divout)=1.65 rise=254
.meas tran tdvo_255 when v(divout)=1.65 rise=255
.meas tran tdvo_256 when v(divout)=1.65 rise=256
.meas tran tdvo_257 when v(divout)=1.65 rise=257
.meas tran tdvo_258 when v(divout)=1.65 rise=258
.meas tran tdvo_259 when v(divout)=1.65 rise=259
.meas tran tdvo_260 when v(divout)=1.65 rise=260
.meas tran tdvo_261 when v(divout)=1.65 rise=261
.meas tran tdvo_262 when v(divout)=1.65 rise=262
.meas tran tdvo_263 when v(divout)=1.65 rise=263
.meas tran tdvo_264 when v(divout)=1.65 rise=264
.meas tran tdvo_265 when v(divout)=1.65 rise=265
.meas tran tdvo_266 when v(divout)=1.65 rise=266
.meas tran tdvo_267 when v(divout)=1.65 rise=267
.meas tran tdvo_268 when v(divout)=1.65 rise=268
.meas tran tdvo_269 when v(divout)=1.65 rise=269
.meas tran tdvo_270 when v(divout)=1.65 rise=270
.meas tran tdvo_271 when v(divout)=1.65 rise=271
.meas tran tdvo_272 when v(divout)=1.65 rise=272
.meas tran tdvo_273 when v(divout)=1.65 rise=273
.meas tran tdvo_274 when v(divout)=1.65 rise=274
.meas tran tdvo_275 when v(divout)=1.65 rise=275
.meas tran tdvo_276 when v(divout)=1.65 rise=276
.meas tran tdvo_277 when v(divout)=1.65 rise=277
.meas tran tdvo_278 when v(divout)=1.65 rise=278
.meas tran tdvo_279 when v(divout)=1.65 rise=279
.meas tran tdvo_280 when v(divout)=1.65 rise=280
.meas tran tdvo_281 when v(divout)=1.65 rise=281
.meas tran tdvo_282 when v(divout)=1.65 rise=282
.meas tran tdvo_283 when v(divout)=1.65 rise=283
.meas tran tdvo_284 when v(divout)=1.65 rise=284
.meas tran tdvo_285 when v(divout)=1.65 rise=285
.meas tran tdvo_286 when v(divout)=1.65 rise=286
.meas tran tdvo_287 when v(divout)=1.65 rise=287
.meas tran tdvo_288 when v(divout)=1.65 rise=288
.meas tran tdvo_289 when v(divout)=1.65 rise=289
.meas tran tdvo_290 when v(divout)=1.65 rise=290
.meas tran tdvo_291 when v(divout)=1.65 rise=291
.meas tran tdvo_292 when v(divout)=1.65 rise=292
.meas tran tdvo_293 when v(divout)=1.65 rise=293
.meas tran tdvo_294 when v(divout)=1.65 rise=294
.meas tran tdvo_295 when v(divout)=1.65 rise=295
.meas tran tdvo_296 when v(divout)=1.65 rise=296
.meas tran tdvo_297 when v(divout)=1.65 rise=297
.meas tran tdvo_298 when v(divout)=1.65 rise=298
.meas tran tdvo_299 when v(divout)=1.65 rise=299
.meas tran tdvo_300 when v(divout)=1.65 rise=300
.meas tran tdvo_301 when v(divout)=1.65 rise=301
.meas tran tdvo_302 when v(divout)=1.65 rise=302
.meas tran tdvo_303 when v(divout)=1.65 rise=303
.meas tran tdvo_304 when v(divout)=1.65 rise=304
.meas tran tdvo_305 when v(divout)=1.65 rise=305
.meas tran tdvo_306 when v(divout)=1.65 rise=306
.meas tran tdvo_307 when v(divout)=1.65 rise=307
.meas tran tdvo_308 when v(divout)=1.65 rise=308
.meas tran tdvo_309 when v(divout)=1.65 rise=309
.meas tran tdvo_310 when v(divout)=1.65 rise=310
.meas tran tdvo_311 when v(divout)=1.65 rise=311
.meas tran tdvo_312 when v(divout)=1.65 rise=312
.meas tran tdvo_313 when v(divout)=1.65 rise=313
.meas tran tdvo_314 when v(divout)=1.65 rise=314
.meas tran tdvo_315 when v(divout)=1.65 rise=315
.meas tran tdvo_316 when v(divout)=1.65 rise=316
.meas tran tdvo_317 when v(divout)=1.65 rise=317
.meas tran tdvo_318 when v(divout)=1.65 rise=318
.meas tran tdvo_319 when v(divout)=1.65 rise=319
.meas tran tdvo_320 when v(divout)=1.65 rise=320
.meas tran tdvo_321 when v(divout)=1.65 rise=321
.meas tran tdvo_322 when v(divout)=1.65 rise=322
.meas tran tdvo_323 when v(divout)=1.65 rise=323
.meas tran tdvo_324 when v(divout)=1.65 rise=324
.meas tran tdvo_325 when v(divout)=1.65 rise=325
.meas tran tdvo_326 when v(divout)=1.65 rise=326
.meas tran tdvo_327 when v(divout)=1.65 rise=327
.meas tran tdvo_328 when v(divout)=1.65 rise=328
.meas tran tdvo_329 when v(divout)=1.65 rise=329
.meas tran tdvo_330 when v(divout)=1.65 rise=330
.meas tran tdvo_331 when v(divout)=1.65 rise=331
.meas tran tdvo_332 when v(divout)=1.65 rise=332
.meas tran tdvo_333 when v(divout)=1.65 rise=333
.meas tran tdvo_334 when v(divout)=1.65 rise=334
.meas tran tdvo_335 when v(divout)=1.65 rise=335
.meas tran tdvo_336 when v(divout)=1.65 rise=336
.meas tran tdvo_337 when v(divout)=1.65 rise=337
.meas tran tdvo_338 when v(divout)=1.65 rise=338
.meas tran tdvo_339 when v(divout)=1.65 rise=339
.meas tran tdvo_340 when v(divout)=1.65 rise=340
.meas tran tdvo_341 when v(divout)=1.65 rise=341
.meas tran tdvo_342 when v(divout)=1.65 rise=342
.meas tran tdvo_343 when v(divout)=1.65 rise=343
.meas tran tdvo_344 when v(divout)=1.65 rise=344
.meas tran tdvo_345 when v(divout)=1.65 rise=345
.meas tran tdvo_346 when v(divout)=1.65 rise=346
.meas tran tdvo_347 when v(divout)=1.65 rise=347
.meas tran tdvo_348 when v(divout)=1.65 rise=348
.meas tran tdvo_349 when v(divout)=1.65 rise=349
.meas tran tdvo_350 when v(divout)=1.65 rise=350
.meas tran tdvo_351 when v(divout)=1.65 rise=351
.meas tran tdvo_352 when v(divout)=1.65 rise=352
.meas tran tdvo_353 when v(divout)=1.65 rise=353
.meas tran tdvo_354 when v(divout)=1.65 rise=354
.meas tran tdvo_355 when v(divout)=1.65 rise=355
.meas tran tdvo_356 when v(divout)=1.65 rise=356
.meas tran tdvo_357 when v(divout)=1.65 rise=357
.meas tran tdvo_358 when v(divout)=1.65 rise=358
.meas tran tdvo_359 when v(divout)=1.65 rise=359
.meas tran tdvo_360 when v(divout)=1.65 rise=360
.meas tran tdvo_361 when v(divout)=1.65 rise=361
.meas tran tdvo_362 when v(divout)=1.65 rise=362
.meas tran tdvo_363 when v(divout)=1.65 rise=363
.meas tran tdvo_364 when v(divout)=1.65 rise=364
.meas tran tdvo_365 when v(divout)=1.65 rise=365
.meas tran tdvo_366 when v(divout)=1.65 rise=366
.meas tran tdvo_367 when v(divout)=1.65 rise=367
.meas tran tdvo_368 when v(divout)=1.65 rise=368
.meas tran tdvo_369 when v(divout)=1.65 rise=369
.meas tran tdvo_370 when v(divout)=1.65 rise=370
.meas tran tdvo_371 when v(divout)=1.65 rise=371
.meas tran tdvo_372 when v(divout)=1.65 rise=372
.meas tran tdvo_373 when v(divout)=1.65 rise=373
.meas tran tdvo_374 when v(divout)=1.65 rise=374
.meas tran tdvo_375 when v(divout)=1.65 rise=375
.meas tran tdvo_376 when v(divout)=1.65 rise=376
.meas tran tdvo_377 when v(divout)=1.65 rise=377
.meas tran tdvo_378 when v(divout)=1.65 rise=378
.meas tran tdvo_379 when v(divout)=1.65 rise=379
.meas tran tdvo_380 when v(divout)=1.65 rise=380
.meas tran tdvo_381 when v(divout)=1.65 rise=381
.meas tran tdvo_382 when v(divout)=1.65 rise=382
.meas tran tdvo_383 when v(divout)=1.65 rise=383
.meas tran tdvo_384 when v(divout)=1.65 rise=384
.meas tran tdvo_385 when v(divout)=1.65 rise=385
.meas tran tdvo_386 when v(divout)=1.65 rise=386
.meas tran tdvo_387 when v(divout)=1.65 rise=387
.meas tran tdvo_388 when v(divout)=1.65 rise=388
.meas tran tdvo_389 when v(divout)=1.65 rise=389
.meas tran tdvo_390 when v(divout)=1.65 rise=390
.meas tran tdvo_391 when v(divout)=1.65 rise=391
.meas tran tdvo_392 when v(divout)=1.65 rise=392
.meas tran tdvo_393 when v(divout)=1.65 rise=393
.meas tran tdvo_394 when v(divout)=1.65 rise=394
.meas tran tdvo_395 when v(divout)=1.65 rise=395
.meas tran tdvo_396 when v(divout)=1.65 rise=396
.meas tran tdvo_397 when v(divout)=1.65 rise=397
.meas tran tdvo_398 when v(divout)=1.65 rise=398
.meas tran tdvo_399 when v(divout)=1.65 rise=399
.meas tran tdvo_400 when v(divout)=1.65 rise=400
.meas tran tdvo_401 when v(divout)=1.65 rise=401
.meas tran tdvo_402 when v(divout)=1.65 rise=402
.meas tran tdvo_403 when v(divout)=1.65 rise=403
.meas tran tdvo_404 when v(divout)=1.65 rise=404
.meas tran tdvo_405 when v(divout)=1.65 rise=405
.meas tran tdvo_406 when v(divout)=1.65 rise=406
.meas tran tdvo_407 when v(divout)=1.65 rise=407
.meas tran tdvo_408 when v(divout)=1.65 rise=408
.meas tran tdvo_409 when v(divout)=1.65 rise=409
.meas tran tdvo_410 when v(divout)=1.65 rise=410
.meas tran tdvo_411 when v(divout)=1.65 rise=411
.meas tran tdvo_412 when v(divout)=1.65 rise=412
.meas tran tdvo_413 when v(divout)=1.65 rise=413
.meas tran tdvo_414 when v(divout)=1.65 rise=414
.meas tran tdvo_415 when v(divout)=1.65 rise=415
.meas tran tdvo_416 when v(divout)=1.65 rise=416
.meas tran tdvo_417 when v(divout)=1.65 rise=417
.meas tran tdvo_418 when v(divout)=1.65 rise=418
.meas tran tdvo_419 when v(divout)=1.65 rise=419
.meas tran tdvo_420 when v(divout)=1.65 rise=420
.meas tran tdvo_421 when v(divout)=1.65 rise=421
.meas tran tdvo_422 when v(divout)=1.65 rise=422
.meas tran tdvo_423 when v(divout)=1.65 rise=423
.meas tran tdvo_424 when v(divout)=1.65 rise=424
.meas tran tdvo_425 when v(divout)=1.65 rise=425
.meas tran tdvo_426 when v(divout)=1.65 rise=426
.meas tran tdvo_427 when v(divout)=1.65 rise=427
.meas tran tdvo_428 when v(divout)=1.65 rise=428
.meas tran tdvo_429 when v(divout)=1.65 rise=429
.meas tran tdvo_430 when v(divout)=1.65 rise=430
.meas tran tdvo_431 when v(divout)=1.65 rise=431
.meas tran tdvo_432 when v(divout)=1.65 rise=432
.meas tran tdvo_433 when v(divout)=1.65 rise=433
.meas tran tdvo_434 when v(divout)=1.65 rise=434
.meas tran tdvo_435 when v(divout)=1.65 rise=435
.meas tran tdvo_436 when v(divout)=1.65 rise=436
.meas tran tdvo_437 when v(divout)=1.65 rise=437
.meas tran tdvo_438 when v(divout)=1.65 rise=438
.meas tran tdvo_439 when v(divout)=1.65 rise=439
.meas tran tdvo_440 when v(divout)=1.65 rise=440
.meas tran tdvo_441 when v(divout)=1.65 rise=441
.meas tran tdvo_442 when v(divout)=1.65 rise=442
.meas tran tdvo_443 when v(divout)=1.65 rise=443
.meas tran tdvo_444 when v(divout)=1.65 rise=444
.meas tran tdvo_445 when v(divout)=1.65 rise=445
.meas tran tdvo_446 when v(divout)=1.65 rise=446
.meas tran tdvo_447 when v(divout)=1.65 rise=447
.meas tran tdvo_448 when v(divout)=1.65 rise=448
.meas tran tdvo_449 when v(divout)=1.65 rise=449
.meas tran tdvo_450 when v(divout)=1.65 rise=450
.meas tran tdvo_451 when v(divout)=1.65 rise=451
.meas tran tdvo_452 when v(divout)=1.65 rise=452
.meas tran tdvo_453 when v(divout)=1.65 rise=453
.meas tran tdvo_454 when v(divout)=1.65 rise=454
.meas tran tdvo_455 when v(divout)=1.65 rise=455
.meas tran tdvo_456 when v(divout)=1.65 rise=456
.meas tran tdvo_457 when v(divout)=1.65 rise=457
.meas tran tdvo_458 when v(divout)=1.65 rise=458
.meas tran tdvo_459 when v(divout)=1.65 rise=459
.meas tran tdvo_460 when v(divout)=1.65 rise=460
.meas tran tdvo_461 when v(divout)=1.65 rise=461
.meas tran tdvo_462 when v(divout)=1.65 rise=462
.meas tran tdvo_463 when v(divout)=1.65 rise=463
.meas tran tdvo_464 when v(divout)=1.65 rise=464
.meas tran tdvo_465 when v(divout)=1.65 rise=465
.meas tran tdvo_466 when v(divout)=1.65 rise=466
.meas tran tdvo_467 when v(divout)=1.65 rise=467
.meas tran tdvo_468 when v(divout)=1.65 rise=468
.meas tran tdvo_469 when v(divout)=1.65 rise=469
.meas tran tdvo_470 when v(divout)=1.65 rise=470
.meas tran tdvo_471 when v(divout)=1.65 rise=471
.meas tran tdvo_472 when v(divout)=1.65 rise=472
.meas tran tdvo_473 when v(divout)=1.65 rise=473
.meas tran tdvo_474 when v(divout)=1.65 rise=474
.meas tran tdvo_475 when v(divout)=1.65 rise=475
.meas tran tdvo_476 when v(divout)=1.65 rise=476
.meas tran tdvo_477 when v(divout)=1.65 rise=477
.meas tran tdvo_478 when v(divout)=1.65 rise=478
.meas tran tdvo_479 when v(divout)=1.65 rise=479
.meas tran tdvo_480 when v(divout)=1.65 rise=480
.meas tran tdvo_481 when v(divout)=1.65 rise=481
.meas tran tdvo_482 when v(divout)=1.65 rise=482
.meas tran tdvo_483 when v(divout)=1.65 rise=483
.meas tran tdvo_484 when v(divout)=1.65 rise=484
.meas tran tdvo_485 when v(divout)=1.65 rise=485
.meas tran tdvo_486 when v(divout)=1.65 rise=486
.meas tran tdvo_487 when v(divout)=1.65 rise=487
.meas tran tdvo_488 when v(divout)=1.65 rise=488
.meas tran tdvo_489 when v(divout)=1.65 rise=489
.meas tran tdvo_490 when v(divout)=1.65 rise=490
.meas tran tdvo_491 when v(divout)=1.65 rise=491
.meas tran tdvo_492 when v(divout)=1.65 rise=492
.meas tran tdvo_493 when v(divout)=1.65 rise=493
.meas tran tdvo_494 when v(divout)=1.65 rise=494
.meas tran tdvo_495 when v(divout)=1.65 rise=495
.meas tran tdvo_496 when v(divout)=1.65 rise=496
.meas tran tdvo_497 when v(divout)=1.65 rise=497
.meas tran tdvo_498 when v(divout)=1.65 rise=498
.meas tran tdvo_499 when v(divout)=1.65 rise=499
.meas tran tdvo_500 when v(divout)=1.65 rise=500
.meas tran tdvo_501 when v(divout)=1.65 rise=501
.meas tran tdvo_502 when v(divout)=1.65 rise=502
.meas tran tdvo_503 when v(divout)=1.65 rise=503
.meas tran tdvo_504 when v(divout)=1.65 rise=504
.meas tran tdvo_505 when v(divout)=1.65 rise=505
.meas tran tdvo_506 when v(divout)=1.65 rise=506
.meas tran tdvo_507 when v(divout)=1.65 rise=507
.meas tran tdvo_508 when v(divout)=1.65 rise=508
.meas tran tdvo_509 when v(divout)=1.65 rise=509
.meas tran tdvo_510 when v(divout)=1.65 rise=510
.meas tran tdvo_511 when v(divout)=1.65 rise=511
.meas tran tdvo_512 when v(divout)=1.65 rise=512
.meas tran tdvo_513 when v(divout)=1.65 rise=513
.meas tran tdvo_514 when v(divout)=1.65 rise=514
.meas tran tdvo_515 when v(divout)=1.65 rise=515
.meas tran tdvo_516 when v(divout)=1.65 rise=516
.meas tran tdvo_517 when v(divout)=1.65 rise=517
.meas tran tdvo_518 when v(divout)=1.65 rise=518
.meas tran tdvo_519 when v(divout)=1.65 rise=519
.meas tran tdvo_520 when v(divout)=1.65 rise=520
.meas tran tdvo_521 when v(divout)=1.65 rise=521
.meas tran tdvo_522 when v(divout)=1.65 rise=522
.meas tran tdvo_523 when v(divout)=1.65 rise=523
.meas tran tdvo_524 when v(divout)=1.65 rise=524
.meas tran tdvo_525 when v(divout)=1.65 rise=525
.meas tran tdvo_526 when v(divout)=1.65 rise=526
.meas tran tdvo_527 when v(divout)=1.65 rise=527
.meas tran tdvo_528 when v(divout)=1.65 rise=528
.meas tran tdvo_529 when v(divout)=1.65 rise=529
.meas tran tdvo_530 when v(divout)=1.65 rise=530
.meas tran tdvo_531 when v(divout)=1.65 rise=531
.meas tran tdvo_532 when v(divout)=1.65 rise=532
.meas tran tdvo_533 when v(divout)=1.65 rise=533
.meas tran tdvo_534 when v(divout)=1.65 rise=534
.meas tran tdvo_535 when v(divout)=1.65 rise=535
.meas tran tdvo_536 when v(divout)=1.65 rise=536
.end
