* generated by gen_requests.py (issue #324); variant=cscale10 bundle=slow
* res corner res_wcs comes from corners.process[].sections[] (cornerRES.lib)
.option scale=1
.global sub!
.include ../inputs/vco_cscale10.spice
.include ../inputs/vco_inst.spice
.param p_vctrl=0.3 p_b0v=0 p_b1v=0
Vvctrl vctrl 0 dc {p_vctrl}
Vb0 b0 0 dc {p_b0v}
Vb1 b1 0 dc {p_b1v}
Vdd vdd 0 dc 3.3
Vsub sub! 0 dc 0
Vsubs vsubs 0 dc 0
.ic v(ring1)=0.5
