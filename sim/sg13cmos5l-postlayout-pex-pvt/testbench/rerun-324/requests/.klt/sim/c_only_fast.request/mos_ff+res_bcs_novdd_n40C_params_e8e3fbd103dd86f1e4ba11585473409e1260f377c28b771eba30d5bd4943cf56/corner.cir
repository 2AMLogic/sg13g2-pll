* klt sim -- generated corner deck, do not edit
.lib /opt/pdk/ihp-sg13cmos5l/libs.tech/ngspice/models/cornerMOShv.lib mos_ff
.lib /opt/pdk/ihp-sg13cmos5l/libs.tech/ngspice/models/cornerRES.lib res_bcs
.include /var/tmp/eda-job-klt-sim-d9fceaabf5b0/inputs/netlist.cir
.temp -40
.meas tran per1 trig v(clk) val=1.65 rise=3 targ v(clk) val=1.65 rise=4
.control
pre_osdi /opt/pdk/ihp-sg13cmos5l/libs.tech/ngspice/osdi/psp103.osdi
pre_osdi /opt/pdk/ihp-sg13cmos5l/libs.tech/ngspice/osdi/psp103_nqs.osdi
pre_osdi /opt/pdk/ihp-sg13cmos5l/libs.tech/ngspice/osdi/mosvar.osdi
pre_osdi /opt/pdk/ihp-sg13cmos5l/libs.tech/ngspice/osdi/r3_cmc.osdi
alterparam p_b0v=3.3
alterparam p_b1v=3.3
alterparam p_vctrl=2.7
reset
save all
tran 20p 30n
quit
.endc
.end
