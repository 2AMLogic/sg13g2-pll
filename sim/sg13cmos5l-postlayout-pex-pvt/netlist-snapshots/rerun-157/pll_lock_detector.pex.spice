* extracted by klt extract --deck sg13cmos5l
* parasitic model (--parasitics):
* - capacitance: net-to-ground for every net's own (non-coupled) area/perimeter, plus net-to-net for the vertical-overlap coupling `coupling` describes below -- a coupled net pair gets a direct capacitor between their two hub nodes, not just capacitors to the deck's ground/substrate net
* - coupling: vertical overlap (crossover) unconditionally -- where one net's conductor on an adjacent metal level sits directly over another *distinct* net's conductor, that overlap area is charged between the two nets instead of to ground (issue #760) -- plus lateral (same-layer, sidewall) coupling, but only for a net pair naming one of the caller's declared `--critical-net` nets (issue #976): facing-edge length within that layer's own minimum-spacing lookback is charged between the two nets, *additively* (not deducted from either net's substrate fringe term, unlike the vertical case -- a known simplification). Any same-layer pair with neither side named `--critical-net`, and fringe shielding in general, are still not modelled
* - resistance: single lumped series resistance per net, distributed as a star across that net's device terminals (issue #592) -- not a per-segment, distributed RC ladder, *unless* `--distributed-rc` names this net via `--critical-net` (issue #977, Epic #709 Phase 2b): then the net's terminals are ordered along their approximate physical spread and its total R/C is broken into a chain of per-segment resistors (segment length proportional to inter-terminal distance) with a ground capacitor at each terminal node (proportional to its adjacent segment length/2), instead of one star hub -- still an approximation (terminal position is a device-placement proxy, not true per-segment routing geometry), but a strictly finer-grained one than the single-hub star
* - frequency: quasi-static -- one frequency-independent R and C per net; no skin effect, no distributed transmission-line behavior
* - substrate tie: 1e+12 ohm to ground -- the substrate is capacitively floating in transient analysis (DC reference only); see --substrate-tie-ohms
.GLOBAL vsubs

* cell pll_lock_detector
* pin DN
* pin ERR
* pin ERRD
* pin LOCK
* pin UP
* pin VDD
* pin VSS
* pin VWIN
* pin WIDE
* pin XDW_d1
* pin XDW_d2
* pin XDW_d3
* pin XNW_mid1
* pin XSCH_nn
* pin XSCH_np
* pin XXOR_XN1_mid1
* pin XXOR_XN2_mid1
* pin XXOR_XN3_mid1
* pin XXOR_XN4_mid1
* pin XXOR_n1
* pin XXOR_n2
* pin XXOR_n3
* pin nwide
.SUBCKT pll_lock_detector DN ERR ERRD LOCK UP VDD VSS VWIN WIDE XDW_d1 XDW_d2
+ XDW_d3 XNW_mid1 XSCH_nn XSCH_np XXOR_XN1_mid1 XXOR_XN2_mid1 XXOR_XN3_mid1
+ XXOR_XN4_mid1 XXOR_n1 XXOR_n2 XXOR_n3 nwide
* device instance $1 r0 *1 1.425,10.86 nfet
X$1 VWIN__t3 WIDE__t0 VSS__t1 VSS__t17 sg13_hv_nmos L=16U W=0.25U AS=0.115P
+ AD=0.115P PS=1.4U PD=1.4U
* device instance $2 r0 *1 11.15,3.11 nfet
X$2 XXOR_n1__t6 UP__t3 XXOR_XN1_mid1__t0 VSS__t18 sg13_hv_nmos L=0.5U W=2U
+ AS=0.8P AD=0.8P PS=4.8U PD=4.8U
* device instance $3 r0 *1 15.11,3.11 nfet
X$3 XXOR_XN1_mid1__t1 DN__t2 VSS__t8 VSS__t19 sg13_hv_nmos L=0.5U W=2U AS=0.8P
+ AD=0.8P PS=4.8U PD=4.8U
* device instance $4 r0 *1 19.07,3.11 nfet
X$4 XXOR_n2__t4 UP__t2 XXOR_XN2_mid1__t1 VSS__t20 sg13_hv_nmos L=0.5U W=2U
+ AS=0.8P AD=0.8P PS=4.8U PD=4.8U
* device instance $5 r0 *1 23.03,3.11 nfet
X$5 XXOR_XN2_mid1__t0 XXOR_n1__t4 VSS__t9 VSS__t21 sg13_hv_nmos L=0.5U W=2U
+ AS=0.8P AD=0.8P PS=4.8U PD=4.8U
* device instance $6 r0 *1 26.99,3.11 nfet
X$6 XXOR_n3__t4 DN__t3 XXOR_XN3_mid1__t1 VSS__t22 sg13_hv_nmos L=0.5U W=2U
+ AS=0.8P AD=0.8P PS=4.8U PD=4.8U
* device instance $7 r0 *1 30.95,3.11 nfet
X$7 XXOR_XN3_mid1__t0 XXOR_n1__t5 VSS__t10 VSS__t23 sg13_hv_nmos L=0.5U W=2U
+ AS=0.8P AD=0.8P PS=4.8U PD=4.8U
* device instance $8 r0 *1 34.91,3.11 nfet
X$8 ERR__t6 XXOR_n2__t3 XXOR_XN4_mid1__t1 VSS__t24 sg13_hv_nmos L=0.5U W=2U
+ AS=0.8P AD=0.8P PS=4.8U PD=4.8U
* device instance $9 r0 *1 38.87,3.11 nfet
X$9 XXOR_XN4_mid1__t0 XXOR_n3__t3 VSS__t7 VSS__t25 sg13_hv_nmos L=0.5U W=2U
+ AS=0.8P AD=0.8P PS=4.8U PD=4.8U
* device instance $10 r0 *1 42.83,3.11 nfet
X$10 XDW_d1__t3 ERR__t4 VSS__t11 VSS__t26 sg13_hv_nmos L=0.5U W=2U AS=0.8P
+ AD=0.8P PS=4.8U PD=4.8U
* device instance $11 r0 *1 46.79,3.11 nfet
X$11 XDW_d2__t3 XDW_d1__t2 VSS__t12 VSS__t27 sg13_hv_nmos L=0.5U W=2U AS=0.8P
+ AD=0.8P PS=4.8U PD=4.8U
* device instance $12 r0 *1 50.75,3.11 nfet
X$12 XDW_d3__t3 XDW_d2__t2 VSS__t13 VSS__t28 sg13_hv_nmos L=0.5U W=2U AS=0.8P
+ AD=0.8P PS=4.8U PD=4.8U
* device instance $13 r0 *1 54.71,3.11 nfet
X$13 ERRD__t5 XDW_d3__t2 VSS__t14 VSS__t29 sg13_hv_nmos L=0.5U W=2U AS=0.8P
+ AD=0.8P PS=4.8U PD=4.8U
* device instance $14 r0 *1 58.67,3.11 nfet
X$14 nwide__t4 ERR__t5 XNW_mid1__t1 VSS__t30 sg13_hv_nmos L=0.5U W=2U AS=0.8P
+ AD=0.8P PS=4.8U PD=4.8U
* device instance $15 r0 *1 62.63,3.11 nfet
X$15 XNW_mid1__t0 ERRD__t0 VSS__t15 VSS__t31 sg13_hv_nmos L=0.5U W=2U AS=0.8P
+ AD=0.8P PS=4.8U PD=4.8U
* device instance $16 r0 *1 66.59,3.11 nfet
X$16 WIDE__t2 nwide__t3 VSS__t16 VSS__t32 sg13_hv_nmos L=0.5U W=2U AS=0.8P
+ AD=0.8P PS=4.8U PD=4.8U
* device instance $17 r0 *1 77.19,3.86 nfet
X$17 LOCK__t3 VWIN__t1 XSCH_nn__t1 VSS__t33 sg13_hv_nmos L=2U W=2U AS=0.8P
+ AD=0.8P PS=4.8U PD=4.8U
* device instance $18 r0 *1 81.15,3.86 nfet
X$18 XSCH_nn__t0 VWIN__t6 VSS__t2 VSS__t34 sg13_hv_nmos L=2U W=2U AS=0.8P
+ AD=0.8P PS=4.8U PD=4.8U
* device instance $19 r0 *1 85.11,3.86 nfet
X$19 VDD__t35 LOCK__t1 XSCH_nn__t2 VSS__t35 sg13_hv_nmos L=2U W=2U AS=0.8P
+ AD=0.8P PS=4.8U PD=4.8U
* device instance $20 r0 *1 97.21,3.11 pfet
X$20 XXOR_n1__t2 UP__t0 VDD__t2 VDD__t1 sg13_hv_pmos L=0.5U W=5U AS=2P AD=2P
+ PS=10.8U PD=10.8U
* device instance $21 r0 *1 104.17,3.11 pfet
X$21 XXOR_n1__t3 DN__t1 VDD__t19 VDD__t33 sg13_hv_pmos L=0.5U W=5U AS=2P AD=2P
+ PS=10.8U PD=10.8U
* device instance $22 r0 *1 111.13,3.11 pfet
X$22 XXOR_n2__t1 UP__t1 VDD__t7 VDD__t21 sg13_hv_pmos L=0.5U W=5U AS=2P AD=2P
+ PS=10.8U PD=10.8U
* device instance $23 r0 *1 118.09,3.11 pfet
X$23 XXOR_n2__t2 XXOR_n1__t0 VDD__t8 VDD__t22 sg13_hv_pmos L=0.5U W=5U AS=2P
+ AD=2P PS=10.8U PD=10.8U
* device instance $24 r0 *1 125.05,3.11 pfet
X$24 XXOR_n3__t1 DN__t0 VDD__t9 VDD__t23 sg13_hv_pmos L=0.5U W=5U AS=2P AD=2P
+ PS=10.8U PD=10.8U
* device instance $25 r0 *1 132.01,3.11 pfet
X$25 XXOR_n3__t2 XXOR_n1__t1 VDD__t10 VDD__t24 sg13_hv_pmos L=0.5U W=5U AS=2P
+ AD=2P PS=10.8U PD=10.8U
* device instance $26 r0 *1 138.97,3.11 pfet
X$26 ERR__t2 XXOR_n2__t0 VDD__t11 VDD__t25 sg13_hv_pmos L=0.5U W=5U AS=2P AD=2P
+ PS=10.8U PD=10.8U
* device instance $27 r0 *1 145.93,3.11 pfet
X$27 ERR__t3 XXOR_n3__t0 VDD__t12 VDD__t26 sg13_hv_pmos L=0.5U W=5U AS=2P AD=2P
+ PS=10.8U PD=10.8U
* device instance $28 r0 *1 152.89,3.11 pfet
X$28 XDW_d1__t1 ERR__t0 VDD__t13 VDD__t27 sg13_hv_pmos L=0.5U W=5U AS=2P AD=2P
+ PS=10.8U PD=10.8U
* device instance $29 r0 *1 159.85,3.11 pfet
X$29 XDW_d2__t1 XDW_d1__t0 VDD__t14 VDD__t28 sg13_hv_pmos L=0.5U W=5U AS=2P
+ AD=2P PS=10.8U PD=10.8U
* device instance $30 r0 *1 166.81,3.11 pfet
X$30 XDW_d3__t1 XDW_d2__t0 VDD__t15 VDD__t29 sg13_hv_pmos L=0.5U W=5U AS=2P
+ AD=2P PS=10.8U PD=10.8U
* device instance $31 r0 *1 173.77,3.11 pfet
X$31 ERRD__t1 XDW_d3__t0 VDD__t16 VDD__t30 sg13_hv_pmos L=0.5U W=5U AS=2P AD=2P
+ PS=10.8U PD=10.8U
* device instance $32 r0 *1 180.73,3.11 pfet
X$32 nwide__t1 ERR__t1 VDD__t17 VDD__t31 sg13_hv_pmos L=0.5U W=5U AS=2P AD=2P
+ PS=10.8U PD=10.8U
* device instance $33 r0 *1 187.69,3.11 pfet
X$33 nwide__t2 ERRD__t2 VDD__t18 VDD__t32 sg13_hv_pmos L=0.5U W=5U AS=2P AD=2P
+ PS=10.8U PD=10.8U
* device instance $34 r0 *1 194.65,3.11 pfet
X$34 WIDE__t1 nwide__t0 VDD__t20 VDD__t34 sg13_hv_pmos L=0.5U W=5U AS=2P AD=2P
+ PS=10.8U PD=10.8U
* device instance $35 r0 *1 208.25,3.86 pfet
X$35 XSCH_np__t0 VWIN__t2 VDD__t4 VDD__t3 sg13_hv_pmos L=2U W=5U AS=2P AD=2P
+ PS=10.8U PD=10.8U
* device instance $36 r0 *1 215.21,3.86 pfet
X$36 LOCK__t2 VWIN__t5 XSCH_np__t2 VDD__t6 sg13_hv_pmos L=2U W=5U AS=2P AD=2P
+ PS=10.8U PD=10.8U
* device instance $37 r0 *1 222.17,3.86 pfet
X$37 VSS__t6 LOCK__t0 XSCH_np__t1 VDD__t5 sg13_hv_pmos L=2U W=5U AS=2P AD=2P
+ PS=10.8U PD=10.8U
* device instance $38 r0 *1 938.97,0 cap_cmomi
X$38 VWIN__t4 VSS__t3 cap_cmomi W=40U L=40U MMIN=1 MMAX=4 FEED=double
* device instance $39 r0 *1 984.97,0 cap_cmomi
X$39 ERRD__t3 VSS__t5 cap_cmomi W=40U L=40U MMIN=1 MMAX=4 FEED=double
* device instance $40 r0 *1 1030.97,0 cap_cmomi
X$40 ERRD__t4 VSS__t4 cap_cmomi W=40U L=40U MMIN=1 MMAX=4 FEED=double
* device instance $41 r0 *1 582.47,0.45 rhigh
X$41 VDD__t0 VWIN__t0 VSS__t0 rhigh r=2069885.21739 L=700U W=0.5U
* device instance DN_t0 r0 *1 0,0
RDN_t0 DN__t0 DN 23.9497135528
* device instance DN_t1 r0 *1 0,0
RDN_t1 DN__t1 DN 15.2102864472
* device instance DN_t2 r0 *1 0,0
RDN_t2 DN__t2 DN 22.0662163318
* device instance DN_t3 r0 *1 0,0
RDN_t3 DN__t3 DN 17.0937836682
* device instance DN r0 *1 0,0
CDN DN vsubs 1.9367919e-14
* device instance ERR_t0 r0 *1 0,0
RERR_t0 ERR__t0 ERR 15.4950770887
* device instance ERR_t1 r0 *1 0,0
RERR_t1 ERR__t1 ERR 25.0722436698
* device instance ERR_t2 r0 *1 0,0
RERR_t2 ERR__t2 ERR 10.7064937981
* device instance ERR_t3 r0 *1 0,0
RERR_t3 ERR__t3 ERR 13.1007854434
* device instance ERR_t4 r0 *1 0,0
RERR_t4 ERR__t4 ERR 22.3663795896
* device instance ERR_t5 r0 *1 0,0
RERR_t5 ERR__t5 ERR 16.917302052
* device instance ERR_t6 r0 *1 0,0
RERR_t6 ERR__t6 ERR 25.0909183584
* device instance ERR r0 *1 0,0
CERR ERR vsubs 3.1968322e-14
* device instance ERRD_t0 r0 *1 0,0
RERRD_t0 ERRD__t0 ERRD 996.869522207
* device instance ERRD_t1 r0 *1 0,0
RERRD_t1 ERRD__t1 ERRD 683.15646052
* device instance ERRD_t2 r0 *1 0,0
RERRD_t2 ERRD__t2 ERRD 643.864839438
* device instance ERRD_t3 r0 *1 0,0
RERRD_t3 ERRD__t3 ERRD 1606.63584361
* device instance ERRD_t4 r0 *1 0,0
RERRD_t4 ERRD__t4 ERRD 1736.47931111
* device instance ERRD_t5 r0 *1 0,0
RERRD_t5 ERRD__t5 ERRD 1019.22522312
* device instance ERRD r0 *1 0,0
CERRD ERRD vsubs 1.13688085e-12
* device instance LOCK_t0 r0 *1 0,0
RLOCK_t0 LOCK__t0 LOCK 24.0043717282
* device instance LOCK_t1 r0 *1 0,0
RLOCK_t1 LOCK__t1 LOCK 21.532502861
* device instance LOCK_t2 r0 *1 0,0
RLOCK_t2 LOCK__t2 LOCK 21.6919782718
* device instance LOCK_t3 r0 *1 0,0
RLOCK_t3 LOCK__t3 LOCK 24.163847139
* device instance LOCK r0 *1 0,0
CLOCK LOCK vsubs 2.218896e-14
* device instance UP_t0 r0 *1 0,0
RUP_t0 UP__t0 UP 16.4973894453
* device instance UP_t1 r0 *1 0,0
RUP_t1 UP__t1 UP 22.6098105547
* device instance UP_t2 r0 *1 0,0
RUP_t2 UP__t2 UP 17.814721581
* device instance UP_t3 r0 *1 0,0
RUP_t3 UP__t3 UP 21.292478419
* device instance UP r0 *1 0,0
CUP UP vsubs 1.9455427e-14
* device instance VDD_t0 r0 *1 0,0
RVDD_t0 VDD__t0 VDD 95.0628662072
* device instance VDD_t1 r0 *1 0,0
RVDD_t1 VDD__t1 VDD 15.1382773324
* device instance VDD_t2 r0 *1 0,0
RVDD_t2 VDD__t2 VDD 15.1382773324
* device instance VDD_t3 r0 *1 0,0
RVDD_t3 VDD__t3 VDD 10.0794629736
* device instance VDD_t4 r0 *1 0,0
RVDD_t4 VDD__t4 VDD 10.0794629736
* device instance VDD_t5 r0 *1 0,0
RVDD_t5 VDD__t5 VDD 13.2402819804
* device instance VDD_t6 r0 *1 0,0
RVDD_t6 VDD__t6 VDD 11.6598510329
* device instance VDD_t7 r0 *1 0,0
RVDD_t7 VDD__t7 VDD 11.9771423356
* device instance VDD_t8 r0 *1 0,0
RVDD_t8 VDD__t8 VDD 10.3965749312
* device instance VDD_t9 r0 *1 0,0
RVDD_t9 VDD__t9 VDD 8.81600763441
* device instance VDD_t10 r0 *1 0,0
RVDD_t10 VDD__t10 VDD 7.23544051569
* device instance VDD_t11 r0 *1 0,0
RVDD_t11 VDD__t11 VDD 5.6548737244
* device instance VDD_t12 r0 *1 0,0
RVDD_t12 VDD__t12 VDD 4.07430764162
* device instance VDD_t13 r0 *1 0,0
RVDD_t13 VDD__t13 VDD 2.4937436145
* device instance VDD_t14 r0 *1 0,0
RVDD_t14 VDD__t14 VDD 0.913192317062
* device instance VDD_t15 r0 *1 0,0
RVDD_t15 VDD__t15 VDD 0.667436691928
* device instance VDD_t16 r0 *1 0,0
RVDD_t16 VDD__t16 VDD 2.24797949373
* device instance VDD_t17 r0 *1 0,0
RVDD_t17 VDD__t17 VDD 3.82854285695
* device instance VDD_t18 r0 *1 0,0
RVDD_t18 VDD__t18 VDD 5.40910875722
* device instance VDD_t19 r0 *1 0,0
RVDD_t19 VDD__t19 VDD 13.55770981
* device instance VDD_t20 r0 *1 0,0
RVDD_t20 VDD__t20 VDD 6.98967547345
* device instance VDD_t21 r0 *1 0,0
RVDD_t21 VDD__t21 VDD 11.9771423356
* device instance VDD_t22 r0 *1 0,0
RVDD_t22 VDD__t22 VDD 10.3965749312
* device instance VDD_t23 r0 *1 0,0
RVDD_t23 VDD__t23 VDD 8.81600763441
* device instance VDD_t24 r0 *1 0,0
RVDD_t24 VDD__t24 VDD 7.23544051569
* device instance VDD_t25 r0 *1 0,0
RVDD_t25 VDD__t25 VDD 5.6548737244
* device instance VDD_t26 r0 *1 0,0
RVDD_t26 VDD__t26 VDD 4.07430764162
* device instance VDD_t27 r0 *1 0,0
RVDD_t27 VDD__t27 VDD 2.4937436145
* device instance VDD_t28 r0 *1 0,0
RVDD_t28 VDD__t28 VDD 0.913192317062
* device instance VDD_t29 r0 *1 0,0
RVDD_t29 VDD__t29 VDD 0.667436691928
* device instance VDD_t30 r0 *1 0,0
RVDD_t30 VDD__t30 VDD 2.24797949373
* device instance VDD_t31 r0 *1 0,0
RVDD_t31 VDD__t31 VDD 3.82854285695
* device instance VDD_t32 r0 *1 0,0
RVDD_t32 VDD__t32 VDD 5.40910875722
* device instance VDD_t33 r0 *1 0,0
RVDD_t33 VDD__t33 VDD 13.55770981
* device instance VDD_t34 r0 *1 0,0
RVDD_t34 VDD__t34 VDD 6.98967547345
* device instance VDD_t35 r0 *1 0,0
RVDD_t35 VDD__t35 VDD 17.8868485718
* device instance VDD r0 *1 0,0
CVDD VDD vsubs 9.5082763e-14
* device instance VSS_t0 r0 *1 0,0
RVSS_t0 VSS__t0 VSS 712.681161153
* device instance VSS_t1 r0 *1 0,0
RVSS_t1 VSS__t1 VSS 227.199723183
* device instance VSS_t2 r0 *1 0,0
RVSS_t2 VSS__t2 VSS 97.9619701432
* device instance VSS_t3 r0 *1 0,0
RVSS_t3 VSS__t3 VSS 1289.13040578
* device instance VSS_t4 r0 *1 0,0
RVSS_t4 VSS__t4 VSS 1437.89135699
* device instance VSS_t5 r0 *1 0,0
RVSS_t5 VSS__t5 VSS 1363.51085
* device instance VSS_t6 r0 *1 0,0
RVSS_t6 VSS__t6 VSS 130.071494862
* device instance VSS_t7 r0 *1 0,0
RVSS_t7 VSS__t7 VSS 166.324164946
* device instance VSS_t8 r0 *1 0,0
RVSS_t8 VSS__t8 VSS 204.743534748
* device instance VSS_t9 r0 *1 0,0
RVSS_t9 VSS__t9 VSS 191.937075479
* device instance VSS_t10 r0 *1 0,0
RVSS_t10 VSS__t10 VSS 179.130618688
* device instance VSS_t11 r0 *1 0,0
RVSS_t11 VSS__t11 VSS 159.920939448
* device instance VSS_t12 r0 *1 0,0
RVSS_t12 VSS__t12 VSS 153.517715017
* device instance VSS_t13 r0 *1 0,0
RVSS_t13 VSS__t13 VSS 147.114491794
* device instance VSS_t14 r0 *1 0,0
RVSS_t14 VSS__t14 VSS 140.711269942
* device instance VSS_t15 r0 *1 0,0
RVSS_t15 VSS__t15 VSS 127.904831179
* device instance VSS_t16 r0 *1 0,0
RVSS_t16 VSS__t16 VSS 121.501614788
* device instance VSS_t17 r0 *1 0,0
RVSS_t17 VSS__t17 VSS 227.199723183
* device instance VSS_t18 r0 *1 0,0
RVSS_t18 VSS__t18 VSS 211.14676517
* device instance VSS_t19 r0 *1 0,0
RVSS_t19 VSS__t19 VSS 204.743534748
* device instance VSS_t20 r0 *1 0,0
RVSS_t20 VSS__t20 VSS 198.340304834
* device instance VSS_t21 r0 *1 0,0
RVSS_t21 VSS__t21 VSS 191.937075479
* device instance VSS_t22 r0 *1 0,0
RVSS_t22 VSS__t22 VSS 185.533846741
* device instance VSS_t23 r0 *1 0,0
RVSS_t23 VSS__t23 VSS 179.130618688
* device instance VSS_t24 r0 *1 0,0
RVSS_t24 VSS__t24 VSS 172.727391393
* device instance VSS_t25 r0 *1 0,0
RVSS_t25 VSS__t25 VSS 166.324164946
* device instance VSS_t26 r0 *1 0,0
RVSS_t26 VSS__t26 VSS 159.920939448
* device instance VSS_t27 r0 *1 0,0
RVSS_t27 VSS__t27 VSS 153.517715017
* device instance VSS_t28 r0 *1 0,0
RVSS_t28 VSS__t28 VSS 147.114491794
* device instance VSS_t29 r0 *1 0,0
RVSS_t29 VSS__t29 VSS 140.711269942
* device instance VSS_t30 r0 *1 0,0
RVSS_t30 VSS__t30 VSS 134.308049659
* device instance VSS_t31 r0 *1 0,0
RVSS_t31 VSS__t31 VSS 127.904831179
* device instance VSS_t32 r0 *1 0,0
RVSS_t32 VSS__t32 VSS 121.501614788
* device instance VSS_t33 r0 *1 0,0
RVSS_t33 VSS__t33 VSS 104.364962254
* device instance VSS_t34 r0 *1 0,0
RVSS_t34 VSS__t34 VSS 97.9619701432
* device instance VSS_t35 r0 *1 0,0
RVSS_t35 VSS__t35 VSS 91.5590124658
* device instance VSS r0 *1 0,0
CVSS VSS vsubs 1.690809417e-12
* device instance VWIN_t0 r0 *1 0,0
RVWIN_t0 VWIN__t0 VWIN 539.515167084
* device instance VWIN_t1 r0 *1 0,0
RVWIN_t1 VWIN__t1 VWIN 427.816781069
* device instance VWIN_t2 r0 *1 0,0
RVWIN_t2 VWIN__t2 VWIN 176.91933819
* device instance VWIN_t3 r0 *1 0,0
RVWIN_t3 VWIN__t3 VWIN 573.017533712
* device instance VWIN_t4 r0 *1 0,0
RVWIN_t4 VWIN__t4 VWIN 1221.97168969
* device instance VWIN_t5 r0 *1 0,0
RVWIN_t5 VWIN__t5 VWIN 163.595317888
* device instance VWIN_t6 r0 *1 0,0
RVWIN_t6 VWIN__t6 VWIN 420.235872366
* device instance VWIN r0 *1 0,0
CVWIN VWIN vsubs 6.10487701e-13
* device instance WIDE_t0 r0 *1 0,0
RWIDE_t0 WIDE__t0 WIDE 38.493769284
* device instance WIDE_t1 r0 *1 0,0
RWIDE_t1 WIDE__t1 WIDE 47.791594012
* device instance WIDE_t2 r0 *1 0,0
RWIDE_t2 WIDE__t2 WIDE 9.42373670398
* device instance WIDE r0 *1 0,0
CWIDE WIDE vsubs 2.266444e-14
* device instance XDW_d1_t0 r0 *1 0,0
RXDW_d1_t0 XDW_d1__t0 XDW_d1 23.5677753048
* device instance XDW_d1_t1 r0 *1 0,0
RXDW_d1_t1 XDW_d1__t1 XDW_d1 20.7997746952
* device instance XDW_d1_t2 r0 *1 0,0
RXDW_d1_t2 XDW_d1__t2 XDW_d1 21.3963265507
* device instance XDW_d1_t3 r0 *1 0,0
RXDW_d1_t3 XDW_d1__t3 XDW_d1 22.9712234493
* device instance XDW_d1 r0 *1 0,0
CXDW_d1 XDW_d1 vsubs 2.1821281e-14
* device instance XDW_d2_t0 r0 *1 0,0
RXDW_d2_t0 XDW_d2__t0 XDW_d2 23.9515909392
* device instance XDW_d2_t1 r0 *1 0,0
RXDW_d2_t1 XDW_d2__t1 XDW_d2 21.2079590608
* device instance XDW_d2_t2 r0 *1 0,0
RXDW_d2_t2 XDW_d2__t2 XDW_d2 21.7992590346
* device instance XDW_d2_t3 r0 *1 0,0
RXDW_d2_t3 XDW_d2__t3 XDW_d2 23.3602909654
* device instance XDW_d2 r0 *1 0,0
CXDW_d2 XDW_d2 vsubs 2.2198586e-14
* device instance XDW_d3_t0 r0 *1 0,0
RXDW_d3_t0 XDW_d3__t0 XDW_d3 24.3360284365
* device instance XDW_d3_t1 r0 *1 0,0
RXDW_d3_t1 XDW_d3__t1 XDW_d3 21.6155215635
* device instance XDW_d3_t2 r0 *1 0,0
RXDW_d3_t2 XDW_d3__t2 XDW_d3 22.2018376999
* device instance XDW_d3_t3 r0 *1 0,0
RXDW_d3_t3 XDW_d3__t3 XDW_d3 23.7497123001
* device instance XDW_d3 r0 *1 0,0
CXDW_d3 XDW_d3 vsubs 2.257589e-14
* device instance XNW_mid1_t0 r0 *1 0,0
RXNW_mid1_t0 XNW_mid1__t0 XNW_mid1 15.1667
* device instance XNW_mid1_t1 r0 *1 0,0
RXNW_mid1_t1 XNW_mid1__t1 XNW_mid1 15.1667
* device instance XNW_mid1 r0 *1 0,0
CXNW_mid1 XNW_mid1 vsubs 7.832774e-15
* device instance XSCH_nn_t0 r0 *1 0,0
RXSCH_nn_t0 XSCH_nn__t0 XSCH_nn 0.001
* device instance XSCH_nn_t1 r0 *1 0,0
RXSCH_nn_t1 XSCH_nn__t1 XSCH_nn 23.0067
* device instance XSCH_nn_t2 r0 *1 0,0
RXSCH_nn_t2 XSCH_nn__t2 XSCH_nn 23.0067
* device instance XSCH_nn r0 *1 0,0
CXSCH_nn XSCH_nn vsubs 1.1862094e-14
* device instance XSCH_np_t0 r0 *1 0,0
RXSCH_np_t0 XSCH_np__t0 XSCH_np 25.96655
* device instance XSCH_np_t1 r0 *1 0,0
RXSCH_np_t1 XSCH_np__t1 XSCH_np 25.96655
* device instance XSCH_np_t2 r0 *1 0,0
RXSCH_np_t2 XSCH_np__t2 XSCH_np 0.001
* device instance XSCH_np r0 *1 0,0
CXSCH_np XSCH_np vsubs 1.3172552e-14
* device instance XXOR_XN1_mid1_t0 r0 *1 0,0
RXXOR_XN1_mid1_t0 XXOR_XN1_mid1__t0 XXOR_XN1_mid1 15.6947
* device instance XXOR_XN1_mid1_t1 r0 *1 0,0
RXXOR_XN1_mid1_t1 XXOR_XN1_mid1__t1 XXOR_XN1_mid1 15.6947
* device instance XXOR_XN1_mid1 r0 *1 0,0
CXXOR_XN1_mid1 XXOR_XN1_mid1 vsubs 8.126295e-15
* device instance XXOR_XN2_mid1_t0 r0 *1 0,0
RXXOR_XN2_mid1_t0 XXOR_XN2_mid1__t0 XXOR_XN2_mid1 15.8707
* device instance XXOR_XN2_mid1_t1 r0 *1 0,0
RXXOR_XN2_mid1_t1 XXOR_XN2_mid1__t1 XXOR_XN2_mid1 15.8707
* device instance XXOR_XN2_mid1 r0 *1 0,0
CXXOR_XN2_mid1 XXOR_XN2_mid1 vsubs 8.21542e-15
* device instance XXOR_XN3_mid1_t0 r0 *1 0,0
RXXOR_XN3_mid1_t0 XXOR_XN3_mid1__t0 XXOR_XN3_mid1 16.0467
* device instance XXOR_XN3_mid1_t1 r0 *1 0,0
RXXOR_XN3_mid1_t1 XXOR_XN3_mid1__t1 XXOR_XN3_mid1 16.0467
* device instance XXOR_XN3_mid1 r0 *1 0,0
CXXOR_XN3_mid1 XXOR_XN3_mid1 vsubs 8.307261e-15
* device instance XXOR_XN4_mid1_t0 r0 *1 0,0
RXXOR_XN4_mid1_t0 XXOR_XN4_mid1__t0 XXOR_XN4_mid1 16.2227
* device instance XXOR_XN4_mid1_t1 r0 *1 0,0
RXXOR_XN4_mid1_t1 XXOR_XN4_mid1__t1 XXOR_XN4_mid1 16.2227
* device instance XXOR_XN4_mid1 r0 *1 0,0
CXXOR_XN4_mid1 XXOR_XN4_mid1 vsubs 8.398545e-15
* device instance XXOR_n1_t0 r0 *1 0,0
RXXOR_n1_t0 XXOR_n1__t0 XXOR_n1 20.3488317573
* device instance XXOR_n1_t1 r0 *1 0,0
RXXOR_n1_t1 XXOR_n1__t1 XXOR_n1 26.7445164436
* device instance XXOR_n1_t2 r0 *1 0,0
RXXOR_n1_t2 XXOR_n1__t2 XXOR_n1 10.755304728
* device instance XXOR_n1_t3 r0 *1 0,0
RXXOR_n1_t3 XXOR_n1__t3 XXOR_n1 13.9531470711
* device instance XXOR_n1_t4 r0 *1 0,0
RXXOR_n1_t4 XXOR_n1__t4 XXOR_n1 23.3274459924
* device instance XXOR_n1_t5 r0 *1 0,0
RXXOR_n1_t5 XXOR_n1__t5 XXOR_n1 19.6885219468
* device instance XXOR_n1_t6 r0 *1 0,0
RXXOR_n1_t6 XXOR_n1__t6 XXOR_n1 28.7858320608
* device instance XXOR_n1 r0 *1 0,0
CXXOR_n1 XXOR_n1 vsubs 3.6096918e-14
* device instance XXOR_n2_t0 r0 *1 0,0
RXXOR_n2_t0 XXOR_n2__t0 XXOR_n2 27.1290349732
* device instance XXOR_n2_t1 r0 *1 0,0
RXXOR_n2_t1 XXOR_n2__t1 XXOR_n2 13.2799750191
* device instance XXOR_n2_t2 r0 *1 0,0
RXXOR_n2_t2 XXOR_n2__t2 XXOR_n2 16.7422400077
* device instance XXOR_n2_t3 r0 *1 0,0
RXXOR_n2_t3 XXOR_n2__t3 XXOR_n2 24.63580622
* device instance XXOR_n2_t4 r0 *1 0,0
RXXOR_n2_t4 XXOR_n2__t4 XXOR_n2 32.51544378
* device instance XXOR_n2 r0 *1 0,0
CXXOR_n2 XXOR_n2 vsubs 2.8368061e-14
* device instance XXOR_n3_t0 r0 *1 0,0
RXXOR_n3_t0 XXOR_n3__t0 XXOR_n3 24.627017357
* device instance XXOR_n3_t1 r0 *1 0,0
RXXOR_n3_t1 XXOR_n3__t1 XXOR_n3 14.7686561144
* device instance XXOR_n3_t2 r0 *1 0,0
RXXOR_n3_t2 XXOR_n3__t2 XXOR_n3 18.0547765286
* device instance XXOR_n3_t3 r0 *1 0,0
RXXOR_n3_t3 XXOR_n3__t3 XXOR_n3 25.9206911982
* device instance XXOR_n3_t4 r0 *1 0,0
RXXOR_n3_t4 XXOR_n3__t4 XXOR_n3 31.5297588018
* device instance XXOR_n3 r0 *1 0,0
CXXOR_n3 XXOR_n3 vsubs 2.8534757e-14
* device instance nwide_t0 r0 *1 0,0
Rnwide_t0 nwide__t0 nwide 22.9306187403
* device instance nwide_t1 r0 *1 0,0
Rnwide_t1 nwide__t1 nwide 17.3291479263
* device instance nwide_t2 r0 *1 0,0
Rnwide_t2 nwide__t2 nwide 20.1298833333
* device instance nwide_t3 r0 *1 0,0
Rnwide_t3 nwide__t3 nwide 28.6013031305
* device instance nwide_t4 r0 *1 0,0
Rnwide_t4 nwide__t4 nwide 31.7883468695
* device instance nwide r0 *1 0,0
Cnwide nwide vsubs 2.9880803e-14
* device instance cc_DN_ERR r0 *1 0,0
Ccc_DN_ERR DN ERR 1.8151e-17
* device instance cc_DN_ERRD r0 *1 0,0
Ccc_DN_ERRD DN ERRD 1.21e-17
* device instance cc_DN_LOCK r0 *1 0,0
Ccc_DN_LOCK DN LOCK 1.21e-17
* device instance cc_DN_UP r0 *1 0,0
Ccc_DN_UP DN UP 1.8151e-17
* device instance cc_DN_VDD r0 *1 0,0
Ccc_DN_VDD DN VDD 3.6302e-17
* device instance cc_DN_VSS r0 *1 0,0
Ccc_DN_VSS DN VSS 7.2603e-17
* device instance cc_DN_VWIN r0 *1 0,0
Ccc_DN_VWIN DN VWIN 1.21e-17
* device instance cc_DN_WIDE r0 *1 0,0
Ccc_DN_WIDE DN WIDE 6.05e-18
* device instance cc_DN_XDW_d1 r0 *1 0,0
Ccc_DN_XDW_d1 DN XDW_d1 1.21e-17
* device instance cc_DN_XDW_d2 r0 *1 0,0
Ccc_DN_XDW_d2 DN XDW_d2 1.21e-17
* device instance cc_DN_XDW_d3 r0 *1 0,0
Ccc_DN_XDW_d3 DN XDW_d3 1.21e-17
* device instance cc_DN_XNW_mid1 r0 *1 0,0
Ccc_DN_XNW_mid1 DN XNW_mid1 1.21e-17
* device instance cc_DN_XSCH_nn r0 *1 0,0
Ccc_DN_XSCH_nn DN XSCH_nn 1.8151e-17
* device instance cc_DN_XXOR_XN1_mid1 r0 *1 0,0
Ccc_DN_XXOR_XN1_mid1 DN XXOR_XN1_mid1 6.05e-18
* device instance cc_DN_XXOR_XN2_mid1 r0 *1 0,0
Ccc_DN_XXOR_XN2_mid1 DN XXOR_XN2_mid1 1.21e-17
* device instance cc_DN_XXOR_XN3_mid1 r0 *1 0,0
Ccc_DN_XXOR_XN3_mid1 DN XXOR_XN3_mid1 1.21e-17
* device instance cc_DN_XXOR_XN4_mid1 r0 *1 0,0
Ccc_DN_XXOR_XN4_mid1 DN XXOR_XN4_mid1 1.21e-17
* device instance cc_DN_XXOR_n1 r0 *1 0,0
Ccc_DN_XXOR_n1 DN XXOR_n1 3.0251e-17
* device instance cc_DN_XXOR_n2 r0 *1 0,0
Ccc_DN_XXOR_n2 DN XXOR_n2 2.4201e-17
* device instance cc_DN_XXOR_n3 r0 *1 0,0
Ccc_DN_XXOR_n3 DN XXOR_n3 1.21e-17
* device instance cc_DN_nwide r0 *1 0,0
Ccc_DN_nwide DN nwide 1.21e-17
* device instance cc_ERR_ERRD r0 *1 0,0
Ccc_ERR_ERRD ERR ERRD 1.8151e-17
* device instance cc_ERR_LOCK r0 *1 0,0
Ccc_ERR_LOCK ERR LOCK 1.21e-17
* device instance cc_ERR_UP r0 *1 0,0
Ccc_ERR_UP ERR UP 1.21e-17
* device instance cc_ERR_VDD r0 *1 0,0
Ccc_ERR_VDD ERR VDD 9.5191e-17
* device instance cc_ERR_VSS r0 *1 0,0
Ccc_ERR_VSS ERR VSS 5.4452e-17
* device instance cc_ERR_VWIN r0 *1 0,0
Ccc_ERR_VWIN ERR VWIN 1.21e-17
* device instance cc_ERR_WIDE r0 *1 0,0
Ccc_ERR_WIDE ERR WIDE 6.05e-18
* device instance cc_ERR_XDW_d1 r0 *1 0,0
Ccc_ERR_XDW_d1 ERR XDW_d1 2.4201e-17
* device instance cc_ERR_XDW_d2 r0 *1 0,0
Ccc_ERR_XDW_d2 ERR XDW_d2 2.4201e-17
* device instance cc_ERR_XDW_d3 r0 *1 0,0
Ccc_ERR_XDW_d3 ERR XDW_d3 2.4201e-17
* device instance cc_ERR_XNW_mid1 r0 *1 0,0
Ccc_ERR_XNW_mid1 ERR XNW_mid1 1.21e-17
* device instance cc_ERR_XSCH_nn r0 *1 0,0
Ccc_ERR_XSCH_nn ERR XSCH_nn 1.8151e-17
* device instance cc_ERR_XXOR_XN4_mid1 r0 *1 0,0
Ccc_ERR_XXOR_XN4_mid1 ERR XXOR_XN4_mid1 1.1294e-17
* device instance cc_ERR_XXOR_n1 r0 *1 0,0
Ccc_ERR_XXOR_n1 ERR XXOR_n1 2.4201e-17
* device instance cc_ERR_XXOR_n2 r0 *1 0,0
Ccc_ERR_XXOR_n2 ERR XXOR_n2 1.8151e-17
* device instance cc_ERR_XXOR_n3 r0 *1 0,0
Ccc_ERR_XXOR_n3 ERR XXOR_n3 2.4201e-17
* device instance cc_ERR_nwide r0 *1 0,0
Ccc_ERR_nwide ERR nwide 1.21e-17
* device instance cc_ERRD_LOCK r0 *1 0,0
Ccc_ERRD_LOCK ERRD LOCK 2.4201e-17
* device instance cc_ERRD_UP r0 *1 0,0
Ccc_ERRD_UP ERRD UP 1.21e-17
* device instance cc_ERRD_VDD r0 *1 0,0
Ccc_ERRD_VDD ERRD VDD 1.26249e-16
* device instance cc_ERRD_VSS r0 *1 0,0
Ccc_ERRD_VSS ERRD VSS 4.7595e-17
* device instance cc_ERRD_VWIN r0 *1 0,0
Ccc_ERRD_VWIN ERRD VWIN 3.6302e-17
* device instance cc_ERRD_WIDE r0 *1 0,0
Ccc_ERRD_WIDE ERRD WIDE 1.21e-17
* device instance cc_ERRD_XDW_d1 r0 *1 0,0
Ccc_ERRD_XDW_d1 ERRD XDW_d1 1.21e-17
* device instance cc_ERRD_XDW_d2 r0 *1 0,0
Ccc_ERRD_XDW_d2 ERRD XDW_d2 1.21e-17
* device instance cc_ERRD_XDW_d3 r0 *1 0,0
Ccc_ERRD_XDW_d3 ERRD XDW_d3 1.21e-17
* device instance cc_ERRD_XNW_mid1 r0 *1 0,0
Ccc_ERRD_XNW_mid1 ERRD XNW_mid1 1.21e-17
* device instance cc_ERRD_XSCH_nn r0 *1 0,0
Ccc_ERRD_XSCH_nn ERRD XSCH_nn 1.8151e-17
* device instance cc_ERRD_XSCH_np r0 *1 0,0
Ccc_ERRD_XSCH_np ERRD XSCH_np 1.8151e-17
* device instance cc_ERRD_XXOR_n1 r0 *1 0,0
Ccc_ERRD_XXOR_n1 ERRD XXOR_n1 2.4201e-17
* device instance cc_ERRD_XXOR_n2 r0 *1 0,0
Ccc_ERRD_XXOR_n2 ERRD XXOR_n2 1.8151e-17
* device instance cc_ERRD_XXOR_n3 r0 *1 0,0
Ccc_ERRD_XXOR_n3 ERRD XXOR_n3 1.8151e-17
* device instance cc_ERRD_nwide r0 *1 0,0
Ccc_ERRD_nwide ERRD nwide 3.0251e-17
* device instance cc_LOCK_UP r0 *1 0,0
Ccc_LOCK_UP LOCK UP 1.21e-17
* device instance cc_LOCK_VDD r0 *1 0,0
Ccc_LOCK_VDD LOCK VDD 1.14955e-16
* device instance cc_LOCK_VSS r0 *1 0,0
Ccc_LOCK_VSS LOCK VSS 6.05e-18
* device instance cc_LOCK_VWIN r0 *1 0,0
Ccc_LOCK_VWIN LOCK VWIN 1.8151e-17
* device instance cc_LOCK_WIDE r0 *1 0,0
Ccc_LOCK_WIDE LOCK WIDE 6.05e-18
* device instance cc_LOCK_XDW_d1 r0 *1 0,0
Ccc_LOCK_XDW_d1 LOCK XDW_d1 1.21e-17
* device instance cc_LOCK_XDW_d2 r0 *1 0,0
Ccc_LOCK_XDW_d2 LOCK XDW_d2 1.21e-17
* device instance cc_LOCK_XDW_d3 r0 *1 0,0
Ccc_LOCK_XDW_d3 LOCK XDW_d3 1.21e-17
* device instance cc_LOCK_XSCH_nn r0 *1 0,0
Ccc_LOCK_XSCH_nn LOCK XSCH_nn 1.7344e-17
* device instance cc_LOCK_XSCH_np r0 *1 0,0
Ccc_LOCK_XSCH_np LOCK XSCH_np 1.7344e-17
* device instance cc_LOCK_XXOR_n1 r0 *1 0,0
Ccc_LOCK_XXOR_n1 LOCK XXOR_n1 2.4201e-17
* device instance cc_LOCK_XXOR_n2 r0 *1 0,0
Ccc_LOCK_XXOR_n2 LOCK XXOR_n2 1.8151e-17
* device instance cc_LOCK_XXOR_n3 r0 *1 0,0
Ccc_LOCK_XXOR_n3 LOCK XXOR_n3 1.8151e-17
* device instance cc_LOCK_nwide r0 *1 0,0
Ccc_LOCK_nwide LOCK nwide 1.8151e-17
* device instance cc_UP_VDD r0 *1 0,0
Ccc_UP_VDD UP VDD 2.4201e-17
* device instance cc_UP_VSS r0 *1 0,0
Ccc_UP_VSS UP VSS 7.2603e-17
* device instance cc_UP_VWIN r0 *1 0,0
Ccc_UP_VWIN UP VWIN 1.21e-17
* device instance cc_UP_WIDE r0 *1 0,0
Ccc_UP_WIDE UP WIDE 6.05e-18
* device instance cc_UP_XDW_d1 r0 *1 0,0
Ccc_UP_XDW_d1 UP XDW_d1 1.21e-17
* device instance cc_UP_XDW_d2 r0 *1 0,0
Ccc_UP_XDW_d2 UP XDW_d2 1.21e-17
* device instance cc_UP_XDW_d3 r0 *1 0,0
Ccc_UP_XDW_d3 UP XDW_d3 1.21e-17
* device instance cc_UP_XNW_mid1 r0 *1 0,0
Ccc_UP_XNW_mid1 UP XNW_mid1 1.21e-17
* device instance cc_UP_XSCH_nn r0 *1 0,0
Ccc_UP_XSCH_nn UP XSCH_nn 1.8151e-17
* device instance cc_UP_XXOR_XN1_mid1 r0 *1 0,0
Ccc_UP_XXOR_XN1_mid1 UP XXOR_XN1_mid1 1.21e-17
* device instance cc_UP_XXOR_XN2_mid1 r0 *1 0,0
Ccc_UP_XXOR_XN2_mid1 UP XXOR_XN2_mid1 1.21e-17
* device instance cc_UP_XXOR_XN3_mid1 r0 *1 0,0
Ccc_UP_XXOR_XN3_mid1 UP XXOR_XN3_mid1 1.21e-17
* device instance cc_UP_XXOR_XN4_mid1 r0 *1 0,0
Ccc_UP_XXOR_XN4_mid1 UP XXOR_XN4_mid1 1.21e-17
* device instance cc_UP_XXOR_n1 r0 *1 0,0
Ccc_UP_XXOR_n1 UP XXOR_n1 3.0251e-17
* device instance cc_UP_XXOR_n2 r0 *1 0,0
Ccc_UP_XXOR_n2 UP XXOR_n2 1.21e-17
* device instance cc_UP_XXOR_n3 r0 *1 0,0
Ccc_UP_XXOR_n3 UP XXOR_n3 1.21e-17
* device instance cc_UP_nwide r0 *1 0,0
Ccc_UP_nwide UP nwide 1.21e-17
* device instance cc_VDD_VSS r0 *1 0,0
Ccc_VDD_VSS VDD VSS 6.05e-18
* device instance cc_VDD_VWIN r0 *1 0,0
Ccc_VDD_VWIN VDD VWIN 1.21e-17
* device instance cc_VDD_WIDE r0 *1 0,0
Ccc_VDD_WIDE VDD WIDE 1.1294e-17
* device instance cc_VDD_XDW_d1 r0 *1 0,0
Ccc_VDD_XDW_d1 VDD XDW_d1 1.7344e-17
* device instance cc_VDD_XDW_d2 r0 *1 0,0
Ccc_VDD_XDW_d2 VDD XDW_d2 1.7344e-17
* device instance cc_VDD_XDW_d3 r0 *1 0,0
Ccc_VDD_XDW_d3 VDD XDW_d3 1.7344e-17
* device instance cc_VDD_XSCH_nn r0 *1 0,0
Ccc_VDD_XSCH_nn VDD XSCH_nn 5.244e-18
* device instance cc_VDD_XSCH_np r0 *1 0,0
Ccc_VDD_XSCH_np VDD XSCH_np 2.3394e-17
* device instance cc_VDD_XXOR_n1 r0 *1 0,0
Ccc_VDD_XXOR_n1 VDD XXOR_n1 3.4688e-17
* device instance cc_VDD_XXOR_n2 r0 *1 0,0
Ccc_VDD_XXOR_n2 VDD XXOR_n2 2.8638e-17
* device instance cc_VDD_XXOR_n3 r0 *1 0,0
Ccc_VDD_XXOR_n3 VDD XXOR_n3 2.8638e-17
* device instance cc_VDD_nwide r0 *1 0,0
Ccc_VDD_nwide VDD nwide 2.8638e-17
* device instance cc_VSS_VWIN r0 *1 0,0
Ccc_VSS_VWIN VSS VWIN 4.7595e-17
* device instance cc_VSS_WIDE r0 *1 0,0
Ccc_VSS_WIDE VSS WIDE 2.3394e-17
* device instance cc_VSS_XDW_d1 r0 *1 0,0
Ccc_VSS_XDW_d1 VSS XDW_d1 2.9445e-17
* device instance cc_VSS_XDW_d2 r0 *1 0,0
Ccc_VSS_XDW_d2 VSS XDW_d2 2.9445e-17
* device instance cc_VSS_XDW_d3 r0 *1 0,0
Ccc_VSS_XDW_d3 VSS XDW_d3 2.9445e-17
* device instance cc_VSS_XNW_mid1 r0 *1 0,0
Ccc_VSS_XNW_mid1 VSS XNW_mid1 1.7344e-17
* device instance cc_VSS_XSCH_nn r0 *1 0,0
Ccc_VSS_XSCH_nn VSS XSCH_nn 2.3394e-17
* device instance cc_VSS_XSCH_np r0 *1 0,0
Ccc_VSS_XSCH_np VSS XSCH_np 2.3394e-17
* device instance cc_VSS_XXOR_XN1_mid1 r0 *1 0,0
Ccc_VSS_XXOR_XN1_mid1 VSS XXOR_XN1_mid1 1.7344e-17
* device instance cc_VSS_XXOR_XN2_mid1 r0 *1 0,0
Ccc_VSS_XXOR_XN2_mid1 VSS XXOR_XN2_mid1 1.7344e-17
* device instance cc_VSS_XXOR_XN3_mid1 r0 *1 0,0
Ccc_VSS_XXOR_XN3_mid1 VSS XXOR_XN3_mid1 1.7344e-17
* device instance cc_VSS_XXOR_XN4_mid1 r0 *1 0,0
Ccc_VSS_XXOR_XN4_mid1 VSS XXOR_XN4_mid1 1.7344e-17
* device instance cc_VSS_XXOR_n1 r0 *1 0,0
Ccc_VSS_XXOR_n1 VSS XXOR_n1 4.2352e-17
* device instance cc_VSS_XXOR_n2 r0 *1 0,0
Ccc_VSS_XXOR_n2 VSS XXOR_n2 3.0251e-17
* device instance cc_VSS_XXOR_n3 r0 *1 0,0
Ccc_VSS_XXOR_n3 VSS XXOR_n3 3.0251e-17
* device instance cc_VSS_nwide r0 *1 0,0
Ccc_VSS_nwide VSS nwide 3.0251e-17
* device instance cc_VWIN_WIDE r0 *1 0,0
Ccc_VWIN_WIDE VWIN WIDE 1.21e-17
* device instance cc_VWIN_XDW_d1 r0 *1 0,0
Ccc_VWIN_XDW_d1 VWIN XDW_d1 2.4201e-17
* device instance cc_VWIN_XDW_d2 r0 *1 0,0
Ccc_VWIN_XDW_d2 VWIN XDW_d2 2.4201e-17
* device instance cc_VWIN_XDW_d3 r0 *1 0,0
Ccc_VWIN_XDW_d3 VWIN XDW_d3 2.4201e-17
* device instance cc_VWIN_XNW_mid1 r0 *1 0,0
Ccc_VWIN_XNW_mid1 VWIN XNW_mid1 1.21e-17
* device instance cc_VWIN_XSCH_nn r0 *1 0,0
Ccc_VWIN_XSCH_nn VWIN XSCH_nn 1.8151e-17
* device instance cc_VWIN_XSCH_np r0 *1 0,0
Ccc_VWIN_XSCH_np VWIN XSCH_np 1.8151e-17
* device instance cc_VWIN_XXOR_XN1_mid1 r0 *1 0,0
Ccc_VWIN_XXOR_XN1_mid1 VWIN XXOR_XN1_mid1 1.21e-17
* device instance cc_VWIN_XXOR_XN2_mid1 r0 *1 0,0
Ccc_VWIN_XXOR_XN2_mid1 VWIN XXOR_XN2_mid1 1.21e-17
* device instance cc_VWIN_XXOR_XN3_mid1 r0 *1 0,0
Ccc_VWIN_XXOR_XN3_mid1 VWIN XXOR_XN3_mid1 1.21e-17
* device instance cc_VWIN_XXOR_XN4_mid1 r0 *1 0,0
Ccc_VWIN_XXOR_XN4_mid1 VWIN XXOR_XN4_mid1 1.21e-17
* device instance cc_VWIN_XXOR_n1 r0 *1 0,0
Ccc_VWIN_XXOR_n1 VWIN XXOR_n1 4.2352e-17
* device instance cc_VWIN_XXOR_n2 r0 *1 0,0
Ccc_VWIN_XXOR_n2 VWIN XXOR_n2 3.0251e-17
* device instance cc_VWIN_XXOR_n3 r0 *1 0,0
Ccc_VWIN_XXOR_n3 VWIN XXOR_n3 3.0251e-17
* device instance cc_VWIN_nwide r0 *1 0,0
Ccc_VWIN_nwide VWIN nwide 3.0251e-17
* device instance cc_WIDE_XDW_d1 r0 *1 0,0
Ccc_WIDE_XDW_d1 WIDE XDW_d1 2.4201e-17
* device instance cc_WIDE_XDW_d2 r0 *1 0,0
Ccc_WIDE_XDW_d2 WIDE XDW_d2 2.4201e-17
* device instance cc_WIDE_XDW_d3 r0 *1 0,0
Ccc_WIDE_XDW_d3 WIDE XDW_d3 2.4201e-17
* device instance cc_WIDE_XNW_mid1 r0 *1 0,0
Ccc_WIDE_XNW_mid1 WIDE XNW_mid1 1.21e-17
* device instance cc_WIDE_XSCH_nn r0 *1 0,0
Ccc_WIDE_XSCH_nn WIDE XSCH_nn 1.8151e-17
* device instance cc_WIDE_XXOR_XN1_mid1 r0 *1 0,0
Ccc_WIDE_XXOR_XN1_mid1 WIDE XXOR_XN1_mid1 1.21e-17
* device instance cc_WIDE_XXOR_XN2_mid1 r0 *1 0,0
Ccc_WIDE_XXOR_XN2_mid1 WIDE XXOR_XN2_mid1 1.21e-17
* device instance cc_WIDE_XXOR_XN3_mid1 r0 *1 0,0
Ccc_WIDE_XXOR_XN3_mid1 WIDE XXOR_XN3_mid1 1.21e-17
* device instance cc_WIDE_XXOR_XN4_mid1 r0 *1 0,0
Ccc_WIDE_XXOR_XN4_mid1 WIDE XXOR_XN4_mid1 1.21e-17
* device instance cc_WIDE_XXOR_n1 r0 *1 0,0
Ccc_WIDE_XXOR_n1 WIDE XXOR_n1 4.2352e-17
* device instance cc_WIDE_XXOR_n2 r0 *1 0,0
Ccc_WIDE_XXOR_n2 WIDE XXOR_n2 3.0251e-17
* device instance cc_WIDE_XXOR_n3 r0 *1 0,0
Ccc_WIDE_XXOR_n3 WIDE XXOR_n3 3.0251e-17
* device instance cc_WIDE_nwide r0 *1 0,0
Ccc_WIDE_nwide WIDE nwide 3.0251e-17
* device instance cc_XDW_d1_XDW_d2 r0 *1 0,0
Ccc_XDW_d1_XDW_d2 XDW_d1 XDW_d2 1.21e-17
* device instance cc_XDW_d1_XDW_d3 r0 *1 0,0
Ccc_XDW_d1_XDW_d3 XDW_d1 XDW_d3 1.21e-17
* device instance cc_XDW_d1_XNW_mid1 r0 *1 0,0
Ccc_XDW_d1_XNW_mid1 XDW_d1 XNW_mid1 1.21e-17
* device instance cc_XDW_d1_XSCH_nn r0 *1 0,0
Ccc_XDW_d1_XSCH_nn XDW_d1 XSCH_nn 1.8151e-17
* device instance cc_XDW_d1_XXOR_n1 r0 *1 0,0
Ccc_XDW_d1_XXOR_n1 XDW_d1 XXOR_n1 2.4201e-17
* device instance cc_XDW_d1_XXOR_n2 r0 *1 0,0
Ccc_XDW_d1_XXOR_n2 XDW_d1 XXOR_n2 1.8151e-17
* device instance cc_XDW_d1_XXOR_n3 r0 *1 0,0
Ccc_XDW_d1_XXOR_n3 XDW_d1 XXOR_n3 1.8151e-17
* device instance cc_XDW_d1_nwide r0 *1 0,0
Ccc_XDW_d1_nwide XDW_d1 nwide 1.21e-17
* device instance cc_XDW_d2_XDW_d3 r0 *1 0,0
Ccc_XDW_d2_XDW_d3 XDW_d2 XDW_d3 1.21e-17
* device instance cc_XDW_d2_XNW_mid1 r0 *1 0,0
Ccc_XDW_d2_XNW_mid1 XDW_d2 XNW_mid1 1.21e-17
* device instance cc_XDW_d2_XSCH_nn r0 *1 0,0
Ccc_XDW_d2_XSCH_nn XDW_d2 XSCH_nn 1.8151e-17
* device instance cc_XDW_d2_XXOR_n1 r0 *1 0,0
Ccc_XDW_d2_XXOR_n1 XDW_d2 XXOR_n1 2.4201e-17
* device instance cc_XDW_d2_XXOR_n2 r0 *1 0,0
Ccc_XDW_d2_XXOR_n2 XDW_d2 XXOR_n2 1.8151e-17
* device instance cc_XDW_d2_XXOR_n3 r0 *1 0,0
Ccc_XDW_d2_XXOR_n3 XDW_d2 XXOR_n3 1.8151e-17
* device instance cc_XDW_d2_nwide r0 *1 0,0
Ccc_XDW_d2_nwide XDW_d2 nwide 1.21e-17
* device instance cc_XDW_d3_XNW_mid1 r0 *1 0,0
Ccc_XDW_d3_XNW_mid1 XDW_d3 XNW_mid1 1.21e-17
* device instance cc_XDW_d3_XSCH_nn r0 *1 0,0
Ccc_XDW_d3_XSCH_nn XDW_d3 XSCH_nn 1.8151e-17
* device instance cc_XDW_d3_XXOR_n1 r0 *1 0,0
Ccc_XDW_d3_XXOR_n1 XDW_d3 XXOR_n1 2.4201e-17
* device instance cc_XDW_d3_XXOR_n2 r0 *1 0,0
Ccc_XDW_d3_XXOR_n2 XDW_d3 XXOR_n2 1.8151e-17
* device instance cc_XDW_d3_XXOR_n3 r0 *1 0,0
Ccc_XDW_d3_XXOR_n3 XDW_d3 XXOR_n3 1.8151e-17
* device instance cc_XDW_d3_nwide r0 *1 0,0
Ccc_XDW_d3_nwide XDW_d3 nwide 1.21e-17
* device instance cc_XNW_mid1_nwide r0 *1 0,0
Ccc_XNW_mid1_nwide XNW_mid1 nwide 1.1294e-17
* device instance cc_XXOR_XN1_mid1_XXOR_n1 r0 *1 0,0
Ccc_XXOR_XN1_mid1_XXOR_n1 XXOR_XN1_mid1 XXOR_n1 1.1294e-17
* device instance cc_XXOR_XN2_mid1_XXOR_n1 r0 *1 0,0
Ccc_XXOR_XN2_mid1_XXOR_n1 XXOR_XN2_mid1 XXOR_n1 6.05e-18
* device instance cc_XXOR_XN2_mid1_XXOR_n2 r0 *1 0,0
Ccc_XXOR_XN2_mid1_XXOR_n2 XXOR_XN2_mid1 XXOR_n2 1.1294e-17
* device instance cc_XXOR_XN3_mid1_XXOR_n1 r0 *1 0,0
Ccc_XXOR_XN3_mid1_XXOR_n1 XXOR_XN3_mid1 XXOR_n1 6.05e-18
* device instance cc_XXOR_XN3_mid1_XXOR_n3 r0 *1 0,0
Ccc_XXOR_XN3_mid1_XXOR_n3 XXOR_XN3_mid1 XXOR_n3 1.1294e-17
* device instance cc_XXOR_XN4_mid1_XXOR_n3 r0 *1 0,0
Ccc_XXOR_XN4_mid1_XXOR_n3 XXOR_XN4_mid1 XXOR_n3 6.05e-18
* device instance cc_XXOR_n1_XXOR_n2 r0 *1 0,0
Ccc_XXOR_n1_XXOR_n2 XXOR_n1 XXOR_n2 2.4201e-17
* device instance cc_XXOR_n1_XXOR_n3 r0 *1 0,0
Ccc_XXOR_n1_XXOR_n3 XXOR_n1 XXOR_n3 1.8151e-17
* device instance cc_XXOR_n1_nwide r0 *1 0,0
Ccc_XXOR_n1_nwide XXOR_n1 nwide 1.21e-17
* device instance cc_XXOR_n2_XXOR_n3 r0 *1 0,0
Ccc_XXOR_n2_XXOR_n3 XXOR_n2 XXOR_n3 2.4201e-17
* device instance cc_XXOR_n2_nwide r0 *1 0,0
Ccc_XXOR_n2_nwide XXOR_n2 nwide 1.21e-17
* device instance cc_XXOR_n3_nwide r0 *1 0,0
Ccc_XXOR_n3_nwide XXOR_n3 nwide 1.21e-17
* device instance vsubs_dctie r0 *1 0,0
Rvsubs_dctie vsubs 0 1e+12
.ENDS pll_lock_detector
