* extracted by klt extract --deck sg13cmos5l
* parasitic model (--parasitics):
* - capacitance: net-to-ground for every net's own (non-coupled) area/perimeter, plus net-to-net for the vertical-overlap coupling `coupling` describes below -- a coupled net pair gets a direct capacitor between their two hub nodes, not just capacitors to the deck's ground/substrate net
* - coupling: vertical overlap (crossover) unconditionally -- where one net's conductor on an adjacent metal level sits directly over another *distinct* net's conductor, that overlap area is charged between the two nets instead of to ground (issue #760) -- plus lateral (same-layer, sidewall) coupling, but only for a net pair naming one of the caller's declared `--critical-net` nets (issue #976): facing-edge length within that layer's own minimum-spacing lookback is charged between the two nets, *additively* (not deducted from either net's substrate fringe term, unlike the vertical case -- a known simplification). Any same-layer pair with neither side named `--critical-net`, and fringe shielding in general, are still not modelled
* - resistance: single lumped series resistance per net, distributed as a star across that net's device terminals (issue #592) -- not a per-segment, distributed RC ladder, *unless* `--distributed-rc` names this net via `--critical-net` (issue #977, Epic #709 Phase 2b): then the net's terminals are ordered along their approximate physical spread and its total R/C is broken into a chain of per-segment resistors (segment length proportional to inter-terminal distance) with a ground capacitor at each terminal node (proportional to its adjacent segment length/2), instead of one star hub -- still an approximation (terminal position is a device-placement proxy, not true per-segment routing geometry), but a strictly finer-grained one than the single-hub star
* - frequency: quasi-static -- one frequency-independent R and C per net; no skin effect, no distributed transmission-line behavior
.GLOBAL vsubs

* cell pll_divider_chain
* pin CKIN
* pin CKIN_VCO
* pin DIVOUT
* pin FB
* pin P0
* pin P1
* pin P2
* pin P3
* pin P4
* pin P5
* pin VDD_DIV
* pin VSS
* pin XD0_XDFFM_CKBB
* pin XD0_XDFFM_CLKB
* pin XD0_XDFFM_M
* pin XD0_XDFFM_MB
* pin XD0_XDFFM_MFB
* pin XD0_XDFFM_S
* pin XD0_XDFFM_SB
* pin XD0_XDFFM_SFB
* pin XD0_XDFFQ_CKBB
* pin XD0_XDFFQ_CLKB
* pin XD0_XDFFQ_M
* pin XD0_XDFFQ_MB
* pin XD0_XDFFQ_MFB
* pin XD0_XDFFQ_S
* pin XD0_XDFFQ_SB
* pin XD0_XDFFQ_SFB
* pin XD0_XN2_mid1
* pin XD0_XN3_mid1
* pin XD0_XN3_mid2
* pin XD0_XNOR_midp
* pin XD0_dmodout
* pin XD0_dq
* pin XD0_nm
* pin XD0_nt
* pin XD0_t1
* pin XD1_XDFFM_CKBB
* pin XD1_XDFFM_CLKB
* pin XD1_XDFFM_M
* pin XD1_XDFFM_MB
* pin XD1_XDFFM_MFB
* pin XD1_XDFFM_S
* pin XD1_XDFFM_SB
* pin XD1_XDFFM_SFB
* pin XD1_XDFFQ_CKBB
* pin XD1_XDFFQ_CLKB
* pin XD1_XDFFQ_M
* pin XD1_XDFFQ_MB
* pin XD1_XDFFQ_MFB
* pin XD1_XDFFQ_S
* pin XD1_XDFFQ_SB
* pin XD1_XDFFQ_SFB
* pin XD1_XN2_mid1
* pin XD1_XN3_mid1
* pin XD1_XN3_mid2
* pin XD1_XNOR_midp
* pin XD1_dmodout
* pin XD1_dq
* pin XD1_nm
* pin XD1_nt
* pin XD1_t1
* pin XD2_XDFFM_CKBB
* pin XD2_XDFFM_CLKB
* pin XD2_XDFFM_M
* pin XD2_XDFFM_MB
* pin XD2_XDFFM_MFB
* pin XD2_XDFFM_S
* pin XD2_XDFFM_SB
* pin XD2_XDFFM_SFB
* pin XD2_XDFFQ_CKBB
* pin XD2_XDFFQ_CLKB
* pin XD2_XDFFQ_M
* pin XD2_XDFFQ_MB
* pin XD2_XDFFQ_MFB
* pin XD2_XDFFQ_S
* pin XD2_XDFFQ_SB
* pin XD2_XDFFQ_SFB
* pin XD2_XN2_mid1
* pin XD2_XN3_mid1
* pin XD2_XN3_mid2
* pin XD2_XNOR_midp
* pin XD2_dmodout
* pin XD2_dq
* pin XD2_nm
* pin XD2_nt
* pin XD2_t1
* pin XD3_XDFFM_CKBB
* pin XD3_XDFFM_CLKB
* pin XD3_XDFFM_M
* pin XD3_XDFFM_MB
* pin XD3_XDFFM_MFB
* pin XD3_XDFFM_S
* pin XD3_XDFFM_SB
* pin XD3_XDFFM_SFB
* pin XD3_XDFFQ_CKBB
* pin XD3_XDFFQ_CLKB
* pin XD3_XDFFQ_M
* pin XD3_XDFFQ_MB
* pin XD3_XDFFQ_MFB
* pin XD3_XDFFQ_S
* pin XD3_XDFFQ_SB
* pin XD3_XDFFQ_SFB
* pin XD3_XN2_mid1
* pin XD3_XN3_mid1
* pin XD3_XN3_mid2
* pin XD3_XNOR_midp
* pin XD3_dmodout
* pin XD3_dq
* pin XD3_nm
* pin XD3_nt
* pin XD3_t1
* pin XD4_XDFFM_CKBB
* pin XD4_XDFFM_CLKB
* pin XD4_XDFFM_M
* pin XD4_XDFFM_MB
* pin XD4_XDFFM_MFB
* pin XD4_XDFFM_S
* pin XD4_XDFFM_SB
* pin XD4_XDFFM_SFB
* pin XD4_XDFFQ_CKBB
* pin XD4_XDFFQ_CLKB
* pin XD4_XDFFQ_M
* pin XD4_XDFFQ_MB
* pin XD4_XDFFQ_MFB
* pin XD4_XDFFQ_S
* pin XD4_XDFFQ_SB
* pin XD4_XDFFQ_SFB
* pin XD4_XN2_mid1
* pin XD4_XN3_mid1
* pin XD4_XN3_mid2
* pin XD4_XNOR_midp
* pin XD4_dmodout
* pin XD4_dq
* pin XD4_nm
* pin XD4_nt
* pin XD4_t1
* pin XD5_XDFFM_CKBB
* pin XD5_XDFFM_CLKB
* pin XD5_XDFFM_M
* pin XD5_XDFFM_MB
* pin XD5_XDFFM_MFB
* pin XD5_XDFFM_S
* pin XD5_XDFFM_SB
* pin XD5_XDFFM_SFB
* pin XD5_XDFFQ_CKBB
* pin XD5_XDFFQ_CLKB
* pin XD5_XDFFQ_M
* pin XD5_XDFFQ_MB
* pin XD5_XDFFQ_MFB
* pin XD5_XDFFQ_S
* pin XD5_XDFFQ_SB
* pin XD5_XDFFQ_SFB
* pin XD5_XN2_mid1
* pin XD5_XN3_mid1
* pin XD5_XN3_mid2
* pin XD5_XNOR_midp
* pin XD5_dmodout
* pin XD5_dq
* pin XD5_nm
* pin XD5_nt
* pin XD5_t1
* pin XFRT_CKBB
* pin XFRT_CLKB
* pin XFRT_M
* pin XFRT_MB
* pin XFRT_MFB
* pin XFRT_S
* pin XFRT_SB
* pin XFRT_SFB
* pin ck1
* pin ck2
* pin ck3
* pin ck4
* pin ck5
* pin mod0
* pin mod1
* pin mod2
* pin mod3
* pin mod4
* pin net1
.SUBCKT pll_divider_chain CKIN CKIN_VCO DIVOUT FB P0 P1 P2 P3 P4 P5 VDD_DIV VSS
+ XD0_XDFFM_CKBB XD0_XDFFM_CLKB XD0_XDFFM_M XD0_XDFFM_MB XD0_XDFFM_MFB
+ XD0_XDFFM_S XD0_XDFFM_SB XD0_XDFFM_SFB XD0_XDFFQ_CKBB XD0_XDFFQ_CLKB
+ XD0_XDFFQ_M XD0_XDFFQ_MB XD0_XDFFQ_MFB XD0_XDFFQ_S XD0_XDFFQ_SB XD0_XDFFQ_SFB
+ XD0_XN2_mid1 XD0_XN3_mid1 XD0_XN3_mid2 XD0_XNOR_midp XD0_dmodout XD0_dq
+ XD0_nm XD0_nt XD0_t1 XD1_XDFFM_CKBB XD1_XDFFM_CLKB XD1_XDFFM_M XD1_XDFFM_MB
+ XD1_XDFFM_MFB XD1_XDFFM_S XD1_XDFFM_SB XD1_XDFFM_SFB XD1_XDFFQ_CKBB
+ XD1_XDFFQ_CLKB XD1_XDFFQ_M XD1_XDFFQ_MB XD1_XDFFQ_MFB XD1_XDFFQ_S
+ XD1_XDFFQ_SB XD1_XDFFQ_SFB XD1_XN2_mid1 XD1_XN3_mid1 XD1_XN3_mid2
+ XD1_XNOR_midp XD1_dmodout XD1_dq XD1_nm XD1_nt XD1_t1 XD2_XDFFM_CKBB
+ XD2_XDFFM_CLKB XD2_XDFFM_M XD2_XDFFM_MB XD2_XDFFM_MFB XD2_XDFFM_S
+ XD2_XDFFM_SB XD2_XDFFM_SFB XD2_XDFFQ_CKBB XD2_XDFFQ_CLKB XD2_XDFFQ_M
+ XD2_XDFFQ_MB XD2_XDFFQ_MFB XD2_XDFFQ_S XD2_XDFFQ_SB XD2_XDFFQ_SFB
+ XD2_XN2_mid1 XD2_XN3_mid1 XD2_XN3_mid2 XD2_XNOR_midp XD2_dmodout XD2_dq
+ XD2_nm XD2_nt XD2_t1 XD3_XDFFM_CKBB XD3_XDFFM_CLKB XD3_XDFFM_M XD3_XDFFM_MB
+ XD3_XDFFM_MFB XD3_XDFFM_S XD3_XDFFM_SB XD3_XDFFM_SFB XD3_XDFFQ_CKBB
+ XD3_XDFFQ_CLKB XD3_XDFFQ_M XD3_XDFFQ_MB XD3_XDFFQ_MFB XD3_XDFFQ_S
+ XD3_XDFFQ_SB XD3_XDFFQ_SFB XD3_XN2_mid1 XD3_XN3_mid1 XD3_XN3_mid2
+ XD3_XNOR_midp XD3_dmodout XD3_dq XD3_nm XD3_nt XD3_t1 XD4_XDFFM_CKBB
+ XD4_XDFFM_CLKB XD4_XDFFM_M XD4_XDFFM_MB XD4_XDFFM_MFB XD4_XDFFM_S
+ XD4_XDFFM_SB XD4_XDFFM_SFB XD4_XDFFQ_CKBB XD4_XDFFQ_CLKB XD4_XDFFQ_M
+ XD4_XDFFQ_MB XD4_XDFFQ_MFB XD4_XDFFQ_S XD4_XDFFQ_SB XD4_XDFFQ_SFB
+ XD4_XN2_mid1 XD4_XN3_mid1 XD4_XN3_mid2 XD4_XNOR_midp XD4_dmodout XD4_dq
+ XD4_nm XD4_nt XD4_t1 XD5_XDFFM_CKBB XD5_XDFFM_CLKB XD5_XDFFM_M XD5_XDFFM_MB
+ XD5_XDFFM_MFB XD5_XDFFM_S XD5_XDFFM_SB XD5_XDFFM_SFB XD5_XDFFQ_CKBB
+ XD5_XDFFQ_CLKB XD5_XDFFQ_M XD5_XDFFQ_MB XD5_XDFFQ_MFB XD5_XDFFQ_S
+ XD5_XDFFQ_SB XD5_XDFFQ_SFB XD5_XN2_mid1 XD5_XN3_mid1 XD5_XN3_mid2
+ XD5_XNOR_midp XD5_dmodout XD5_dq XD5_nm XD5_nt XD5_t1 XFRT_CKBB XFRT_CLKB
+ XFRT_M XFRT_MB XFRT_MFB XFRT_S XFRT_SB XFRT_SFB ck1 ck2 ck3 ck4 ck5 mod0 mod1
+ mod2 mod3 mod4 net1
* device instance $1 r0 *1 2.3,3.11 nfet
X$1 XD0_nt__t5 mod0__t4 XD0_XN3_mid1__t0 VSS__t127 sg13_hv_nmos L=0.5U W=2U
+ AS=0.8P AD=0.8P PS=4.8U PD=4.8U
* device instance $2 r0 *1 6.26,3.11 nfet
X$2 XD0_XN3_mid1__t1 P0__t1 XD0_XN3_mid2__t1 VSS__t128 sg13_hv_nmos L=0.5U W=2U
+ AS=0.8P AD=0.8P PS=4.8U PD=4.8U
* device instance $3 r0 *1 10.22,3.11 nfet
X$3 XD0_XN3_mid2__t0 net1__t2 VSS__t10 VSS__t129 sg13_hv_nmos L=0.5U W=2U
+ AS=0.8P AD=0.8P PS=4.8U PD=4.8U
* device instance $4 r0 *1 14.18,3.11 nfet
X$4 XD0_t1__t3 XD0_nt__t4 VSS__t11 VSS__t130 sg13_hv_nmos L=0.5U W=2U AS=0.8P
+ AD=0.8P PS=4.8U PD=4.8U
* device instance $5 r0 *1 18.14,3.11 nfet
X$5 XD0_dq__t2 ck1__t5 VSS__t12 VSS__t131 sg13_hv_nmos L=0.5U W=2U AS=0.8P
+ AD=0.8P PS=4.8U PD=4.8U
* device instance $6 r0 *1 22.1,3.11 nfet
X$6 XD0_dq__t3 XD0_t1__t2 VSS__t13 VSS__t132 sg13_hv_nmos L=0.5U W=2U AS=0.8P
+ AD=0.8P PS=4.8U PD=4.8U
* device instance $7 r0 *1 26.06,3.11 nfet
X$7 XD0_XDFFQ_CLKB__t7 CKIN__t2 VSS__t14 VSS__t133 sg13_hv_nmos L=0.5U W=2U
+ AS=0.8P AD=0.8P PS=4.8U PD=4.8U
* device instance $8 r0 *1 30.02,3.11 nfet
X$8 XD0_XDFFQ_CKBB__t5 XD0_XDFFQ_CLKB__t4 VSS__t39 VSS__t134 sg13_hv_nmos
+ L=0.5U W=2U AS=0.8P AD=0.8P PS=4.8U PD=4.8U
* device instance $9 r0 *1 33.98,3.11 nfet
X$9 XD0_dq__t4 XD0_XDFFQ_CLKB__t5 XD0_XDFFQ_M__t6 VSS__t135 sg13_hv_nmos L=0.5U
+ W=2U AS=0.8P AD=0.8P PS=4.8U PD=4.8U
* device instance $10 r0 *1 37.94,3.11 nfet
X$10 XD0_XDFFQ_MB__t3 XD0_XDFFQ_M__t0 VSS__t49 VSS__t136 sg13_hv_nmos L=0.5U
+ W=2U AS=0.8P AD=0.8P PS=4.8U PD=4.8U
* device instance $11 r0 *1 41.9,3.11 nfet
X$11 XD0_XDFFQ_MFB__t2 XD0_XDFFQ_MB__t2 VSS__t50 VSS__t137 sg13_hv_nmos L=0.5U
+ W=2U AS=0.8P AD=0.8P PS=4.8U PD=4.8U
* device instance $12 r0 *1 45.86,3.11 nfet
X$12 XD0_XDFFQ_MFB__t3 XD0_XDFFQ_CKBB__t3 XD0_XDFFQ_M__t7 VSS__t138
+ sg13_hv_nmos L=0.5U W=2U AS=0.8P AD=0.8P PS=4.8U PD=4.8U
* device instance $13 r0 *1 49.82,3.11 nfet
X$13 XD0_XDFFQ_M__t5 XD0_XDFFQ_CKBB__t4 XD0_XDFFQ_S__t4 VSS__t139 sg13_hv_nmos
+ L=0.5U W=2U AS=0.8P AD=0.8P PS=4.8U PD=4.8U
* device instance $14 r0 *1 53.78,3.11 nfet
X$14 XD0_XDFFQ_SB__t5 XD0_XDFFQ_S__t3 VSS__t51 VSS__t140 sg13_hv_nmos L=0.5U
+ W=2U AS=0.8P AD=0.8P PS=4.8U PD=4.8U
* device instance $15 r0 *1 57.74,3.11 nfet
X$15 XD0_XDFFQ_SFB__t2 XD0_XDFFQ_SB__t3 VSS__t52 VSS__t141 sg13_hv_nmos L=0.5U
+ W=2U AS=0.8P AD=0.8P PS=4.8U PD=4.8U
* device instance $16 r0 *1 61.7,3.11 nfet
X$16 XD0_XDFFQ_SFB__t3 XD0_XDFFQ_CLKB__t6 XD0_XDFFQ_S__t5 VSS__t142
+ sg13_hv_nmos L=0.5U W=2U AS=0.8P AD=0.8P PS=4.8U PD=4.8U
* device instance $17 r0 *1 65.66,3.11 nfet
X$17 ck1__t9 XD0_XDFFQ_SB__t4 VSS__t53 VSS__t143 sg13_hv_nmos L=0.5U W=2U
+ AS=0.8P AD=0.8P PS=4.8U PD=4.8U
* device instance $18 r0 *1 69.62,3.11 nfet
X$18 XD0_nm__t4 mod0__t6 XD0_XN2_mid1__t1 VSS__t144 sg13_hv_nmos L=0.5U W=2U
+ AS=0.8P AD=0.8P PS=4.8U PD=4.8U
* device instance $19 r0 *1 73.58,3.11 nfet
X$19 XD0_XN2_mid1__t0 ck1__t8 VSS__t54 VSS__t145 sg13_hv_nmos L=0.5U W=2U
+ AS=0.8P AD=0.8P PS=4.8U PD=4.8U
* device instance $20 r0 *1 77.54,3.11 nfet
X$20 XD0_dmodout__t3 XD0_nm__t3 VSS__t62 VSS__t146 sg13_hv_nmos L=0.5U W=2U
+ AS=0.8P AD=0.8P PS=4.8U PD=4.8U
* device instance $21 r0 *1 81.5,3.11 nfet
X$21 XD0_XDFFM_CLKB__t7 CKIN__t3 VSS__t55 VSS__t147 sg13_hv_nmos L=0.5U W=2U
+ AS=0.8P AD=0.8P PS=4.8U PD=4.8U
* device instance $22 r0 *1 85.46,3.11 nfet
X$22 XD0_XDFFM_CKBB__t5 XD0_XDFFM_CLKB__t4 VSS__t56 VSS__t148 sg13_hv_nmos
+ L=0.5U W=2U AS=0.8P AD=0.8P PS=4.8U PD=4.8U
* device instance $23 r0 *1 89.42,3.11 nfet
X$23 XD0_dmodout__t2 XD0_XDFFM_CLKB__t5 XD0_XDFFM_M__t6 VSS__t149 sg13_hv_nmos
+ L=0.5U W=2U AS=0.8P AD=0.8P PS=4.8U PD=4.8U
* device instance $24 r0 *1 93.38,3.11 nfet
X$24 XD0_XDFFM_MB__t3 XD0_XDFFM_M__t4 VSS__t57 VSS__t150 sg13_hv_nmos L=0.5U
+ W=2U AS=0.8P AD=0.8P PS=4.8U PD=4.8U
* device instance $25 r0 *1 97.34,3.11 nfet
X$25 XD0_XDFFM_MFB__t2 XD0_XDFFM_MB__t2 VSS__t58 VSS__t151 sg13_hv_nmos L=0.5U
+ W=2U AS=0.8P AD=0.8P PS=4.8U PD=4.8U
* device instance $26 r0 *1 101.3,3.11 nfet
X$26 XD0_XDFFM_MFB__t3 XD0_XDFFM_CKBB__t3 XD0_XDFFM_M__t7 VSS__t152
+ sg13_hv_nmos L=0.5U W=2U AS=0.8P AD=0.8P PS=4.8U PD=4.8U
* device instance $27 r0 *1 105.26,3.11 nfet
X$27 XD0_XDFFM_M__t5 XD0_XDFFM_CKBB__t4 XD0_XDFFM_S__t4 VSS__t153 sg13_hv_nmos
+ L=0.5U W=2U AS=0.8P AD=0.8P PS=4.8U PD=4.8U
* device instance $28 r0 *1 109.22,3.11 nfet
X$28 XD0_XDFFM_SB__t5 XD0_XDFFM_S__t3 VSS__t59 VSS__t154 sg13_hv_nmos L=0.5U
+ W=2U AS=0.8P AD=0.8P PS=4.8U PD=4.8U
* device instance $29 r0 *1 113.18,3.11 nfet
X$29 XD0_XDFFM_SFB__t2 XD0_XDFFM_SB__t3 VSS__t60 VSS__t155 sg13_hv_nmos L=0.5U
+ W=2U AS=0.8P AD=0.8P PS=4.8U PD=4.8U
* device instance $30 r0 *1 117.14,3.11 nfet
X$30 XD0_XDFFM_SFB__t3 XD0_XDFFM_CLKB__t6 XD0_XDFFM_S__t5 VSS__t156
+ sg13_hv_nmos L=0.5U W=2U AS=0.8P AD=0.8P PS=4.8U PD=4.8U
* device instance $31 r0 *1 121.1,3.11 nfet
X$31 net1__t3 XD0_XDFFM_SB__t4 VSS__t61 VSS__t157 sg13_hv_nmos L=0.5U W=2U
+ AS=0.8P AD=0.8P PS=4.8U PD=4.8U
* device instance $32 r0 *1 125.06,3.11 nfet
X$32 XD1_nt__t5 mod1__t6 XD1_XN3_mid1__t1 VSS__t158 sg13_hv_nmos L=0.5U W=2U
+ AS=0.8P AD=0.8P PS=4.8U PD=4.8U
* device instance $33 r0 *1 129.02,3.11 nfet
X$33 XD1_XN3_mid1__t0 P1__t1 XD1_XN3_mid2__t1 VSS__t159 sg13_hv_nmos L=0.5U
+ W=2U AS=0.8P AD=0.8P PS=4.8U PD=4.8U
* device instance $34 r0 *1 132.98,3.11 nfet
X$34 XD1_XN3_mid2__t0 mod0__t5 VSS__t31 VSS__t160 sg13_hv_nmos L=0.5U W=2U
+ AS=0.8P AD=0.8P PS=4.8U PD=4.8U
* device instance $35 r0 *1 136.94,3.11 nfet
X$35 XD1_t1__t3 XD1_nt__t4 VSS__t32 VSS__t161 sg13_hv_nmos L=0.5U W=2U AS=0.8P
+ AD=0.8P PS=4.8U PD=4.8U
* device instance $36 r0 *1 140.9,3.11 nfet
X$36 XD1_dq__t2 ck2__t5 VSS__t33 VSS__t162 sg13_hv_nmos L=0.5U W=2U AS=0.8P
+ AD=0.8P PS=4.8U PD=4.8U
* device instance $37 r0 *1 144.86,3.11 nfet
X$37 XD1_dq__t3 XD1_t1__t2 VSS__t34 VSS__t163 sg13_hv_nmos L=0.5U W=2U AS=0.8P
+ AD=0.8P PS=4.8U PD=4.8U
* device instance $38 r0 *1 148.82,3.11 nfet
X$38 XD1_XDFFQ_CLKB__t7 ck1__t6 VSS__t35 VSS__t164 sg13_hv_nmos L=0.5U W=2U
+ AS=0.8P AD=0.8P PS=4.8U PD=4.8U
* device instance $39 r0 *1 152.78,3.11 nfet
X$39 XD1_XDFFQ_CKBB__t5 XD1_XDFFQ_CLKB__t4 VSS__t36 VSS__t165 sg13_hv_nmos
+ L=0.5U W=2U AS=0.8P AD=0.8P PS=4.8U PD=4.8U
* device instance $40 r0 *1 156.74,3.11 nfet
X$40 XD1_dq__t4 XD1_XDFFQ_CLKB__t5 XD1_XDFFQ_M__t6 VSS__t166 sg13_hv_nmos
+ L=0.5U W=2U AS=0.8P AD=0.8P PS=4.8U PD=4.8U
* device instance $41 r0 *1 160.7,3.11 nfet
X$41 XD1_XDFFQ_MB__t3 XD1_XDFFQ_M__t4 VSS__t37 VSS__t167 sg13_hv_nmos L=0.5U
+ W=2U AS=0.8P AD=0.8P PS=4.8U PD=4.8U
* device instance $42 r0 *1 164.66,3.11 nfet
X$42 XD1_XDFFQ_MFB__t2 XD1_XDFFQ_MB__t2 VSS__t38 VSS__t168 sg13_hv_nmos L=0.5U
+ W=2U AS=0.8P AD=0.8P PS=4.8U PD=4.8U
* device instance $43 r0 *1 168.62,3.11 nfet
X$43 XD1_XDFFQ_MFB__t3 XD1_XDFFQ_CKBB__t3 XD1_XDFFQ_M__t7 VSS__t169
+ sg13_hv_nmos L=0.5U W=2U AS=0.8P AD=0.8P PS=4.8U PD=4.8U
* device instance $44 r0 *1 172.58,3.11 nfet
X$44 XD1_XDFFQ_M__t5 XD1_XDFFQ_CKBB__t4 XD1_XDFFQ_S__t4 VSS__t170 sg13_hv_nmos
+ L=0.5U W=2U AS=0.8P AD=0.8P PS=4.8U PD=4.8U
* device instance $45 r0 *1 176.54,3.11 nfet
X$45 XD1_XDFFQ_SB__t5 XD1_XDFFQ_S__t3 VSS__t48 VSS__t171 sg13_hv_nmos L=0.5U
+ W=2U AS=0.8P AD=0.8P PS=4.8U PD=4.8U
* device instance $46 r0 *1 180.5,3.11 nfet
X$46 XD1_XDFFQ_SFB__t2 XD1_XDFFQ_SB__t3 VSS__t40 VSS__t172 sg13_hv_nmos L=0.5U
+ W=2U AS=0.8P AD=0.8P PS=4.8U PD=4.8U
* device instance $47 r0 *1 184.46,3.11 nfet
X$47 XD1_XDFFQ_SFB__t3 XD1_XDFFQ_CLKB__t6 XD1_XDFFQ_S__t5 VSS__t173
+ sg13_hv_nmos L=0.5U W=2U AS=0.8P AD=0.8P PS=4.8U PD=4.8U
* device instance $48 r0 *1 188.42,3.11 nfet
X$48 ck2__t9 XD1_XDFFQ_SB__t4 VSS__t41 VSS__t174 sg13_hv_nmos L=0.5U W=2U
+ AS=0.8P AD=0.8P PS=4.8U PD=4.8U
* device instance $49 r0 *1 192.38,3.11 nfet
X$49 XD1_nm__t4 mod1__t5 XD1_XN2_mid1__t1 VSS__t175 sg13_hv_nmos L=0.5U W=2U
+ AS=0.8P AD=0.8P PS=4.8U PD=4.8U
* device instance $50 r0 *1 196.34,3.11 nfet
X$50 XD1_XN2_mid1__t0 ck2__t6 VSS__t42 VSS__t176 sg13_hv_nmos L=0.5U W=2U
+ AS=0.8P AD=0.8P PS=4.8U PD=4.8U
* device instance $51 r0 *1 200.3,3.11 nfet
X$51 XD1_dmodout__t2 XD1_nm__t3 VSS__t43 VSS__t177 sg13_hv_nmos L=0.5U W=2U
+ AS=0.8P AD=0.8P PS=4.8U PD=4.8U
* device instance $52 r0 *1 204.26,3.11 nfet
X$52 XD1_XDFFM_CLKB__t7 ck1__t7 VSS__t44 VSS__t178 sg13_hv_nmos L=0.5U W=2U
+ AS=0.8P AD=0.8P PS=4.8U PD=4.8U
* device instance $53 r0 *1 208.22,3.11 nfet
X$53 XD1_XDFFM_CKBB__t5 XD1_XDFFM_CLKB__t5 VSS__t45 VSS__t179 sg13_hv_nmos
+ L=0.5U W=2U AS=0.8P AD=0.8P PS=4.8U PD=4.8U
* device instance $54 r0 *1 212.18,3.11 nfet
X$54 XD1_dmodout__t3 XD1_XDFFM_CLKB__t6 XD1_XDFFM_M__t6 VSS__t180 sg13_hv_nmos
+ L=0.5U W=2U AS=0.8P AD=0.8P PS=4.8U PD=4.8U
* device instance $55 r0 *1 216.14,3.11 nfet
X$55 XD1_XDFFM_MB__t3 XD1_XDFFM_M__t4 VSS__t46 VSS__t181 sg13_hv_nmos L=0.5U
+ W=2U AS=0.8P AD=0.8P PS=4.8U PD=4.8U
* device instance $56 r0 *1 220.1,3.11 nfet
X$56 XD1_XDFFM_MFB__t2 XD1_XDFFM_MB__t2 VSS__t47 VSS__t182 sg13_hv_nmos L=0.5U
+ W=2U AS=0.8P AD=0.8P PS=4.8U PD=4.8U
* device instance $57 r0 *1 224.06,3.11 nfet
X$57 XD1_XDFFM_MFB__t3 XD1_XDFFM_CKBB__t4 XD1_XDFFM_M__t7 VSS__t183
+ sg13_hv_nmos L=0.5U W=2U AS=0.8P AD=0.8P PS=4.8U PD=4.8U
* device instance $58 r0 *1 228.02,3.11 nfet
X$58 XD1_XDFFM_M__t5 XD1_XDFFM_CKBB__t3 XD1_XDFFM_S__t4 VSS__t184 sg13_hv_nmos
+ L=0.5U W=2U AS=0.8P AD=0.8P PS=4.8U PD=4.8U
* device instance $59 r0 *1 231.98,3.11 nfet
X$59 XD1_XDFFM_SB__t5 XD1_XDFFM_S__t3 VSS__t8 VSS__t185 sg13_hv_nmos L=0.5U
+ W=2U AS=0.8P AD=0.8P PS=4.8U PD=4.8U
* device instance $60 r0 *1 235.94,3.11 nfet
X$60 XD1_XDFFM_SFB__t2 XD1_XDFFM_SB__t4 VSS__t9 VSS__t186 sg13_hv_nmos L=0.5U
+ W=2U AS=0.8P AD=0.8P PS=4.8U PD=4.8U
* device instance $61 r0 *1 239.9,3.11 nfet
X$61 XD1_XDFFM_SFB__t3 XD1_XDFFM_CLKB__t4 XD1_XDFFM_S__t5 VSS__t187
+ sg13_hv_nmos L=0.5U W=2U AS=0.8P AD=0.8P PS=4.8U PD=4.8U
* device instance $62 r0 *1 243.86,3.11 nfet
X$62 mod0__t7 XD1_XDFFM_SB__t3 VSS__t4 VSS__t188 sg13_hv_nmos L=0.5U W=2U
+ AS=0.8P AD=0.8P PS=4.8U PD=4.8U
* device instance $63 r0 *1 247.82,3.11 nfet
X$63 XD2_nt__t5 mod2__t4 XD2_XN3_mid1__t1 VSS__t189 sg13_hv_nmos L=0.5U W=2U
+ AS=0.8P AD=0.8P PS=4.8U PD=4.8U
* device instance $64 r0 *1 251.78,3.11 nfet
X$64 XD2_XN3_mid1__t0 P2__t1 XD2_XN3_mid2__t1 VSS__t190 sg13_hv_nmos L=0.5U
+ W=2U AS=0.8P AD=0.8P PS=4.8U PD=4.8U
* device instance $65 r0 *1 255.74,3.11 nfet
X$65 XD2_XN3_mid2__t0 mod1__t4 VSS__t5 VSS__t191 sg13_hv_nmos L=0.5U W=2U
+ AS=0.8P AD=0.8P PS=4.8U PD=4.8U
* device instance $66 r0 *1 259.7,3.11 nfet
X$66 XD2_t1__t3 XD2_nt__t4 VSS__t6 VSS__t192 sg13_hv_nmos L=0.5U W=2U AS=0.8P
+ AD=0.8P PS=4.8U PD=4.8U
* device instance $67 r0 *1 263.66,3.11 nfet
X$67 XD2_dq__t3 ck3__t6 VSS__t15 VSS__t193 sg13_hv_nmos L=0.5U W=2U AS=0.8P
+ AD=0.8P PS=4.8U PD=4.8U
* device instance $68 r0 *1 267.62,3.11 nfet
X$68 XD2_dq__t2 XD2_t1__t2 VSS__t7 VSS__t194 sg13_hv_nmos L=0.5U W=2U AS=0.8P
+ AD=0.8P PS=4.8U PD=4.8U
* device instance $69 r0 *1 271.58,3.11 nfet
X$69 XD2_XDFFQ_CLKB__t7 ck2__t8 VSS__t119 VSS__t195 sg13_hv_nmos L=0.5U W=2U
+ AS=0.8P AD=0.8P PS=4.8U PD=4.8U
* device instance $70 r0 *1 275.54,3.11 nfet
X$70 XD2_XDFFQ_CKBB__t5 XD2_XDFFQ_CLKB__t4 VSS__t100 VSS__t196 sg13_hv_nmos
+ L=0.5U W=2U AS=0.8P AD=0.8P PS=4.8U PD=4.8U
* device instance $71 r0 *1 279.5,3.11 nfet
X$71 XD2_dq__t4 XD2_XDFFQ_CLKB__t5 XD2_XDFFQ_M__t6 VSS__t197 sg13_hv_nmos
+ L=0.5U W=2U AS=0.8P AD=0.8P PS=4.8U PD=4.8U
* device instance $72 r0 *1 283.46,3.11 nfet
X$72 XD2_XDFFQ_MB__t3 XD2_XDFFQ_M__t4 VSS__t101 VSS__t198 sg13_hv_nmos L=0.5U
+ W=2U AS=0.8P AD=0.8P PS=4.8U PD=4.8U
* device instance $73 r0 *1 287.42,3.11 nfet
X$73 XD2_XDFFQ_MFB__t2 XD2_XDFFQ_MB__t2 VSS__t102 VSS__t199 sg13_hv_nmos L=0.5U
+ W=2U AS=0.8P AD=0.8P PS=4.8U PD=4.8U
* device instance $74 r0 *1 291.38,3.11 nfet
X$74 XD2_XDFFQ_MFB__t3 XD2_XDFFQ_CKBB__t4 XD2_XDFFQ_M__t7 VSS__t200
+ sg13_hv_nmos L=0.5U W=2U AS=0.8P AD=0.8P PS=4.8U PD=4.8U
* device instance $75 r0 *1 295.34,3.11 nfet
X$75 XD2_XDFFQ_M__t5 XD2_XDFFQ_CKBB__t3 XD2_XDFFQ_S__t4 VSS__t201 sg13_hv_nmos
+ L=0.5U W=2U AS=0.8P AD=0.8P PS=4.8U PD=4.8U
* device instance $76 r0 *1 299.3,3.11 nfet
X$76 XD2_XDFFQ_SB__t5 XD2_XDFFQ_S__t3 VSS__t103 VSS__t202 sg13_hv_nmos L=0.5U
+ W=2U AS=0.8P AD=0.8P PS=4.8U PD=4.8U
* device instance $77 r0 *1 303.26,3.11 nfet
X$77 XD2_XDFFQ_SFB__t2 XD2_XDFFQ_SB__t3 VSS__t104 VSS__t203 sg13_hv_nmos L=0.5U
+ W=2U AS=0.8P AD=0.8P PS=4.8U PD=4.8U
* device instance $78 r0 *1 307.22,3.11 nfet
X$78 XD2_XDFFQ_SFB__t3 XD2_XDFFQ_CLKB__t6 XD2_XDFFQ_S__t5 VSS__t204
+ sg13_hv_nmos L=0.5U W=2U AS=0.8P AD=0.8P PS=4.8U PD=4.8U
* device instance $79 r0 *1 311.18,3.11 nfet
X$79 ck3__t9 XD2_XDFFQ_SB__t4 VSS__t105 VSS__t205 sg13_hv_nmos L=0.5U W=2U
+ AS=0.8P AD=0.8P PS=4.8U PD=4.8U
* device instance $80 r0 *1 315.14,3.11 nfet
X$80 XD2_nm__t4 mod2__t6 XD2_XN2_mid1__t1 VSS__t206 sg13_hv_nmos L=0.5U W=2U
+ AS=0.8P AD=0.8P PS=4.8U PD=4.8U
* device instance $81 r0 *1 319.1,3.11 nfet
X$81 XD2_XN2_mid1__t0 ck3__t8 VSS__t106 VSS__t207 sg13_hv_nmos L=0.5U W=2U
+ AS=0.8P AD=0.8P PS=4.8U PD=4.8U
* device instance $82 r0 *1 323.06,3.11 nfet
X$82 XD2_dmodout__t2 XD2_nm__t3 VSS__t107 VSS__t208 sg13_hv_nmos L=0.5U W=2U
+ AS=0.8P AD=0.8P PS=4.8U PD=4.8U
* device instance $83 r0 *1 327.02,3.11 nfet
X$83 XD2_XDFFM_CLKB__t7 ck2__t7 VSS__t108 VSS__t209 sg13_hv_nmos L=0.5U W=2U
+ AS=0.8P AD=0.8P PS=4.8U PD=4.8U
* device instance $84 r0 *1 330.98,3.11 nfet
X$84 XD2_XDFFM_CKBB__t5 XD2_XDFFM_CLKB__t5 VSS__t109 VSS__t210 sg13_hv_nmos
+ L=0.5U W=2U AS=0.8P AD=0.8P PS=4.8U PD=4.8U
* device instance $85 r0 *1 334.94,3.11 nfet
X$85 XD2_dmodout__t3 XD2_XDFFM_CLKB__t6 XD2_XDFFM_M__t7 VSS__t211 sg13_hv_nmos
+ L=0.5U W=2U AS=0.8P AD=0.8P PS=4.8U PD=4.8U
* device instance $86 r0 *1 338.9,3.11 nfet
X$86 XD2_XDFFM_MB__t3 XD2_XDFFM_M__t4 VSS__t110 VSS__t212 sg13_hv_nmos L=0.5U
+ W=2U AS=0.8P AD=0.8P PS=4.8U PD=4.8U
* device instance $87 r0 *1 342.86,3.11 nfet
X$87 XD2_XDFFM_MFB__t3 XD2_XDFFM_MB__t2 VSS__t69 VSS__t213 sg13_hv_nmos L=0.5U
+ W=2U AS=0.8P AD=0.8P PS=4.8U PD=4.8U
* device instance $88 r0 *1 346.82,3.11 nfet
X$88 XD2_XDFFM_MFB__t2 XD2_XDFFM_CKBB__t3 XD2_XDFFM_M__t6 VSS__t214
+ sg13_hv_nmos L=0.5U W=2U AS=0.8P AD=0.8P PS=4.8U PD=4.8U
* device instance $89 r0 *1 350.78,3.11 nfet
X$89 XD2_XDFFM_M__t5 XD2_XDFFM_CKBB__t4 XD2_XDFFM_S__t4 VSS__t215 sg13_hv_nmos
+ L=0.5U W=2U AS=0.8P AD=0.8P PS=4.8U PD=4.8U
* device instance $90 r0 *1 354.74,3.11 nfet
X$90 XD2_XDFFM_SB__t5 XD2_XDFFM_S__t3 VSS__t16 VSS__t216 sg13_hv_nmos L=0.5U
+ W=2U AS=0.8P AD=0.8P PS=4.8U PD=4.8U
* device instance $91 r0 *1 358.7,3.11 nfet
X$91 XD2_XDFFM_SFB__t2 XD2_XDFFM_SB__t3 VSS__t17 VSS__t217 sg13_hv_nmos L=0.5U
+ W=2U AS=0.8P AD=0.8P PS=4.8U PD=4.8U
* device instance $92 r0 *1 362.66,3.11 nfet
X$92 XD2_XDFFM_SFB__t3 XD2_XDFFM_CLKB__t4 XD2_XDFFM_S__t5 VSS__t218
+ sg13_hv_nmos L=0.5U W=2U AS=0.8P AD=0.8P PS=4.8U PD=4.8U
* device instance $93 r0 *1 366.62,3.11 nfet
X$93 mod1__t7 XD2_XDFFM_SB__t4 VSS__t18 VSS__t219 sg13_hv_nmos L=0.5U W=2U
+ AS=0.8P AD=0.8P PS=4.8U PD=4.8U
* device instance $94 r0 *1 370.58,3.11 nfet
X$94 XD3_nt__t5 mod3__t4 XD3_XN3_mid1__t1 VSS__t220 sg13_hv_nmos L=0.5U W=2U
+ AS=0.8P AD=0.8P PS=4.8U PD=4.8U
* device instance $95 r0 *1 374.54,3.11 nfet
X$95 XD3_XN3_mid1__t0 P3__t1 XD3_XN3_mid2__t1 VSS__t221 sg13_hv_nmos L=0.5U
+ W=2U AS=0.8P AD=0.8P PS=4.8U PD=4.8U
* device instance $96 r0 *1 378.5,3.11 nfet
X$96 XD3_XN3_mid2__t0 mod2__t5 VSS__t19 VSS__t222 sg13_hv_nmos L=0.5U W=2U
+ AS=0.8P AD=0.8P PS=4.8U PD=4.8U
* device instance $97 r0 *1 382.46,3.11 nfet
X$97 XD3_t1__t3 XD3_nt__t4 VSS__t20 VSS__t223 sg13_hv_nmos L=0.5U W=2U AS=0.8P
+ AD=0.8P PS=4.8U PD=4.8U
* device instance $98 r0 *1 386.42,3.11 nfet
X$98 XD3_dq__t2 ck4__t5 VSS__t21 VSS__t224 sg13_hv_nmos L=0.5U W=2U AS=0.8P
+ AD=0.8P PS=4.8U PD=4.8U
* device instance $99 r0 *1 390.38,3.11 nfet
X$99 XD3_dq__t4 XD3_t1__t2 VSS__t30 VSS__t225 sg13_hv_nmos L=0.5U W=2U AS=0.8P
+ AD=0.8P PS=4.8U PD=4.8U
* device instance $100 r0 *1 394.34,3.11 nfet
X$100 XD3_XDFFQ_CLKB__t7 ck3__t7 VSS__t23 VSS__t226 sg13_hv_nmos L=0.5U W=2U
+ AS=0.8P AD=0.8P PS=4.8U PD=4.8U
* device instance $101 r0 *1 398.3,3.11 nfet
X$101 XD3_XDFFQ_CKBB__t5 XD3_XDFFQ_CLKB__t4 VSS__t24 VSS__t227 sg13_hv_nmos
+ L=0.5U W=2U AS=0.8P AD=0.8P PS=4.8U PD=4.8U
* device instance $102 r0 *1 402.26,3.11 nfet
X$102 XD3_dq__t3 XD3_XDFFQ_CLKB__t5 XD3_XDFFQ_M__t6 VSS__t228 sg13_hv_nmos
+ L=0.5U W=2U AS=0.8P AD=0.8P PS=4.8U PD=4.8U
* device instance $103 r0 *1 406.22,3.11 nfet
X$103 XD3_XDFFQ_MB__t3 XD3_XDFFQ_M__t4 VSS__t25 VSS__t229 sg13_hv_nmos L=0.5U
+ W=2U AS=0.8P AD=0.8P PS=4.8U PD=4.8U
* device instance $104 r0 *1 410.18,3.11 nfet
X$104 XD3_XDFFQ_MFB__t2 XD3_XDFFQ_MB__t2 VSS__t26 VSS__t230 sg13_hv_nmos L=0.5U
+ W=2U AS=0.8P AD=0.8P PS=4.8U PD=4.8U
* device instance $105 r0 *1 414.14,3.11 nfet
X$105 XD3_XDFFQ_MFB__t3 XD3_XDFFQ_CKBB__t3 XD3_XDFFQ_M__t7 VSS__t231
+ sg13_hv_nmos L=0.5U W=2U AS=0.8P AD=0.8P PS=4.8U PD=4.8U
* device instance $106 r0 *1 418.1,3.11 nfet
X$106 XD3_XDFFQ_M__t5 XD3_XDFFQ_CKBB__t4 XD3_XDFFQ_S__t4 VSS__t232 sg13_hv_nmos
+ L=0.5U W=2U AS=0.8P AD=0.8P PS=4.8U PD=4.8U
* device instance $107 r0 *1 422.06,3.11 nfet
X$107 XD3_XDFFQ_SB__t5 XD3_XDFFQ_S__t3 VSS__t27 VSS__t233 sg13_hv_nmos L=0.5U
+ W=2U AS=0.8P AD=0.8P PS=4.8U PD=4.8U
* device instance $108 r0 *1 426.02,3.11 nfet
X$108 XD3_XDFFQ_SFB__t2 XD3_XDFFQ_SB__t3 VSS__t28 VSS__t234 sg13_hv_nmos L=0.5U
+ W=2U AS=0.8P AD=0.8P PS=4.8U PD=4.8U
* device instance $109 r0 *1 429.98,3.11 nfet
X$109 XD3_XDFFQ_SFB__t3 XD3_XDFFQ_CLKB__t6 XD3_XDFFQ_S__t5 VSS__t235
+ sg13_hv_nmos L=0.5U W=2U AS=0.8P AD=0.8P PS=4.8U PD=4.8U
* device instance $110 r0 *1 433.94,3.11 nfet
X$110 ck4__t9 XD3_XDFFQ_SB__t4 VSS__t29 VSS__t236 sg13_hv_nmos L=0.5U W=2U
+ AS=0.8P AD=0.8P PS=4.8U PD=4.8U
* device instance $111 r0 *1 437.9,3.11 nfet
X$111 XD3_nm__t4 mod3__t5 XD3_XN2_mid1__t1 VSS__t237 sg13_hv_nmos L=0.5U W=2U
+ AS=0.8P AD=0.8P PS=4.8U PD=4.8U
* device instance $112 r0 *1 441.86,3.11 nfet
X$112 XD3_XN2_mid1__t0 ck4__t6 VSS__t22 VSS__t238 sg13_hv_nmos L=0.5U W=2U
+ AS=0.8P AD=0.8P PS=4.8U PD=4.8U
* device instance $113 r0 *1 445.82,3.11 nfet
X$113 XD3_dmodout__t2 XD3_nm__t3 VSS__t0 VSS__t239 sg13_hv_nmos L=0.5U W=2U
+ AS=0.8P AD=0.8P PS=4.8U PD=4.8U
* device instance $114 r0 *1 449.78,3.11 nfet
X$114 XD3_XDFFM_CLKB__t7 ck3__t5 VSS__t1 VSS__t240 sg13_hv_nmos L=0.5U W=2U
+ AS=0.8P AD=0.8P PS=4.8U PD=4.8U
* device instance $115 r0 *1 453.74,3.11 nfet
X$115 XD3_XDFFM_CKBB__t5 XD3_XDFFM_CLKB__t4 VSS__t2 VSS__t241 sg13_hv_nmos
+ L=0.5U W=2U AS=0.8P AD=0.8P PS=4.8U PD=4.8U
* device instance $116 r0 *1 457.7,3.11 nfet
X$116 XD3_dmodout__t3 XD3_XDFFM_CLKB__t5 XD3_XDFFM_M__t6 VSS__t242 sg13_hv_nmos
+ L=0.5U W=2U AS=0.8P AD=0.8P PS=4.8U PD=4.8U
* device instance $117 r0 *1 461.66,3.11 nfet
X$117 XD3_XDFFM_MB__t3 XD3_XDFFM_M__t4 VSS__t3 VSS__t243 sg13_hv_nmos L=0.5U
+ W=2U AS=0.8P AD=0.8P PS=4.8U PD=4.8U
* device instance $118 r0 *1 465.62,3.11 nfet
X$118 XD3_XDFFM_MFB__t2 XD3_XDFFM_MB__t2 VSS__t99 VSS__t244 sg13_hv_nmos L=0.5U
+ W=2U AS=0.8P AD=0.8P PS=4.8U PD=4.8U
* device instance $119 r0 *1 469.58,3.11 nfet
X$119 XD3_XDFFM_MFB__t3 XD3_XDFFM_CKBB__t3 XD3_XDFFM_M__t7 VSS__t245
+ sg13_hv_nmos L=0.5U W=2U AS=0.8P AD=0.8P PS=4.8U PD=4.8U
* device instance $120 r0 *1 473.54,3.11 nfet
X$120 XD3_XDFFM_M__t5 XD3_XDFFM_CKBB__t4 XD3_XDFFM_S__t4 VSS__t246 sg13_hv_nmos
+ L=0.5U W=2U AS=0.8P AD=0.8P PS=4.8U PD=4.8U
* device instance $121 r0 *1 477.5,3.11 nfet
X$121 XD3_XDFFM_SB__t5 XD3_XDFFM_S__t3 VSS__t120 VSS__t247 sg13_hv_nmos L=0.5U
+ W=2U AS=0.8P AD=0.8P PS=4.8U PD=4.8U
* device instance $122 r0 *1 481.46,3.11 nfet
X$122 XD3_XDFFM_SFB__t2 XD3_XDFFM_SB__t3 VSS__t121 VSS__t248 sg13_hv_nmos
+ L=0.5U W=2U AS=0.8P AD=0.8P PS=4.8U PD=4.8U
* device instance $123 r0 *1 485.42,3.11 nfet
X$123 XD3_XDFFM_SFB__t3 XD3_XDFFM_CLKB__t6 XD3_XDFFM_S__t5 VSS__t249
+ sg13_hv_nmos L=0.5U W=2U AS=0.8P AD=0.8P PS=4.8U PD=4.8U
* device instance $124 r0 *1 489.38,3.11 nfet
X$124 mod2__t7 XD3_XDFFM_SB__t4 VSS__t122 VSS__t250 sg13_hv_nmos L=0.5U W=2U
+ AS=0.8P AD=0.8P PS=4.8U PD=4.8U
* device instance $125 r0 *1 493.34,3.11 nfet
X$125 XD4_nt__t5 mod4__t6 XD4_XN3_mid1__t1 VSS__t251 sg13_hv_nmos L=0.5U W=2U
+ AS=0.8P AD=0.8P PS=4.8U PD=4.8U
* device instance $126 r0 *1 497.3,3.11 nfet
X$126 XD4_XN3_mid1__t0 P4__t1 XD4_XN3_mid2__t1 VSS__t252 sg13_hv_nmos L=0.5U
+ W=2U AS=0.8P AD=0.8P PS=4.8U PD=4.8U
* device instance $127 r0 *1 501.26,3.11 nfet
X$127 XD4_XN3_mid2__t0 mod3__t6 VSS__t123 VSS__t253 sg13_hv_nmos L=0.5U W=2U
+ AS=0.8P AD=0.8P PS=4.8U PD=4.8U
* device instance $128 r0 *1 505.22,3.11 nfet
X$128 XD4_t1__t3 XD4_nt__t4 VSS__t124 VSS__t254 sg13_hv_nmos L=0.5U W=2U
+ AS=0.8P AD=0.8P PS=4.8U PD=4.8U
* device instance $129 r0 *1 509.18,3.11 nfet
X$129 XD4_dq__t4 ck5__t8 VSS__t125 VSS__t255 sg13_hv_nmos L=0.5U W=2U AS=0.8P
+ AD=0.8P PS=4.8U PD=4.8U
* device instance $130 r0 *1 513.14,3.11 nfet
X$130 XD4_dq__t3 XD4_t1__t2 VSS__t118 VSS__t256 sg13_hv_nmos L=0.5U W=2U
+ AS=0.8P AD=0.8P PS=4.8U PD=4.8U
* device instance $131 r0 *1 517.1,3.11 nfet
X$131 XD4_XDFFQ_CLKB__t7 ck4__t8 VSS__t95 VSS__t257 sg13_hv_nmos L=0.5U W=2U
+ AS=0.8P AD=0.8P PS=4.8U PD=4.8U
* device instance $132 r0 *1 521.06,3.11 nfet
X$132 XD4_XDFFQ_CKBB__t5 XD4_XDFFQ_CLKB__t5 VSS__t96 VSS__t258 sg13_hv_nmos
+ L=0.5U W=2U AS=0.8P AD=0.8P PS=4.8U PD=4.8U
* device instance $133 r0 *1 525.02,3.11 nfet
X$133 XD4_dq__t2 XD4_XDFFQ_CLKB__t6 XD4_XDFFQ_M__t6 VSS__t259 sg13_hv_nmos
+ L=0.5U W=2U AS=0.8P AD=0.8P PS=4.8U PD=4.8U
* device instance $134 r0 *1 528.98,3.11 nfet
X$134 XD4_XDFFQ_MB__t3 XD4_XDFFQ_M__t4 VSS__t97 VSS__t260 sg13_hv_nmos L=0.5U
+ W=2U AS=0.8P AD=0.8P PS=4.8U PD=4.8U
* device instance $135 r0 *1 532.94,3.11 nfet
X$135 XD4_XDFFQ_MFB__t2 XD4_XDFFQ_MB__t2 VSS__t98 VSS__t261 sg13_hv_nmos L=0.5U
+ W=2U AS=0.8P AD=0.8P PS=4.8U PD=4.8U
* device instance $136 r0 *1 536.9,3.11 nfet
X$136 XD4_XDFFQ_MFB__t3 XD4_XDFFQ_CKBB__t4 XD4_XDFFQ_M__t7 VSS__t262
+ sg13_hv_nmos L=0.5U W=2U AS=0.8P AD=0.8P PS=4.8U PD=4.8U
* device instance $137 r0 *1 540.86,3.11 nfet
X$137 XD4_XDFFQ_M__t5 XD4_XDFFQ_CKBB__t3 XD4_XDFFQ_S__t4 VSS__t263 sg13_hv_nmos
+ L=0.5U W=2U AS=0.8P AD=0.8P PS=4.8U PD=4.8U
* device instance $138 r0 *1 544.82,3.11 nfet
X$138 XD4_XDFFQ_SB__t5 XD4_XDFFQ_S__t3 VSS__t78 VSS__t264 sg13_hv_nmos L=0.5U
+ W=2U AS=0.8P AD=0.8P PS=4.8U PD=4.8U
* device instance $139 r0 *1 548.78,3.11 nfet
X$139 XD4_XDFFQ_SFB__t2 XD4_XDFFQ_SB__t3 VSS__t79 VSS__t265 sg13_hv_nmos L=0.5U
+ W=2U AS=0.8P AD=0.8P PS=4.8U PD=4.8U
* device instance $140 r0 *1 552.74,3.11 nfet
X$140 XD4_XDFFQ_SFB__t3 XD4_XDFFQ_CLKB__t4 XD4_XDFFQ_S__t5 VSS__t266
+ sg13_hv_nmos L=0.5U W=2U AS=0.8P AD=0.8P PS=4.8U PD=4.8U
* device instance $141 r0 *1 556.7,3.11 nfet
X$141 ck5__t9 XD4_XDFFQ_SB__t4 VSS__t80 VSS__t267 sg13_hv_nmos L=0.5U W=2U
+ AS=0.8P AD=0.8P PS=4.8U PD=4.8U
* device instance $142 r0 *1 560.66,3.11 nfet
X$142 XD4_nm__t4 mod4__t4 XD4_XN2_mid1__t1 VSS__t268 sg13_hv_nmos L=0.5U W=2U
+ AS=0.8P AD=0.8P PS=4.8U PD=4.8U
* device instance $143 r0 *1 564.62,3.11 nfet
X$143 XD4_XN2_mid1__t0 ck5__t6 VSS__t81 VSS__t269 sg13_hv_nmos L=0.5U W=2U
+ AS=0.8P AD=0.8P PS=4.8U PD=4.8U
* device instance $144 r0 *1 568.58,3.11 nfet
X$144 XD4_dmodout__t2 XD4_nm__t3 VSS__t82 VSS__t270 sg13_hv_nmos L=0.5U W=2U
+ AS=0.8P AD=0.8P PS=4.8U PD=4.8U
* device instance $145 r0 *1 572.54,3.11 nfet
X$145 XD4_XDFFM_CLKB__t7 ck4__t7 VSS__t83 VSS__t271 sg13_hv_nmos L=0.5U W=2U
+ AS=0.8P AD=0.8P PS=4.8U PD=4.8U
* device instance $146 r0 *1 576.5,3.11 nfet
X$146 XD4_XDFFM_CKBB__t5 XD4_XDFFM_CLKB__t4 VSS__t84 VSS__t272 sg13_hv_nmos
+ L=0.5U W=2U AS=0.8P AD=0.8P PS=4.8U PD=4.8U
* device instance $147 r0 *1 580.46,3.11 nfet
X$147 XD4_dmodout__t3 XD4_XDFFM_CLKB__t5 XD4_XDFFM_M__t6 VSS__t273 sg13_hv_nmos
+ L=0.5U W=2U AS=0.8P AD=0.8P PS=4.8U PD=4.8U
* device instance $148 r0 *1 584.42,3.11 nfet
X$148 XD4_XDFFM_MB__t3 XD4_XDFFM_M__t4 VSS__t85 VSS__t274 sg13_hv_nmos L=0.5U
+ W=2U AS=0.8P AD=0.8P PS=4.8U PD=4.8U
* device instance $149 r0 *1 588.38,3.11 nfet
X$149 XD4_XDFFM_MFB__t3 XD4_XDFFM_MB__t2 VSS__t94 VSS__t275 sg13_hv_nmos L=0.5U
+ W=2U AS=0.8P AD=0.8P PS=4.8U PD=4.8U
* device instance $150 r0 *1 592.34,3.11 nfet
X$150 XD4_XDFFM_MFB__t2 XD4_XDFFM_CKBB__t3 XD4_XDFFM_M__t7 VSS__t276
+ sg13_hv_nmos L=0.5U W=2U AS=0.8P AD=0.8P PS=4.8U PD=4.8U
* device instance $151 r0 *1 596.3,3.11 nfet
X$151 XD4_XDFFM_M__t5 XD4_XDFFM_CKBB__t4 XD4_XDFFM_S__t4 VSS__t277 sg13_hv_nmos
+ L=0.5U W=2U AS=0.8P AD=0.8P PS=4.8U PD=4.8U
* device instance $152 r0 *1 600.26,3.11 nfet
X$152 XD4_XDFFM_SB__t5 XD4_XDFFM_S__t3 VSS__t87 VSS__t278 sg13_hv_nmos L=0.5U
+ W=2U AS=0.8P AD=0.8P PS=4.8U PD=4.8U
* device instance $153 r0 *1 604.22,3.11 nfet
X$153 XD4_XDFFM_SFB__t2 XD4_XDFFM_SB__t3 VSS__t88 VSS__t279 sg13_hv_nmos L=0.5U
+ W=2U AS=0.8P AD=0.8P PS=4.8U PD=4.8U
* device instance $154 r0 *1 608.18,3.11 nfet
X$154 XD4_XDFFM_SFB__t3 XD4_XDFFM_CLKB__t6 XD4_XDFFM_S__t5 VSS__t280
+ sg13_hv_nmos L=0.5U W=2U AS=0.8P AD=0.8P PS=4.8U PD=4.8U
* device instance $155 r0 *1 612.14,3.11 nfet
X$155 mod3__t7 XD4_XDFFM_SB__t4 VSS__t89 VSS__t281 sg13_hv_nmos L=0.5U W=2U
+ AS=0.8P AD=0.8P PS=4.8U PD=4.8U
* device instance $156 r0 *1 616.1,3.11 nfet
X$156 XD5_nt__t5 VDD_DIV__t339 XD5_XN3_mid1__t1 VSS__t282 sg13_hv_nmos L=0.5U
+ W=2U AS=0.8P AD=0.8P PS=4.8U PD=4.8U
* device instance $157 r0 *1 620.06,3.11 nfet
X$157 XD5_XN3_mid1__t0 P5__t1 XD5_XN3_mid2__t1 VSS__t283 sg13_hv_nmos L=0.5U
+ W=2U AS=0.8P AD=0.8P PS=4.8U PD=4.8U
* device instance $158 r0 *1 624.02,3.11 nfet
X$158 XD5_XN3_mid2__t0 mod4__t5 VSS__t90 VSS__t284 sg13_hv_nmos L=0.5U W=2U
+ AS=0.8P AD=0.8P PS=4.8U PD=4.8U
* device instance $159 r0 *1 627.98,3.11 nfet
X$159 XD5_t1__t3 XD5_nt__t4 VSS__t91 VSS__t285 sg13_hv_nmos L=0.5U W=2U AS=0.8P
+ AD=0.8P PS=4.8U PD=4.8U
* device instance $160 r0 *1 631.94,3.11 nfet
X$160 XD5_dq__t3 DIVOUT__t5 VSS__t92 VSS__t286 sg13_hv_nmos L=0.5U W=2U AS=0.8P
+ AD=0.8P PS=4.8U PD=4.8U
* device instance $161 r0 *1 635.9,3.11 nfet
X$161 XD5_dq__t4 XD5_t1__t2 VSS__t93 VSS__t287 sg13_hv_nmos L=0.5U W=2U AS=0.8P
+ AD=0.8P PS=4.8U PD=4.8U
* device instance $162 r0 *1 639.86,3.11 nfet
X$162 XD5_XDFFQ_CLKB__t7 ck5__t7 VSS__t86 VSS__t288 sg13_hv_nmos L=0.5U W=2U
+ AS=0.8P AD=0.8P PS=4.8U PD=4.8U
* device instance $163 r0 *1 643.82,3.11 nfet
X$163 XD5_XDFFQ_CKBB__t5 XD5_XDFFQ_CLKB__t4 VSS__t63 VSS__t289 sg13_hv_nmos
+ L=0.5U W=2U AS=0.8P AD=0.8P PS=4.8U PD=4.8U
* device instance $164 r0 *1 647.78,3.11 nfet
X$164 XD5_dq__t2 XD5_XDFFQ_CLKB__t5 XD5_XDFFQ_M__t6 VSS__t290 sg13_hv_nmos
+ L=0.5U W=2U AS=0.8P AD=0.8P PS=4.8U PD=4.8U
* device instance $165 r0 *1 651.74,3.11 nfet
X$165 XD5_XDFFQ_MB__t3 XD5_XDFFQ_M__t4 VSS__t64 VSS__t291 sg13_hv_nmos L=0.5U
+ W=2U AS=0.8P AD=0.8P PS=4.8U PD=4.8U
* device instance $166 r0 *1 655.7,3.11 nfet
X$166 XD5_XDFFQ_MFB__t2 XD5_XDFFQ_MB__t2 VSS__t65 VSS__t292 sg13_hv_nmos L=0.5U
+ W=2U AS=0.8P AD=0.8P PS=4.8U PD=4.8U
* device instance $167 r0 *1 659.66,3.11 nfet
X$167 XD5_XDFFQ_MFB__t3 XD5_XDFFQ_CKBB__t3 XD5_XDFFQ_M__t7 VSS__t293
+ sg13_hv_nmos L=0.5U W=2U AS=0.8P AD=0.8P PS=4.8U PD=4.8U
* device instance $168 r0 *1 663.62,3.11 nfet
X$168 XD5_XDFFQ_M__t5 XD5_XDFFQ_CKBB__t4 XD5_XDFFQ_S__t4 VSS__t294 sg13_hv_nmos
+ L=0.5U W=2U AS=0.8P AD=0.8P PS=4.8U PD=4.8U
* device instance $169 r0 *1 667.58,3.11 nfet
X$169 XD5_XDFFQ_SB__t5 XD5_XDFFQ_S__t3 VSS__t66 VSS__t295 sg13_hv_nmos L=0.5U
+ W=2U AS=0.8P AD=0.8P PS=4.8U PD=4.8U
* device instance $170 r0 *1 671.54,3.11 nfet
X$170 XD5_XDFFQ_SFB__t2 XD5_XDFFQ_SB__t3 VSS__t67 VSS__t296 sg13_hv_nmos L=0.5U
+ W=2U AS=0.8P AD=0.8P PS=4.8U PD=4.8U
* device instance $171 r0 *1 675.5,3.11 nfet
X$171 XD5_XDFFQ_SFB__t3 XD5_XDFFQ_CLKB__t6 XD5_XDFFQ_S__t5 VSS__t297
+ sg13_hv_nmos L=0.5U W=2U AS=0.8P AD=0.8P PS=4.8U PD=4.8U
* device instance $172 r0 *1 679.46,3.11 nfet
X$172 DIVOUT__t6 XD5_XDFFQ_SB__t4 VSS__t68 VSS__t298 sg13_hv_nmos L=0.5U W=2U
+ AS=0.8P AD=0.8P PS=4.8U PD=4.8U
* device instance $173 r0 *1 683.42,3.11 nfet
X$173 XD5_nm__t4 VDD_DIV__t338 XD5_XN2_mid1__t1 VSS__t299 sg13_hv_nmos L=0.5U
+ W=2U AS=0.8P AD=0.8P PS=4.8U PD=4.8U
* device instance $174 r0 *1 687.38,3.11 nfet
X$174 XD5_XN2_mid1__t0 DIVOUT__t4 VSS__t77 VSS__t300 sg13_hv_nmos L=0.5U W=2U
+ AS=0.8P AD=0.8P PS=4.8U PD=4.8U
* device instance $175 r0 *1 691.34,3.11 nfet
X$175 XD5_dmodout__t2 XD5_nm__t3 VSS__t70 VSS__t301 sg13_hv_nmos L=0.5U W=2U
+ AS=0.8P AD=0.8P PS=4.8U PD=4.8U
* device instance $176 r0 *1 695.3,3.11 nfet
X$176 XD5_XDFFM_CLKB__t7 ck5__t5 VSS__t71 VSS__t302 sg13_hv_nmos L=0.5U W=2U
+ AS=0.8P AD=0.8P PS=4.8U PD=4.8U
* device instance $177 r0 *1 699.26,3.11 nfet
X$177 XD5_XDFFM_CKBB__t5 XD5_XDFFM_CLKB__t4 VSS__t72 VSS__t303 sg13_hv_nmos
+ L=0.5U W=2U AS=0.8P AD=0.8P PS=4.8U PD=4.8U
* device instance $178 r0 *1 703.22,3.11 nfet
X$178 XD5_dmodout__t3 XD5_XDFFM_CLKB__t5 XD5_XDFFM_M__t6 VSS__t304 sg13_hv_nmos
+ L=0.5U W=2U AS=0.8P AD=0.8P PS=4.8U PD=4.8U
* device instance $179 r0 *1 707.18,3.11 nfet
X$179 XD5_XDFFM_MB__t3 XD5_XDFFM_M__t4 VSS__t73 VSS__t305 sg13_hv_nmos L=0.5U
+ W=2U AS=0.8P AD=0.8P PS=4.8U PD=4.8U
* device instance $180 r0 *1 711.14,3.11 nfet
X$180 XD5_XDFFM_MFB__t2 XD5_XDFFM_MB__t2 VSS__t74 VSS__t306 sg13_hv_nmos L=0.5U
+ W=2U AS=0.8P AD=0.8P PS=4.8U PD=4.8U
* device instance $181 r0 *1 715.1,3.11 nfet
X$181 XD5_XDFFM_MFB__t3 XD5_XDFFM_CKBB__t3 XD5_XDFFM_M__t7 VSS__t307
+ sg13_hv_nmos L=0.5U W=2U AS=0.8P AD=0.8P PS=4.8U PD=4.8U
* device instance $182 r0 *1 719.06,3.11 nfet
X$182 XD5_XDFFM_M__t5 XD5_XDFFM_CKBB__t4 XD5_XDFFM_S__t4 VSS__t308 sg13_hv_nmos
+ L=0.5U W=2U AS=0.8P AD=0.8P PS=4.8U PD=4.8U
* device instance $183 r0 *1 723.02,3.11 nfet
X$183 XD5_XDFFM_SB__t5 XD5_XDFFM_S__t3 VSS__t75 VSS__t309 sg13_hv_nmos L=0.5U
+ W=2U AS=0.8P AD=0.8P PS=4.8U PD=4.8U
* device instance $184 r0 *1 726.98,3.11 nfet
X$184 XD5_XDFFM_SFB__t2 XD5_XDFFM_SB__t3 VSS__t76 VSS__t310 sg13_hv_nmos L=0.5U
+ W=2U AS=0.8P AD=0.8P PS=4.8U PD=4.8U
* device instance $185 r0 *1 730.94,3.11 nfet
X$185 XD5_XDFFM_SFB__t3 XD5_XDFFM_CLKB__t6 XD5_XDFFM_S__t5 VSS__t311
+ sg13_hv_nmos L=0.5U W=2U AS=0.8P AD=0.8P PS=4.8U PD=4.8U
* device instance $186 r0 *1 734.9,3.11 nfet
X$186 mod4__t7 XD5_XDFFM_SB__t4 VSS__t111 VSS__t312 sg13_hv_nmos L=0.5U W=2U
+ AS=0.8P AD=0.8P PS=4.8U PD=4.8U
* device instance $187 r0 *1 738.86,3.11 nfet
X$187 XFRT_CLKB__t7 CKIN_VCO__t1 VSS__t112 VSS__t313 sg13_hv_nmos L=0.5U W=2U
+ AS=0.8P AD=0.8P PS=4.8U PD=4.8U
* device instance $188 r0 *1 742.82,3.11 nfet
X$188 XFRT_CKBB__t5 XFRT_CLKB__t4 VSS__t113 VSS__t314 sg13_hv_nmos L=0.5U W=2U
+ AS=0.8P AD=0.8P PS=4.8U PD=4.8U
* device instance $189 r0 *1 746.78,3.11 nfet
X$189 DIVOUT__t7 XFRT_CLKB__t5 XFRT_M__t6 VSS__t315 sg13_hv_nmos L=0.5U W=2U
+ AS=0.8P AD=0.8P PS=4.8U PD=4.8U
* device instance $190 r0 *1 750.74,3.11 nfet
X$190 XFRT_MB__t3 XFRT_M__t4 VSS__t114 VSS__t316 sg13_hv_nmos L=0.5U W=2U
+ AS=0.8P AD=0.8P PS=4.8U PD=4.8U
* device instance $191 r0 *1 754.7,3.11 nfet
X$191 XFRT_MFB__t2 XFRT_MB__t2 VSS__t115 VSS__t317 sg13_hv_nmos L=0.5U W=2U
+ AS=0.8P AD=0.8P PS=4.8U PD=4.8U
* device instance $192 r0 *1 758.66,3.11 nfet
X$192 XFRT_MFB__t3 XFRT_CKBB__t3 XFRT_M__t7 VSS__t318 sg13_hv_nmos L=0.5U W=2U
+ AS=0.8P AD=0.8P PS=4.8U PD=4.8U
* device instance $193 r0 *1 762.62,3.11 nfet
X$193 XFRT_M__t5 XFRT_CKBB__t4 XFRT_S__t4 VSS__t319 sg13_hv_nmos L=0.5U W=2U
+ AS=0.8P AD=0.8P PS=4.8U PD=4.8U
* device instance $194 r0 *1 766.58,3.11 nfet
X$194 XFRT_SB__t5 XFRT_S__t3 VSS__t116 VSS__t320 sg13_hv_nmos L=0.5U W=2U
+ AS=0.8P AD=0.8P PS=4.8U PD=4.8U
* device instance $195 r0 *1 770.54,3.11 nfet
X$195 XFRT_SFB__t2 XFRT_SB__t3 VSS__t117 VSS__t321 sg13_hv_nmos L=0.5U W=2U
+ AS=0.8P AD=0.8P PS=4.8U PD=4.8U
* device instance $196 r0 *1 774.5,3.11 nfet
X$196 XFRT_SFB__t3 XFRT_CLKB__t6 XFRT_S__t5 VSS__t322 sg13_hv_nmos L=0.5U W=2U
+ AS=0.8P AD=0.8P PS=4.8U PD=4.8U
* device instance $197 r0 *1 778.46,3.11 nfet
X$197 FB__t1 XFRT_SB__t4 VSS__t126 VSS__t323 sg13_hv_nmos L=0.5U W=2U AS=0.8P
+ AD=0.8P PS=4.8U PD=4.8U
* device instance $198 r0 *1 790.56,3.11 pfet
X$198 XD0_nt__t3 mod0__t2 VDD_DIV__t1 VDD_DIV__t0 sg13_hv_pmos L=0.5U W=5U
+ AS=2P AD=2P PS=10.8U PD=10.8U
* device instance $199 r0 *1 797.52,3.11 pfet
X$199 XD0_nt__t2 P0__t0 VDD_DIV__t54 VDD_DIV__t213 sg13_hv_pmos L=0.5U W=5U
+ AS=2P AD=2P PS=10.8U PD=10.8U
* device instance $200 r0 *1 804.48,3.11 pfet
X$200 XD0_nt__t1 net1__t0 VDD_DIV__t53 VDD_DIV__t212 sg13_hv_pmos L=0.5U W=5U
+ AS=2P AD=2P PS=10.8U PD=10.8U
* device instance $201 r0 *1 811.44,3.11 pfet
X$201 XD0_t1__t1 XD0_nt__t0 VDD_DIV__t60 VDD_DIV__t222 sg13_hv_pmos L=0.5U W=5U
+ AS=2P AD=2P PS=10.8U PD=10.8U
* device instance $202 r0 *1 818.4,3.11 pfet
X$202 XD0_XNOR_midp__t0 ck1__t1 VDD_DIV__t61 VDD_DIV__t223 sg13_hv_pmos L=0.5U
+ W=5U AS=2P AD=2P PS=10.8U PD=10.8U
* device instance $203 r0 *1 825.36,3.11 pfet
X$203 XD0_dq__t0 XD0_t1__t0 XD0_XNOR_midp__t1 VDD_DIV__t224 sg13_hv_pmos L=0.5U
+ W=5U AS=2P AD=2P PS=10.8U PD=10.8U
* device instance $204 r0 *1 832.32,3.11 pfet
X$204 XD0_XDFFQ_CLKB__t3 CKIN__t0 VDD_DIV__t62 VDD_DIV__t225 sg13_hv_pmos
+ L=0.5U W=5U AS=2P AD=2P PS=10.8U PD=10.8U
* device instance $205 r0 *1 839.28,3.11 pfet
X$205 XD0_XDFFQ_CKBB__t2 XD0_XDFFQ_CLKB__t2 VDD_DIV__t72 VDD_DIV__t239
+ sg13_hv_pmos L=0.5U W=5U AS=2P AD=2P PS=10.8U PD=10.8U
* device instance $206 r0 *1 846.24,3.11 pfet
X$206 XD0_XDFFQ_M__t2 XD0_XDFFQ_CKBB__t0 XD0_dq__t1 VDD_DIV__t227 sg13_hv_pmos
+ L=0.5U W=5U AS=2P AD=2P PS=10.8U PD=10.8U
* device instance $207 r0 *1 853.2,3.11 pfet
X$207 XD0_XDFFQ_MB__t1 XD0_XDFFQ_M__t1 VDD_DIV__t64 VDD_DIV__t228 sg13_hv_pmos
+ L=0.5U W=5U AS=2P AD=2P PS=10.8U PD=10.8U
* device instance $208 r0 *1 860.16,3.11 pfet
X$208 XD0_XDFFQ_MFB__t0 XD0_XDFFQ_MB__t0 VDD_DIV__t65 VDD_DIV__t229
+ sg13_hv_pmos L=0.5U W=5U AS=2P AD=2P PS=10.8U PD=10.8U
* device instance $209 r0 *1 867.12,3.11 pfet
X$209 XD0_XDFFQ_M__t3 XD0_XDFFQ_CLKB__t0 XD0_XDFFQ_MFB__t1 VDD_DIV__t230
+ sg13_hv_pmos L=0.5U W=5U AS=2P AD=2P PS=10.8U PD=10.8U
* device instance $210 r0 *1 874.08,3.11 pfet
X$210 XD0_XDFFQ_S__t1 XD0_XDFFQ_CLKB__t1 XD0_XDFFQ_M__t4 VDD_DIV__t231
+ sg13_hv_pmos L=0.5U W=5U AS=2P AD=2P PS=10.8U PD=10.8U
* device instance $211 r0 *1 881.04,3.11 pfet
X$211 XD0_XDFFQ_SB__t2 XD0_XDFFQ_S__t0 VDD_DIV__t66 VDD_DIV__t232 sg13_hv_pmos
+ L=0.5U W=5U AS=2P AD=2P PS=10.8U PD=10.8U
* device instance $212 r0 *1 888,3.11 pfet
X$212 XD0_XDFFQ_SFB__t0 XD0_XDFFQ_SB__t0 VDD_DIV__t67 VDD_DIV__t233
+ sg13_hv_pmos L=0.5U W=5U AS=2P AD=2P PS=10.8U PD=10.8U
* device instance $213 r0 *1 894.96,3.11 pfet
X$213 XD0_XDFFQ_S__t2 XD0_XDFFQ_CKBB__t1 XD0_XDFFQ_SFB__t1 VDD_DIV__t234
+ sg13_hv_pmos L=0.5U W=5U AS=2P AD=2P PS=10.8U PD=10.8U
* device instance $214 r0 *1 901.92,3.11 pfet
X$214 ck1__t4 XD0_XDFFQ_SB__t1 VDD_DIV__t68 VDD_DIV__t235 sg13_hv_pmos L=0.5U
+ W=5U AS=2P AD=2P PS=10.8U PD=10.8U
* device instance $215 r0 *1 908.88,3.11 pfet
X$215 XD0_nm__t1 mod0__t1 VDD_DIV__t69 VDD_DIV__t236 sg13_hv_pmos L=0.5U W=5U
+ AS=2P AD=2P PS=10.8U PD=10.8U
* device instance $216 r0 *1 915.84,3.11 pfet
X$216 XD0_nm__t2 ck1__t2 VDD_DIV__t70 VDD_DIV__t237 sg13_hv_pmos L=0.5U W=5U
+ AS=2P AD=2P PS=10.8U PD=10.8U
* device instance $217 r0 *1 922.8,3.11 pfet
X$217 XD0_dmodout__t0 XD0_nm__t0 VDD_DIV__t71 VDD_DIV__t238 sg13_hv_pmos L=0.5U
+ W=5U AS=2P AD=2P PS=10.8U PD=10.8U
* device instance $218 r0 *1 929.76,3.11 pfet
X$218 XD0_XDFFM_CLKB__t3 CKIN__t1 VDD_DIV__t63 VDD_DIV__t226 sg13_hv_pmos
+ L=0.5U W=5U AS=2P AD=2P PS=10.8U PD=10.8U
* device instance $219 r0 *1 936.72,3.11 pfet
X$219 XD0_XDFFM_CKBB__t2 XD0_XDFFM_CLKB__t0 VDD_DIV__t38 VDD_DIV__t191
+ sg13_hv_pmos L=0.5U W=5U AS=2P AD=2P PS=10.8U PD=10.8U
* device instance $220 r0 *1 943.68,3.11 pfet
X$220 XD0_XDFFM_M__t1 XD0_XDFFM_CKBB__t0 XD0_dmodout__t1 VDD_DIV__t192
+ sg13_hv_pmos L=0.5U W=5U AS=2P AD=2P PS=10.8U PD=10.8U
* device instance $221 r0 *1 950.64,3.11 pfet
X$221 XD0_XDFFM_MB__t1 XD0_XDFFM_M__t0 VDD_DIV__t39 VDD_DIV__t193 sg13_hv_pmos
+ L=0.5U W=5U AS=2P AD=2P PS=10.8U PD=10.8U
* device instance $222 r0 *1 957.6,3.11 pfet
X$222 XD0_XDFFM_MFB__t0 XD0_XDFFM_MB__t0 VDD_DIV__t40 VDD_DIV__t194
+ sg13_hv_pmos L=0.5U W=5U AS=2P AD=2P PS=10.8U PD=10.8U
* device instance $223 r0 *1 964.56,3.11 pfet
X$223 XD0_XDFFM_M__t2 XD0_XDFFM_CLKB__t1 XD0_XDFFM_MFB__t1 VDD_DIV__t195
+ sg13_hv_pmos L=0.5U W=5U AS=2P AD=2P PS=10.8U PD=10.8U
* device instance $224 r0 *1 971.52,3.11 pfet
X$224 XD0_XDFFM_S__t1 XD0_XDFFM_CLKB__t2 XD0_XDFFM_M__t3 VDD_DIV__t196
+ sg13_hv_pmos L=0.5U W=5U AS=2P AD=2P PS=10.8U PD=10.8U
* device instance $225 r0 *1 978.48,3.11 pfet
X$225 XD0_XDFFM_SB__t2 XD0_XDFFM_S__t0 VDD_DIV__t41 VDD_DIV__t197 sg13_hv_pmos
+ L=0.5U W=5U AS=2P AD=2P PS=10.8U PD=10.8U
* device instance $226 r0 *1 985.44,3.11 pfet
X$226 XD0_XDFFM_SFB__t0 XD0_XDFFM_SB__t0 VDD_DIV__t42 VDD_DIV__t198
+ sg13_hv_pmos L=0.5U W=5U AS=2P AD=2P PS=10.8U PD=10.8U
* device instance $227 r0 *1 992.4,3.11 pfet
X$227 XD0_XDFFM_S__t2 XD0_XDFFM_CKBB__t1 XD0_XDFFM_SFB__t1 VDD_DIV__t199
+ sg13_hv_pmos L=0.5U W=5U AS=2P AD=2P PS=10.8U PD=10.8U
* device instance $228 r0 *1 999.36,3.11 pfet
X$228 net1__t1 XD0_XDFFM_SB__t1 VDD_DIV__t43 VDD_DIV__t200 sg13_hv_pmos L=0.5U
+ W=5U AS=2P AD=2P PS=10.8U PD=10.8U
* device instance $229 r0 *1 1006.32,3.11 pfet
X$229 XD1_nt__t1 mod1__t1 VDD_DIV__t44 VDD_DIV__t201 sg13_hv_pmos L=0.5U W=5U
+ AS=2P AD=2P PS=10.8U PD=10.8U
* device instance $230 r0 *1 1013.28,3.11 pfet
X$230 XD1_nt__t3 P1__t0 VDD_DIV__t55 VDD_DIV__t214 sg13_hv_pmos L=0.5U W=5U
+ AS=2P AD=2P PS=10.8U PD=10.8U
* device instance $231 r0 *1 1020.24,3.11 pfet
X$231 XD1_nt__t2 mod0__t0 VDD_DIV__t46 VDD_DIV__t203 sg13_hv_pmos L=0.5U W=5U
+ AS=2P AD=2P PS=10.8U PD=10.8U
* device instance $232 r0 *1 1027.2,3.11 pfet
X$232 XD1_t1__t1 XD1_nt__t0 VDD_DIV__t47 VDD_DIV__t204 sg13_hv_pmos L=0.5U W=5U
+ AS=2P AD=2P PS=10.8U PD=10.8U
* device instance $233 r0 *1 1034.16,3.11 pfet
X$233 XD1_XNOR_midp__t0 ck2__t2 VDD_DIV__t48 VDD_DIV__t205 sg13_hv_pmos L=0.5U
+ W=5U AS=2P AD=2P PS=10.8U PD=10.8U
* device instance $234 r0 *1 1041.12,3.11 pfet
X$234 XD1_dq__t0 XD1_t1__t0 XD1_XNOR_midp__t1 VDD_DIV__t206 sg13_hv_pmos L=0.5U
+ W=5U AS=2P AD=2P PS=10.8U PD=10.8U
* device instance $235 r0 *1 1048.08,3.11 pfet
X$235 XD1_XDFFQ_CLKB__t3 ck1__t0 VDD_DIV__t49 VDD_DIV__t207 sg13_hv_pmos L=0.5U
+ W=5U AS=2P AD=2P PS=10.8U PD=10.8U
* device instance $236 r0 *1 1055.04,3.11 pfet
X$236 XD1_XDFFQ_CKBB__t2 XD1_XDFFQ_CLKB__t0 VDD_DIV__t50 VDD_DIV__t208
+ sg13_hv_pmos L=0.5U W=5U AS=2P AD=2P PS=10.8U PD=10.8U
* device instance $237 r0 *1 1062,3.11 pfet
X$237 XD1_XDFFQ_M__t1 XD1_XDFFQ_CKBB__t0 XD1_dq__t1 VDD_DIV__t209 sg13_hv_pmos
+ L=0.5U W=5U AS=2P AD=2P PS=10.8U PD=10.8U
* device instance $238 r0 *1 1068.96,3.11 pfet
X$238 XD1_XDFFQ_MB__t1 XD1_XDFFQ_M__t0 VDD_DIV__t51 VDD_DIV__t210 sg13_hv_pmos
+ L=0.5U W=5U AS=2P AD=2P PS=10.8U PD=10.8U
* device instance $239 r0 *1 1075.92,3.11 pfet
X$239 XD1_XDFFQ_MFB__t0 XD1_XDFFQ_MB__t0 VDD_DIV__t52 VDD_DIV__t211
+ sg13_hv_pmos L=0.5U W=5U AS=2P AD=2P PS=10.8U PD=10.8U
* device instance $240 r0 *1 1082.88,3.11 pfet
X$240 XD1_XDFFQ_M__t2 XD1_XDFFQ_CLKB__t1 XD1_XDFFQ_MFB__t1 VDD_DIV__t221
+ sg13_hv_pmos L=0.5U W=5U AS=2P AD=2P PS=10.8U PD=10.8U
* device instance $241 r0 *1 1089.84,3.11 pfet
X$241 XD1_XDFFQ_S__t1 XD1_XDFFQ_CLKB__t2 XD1_XDFFQ_M__t3 VDD_DIV__t292
+ sg13_hv_pmos L=0.5U W=5U AS=2P AD=2P PS=10.8U PD=10.8U
* device instance $242 r0 *1 1096.8,3.11 pfet
X$242 XD1_XDFFQ_SB__t2 XD1_XDFFQ_S__t0 VDD_DIV__t110 VDD_DIV__t293 sg13_hv_pmos
+ L=0.5U W=5U AS=2P AD=2P PS=10.8U PD=10.8U
* device instance $243 r0 *1 1103.76,3.11 pfet
X$243 XD1_XDFFQ_SFB__t0 XD1_XDFFQ_SB__t0 VDD_DIV__t111 VDD_DIV__t294
+ sg13_hv_pmos L=0.5U W=5U AS=2P AD=2P PS=10.8U PD=10.8U
* device instance $244 r0 *1 1110.72,3.11 pfet
X$244 XD1_XDFFQ_S__t2 XD1_XDFFQ_CKBB__t1 XD1_XDFFQ_SFB__t1 VDD_DIV__t295
+ sg13_hv_pmos L=0.5U W=5U AS=2P AD=2P PS=10.8U PD=10.8U
* device instance $245 r0 *1 1117.68,3.11 pfet
X$245 ck2__t4 XD1_XDFFQ_SB__t1 VDD_DIV__t112 VDD_DIV__t296 sg13_hv_pmos L=0.5U
+ W=5U AS=2P AD=2P PS=10.8U PD=10.8U
* device instance $246 r0 *1 1124.64,3.11 pfet
X$246 XD1_nm__t1 mod1__t2 VDD_DIV__t113 VDD_DIV__t297 sg13_hv_pmos L=0.5U W=5U
+ AS=2P AD=2P PS=10.8U PD=10.8U
* device instance $247 r0 *1 1131.6,3.11 pfet
X$247 XD1_nm__t2 ck2__t3 VDD_DIV__t114 VDD_DIV__t298 sg13_hv_pmos L=0.5U W=5U
+ AS=2P AD=2P PS=10.8U PD=10.8U
* device instance $248 r0 *1 1138.56,3.11 pfet
X$248 XD1_dmodout__t0 XD1_nm__t0 VDD_DIV__t115 VDD_DIV__t299 sg13_hv_pmos
+ L=0.5U W=5U AS=2P AD=2P PS=10.8U PD=10.8U
* device instance $249 r0 *1 1145.52,3.11 pfet
X$249 XD1_XDFFM_CLKB__t3 ck1__t3 VDD_DIV__t124 VDD_DIV__t312 sg13_hv_pmos
+ L=0.5U W=5U AS=2P AD=2P PS=10.8U PD=10.8U
* device instance $250 r0 *1 1152.48,3.11 pfet
X$250 XD1_XDFFM_CKBB__t2 XD1_XDFFM_CLKB__t0 VDD_DIV__t117 VDD_DIV__t301
+ sg13_hv_pmos L=0.5U W=5U AS=2P AD=2P PS=10.8U PD=10.8U
* device instance $251 r0 *1 1159.44,3.11 pfet
X$251 XD1_XDFFM_M__t1 XD1_XDFFM_CKBB__t0 XD1_dmodout__t1 VDD_DIV__t302
+ sg13_hv_pmos L=0.5U W=5U AS=2P AD=2P PS=10.8U PD=10.8U
* device instance $252 r0 *1 1166.4,3.11 pfet
X$252 XD1_XDFFM_MB__t1 XD1_XDFFM_M__t0 VDD_DIV__t118 VDD_DIV__t303 sg13_hv_pmos
+ L=0.5U W=5U AS=2P AD=2P PS=10.8U PD=10.8U
* device instance $253 r0 *1 1173.36,3.11 pfet
X$253 XD1_XDFFM_MFB__t0 XD1_XDFFM_MB__t0 VDD_DIV__t119 VDD_DIV__t304
+ sg13_hv_pmos L=0.5U W=5U AS=2P AD=2P PS=10.8U PD=10.8U
* device instance $254 r0 *1 1180.32,3.11 pfet
X$254 XD1_XDFFM_M__t2 XD1_XDFFM_CLKB__t1 XD1_XDFFM_MFB__t1 VDD_DIV__t305
+ sg13_hv_pmos L=0.5U W=5U AS=2P AD=2P PS=10.8U PD=10.8U
* device instance $255 r0 *1 1187.28,3.11 pfet
X$255 XD1_XDFFM_S__t1 XD1_XDFFM_CLKB__t2 XD1_XDFFM_M__t3 VDD_DIV__t306
+ sg13_hv_pmos L=0.5U W=5U AS=2P AD=2P PS=10.8U PD=10.8U
* device instance $256 r0 *1 1194.24,3.11 pfet
X$256 XD1_XDFFM_SB__t2 XD1_XDFFM_S__t0 VDD_DIV__t120 VDD_DIV__t307 sg13_hv_pmos
+ L=0.5U W=5U AS=2P AD=2P PS=10.8U PD=10.8U
* device instance $257 r0 *1 1201.2,3.11 pfet
X$257 XD1_XDFFM_SFB__t0 XD1_XDFFM_SB__t0 VDD_DIV__t121 VDD_DIV__t308
+ sg13_hv_pmos L=0.5U W=5U AS=2P AD=2P PS=10.8U PD=10.8U
* device instance $258 r0 *1 1208.16,3.11 pfet
X$258 XD1_XDFFM_S__t2 XD1_XDFFM_CKBB__t1 XD1_XDFFM_SFB__t1 VDD_DIV__t309
+ sg13_hv_pmos L=0.5U W=5U AS=2P AD=2P PS=10.8U PD=10.8U
* device instance $259 r0 *1 1215.12,3.11 pfet
X$259 mod0__t3 XD1_XDFFM_SB__t1 VDD_DIV__t122 VDD_DIV__t310 sg13_hv_pmos L=0.5U
+ W=5U AS=2P AD=2P PS=10.8U PD=10.8U
* device instance $260 r0 *1 1222.08,3.11 pfet
X$260 XD2_nt__t3 mod2__t2 VDD_DIV__t123 VDD_DIV__t311 sg13_hv_pmos L=0.5U W=5U
+ AS=2P AD=2P PS=10.8U PD=10.8U
* device instance $261 r0 *1 1229.04,3.11 pfet
X$261 XD2_nt__t2 P2__t0 VDD_DIV__t80 VDD_DIV__t251 sg13_hv_pmos L=0.5U W=5U
+ AS=2P AD=2P PS=10.8U PD=10.8U
* device instance $262 r0 *1 1236,3.11 pfet
X$262 XD2_nt__t1 mod1__t0 VDD_DIV__t21 VDD_DIV__t166 sg13_hv_pmos L=0.5U W=5U
+ AS=2P AD=2P PS=10.8U PD=10.8U
* device instance $263 r0 *1 1242.96,3.11 pfet
X$263 XD2_t1__t1 XD2_nt__t0 VDD_DIV__t22 VDD_DIV__t167 sg13_hv_pmos L=0.5U W=5U
+ AS=2P AD=2P PS=10.8U PD=10.8U
* device instance $264 r0 *1 1249.92,3.11 pfet
X$264 XD2_XNOR_midp__t0 ck3__t1 VDD_DIV__t23 VDD_DIV__t168 sg13_hv_pmos L=0.5U
+ W=5U AS=2P AD=2P PS=10.8U PD=10.8U
* device instance $265 r0 *1 1256.88,3.11 pfet
X$265 XD2_dq__t0 XD2_t1__t0 XD2_XNOR_midp__t1 VDD_DIV__t169 sg13_hv_pmos L=0.5U
+ W=5U AS=2P AD=2P PS=10.8U PD=10.8U
* device instance $266 r0 *1 1263.84,3.11 pfet
X$266 XD2_XDFFQ_CLKB__t3 ck2__t0 VDD_DIV__t24 VDD_DIV__t170 sg13_hv_pmos L=0.5U
+ W=5U AS=2P AD=2P PS=10.8U PD=10.8U
* device instance $267 r0 *1 1270.8,3.11 pfet
X$267 XD2_XDFFQ_CKBB__t2 XD2_XDFFQ_CLKB__t0 VDD_DIV__t25 VDD_DIV__t171
+ sg13_hv_pmos L=0.5U W=5U AS=2P AD=2P PS=10.8U PD=10.8U
* device instance $268 r0 *1 1277.76,3.11 pfet
X$268 XD2_XDFFQ_M__t1 XD2_XDFFQ_CKBB__t0 XD2_dq__t1 VDD_DIV__t172 sg13_hv_pmos
+ L=0.5U W=5U AS=2P AD=2P PS=10.8U PD=10.8U
* device instance $269 r0 *1 1284.72,3.11 pfet
X$269 XD2_XDFFQ_MB__t1 XD2_XDFFQ_M__t0 VDD_DIV__t26 VDD_DIV__t173 sg13_hv_pmos
+ L=0.5U W=5U AS=2P AD=2P PS=10.8U PD=10.8U
* device instance $270 r0 *1 1291.68,3.11 pfet
X$270 XD2_XDFFQ_MFB__t0 XD2_XDFFQ_MB__t0 VDD_DIV__t27 VDD_DIV__t174
+ sg13_hv_pmos L=0.5U W=5U AS=2P AD=2P PS=10.8U PD=10.8U
* device instance $271 r0 *1 1298.64,3.11 pfet
X$271 XD2_XDFFQ_M__t2 XD2_XDFFQ_CLKB__t1 XD2_XDFFQ_MFB__t1 VDD_DIV__t175
+ sg13_hv_pmos L=0.5U W=5U AS=2P AD=2P PS=10.8U PD=10.8U
* device instance $272 r0 *1 1305.6,3.11 pfet
X$272 XD2_XDFFQ_S__t1 XD2_XDFFQ_CLKB__t2 XD2_XDFFQ_M__t3 VDD_DIV__t176
+ sg13_hv_pmos L=0.5U W=5U AS=2P AD=2P PS=10.8U PD=10.8U
* device instance $273 r0 *1 1312.56,3.11 pfet
X$273 XD2_XDFFQ_SB__t2 XD2_XDFFQ_S__t0 VDD_DIV__t37 VDD_DIV__t190 sg13_hv_pmos
+ L=0.5U W=5U AS=2P AD=2P PS=10.8U PD=10.8U
* device instance $274 r0 *1 1319.52,3.11 pfet
X$274 XD2_XDFFQ_SFB__t0 XD2_XDFFQ_SB__t0 VDD_DIV__t28 VDD_DIV__t178
+ sg13_hv_pmos L=0.5U W=5U AS=2P AD=2P PS=10.8U PD=10.8U
* device instance $275 r0 *1 1326.48,3.11 pfet
X$275 XD2_XDFFQ_S__t2 XD2_XDFFQ_CKBB__t1 XD2_XDFFQ_SFB__t1 VDD_DIV__t179
+ sg13_hv_pmos L=0.5U W=5U AS=2P AD=2P PS=10.8U PD=10.8U
* device instance $276 r0 *1 1333.44,3.11 pfet
X$276 ck3__t4 XD2_XDFFQ_SB__t1 VDD_DIV__t29 VDD_DIV__t180 sg13_hv_pmos L=0.5U
+ W=5U AS=2P AD=2P PS=10.8U PD=10.8U
* device instance $277 r0 *1 1340.4,3.11 pfet
X$277 XD2_nm__t1 mod2__t1 VDD_DIV__t30 VDD_DIV__t181 sg13_hv_pmos L=0.5U W=5U
+ AS=2P AD=2P PS=10.8U PD=10.8U
* device instance $278 r0 *1 1347.36,3.11 pfet
X$278 XD2_nm__t2 ck3__t2 VDD_DIV__t31 VDD_DIV__t182 sg13_hv_pmos L=0.5U W=5U
+ AS=2P AD=2P PS=10.8U PD=10.8U
* device instance $279 r0 *1 1354.32,3.11 pfet
X$279 XD2_dmodout__t0 XD2_nm__t0 VDD_DIV__t32 VDD_DIV__t183 sg13_hv_pmos L=0.5U
+ W=5U AS=2P AD=2P PS=10.8U PD=10.8U
* device instance $280 r0 *1 1361.28,3.11 pfet
X$280 XD2_XDFFM_CLKB__t3 ck2__t1 VDD_DIV__t33 VDD_DIV__t184 sg13_hv_pmos L=0.5U
+ W=5U AS=2P AD=2P PS=10.8U PD=10.8U
* device instance $281 r0 *1 1368.24,3.11 pfet
X$281 XD2_XDFFM_CKBB__t2 XD2_XDFFM_CLKB__t1 VDD_DIV__t34 VDD_DIV__t185
+ sg13_hv_pmos L=0.5U W=5U AS=2P AD=2P PS=10.8U PD=10.8U
* device instance $282 r0 *1 1375.2,3.11 pfet
X$282 XD2_XDFFM_M__t1 XD2_XDFFM_CKBB__t1 XD2_dmodout__t1 VDD_DIV__t186
+ sg13_hv_pmos L=0.5U W=5U AS=2P AD=2P PS=10.8U PD=10.8U
* device instance $283 r0 *1 1382.16,3.11 pfet
X$283 XD2_XDFFM_MB__t1 XD2_XDFFM_M__t0 VDD_DIV__t35 VDD_DIV__t187 sg13_hv_pmos
+ L=0.5U W=5U AS=2P AD=2P PS=10.8U PD=10.8U
* device instance $284 r0 *1 1389.12,3.11 pfet
X$284 XD2_XDFFM_MFB__t0 XD2_XDFFM_MB__t0 VDD_DIV__t36 VDD_DIV__t188
+ sg13_hv_pmos L=0.5U W=5U AS=2P AD=2P PS=10.8U PD=10.8U
* device instance $285 r0 *1 1396.08,3.11 pfet
X$285 XD2_XDFFM_M__t2 XD2_XDFFM_CLKB__t2 XD2_XDFFM_MFB__t1 VDD_DIV__t189
+ sg13_hv_pmos L=0.5U W=5U AS=2P AD=2P PS=10.8U PD=10.8U
* device instance $286 r0 *1 1403.04,3.11 pfet
X$286 XD2_XDFFM_S__t2 XD2_XDFFM_CLKB__t0 XD2_XDFFM_M__t3 VDD_DIV__t177
+ sg13_hv_pmos L=0.5U W=5U AS=2P AD=2P PS=10.8U PD=10.8U
* device instance $287 r0 *1 1410,3.11 pfet
X$287 XD2_XDFFM_SB__t2 XD2_XDFFM_S__t0 VDD_DIV__t4 VDD_DIV__t142 sg13_hv_pmos
+ L=0.5U W=5U AS=2P AD=2P PS=10.8U PD=10.8U
* device instance $288 r0 *1 1416.96,3.11 pfet
X$288 XD2_XDFFM_SFB__t0 XD2_XDFFM_SB__t0 VDD_DIV__t5 VDD_DIV__t143 sg13_hv_pmos
+ L=0.5U W=5U AS=2P AD=2P PS=10.8U PD=10.8U
* device instance $289 r0 *1 1423.92,3.11 pfet
X$289 XD2_XDFFM_S__t1 XD2_XDFFM_CKBB__t0 XD2_XDFFM_SFB__t1 VDD_DIV__t144
+ sg13_hv_pmos L=0.5U W=5U AS=2P AD=2P PS=10.8U PD=10.8U
* device instance $290 r0 *1 1430.88,3.11 pfet
X$290 mod1__t3 XD2_XDFFM_SB__t1 VDD_DIV__t6 VDD_DIV__t145 sg13_hv_pmos L=0.5U
+ W=5U AS=2P AD=2P PS=10.8U PD=10.8U
* device instance $291 r0 *1 1437.84,3.11 pfet
X$291 XD3_nt__t1 mod3__t0 VDD_DIV__t7 VDD_DIV__t146 sg13_hv_pmos L=0.5U W=5U
+ AS=2P AD=2P PS=10.8U PD=10.8U
* device instance $292 r0 *1 1444.8,3.11 pfet
X$292 XD3_nt__t2 P3__t0 VDD_DIV__t8 VDD_DIV__t147 sg13_hv_pmos L=0.5U W=5U
+ AS=2P AD=2P PS=10.8U PD=10.8U
* device instance $293 r0 *1 1451.76,3.11 pfet
X$293 XD3_nt__t3 mod2__t0 VDD_DIV__t9 VDD_DIV__t148 sg13_hv_pmos L=0.5U W=5U
+ AS=2P AD=2P PS=10.8U PD=10.8U
* device instance $294 r0 *1 1458.72,3.11 pfet
X$294 XD3_t1__t1 XD3_nt__t0 VDD_DIV__t10 VDD_DIV__t149 sg13_hv_pmos L=0.5U W=5U
+ AS=2P AD=2P PS=10.8U PD=10.8U
* device instance $295 r0 *1 1465.68,3.11 pfet
X$295 XD3_XNOR_midp__t0 ck4__t0 VDD_DIV__t11 VDD_DIV__t150 sg13_hv_pmos L=0.5U
+ W=5U AS=2P AD=2P PS=10.8U PD=10.8U
* device instance $296 r0 *1 1472.64,3.11 pfet
X$296 XD3_dq__t0 XD3_t1__t0 XD3_XNOR_midp__t1 VDD_DIV__t151 sg13_hv_pmos L=0.5U
+ W=5U AS=2P AD=2P PS=10.8U PD=10.8U
* device instance $297 r0 *1 1479.6,3.11 pfet
X$297 XD3_XDFFQ_CLKB__t3 ck3__t0 VDD_DIV__t12 VDD_DIV__t152 sg13_hv_pmos L=0.5U
+ W=5U AS=2P AD=2P PS=10.8U PD=10.8U
* device instance $298 r0 *1 1486.56,3.11 pfet
X$298 XD3_XDFFQ_CKBB__t2 XD3_XDFFQ_CLKB__t2 VDD_DIV__t20 VDD_DIV__t165
+ sg13_hv_pmos L=0.5U W=5U AS=2P AD=2P PS=10.8U PD=10.8U
* device instance $299 r0 *1 1493.52,3.11 pfet
X$299 XD3_XDFFQ_M__t1 XD3_XDFFQ_CKBB__t0 XD3_dq__t1 VDD_DIV__t154 sg13_hv_pmos
+ L=0.5U W=5U AS=2P AD=2P PS=10.8U PD=10.8U
* device instance $300 r0 *1 1500.48,3.11 pfet
X$300 XD3_XDFFQ_MB__t1 XD3_XDFFQ_M__t0 VDD_DIV__t13 VDD_DIV__t155 sg13_hv_pmos
+ L=0.5U W=5U AS=2P AD=2P PS=10.8U PD=10.8U
* device instance $301 r0 *1 1507.44,3.11 pfet
X$301 XD3_XDFFQ_MFB__t0 XD3_XDFFQ_MB__t0 VDD_DIV__t14 VDD_DIV__t156
+ sg13_hv_pmos L=0.5U W=5U AS=2P AD=2P PS=10.8U PD=10.8U
* device instance $302 r0 *1 1514.4,3.11 pfet
X$302 XD3_XDFFQ_M__t2 XD3_XDFFQ_CLKB__t0 XD3_XDFFQ_MFB__t1 VDD_DIV__t157
+ sg13_hv_pmos L=0.5U W=5U AS=2P AD=2P PS=10.8U PD=10.8U
* device instance $303 r0 *1 1521.36,3.11 pfet
X$303 XD3_XDFFQ_S__t1 XD3_XDFFQ_CLKB__t1 XD3_XDFFQ_M__t3 VDD_DIV__t158
+ sg13_hv_pmos L=0.5U W=5U AS=2P AD=2P PS=10.8U PD=10.8U
* device instance $304 r0 *1 1528.32,3.11 pfet
X$304 XD3_XDFFQ_SB__t2 XD3_XDFFQ_S__t0 VDD_DIV__t15 VDD_DIV__t159 sg13_hv_pmos
+ L=0.5U W=5U AS=2P AD=2P PS=10.8U PD=10.8U
* device instance $305 r0 *1 1535.28,3.11 pfet
X$305 XD3_XDFFQ_SFB__t0 XD3_XDFFQ_SB__t0 VDD_DIV__t16 VDD_DIV__t160
+ sg13_hv_pmos L=0.5U W=5U AS=2P AD=2P PS=10.8U PD=10.8U
* device instance $306 r0 *1 1542.24,3.11 pfet
X$306 XD3_XDFFQ_S__t2 XD3_XDFFQ_CKBB__t1 XD3_XDFFQ_SFB__t1 VDD_DIV__t161
+ sg13_hv_pmos L=0.5U W=5U AS=2P AD=2P PS=10.8U PD=10.8U
* device instance $307 r0 *1 1549.2,3.11 pfet
X$307 ck4__t4 XD3_XDFFQ_SB__t1 VDD_DIV__t17 VDD_DIV__t162 sg13_hv_pmos L=0.5U
+ W=5U AS=2P AD=2P PS=10.8U PD=10.8U
* device instance $308 r0 *1 1556.16,3.11 pfet
X$308 XD3_nm__t1 mod3__t1 VDD_DIV__t18 VDD_DIV__t163 sg13_hv_pmos L=0.5U W=5U
+ AS=2P AD=2P PS=10.8U PD=10.8U
* device instance $309 r0 *1 1563.12,3.11 pfet
X$309 XD3_nm__t2 ck4__t1 VDD_DIV__t19 VDD_DIV__t164 sg13_hv_pmos L=0.5U W=5U
+ AS=2P AD=2P PS=10.8U PD=10.8U
* device instance $310 r0 *1 1570.08,3.11 pfet
X$310 XD3_dmodout__t0 XD3_nm__t0 VDD_DIV__t45 VDD_DIV__t202 sg13_hv_pmos L=0.5U
+ W=5U AS=2P AD=2P PS=10.8U PD=10.8U
* device instance $311 r0 *1 1577.04,3.11 pfet
X$311 XD3_XDFFM_CLKB__t3 ck3__t3 VDD_DIV__t56 VDD_DIV__t215 sg13_hv_pmos L=0.5U
+ W=5U AS=2P AD=2P PS=10.8U PD=10.8U
* device instance $312 r0 *1 1584,3.11 pfet
X$312 XD3_XDFFM_CKBB__t2 XD3_XDFFM_CLKB__t1 VDD_DIV__t57 VDD_DIV__t216
+ sg13_hv_pmos L=0.5U W=5U AS=2P AD=2P PS=10.8U PD=10.8U
* device instance $313 r0 *1 1590.96,3.11 pfet
X$313 XD3_XDFFM_M__t1 XD3_XDFFM_CKBB__t0 XD3_dmodout__t1 VDD_DIV__t217
+ sg13_hv_pmos L=0.5U W=5U AS=2P AD=2P PS=10.8U PD=10.8U
* device instance $314 r0 *1 1597.92,3.11 pfet
X$314 XD3_XDFFM_MB__t1 XD3_XDFFM_M__t0 VDD_DIV__t58 VDD_DIV__t218 sg13_hv_pmos
+ L=0.5U W=5U AS=2P AD=2P PS=10.8U PD=10.8U
* device instance $315 r0 *1 1604.88,3.11 pfet
X$315 XD3_XDFFM_MFB__t0 XD3_XDFFM_MB__t0 VDD_DIV__t59 VDD_DIV__t219
+ sg13_hv_pmos L=0.5U W=5U AS=2P AD=2P PS=10.8U PD=10.8U
* device instance $316 r0 *1 1611.84,3.11 pfet
X$316 XD3_XDFFM_M__t2 XD3_XDFFM_CLKB__t2 XD3_XDFFM_MFB__t1 VDD_DIV__t220
+ sg13_hv_pmos L=0.5U W=5U AS=2P AD=2P PS=10.8U PD=10.8U
* device instance $317 r0 *1 1618.8,3.11 pfet
X$317 XD3_XDFFM_S__t1 XD3_XDFFM_CLKB__t0 XD3_XDFFM_M__t3 VDD_DIV__t153
+ sg13_hv_pmos L=0.5U W=5U AS=2P AD=2P PS=10.8U PD=10.8U
* device instance $318 r0 *1 1625.76,3.11 pfet
X$318 XD3_XDFFM_SB__t2 XD3_XDFFM_S__t0 VDD_DIV__t89 VDD_DIV__t264 sg13_hv_pmos
+ L=0.5U W=5U AS=2P AD=2P PS=10.8U PD=10.8U
* device instance $319 r0 *1 1632.72,3.11 pfet
X$319 XD3_XDFFM_SFB__t0 XD3_XDFFM_SB__t0 VDD_DIV__t90 VDD_DIV__t265
+ sg13_hv_pmos L=0.5U W=5U AS=2P AD=2P PS=10.8U PD=10.8U
* device instance $320 r0 *1 1639.68,3.11 pfet
X$320 XD3_XDFFM_S__t2 XD3_XDFFM_CKBB__t1 XD3_XDFFM_SFB__t1 VDD_DIV__t266
+ sg13_hv_pmos L=0.5U W=5U AS=2P AD=2P PS=10.8U PD=10.8U
* device instance $321 r0 *1 1646.64,3.11 pfet
X$321 mod2__t3 XD3_XDFFM_SB__t1 VDD_DIV__t91 VDD_DIV__t267 sg13_hv_pmos L=0.5U
+ W=5U AS=2P AD=2P PS=10.8U PD=10.8U
* device instance $322 r0 *1 1653.6,3.11 pfet
X$322 XD4_nt__t1 mod4__t1 VDD_DIV__t92 VDD_DIV__t268 sg13_hv_pmos L=0.5U W=5U
+ AS=2P AD=2P PS=10.8U PD=10.8U
* device instance $323 r0 *1 1660.56,3.11 pfet
X$323 XD4_nt__t2 P4__t0 VDD_DIV__t93 VDD_DIV__t269 sg13_hv_pmos L=0.5U W=5U
+ AS=2P AD=2P PS=10.8U PD=10.8U
* device instance $324 r0 *1 1667.52,3.11 pfet
X$324 XD4_nt__t3 mod3__t2 VDD_DIV__t94 VDD_DIV__t270 sg13_hv_pmos L=0.5U W=5U
+ AS=2P AD=2P PS=10.8U PD=10.8U
* device instance $325 r0 *1 1674.48,3.11 pfet
X$325 XD4_t1__t1 XD4_nt__t0 VDD_DIV__t95 VDD_DIV__t271 sg13_hv_pmos L=0.5U W=5U
+ AS=2P AD=2P PS=10.8U PD=10.8U
* device instance $326 r0 *1 1681.44,3.11 pfet
X$326 XD4_XNOR_midp__t0 ck5__t1 VDD_DIV__t96 VDD_DIV__t272 sg13_hv_pmos L=0.5U
+ W=5U AS=2P AD=2P PS=10.8U PD=10.8U
* device instance $327 r0 *1 1688.4,3.11 pfet
X$327 XD4_dq__t0 XD4_t1__t0 XD4_XNOR_midp__t1 VDD_DIV__t273 sg13_hv_pmos L=0.5U
+ W=5U AS=2P AD=2P PS=10.8U PD=10.8U
* device instance $328 r0 *1 1695.36,3.11 pfet
X$328 XD4_XDFFQ_CLKB__t3 ck4__t2 VDD_DIV__t97 VDD_DIV__t274 sg13_hv_pmos L=0.5U
+ W=5U AS=2P AD=2P PS=10.8U PD=10.8U
* device instance $329 r0 *1 1702.32,3.11 pfet
X$329 XD4_XDFFQ_CKBB__t2 XD4_XDFFQ_CLKB__t2 VDD_DIV__t107 VDD_DIV__t288
+ sg13_hv_pmos L=0.5U W=5U AS=2P AD=2P PS=10.8U PD=10.8U
* device instance $330 r0 *1 1709.28,3.11 pfet
X$330 XD4_XDFFQ_M__t1 XD4_XDFFQ_CKBB__t0 XD4_dq__t1 VDD_DIV__t276 sg13_hv_pmos
+ L=0.5U W=5U AS=2P AD=2P PS=10.8U PD=10.8U
* device instance $331 r0 *1 1716.24,3.11 pfet
X$331 XD4_XDFFQ_MB__t1 XD4_XDFFQ_M__t0 VDD_DIV__t99 VDD_DIV__t277 sg13_hv_pmos
+ L=0.5U W=5U AS=2P AD=2P PS=10.8U PD=10.8U
* device instance $332 r0 *1 1723.2,3.11 pfet
X$332 XD4_XDFFQ_MFB__t0 XD4_XDFFQ_MB__t0 VDD_DIV__t100 VDD_DIV__t278
+ sg13_hv_pmos L=0.5U W=5U AS=2P AD=2P PS=10.8U PD=10.8U
* device instance $333 r0 *1 1730.16,3.11 pfet
X$333 XD4_XDFFQ_M__t2 XD4_XDFFQ_CLKB__t0 XD4_XDFFQ_MFB__t1 VDD_DIV__t279
+ sg13_hv_pmos L=0.5U W=5U AS=2P AD=2P PS=10.8U PD=10.8U
* device instance $334 r0 *1 1737.12,3.11 pfet
X$334 XD4_XDFFQ_S__t1 XD4_XDFFQ_CLKB__t1 XD4_XDFFQ_M__t3 VDD_DIV__t280
+ sg13_hv_pmos L=0.5U W=5U AS=2P AD=2P PS=10.8U PD=10.8U
* device instance $335 r0 *1 1744.08,3.11 pfet
X$335 XD4_XDFFQ_SB__t2 XD4_XDFFQ_S__t0 VDD_DIV__t101 VDD_DIV__t281 sg13_hv_pmos
+ L=0.5U W=5U AS=2P AD=2P PS=10.8U PD=10.8U
* device instance $336 r0 *1 1751.04,3.11 pfet
X$336 XD4_XDFFQ_SFB__t0 XD4_XDFFQ_SB__t0 VDD_DIV__t102 VDD_DIV__t282
+ sg13_hv_pmos L=0.5U W=5U AS=2P AD=2P PS=10.8U PD=10.8U
* device instance $337 r0 *1 1758,3.11 pfet
X$337 XD4_XDFFQ_S__t2 XD4_XDFFQ_CKBB__t1 XD4_XDFFQ_SFB__t1 VDD_DIV__t283
+ sg13_hv_pmos L=0.5U W=5U AS=2P AD=2P PS=10.8U PD=10.8U
* device instance $338 r0 *1 1764.96,3.11 pfet
X$338 ck5__t4 XD4_XDFFQ_SB__t1 VDD_DIV__t103 VDD_DIV__t284 sg13_hv_pmos L=0.5U
+ W=5U AS=2P AD=2P PS=10.8U PD=10.8U
* device instance $339 r0 *1 1771.92,3.11 pfet
X$339 XD4_nm__t1 mod4__t2 VDD_DIV__t104 VDD_DIV__t285 sg13_hv_pmos L=0.5U W=5U
+ AS=2P AD=2P PS=10.8U PD=10.8U
* device instance $340 r0 *1 1778.88,3.11 pfet
X$340 XD4_nm__t2 ck5__t2 VDD_DIV__t105 VDD_DIV__t286 sg13_hv_pmos L=0.5U W=5U
+ AS=2P AD=2P PS=10.8U PD=10.8U
* device instance $341 r0 *1 1785.84,3.11 pfet
X$341 XD4_dmodout__t0 XD4_nm__t0 VDD_DIV__t106 VDD_DIV__t287 sg13_hv_pmos
+ L=0.5U W=5U AS=2P AD=2P PS=10.8U PD=10.8U
* device instance $342 r0 *1 1792.8,3.11 pfet
X$342 XD4_XDFFM_CLKB__t3 ck4__t3 VDD_DIV__t98 VDD_DIV__t275 sg13_hv_pmos L=0.5U
+ W=5U AS=2P AD=2P PS=10.8U PD=10.8U
* device instance $343 r0 *1 1799.76,3.11 pfet
X$343 XD4_XDFFM_CKBB__t2 XD4_XDFFM_CLKB__t0 VDD_DIV__t73 VDD_DIV__t240
+ sg13_hv_pmos L=0.5U W=5U AS=2P AD=2P PS=10.8U PD=10.8U
* device instance $344 r0 *1 1806.72,3.11 pfet
X$344 XD4_XDFFM_M__t1 XD4_XDFFM_CKBB__t0 XD4_dmodout__t1 VDD_DIV__t241
+ sg13_hv_pmos L=0.5U W=5U AS=2P AD=2P PS=10.8U PD=10.8U
* device instance $345 r0 *1 1813.68,3.11 pfet
X$345 XD4_XDFFM_MB__t1 XD4_XDFFM_M__t0 VDD_DIV__t74 VDD_DIV__t242 sg13_hv_pmos
+ L=0.5U W=5U AS=2P AD=2P PS=10.8U PD=10.8U
* device instance $346 r0 *1 1820.64,3.11 pfet
X$346 XD4_XDFFM_MFB__t0 XD4_XDFFM_MB__t0 VDD_DIV__t75 VDD_DIV__t243
+ sg13_hv_pmos L=0.5U W=5U AS=2P AD=2P PS=10.8U PD=10.8U
* device instance $347 r0 *1 1827.6,3.11 pfet
X$347 XD4_XDFFM_M__t2 XD4_XDFFM_CLKB__t1 XD4_XDFFM_MFB__t1 VDD_DIV__t244
+ sg13_hv_pmos L=0.5U W=5U AS=2P AD=2P PS=10.8U PD=10.8U
* device instance $348 r0 *1 1834.56,3.11 pfet
X$348 XD4_XDFFM_S__t1 XD4_XDFFM_CLKB__t2 XD4_XDFFM_M__t3 VDD_DIV__t245
+ sg13_hv_pmos L=0.5U W=5U AS=2P AD=2P PS=10.8U PD=10.8U
* device instance $349 r0 *1 1841.52,3.11 pfet
X$349 XD4_XDFFM_SB__t2 XD4_XDFFM_S__t0 VDD_DIV__t76 VDD_DIV__t246 sg13_hv_pmos
+ L=0.5U W=5U AS=2P AD=2P PS=10.8U PD=10.8U
* device instance $350 r0 *1 1848.48,3.11 pfet
X$350 XD4_XDFFM_SFB__t0 XD4_XDFFM_SB__t0 VDD_DIV__t77 VDD_DIV__t247
+ sg13_hv_pmos L=0.5U W=5U AS=2P AD=2P PS=10.8U PD=10.8U
* device instance $351 r0 *1 1855.44,3.11 pfet
X$351 XD4_XDFFM_S__t2 XD4_XDFFM_CKBB__t1 XD4_XDFFM_SFB__t1 VDD_DIV__t248
+ sg13_hv_pmos L=0.5U W=5U AS=2P AD=2P PS=10.8U PD=10.8U
* device instance $352 r0 *1 1862.4,3.11 pfet
X$352 mod3__t3 XD4_XDFFM_SB__t1 VDD_DIV__t78 VDD_DIV__t249 sg13_hv_pmos L=0.5U
+ W=5U AS=2P AD=2P PS=10.8U PD=10.8U
* device instance $353 r0 *1 1869.36,3.11 pfet
X$353 XD5_nt__t1 VDD_DIV__t2 VDD_DIV__t79 VDD_DIV__t250 sg13_hv_pmos L=0.5U
+ W=5U AS=2P AD=2P PS=10.8U PD=10.8U
* device instance $354 r0 *1 1876.32,3.11 pfet
X$354 XD5_nt__t3 P5__t0 VDD_DIV__t88 VDD_DIV__t263 sg13_hv_pmos L=0.5U W=5U
+ AS=2P AD=2P PS=10.8U PD=10.8U
* device instance $355 r0 *1 1883.28,3.11 pfet
X$355 XD5_nt__t2 mod4__t0 VDD_DIV__t81 VDD_DIV__t252 sg13_hv_pmos L=0.5U W=5U
+ AS=2P AD=2P PS=10.8U PD=10.8U
* device instance $356 r0 *1 1890.24,3.11 pfet
X$356 XD5_t1__t1 XD5_nt__t0 VDD_DIV__t82 VDD_DIV__t253 sg13_hv_pmos L=0.5U W=5U
+ AS=2P AD=2P PS=10.8U PD=10.8U
* device instance $357 r0 *1 1897.2,3.11 pfet
X$357 XD5_XNOR_midp__t0 DIVOUT__t0 VDD_DIV__t83 VDD_DIV__t254 sg13_hv_pmos
+ L=0.5U W=5U AS=2P AD=2P PS=10.8U PD=10.8U
* device instance $358 r0 *1 1904.16,3.11 pfet
X$358 XD5_dq__t0 XD5_t1__t0 XD5_XNOR_midp__t1 VDD_DIV__t255 sg13_hv_pmos L=0.5U
+ W=5U AS=2P AD=2P PS=10.8U PD=10.8U
* device instance $359 r0 *1 1911.12,3.11 pfet
X$359 XD5_XDFFQ_CLKB__t3 ck5__t0 VDD_DIV__t84 VDD_DIV__t256 sg13_hv_pmos L=0.5U
+ W=5U AS=2P AD=2P PS=10.8U PD=10.8U
* device instance $360 r0 *1 1918.08,3.11 pfet
X$360 XD5_XDFFQ_CKBB__t2 XD5_XDFFQ_CLKB__t0 VDD_DIV__t85 VDD_DIV__t257
+ sg13_hv_pmos L=0.5U W=5U AS=2P AD=2P PS=10.8U PD=10.8U
* device instance $361 r0 *1 1925.04,3.11 pfet
X$361 XD5_XDFFQ_M__t1 XD5_XDFFQ_CKBB__t0 XD5_dq__t1 VDD_DIV__t258 sg13_hv_pmos
+ L=0.5U W=5U AS=2P AD=2P PS=10.8U PD=10.8U
* device instance $362 r0 *1 1932,3.11 pfet
X$362 XD5_XDFFQ_MB__t1 XD5_XDFFQ_M__t0 VDD_DIV__t86 VDD_DIV__t259 sg13_hv_pmos
+ L=0.5U W=5U AS=2P AD=2P PS=10.8U PD=10.8U
* device instance $363 r0 *1 1938.96,3.11 pfet
X$363 XD5_XDFFQ_MFB__t0 XD5_XDFFQ_MB__t0 VDD_DIV__t87 VDD_DIV__t260
+ sg13_hv_pmos L=0.5U W=5U AS=2P AD=2P PS=10.8U PD=10.8U
* device instance $364 r0 *1 1945.92,3.11 pfet
X$364 XD5_XDFFQ_M__t2 XD5_XDFFQ_CLKB__t1 XD5_XDFFQ_MFB__t1 VDD_DIV__t261
+ sg13_hv_pmos L=0.5U W=5U AS=2P AD=2P PS=10.8U PD=10.8U
* device instance $365 r0 *1 1952.88,3.11 pfet
X$365 XD5_XDFFQ_S__t1 XD5_XDFFQ_CLKB__t2 XD5_XDFFQ_M__t3 VDD_DIV__t262
+ sg13_hv_pmos L=0.5U W=5U AS=2P AD=2P PS=10.8U PD=10.8U
* device instance $366 r0 *1 1959.84,3.11 pfet
X$366 XD5_XDFFQ_SB__t2 XD5_XDFFQ_S__t0 VDD_DIV__t116 VDD_DIV__t300 sg13_hv_pmos
+ L=0.5U W=5U AS=2P AD=2P PS=10.8U PD=10.8U
* device instance $367 r0 *1 1966.8,3.11 pfet
X$367 XD5_XDFFQ_SFB__t0 XD5_XDFFQ_SB__t0 VDD_DIV__t125 VDD_DIV__t313
+ sg13_hv_pmos L=0.5U W=5U AS=2P AD=2P PS=10.8U PD=10.8U
* device instance $368 r0 *1 1973.76,3.11 pfet
X$368 XD5_XDFFQ_S__t2 XD5_XDFFQ_CKBB__t1 XD5_XDFFQ_SFB__t1 VDD_DIV__t314
+ sg13_hv_pmos L=0.5U W=5U AS=2P AD=2P PS=10.8U PD=10.8U
* device instance $369 r0 *1 1980.72,3.11 pfet
X$369 DIVOUT__t2 XD5_XDFFQ_SB__t1 VDD_DIV__t126 VDD_DIV__t315 sg13_hv_pmos
+ L=0.5U W=5U AS=2P AD=2P PS=10.8U PD=10.8U
* device instance $370 r0 *1 1987.68,3.11 pfet
X$370 XD5_nm__t1 VDD_DIV__t3 VDD_DIV__t127 VDD_DIV__t316 sg13_hv_pmos L=0.5U
+ W=5U AS=2P AD=2P PS=10.8U PD=10.8U
* device instance $371 r0 *1 1994.64,3.11 pfet
X$371 XD5_nm__t2 DIVOUT__t1 VDD_DIV__t128 VDD_DIV__t317 sg13_hv_pmos L=0.5U
+ W=5U AS=2P AD=2P PS=10.8U PD=10.8U
* device instance $372 r0 *1 2001.6,3.11 pfet
X$372 XD5_dmodout__t0 XD5_nm__t0 VDD_DIV__t129 VDD_DIV__t318 sg13_hv_pmos
+ L=0.5U W=5U AS=2P AD=2P PS=10.8U PD=10.8U
* device instance $373 r0 *1 2008.56,3.11 pfet
X$373 XD5_XDFFM_CLKB__t3 ck5__t3 VDD_DIV__t130 VDD_DIV__t319 sg13_hv_pmos
+ L=0.5U W=5U AS=2P AD=2P PS=10.8U PD=10.8U
* device instance $374 r0 *1 2015.52,3.11 pfet
X$374 XD5_XDFFM_CKBB__t2 XD5_XDFFM_CLKB__t0 VDD_DIV__t131 VDD_DIV__t320
+ sg13_hv_pmos L=0.5U W=5U AS=2P AD=2P PS=10.8U PD=10.8U
* device instance $375 r0 *1 2022.48,3.11 pfet
X$375 XD5_XDFFM_M__t1 XD5_XDFFM_CKBB__t0 XD5_dmodout__t1 VDD_DIV__t321
+ sg13_hv_pmos L=0.5U W=5U AS=2P AD=2P PS=10.8U PD=10.8U
* device instance $376 r0 *1 2029.44,3.11 pfet
X$376 XD5_XDFFM_MB__t1 XD5_XDFFM_M__t0 VDD_DIV__t132 VDD_DIV__t322 sg13_hv_pmos
+ L=0.5U W=5U AS=2P AD=2P PS=10.8U PD=10.8U
* device instance $377 r0 *1 2036.4,3.11 pfet
X$377 XD5_XDFFM_MFB__t0 XD5_XDFFM_MB__t0 VDD_DIV__t133 VDD_DIV__t323
+ sg13_hv_pmos L=0.5U W=5U AS=2P AD=2P PS=10.8U PD=10.8U
* device instance $378 r0 *1 2043.36,3.11 pfet
X$378 XD5_XDFFM_M__t2 XD5_XDFFM_CLKB__t2 XD5_XDFFM_MFB__t1 VDD_DIV__t337
+ sg13_hv_pmos L=0.5U W=5U AS=2P AD=2P PS=10.8U PD=10.8U
* device instance $379 r0 *1 2050.32,3.11 pfet
X$379 XD5_XDFFM_S__t1 XD5_XDFFM_CLKB__t1 XD5_XDFFM_M__t3 VDD_DIV__t325
+ sg13_hv_pmos L=0.5U W=5U AS=2P AD=2P PS=10.8U PD=10.8U
* device instance $380 r0 *1 2057.28,3.11 pfet
X$380 XD5_XDFFM_SB__t2 XD5_XDFFM_S__t0 VDD_DIV__t135 VDD_DIV__t326 sg13_hv_pmos
+ L=0.5U W=5U AS=2P AD=2P PS=10.8U PD=10.8U
* device instance $381 r0 *1 2064.24,3.11 pfet
X$381 XD5_XDFFM_SFB__t0 XD5_XDFFM_SB__t0 VDD_DIV__t136 VDD_DIV__t327
+ sg13_hv_pmos L=0.5U W=5U AS=2P AD=2P PS=10.8U PD=10.8U
* device instance $382 r0 *1 2071.2,3.11 pfet
X$382 XD5_XDFFM_S__t2 XD5_XDFFM_CKBB__t1 XD5_XDFFM_SFB__t1 VDD_DIV__t328
+ sg13_hv_pmos L=0.5U W=5U AS=2P AD=2P PS=10.8U PD=10.8U
* device instance $383 r0 *1 2078.16,3.11 pfet
X$383 mod4__t3 XD5_XDFFM_SB__t1 VDD_DIV__t137 VDD_DIV__t329 sg13_hv_pmos L=0.5U
+ W=5U AS=2P AD=2P PS=10.8U PD=10.8U
* device instance $384 r0 *1 2085.12,3.11 pfet
X$384 XFRT_CLKB__t3 CKIN_VCO__t0 VDD_DIV__t138 VDD_DIV__t330 sg13_hv_pmos
+ L=0.5U W=5U AS=2P AD=2P PS=10.8U PD=10.8U
* device instance $385 r0 *1 2092.08,3.11 pfet
X$385 XFRT_CKBB__t2 XFRT_CLKB__t0 VDD_DIV__t139 VDD_DIV__t331 sg13_hv_pmos
+ L=0.5U W=5U AS=2P AD=2P PS=10.8U PD=10.8U
* device instance $386 r0 *1 2099.04,3.11 pfet
X$386 XFRT_M__t1 XFRT_CKBB__t1 DIVOUT__t3 VDD_DIV__t332 sg13_hv_pmos L=0.5U
+ W=5U AS=2P AD=2P PS=10.8U PD=10.8U
* device instance $387 r0 *1 2106,3.11 pfet
X$387 XFRT_MB__t1 XFRT_M__t0 VDD_DIV__t140 VDD_DIV__t333 sg13_hv_pmos L=0.5U
+ W=5U AS=2P AD=2P PS=10.8U PD=10.8U
* device instance $388 r0 *1 2112.96,3.11 pfet
X$388 XFRT_MFB__t0 XFRT_MB__t0 VDD_DIV__t141 VDD_DIV__t334 sg13_hv_pmos L=0.5U
+ W=5U AS=2P AD=2P PS=10.8U PD=10.8U
* device instance $389 r0 *1 2119.92,3.11 pfet
X$389 XFRT_M__t2 XFRT_CLKB__t1 XFRT_MFB__t1 VDD_DIV__t335 sg13_hv_pmos L=0.5U
+ W=5U AS=2P AD=2P PS=10.8U PD=10.8U
* device instance $390 r0 *1 2126.88,3.11 pfet
X$390 XFRT_S__t2 XFRT_CLKB__t2 XFRT_M__t3 VDD_DIV__t336 sg13_hv_pmos L=0.5U
+ W=5U AS=2P AD=2P PS=10.8U PD=10.8U
* device instance $391 r0 *1 2133.84,3.11 pfet
X$391 XFRT_SB__t2 XFRT_S__t0 VDD_DIV__t134 VDD_DIV__t324 sg13_hv_pmos L=0.5U
+ W=5U AS=2P AD=2P PS=10.8U PD=10.8U
* device instance $392 r0 *1 2140.8,3.11 pfet
X$392 XFRT_SFB__t0 XFRT_SB__t0 VDD_DIV__t108 VDD_DIV__t289 sg13_hv_pmos L=0.5U
+ W=5U AS=2P AD=2P PS=10.8U PD=10.8U
* device instance $393 r0 *1 2147.76,3.11 pfet
X$393 XFRT_S__t1 XFRT_CKBB__t0 XFRT_SFB__t1 VDD_DIV__t290 sg13_hv_pmos L=0.5U
+ W=5U AS=2P AD=2P PS=10.8U PD=10.8U
* device instance $394 r0 *1 2154.72,3.11 pfet
X$394 FB__t0 XFRT_SB__t1 VDD_DIV__t109 VDD_DIV__t291 sg13_hv_pmos L=0.5U W=5U
+ AS=2P AD=2P PS=10.8U PD=10.8U
* device instance CKIN_t0 r0 *1 0,0
RCKIN_t0 CKIN__t0 CKIN 59.859668603
* device instance CKIN_t1 r0 *1 0,0
RCKIN_t1 CKIN__t1 CKIN 75.843681397
* device instance CKIN_t2 r0 *1 0,0
RCKIN_t2 CKIN__t2 CKIN 72.3988510535
* device instance CKIN_t3 r0 *1 0,0
RCKIN_t3 CKIN__t3 CKIN 63.3044989465
* device instance CKIN r0 *1 0,0
CCKIN CKIN vsubs 5.9477936e-14
* device instance CKIN_VCO_t0 r0 *1 0,0
RCKIN_VCO_t0 CKIN_VCO__t0 CKIN_VCO 199.01145
* device instance CKIN_VCO_t1 r0 *1 0,0
RCKIN_VCO_t1 CKIN_VCO__t1 CKIN_VCO 199.01145
* device instance CKIN_VCO r0 *1 0,0
CCKIN_VCO CKIN_VCO vsubs 8.7562311e-14
* device instance DIVOUT_t0 r0 *1 0,0
RDIVOUT_t0 DIVOUT__t0 DIVOUT 48.1743570121
* device instance DIVOUT_t1 r0 *1 0,0
RDIVOUT_t1 DIVOUT__t1 DIVOUT 56.5934535089
* device instance DIVOUT_t2 r0 *1 0,0
RDIVOUT_t2 DIVOUT__t2 DIVOUT 55.3907254379
* device instance DIVOUT_t3 r0 *1 0,0
RDIVOUT_t3 DIVOUT__t3 DIVOUT 65.6139140411
* device instance DIVOUT_t4 r0 *1 0,0
RDIVOUT_t4 DIVOUT__t4 DIVOUT 56.3575736501
* device instance DIVOUT_t5 r0 *1 0,0
RDIVOUT_t5 DIVOUT__t5 DIVOUT 61.1477492431
* device instance DIVOUT_t6 r0 *1 0,0
RDIVOUT_t6 DIVOUT__t6 DIVOUT 57.0418844491
* device instance DIVOUT_t7 r0 *1 0,0
RDIVOUT_t7 DIVOUT__t7 DIVOUT 51.2252426576
* device instance DIVOUT r0 *1 0,0
CDIVOUT DIVOUT vsubs 9.9295544e-14
* device instance FB_t0 r0 *1 0,0
RFB_t0 FB__t0 FB 204.8868
* device instance FB_t1 r0 *1 0,0
RFB_t1 FB__t1 FB 204.8868
* device instance FB r0 *1 0,0
CFB FB vsubs 9.0130486e-14
* device instance P0_t0 r0 *1 0,0
RP0_t0 P0__t0 P0 118.13815
* device instance P0_t1 r0 *1 0,0
RP0_t1 P0__t1 P0 118.13815
* device instance P0 r0 *1 0,0
CP0 P0 vsubs 5.181313e-14
* device instance P1_t0 r0 *1 0,0
RP1_t0 P1__t0 P1 131.95385
* device instance P1_t1 r0 *1 0,0
RP1_t1 P1__t1 P1 131.95385
* device instance P1 r0 *1 0,0
CP1 P1 vsubs 5.7941249e-14
* device instance P2_t0 r0 *1 0,0
RP2_t0 P2__t0 P2 145.76965
* device instance P2_t1 r0 *1 0,0
RP2_t1 P2__t1 P2 145.76965
* device instance P2 r0 *1 0,0
CP2 P2 vsubs 6.4069368e-14
* device instance P3_t0 r0 *1 0,0
RP3_t0 P3__t0 P3 159.58545
* device instance P3_t1 r0 *1 0,0
RP3_t1 P3__t1 P3 159.58545
* device instance P3 r0 *1 0,0
CP3 P3 vsubs 7.0197486e-14
* device instance P4_t0 r0 *1 0,0
RP4_t0 P4__t0 P4 173.40125
* device instance P4_t1 r0 *1 0,0
RP4_t1 P4__t1 P4 173.40125
* device instance P4 r0 *1 0,0
CP4 P4 vsubs 7.6325605e-14
* device instance P5_t0 r0 *1 0,0
RP5_t0 P5__t0 P5 187.2171
* device instance P5_t1 r0 *1 0,0
RP5_t1 P5__t1 P5 187.2171
* device instance P5 r0 *1 0,0
CP5 P5 vsubs 8.2453724e-14
* device instance VDD_DIV_t0 r0 *1 0,0
RVDD_DIV_t0 VDD_DIV__t0 VDD_DIV 8.51334633147
* device instance VDD_DIV_t1 r0 *1 0,0
RVDD_DIV_t1 VDD_DIV__t1 VDD_DIV 8.51334633147
* device instance VDD_DIV_t2 r0 *1 0,0
RVDD_DIV_t2 VDD_DIV__t2 VDD_DIV 5.07005048683
* device instance VDD_DIV_t3 r0 *1 0,0
RVDD_DIV_t3 VDD_DIV__t3 VDD_DIV 6.55984239593
* device instance VDD_DIV_t4 r0 *1 0,0
RVDD_DIV_t4 VDD_DIV__t4 VDD_DIV 0.713847513221
* device instance VDD_DIV_t5 r0 *1 0,0
RVDD_DIV_t5 VDD_DIV__t5 VDD_DIV 0.626212695039
* device instance VDD_DIV_t6 r0 *1 0,0
RVDD_DIV_t6 VDD_DIV__t6 VDD_DIV 0.450943058674
* device instance VDD_DIV_t7 r0 *1 0,0
RVDD_DIV_t7 VDD_DIV__t7 VDD_DIV 0.363308240491
* device instance VDD_DIV_t8 r0 *1 0,0
RVDD_DIV_t8 VDD_DIV__t8 VDD_DIV 0.275673422309
* device instance VDD_DIV_t9 r0 *1 0,0
RVDD_DIV_t9 VDD_DIV__t9 VDD_DIV 0.188038604126
* device instance VDD_DIV_t10 r0 *1 0,0
RVDD_DIV_t10 VDD_DIV__t10 VDD_DIV 0.100403785943
* device instance VDD_DIV_t11 r0 *1 0,0
RVDD_DIV_t11 VDD_DIV__t11 VDD_DIV 0.0127689677609
* device instance VDD_DIV_t12 r0 *1 0,0
RVDD_DIV_t12 VDD_DIV__t12 VDD_DIV 0.162500668604
* device instance VDD_DIV_t13 r0 *1 0,0
RVDD_DIV_t13 VDD_DIV__t13 VDD_DIV 0.425405123152
* device instance VDD_DIV_t14 r0 *1 0,0
RVDD_DIV_t14 VDD_DIV__t14 VDD_DIV 0.513039941334
* device instance VDD_DIV_t15 r0 *1 0,0
RVDD_DIV_t15 VDD_DIV__t15 VDD_DIV 0.775944395882
* device instance VDD_DIV_t16 r0 *1 0,0
RVDD_DIV_t16 VDD_DIV__t16 VDD_DIV 0.863579214065
* device instance VDD_DIV_t17 r0 *1 0,0
RVDD_DIV_t17 VDD_DIV__t17 VDD_DIV 1.03884885043
* device instance VDD_DIV_t18 r0 *1 0,0
RVDD_DIV_t18 VDD_DIV__t18 VDD_DIV 1.12648366861
* device instance VDD_DIV_t19 r0 *1 0,0
RVDD_DIV_t19 VDD_DIV__t19 VDD_DIV 1.21411848679
* device instance VDD_DIV_t20 r0 *1 0,0
RVDD_DIV_t20 VDD_DIV__t20 VDD_DIV 0.250135486787
* device instance VDD_DIV_t21 r0 *1 0,0
RVDD_DIV_t21 VDD_DIV__t21 VDD_DIV 2.90471796778
* device instance VDD_DIV_t22 r0 *1 0,0
RVDD_DIV_t22 VDD_DIV__t22 VDD_DIV 2.8170831496
* device instance VDD_DIV_t23 r0 *1 0,0
RVDD_DIV_t23 VDD_DIV__t23 VDD_DIV 2.72944833142
* device instance VDD_DIV_t24 r0 *1 0,0
RVDD_DIV_t24 VDD_DIV__t24 VDD_DIV 2.55417869505
* device instance VDD_DIV_t25 r0 *1 0,0
RVDD_DIV_t25 VDD_DIV__t25 VDD_DIV 2.46654387687
* device instance VDD_DIV_t26 r0 *1 0,0
RVDD_DIV_t26 VDD_DIV__t26 VDD_DIV 2.29127424051
* device instance VDD_DIV_t27 r0 *1 0,0
RVDD_DIV_t27 VDD_DIV__t27 VDD_DIV 2.20363942232
* device instance VDD_DIV_t28 r0 *1 0,0
RVDD_DIV_t28 VDD_DIV__t28 VDD_DIV 1.85310014959
* device instance VDD_DIV_t29 r0 *1 0,0
RVDD_DIV_t29 VDD_DIV__t29 VDD_DIV 1.67783051323
* device instance VDD_DIV_t30 r0 *1 0,0
RVDD_DIV_t30 VDD_DIV__t30 VDD_DIV 1.59019569505
* device instance VDD_DIV_t31 r0 *1 0,0
RVDD_DIV_t31 VDD_DIV__t31 VDD_DIV 1.50256087686
* device instance VDD_DIV_t32 r0 *1 0,0
RVDD_DIV_t32 VDD_DIV__t32 VDD_DIV 1.41492605868
* device instance VDD_DIV_t33 r0 *1 0,0
RVDD_DIV_t33 VDD_DIV__t33 VDD_DIV 1.3272912405
* device instance VDD_DIV_t34 r0 *1 0,0
RVDD_DIV_t34 VDD_DIV__t34 VDD_DIV 1.23965642232
* device instance VDD_DIV_t35 r0 *1 0,0
RVDD_DIV_t35 VDD_DIV__t35 VDD_DIV 1.06438678595
* device instance VDD_DIV_t36 r0 *1 0,0
RVDD_DIV_t36 VDD_DIV__t36 VDD_DIV 0.976751967769
* device instance VDD_DIV_t37 r0 *1 0,0
RVDD_DIV_t37 VDD_DIV__t37 VDD_DIV 1.94073496778
* device instance VDD_DIV_t38 r0 *1 0,0
RVDD_DIV_t38 VDD_DIV__t38 VDD_DIV 6.67301514963
* device instance VDD_DIV_t39 r0 *1 0,0
RVDD_DIV_t39 VDD_DIV__t39 VDD_DIV 6.49774551327
* device instance VDD_DIV_t40 r0 *1 0,0
RVDD_DIV_t40 VDD_DIV__t40 VDD_DIV 6.41011069509
* device instance VDD_DIV_t41 r0 *1 0,0
RVDD_DIV_t41 VDD_DIV__t41 VDD_DIV 6.14720624054
* device instance VDD_DIV_t42 r0 *1 0,0
RVDD_DIV_t42 VDD_DIV__t42 VDD_DIV 6.05957142236
* device instance VDD_DIV_t43 r0 *1 0,0
RVDD_DIV_t43 VDD_DIV__t43 VDD_DIV 5.88430178599
* device instance VDD_DIV_t44 r0 *1 0,0
RVDD_DIV_t44 VDD_DIV__t44 VDD_DIV 5.79666696781
* device instance VDD_DIV_t45 r0 *1 0,0
RVDD_DIV_t45 VDD_DIV__t45 VDD_DIV 1.30175330498
* device instance VDD_DIV_t46 r0 *1 0,0
RVDD_DIV_t46 VDD_DIV__t46 VDD_DIV 5.62139733144
* device instance VDD_DIV_t47 r0 *1 0,0
RVDD_DIV_t47 VDD_DIV__t47 VDD_DIV 5.53376251326
* device instance VDD_DIV_t48 r0 *1 0,0
RVDD_DIV_t48 VDD_DIV__t48 VDD_DIV 5.44612769508
* device instance VDD_DIV_t49 r0 *1 0,0
RVDD_DIV_t49 VDD_DIV__t49 VDD_DIV 5.27085805871
* device instance VDD_DIV_t50 r0 *1 0,0
RVDD_DIV_t50 VDD_DIV__t50 VDD_DIV 5.18322324053
* device instance VDD_DIV_t51 r0 *1 0,0
RVDD_DIV_t51 VDD_DIV__t51 VDD_DIV 5.00795360417
* device instance VDD_DIV_t52 r0 *1 0,0
RVDD_DIV_t52 VDD_DIV__t52 VDD_DIV 4.92031878598
* device instance VDD_DIV_t53 r0 *1 0,0
RVDD_DIV_t53 VDD_DIV__t53 VDD_DIV 8.3380766951
* device instance VDD_DIV_t54 r0 *1 0,0
RVDD_DIV_t54 VDD_DIV__t54 VDD_DIV 8.42571151328
* device instance VDD_DIV_t55 r0 *1 0,0
RVDD_DIV_t55 VDD_DIV__t55 VDD_DIV 5.70903214963
* device instance VDD_DIV_t56 r0 *1 0,0
RVDD_DIV_t56 VDD_DIV__t56 VDD_DIV 1.38938812316
* device instance VDD_DIV_t57 r0 *1 0,0
RVDD_DIV_t57 VDD_DIV__t57 VDD_DIV 1.47702294134
* device instance VDD_DIV_t58 r0 *1 0,0
RVDD_DIV_t58 VDD_DIV__t58 VDD_DIV 1.65229257771
* device instance VDD_DIV_t59 r0 *1 0,0
RVDD_DIV_t59 VDD_DIV__t59 VDD_DIV 1.73992739589
* device instance VDD_DIV_t60 r0 *1 0,0
RVDD_DIV_t60 VDD_DIV__t60 VDD_DIV 8.25044187692
* device instance VDD_DIV_t61 r0 *1 0,0
RVDD_DIV_t61 VDD_DIV__t61 VDD_DIV 8.16280705874
* device instance VDD_DIV_t62 r0 *1 0,0
RVDD_DIV_t62 VDD_DIV__t62 VDD_DIV 7.98753742237
* device instance VDD_DIV_t63 r0 *1 0,0
RVDD_DIV_t63 VDD_DIV__t63 VDD_DIV 6.76064996782
* device instance VDD_DIV_t64 r0 *1 0,0
RVDD_DIV_t64 VDD_DIV__t64 VDD_DIV 7.72463296782
* device instance VDD_DIV_t65 r0 *1 0,0
RVDD_DIV_t65 VDD_DIV__t65 VDD_DIV 7.63699814964
* device instance VDD_DIV_t66 r0 *1 0,0
RVDD_DIV_t66 VDD_DIV__t66 VDD_DIV 7.37409369509
* device instance VDD_DIV_t67 r0 *1 0,0
RVDD_DIV_t67 VDD_DIV__t67 VDD_DIV 7.28645887691
* device instance VDD_DIV_t68 r0 *1 0,0
RVDD_DIV_t68 VDD_DIV__t68 VDD_DIV 7.11118924055
* device instance VDD_DIV_t69 r0 *1 0,0
RVDD_DIV_t69 VDD_DIV__t69 VDD_DIV 7.02355442236
* device instance VDD_DIV_t70 r0 *1 0,0
RVDD_DIV_t70 VDD_DIV__t70 VDD_DIV 6.93591960418
* device instance VDD_DIV_t71 r0 *1 0,0
RVDD_DIV_t71 VDD_DIV__t71 VDD_DIV 6.848284786
* device instance VDD_DIV_t72 r0 *1 0,0
RVDD_DIV_t72 VDD_DIV__t72 VDD_DIV 7.89990260419
* device instance VDD_DIV_t73 r0 *1 0,0
RVDD_DIV_t73 VDD_DIV__t73 VDD_DIV 4.193702305
* device instance VDD_DIV_t74 r0 *1 0,0
RVDD_DIV_t74 VDD_DIV__t74 VDD_DIV 4.36897194137
* device instance VDD_DIV_t75 r0 *1 0,0
RVDD_DIV_t75 VDD_DIV__t75 VDD_DIV 4.45660675955
* device instance VDD_DIV_t76 r0 *1 0,0
RVDD_DIV_t76 VDD_DIV__t76 VDD_DIV 4.7195112141
* device instance VDD_DIV_t77 r0 *1 0,0
RVDD_DIV_t77 VDD_DIV__t77 VDD_DIV 4.80714603228
* device instance VDD_DIV_t78 r0 *1 0,0
RVDD_DIV_t78 VDD_DIV__t78 VDD_DIV 4.98241566864
* device instance VDD_DIV_t79 r0 *1 0,0
RVDD_DIV_t79 VDD_DIV__t79 VDD_DIV 5.07005048683
* device instance VDD_DIV_t80 r0 *1 0,0
RVDD_DIV_t80 VDD_DIV__t80 VDD_DIV 2.99235278597
* device instance VDD_DIV_t81 r0 *1 0,0
RVDD_DIV_t81 VDD_DIV__t81 VDD_DIV 5.24532012319
* device instance VDD_DIV_t82 r0 *1 0,0
RVDD_DIV_t82 VDD_DIV__t82 VDD_DIV 5.33295494137
* device instance VDD_DIV_t83 r0 *1 0,0
RVDD_DIV_t83 VDD_DIV__t83 VDD_DIV 5.42058975956
* device instance VDD_DIV_t84 r0 *1 0,0
RVDD_DIV_t84 VDD_DIV__t84 VDD_DIV 5.59585939592
* device instance VDD_DIV_t85 r0 *1 0,0
RVDD_DIV_t85 VDD_DIV__t85 VDD_DIV 5.6834942141
* device instance VDD_DIV_t86 r0 *1 0,0
RVDD_DIV_t86 VDD_DIV__t86 VDD_DIV 5.85876385047
* device instance VDD_DIV_t87 r0 *1 0,0
RVDD_DIV_t87 VDD_DIV__t87 VDD_DIV 5.94639866865
* device instance VDD_DIV_t88 r0 *1 0,0
RVDD_DIV_t88 VDD_DIV__t88 VDD_DIV 5.15768530501
* device instance VDD_DIV_t89 r0 *1 0,0
RVDD_DIV_t89 VDD_DIV__t89 VDD_DIV 2.00283185044
* device instance VDD_DIV_t90 r0 *1 0,0
RVDD_DIV_t90 VDD_DIV__t90 VDD_DIV 2.09046666862
* device instance VDD_DIV_t91 r0 *1 0,0
RVDD_DIV_t91 VDD_DIV__t91 VDD_DIV 2.26573630499
* device instance VDD_DIV_t92 r0 *1 0,0
RVDD_DIV_t92 VDD_DIV__t92 VDD_DIV 2.35337112317
* device instance VDD_DIV_t93 r0 *1 0,0
RVDD_DIV_t93 VDD_DIV__t93 VDD_DIV 2.44100594135
* device instance VDD_DIV_t94 r0 *1 0,0
RVDD_DIV_t94 VDD_DIV__t94 VDD_DIV 2.52864075953
* device instance VDD_DIV_t95 r0 *1 0,0
RVDD_DIV_t95 VDD_DIV__t95 VDD_DIV 2.61627557772
* device instance VDD_DIV_t96 r0 *1 0,0
RVDD_DIV_t96 VDD_DIV__t96 VDD_DIV 2.7039103959
* device instance VDD_DIV_t97 r0 *1 0,0
RVDD_DIV_t97 VDD_DIV__t97 VDD_DIV 2.87918003226
* device instance VDD_DIV_t98 r0 *1 0,0
RVDD_DIV_t98 VDD_DIV__t98 VDD_DIV 4.10606748682
* device instance VDD_DIV_t99 r0 *1 0,0
RVDD_DIV_t99 VDD_DIV__t99 VDD_DIV 3.14208448681
* device instance VDD_DIV_t100 r0 *1 0,0
RVDD_DIV_t100 VDD_DIV__t100 VDD_DIV 3.22971930499
* device instance VDD_DIV_t101 r0 *1 0,0
RVDD_DIV_t101 VDD_DIV__t101 VDD_DIV 3.49262375954
* device instance VDD_DIV_t102 r0 *1 0,0
RVDD_DIV_t102 VDD_DIV__t102 VDD_DIV 3.58025857772
* device instance VDD_DIV_t103 r0 *1 0,0
RVDD_DIV_t103 VDD_DIV__t103 VDD_DIV 3.75552821409
* device instance VDD_DIV_t104 r0 *1 0,0
RVDD_DIV_t104 VDD_DIV__t104 VDD_DIV 3.84316303227
* device instance VDD_DIV_t105 r0 *1 0,0
RVDD_DIV_t105 VDD_DIV__t105 VDD_DIV 3.93079785045
* device instance VDD_DIV_t106 r0 *1 0,0
RVDD_DIV_t106 VDD_DIV__t106 VDD_DIV 4.01843266864
* device instance VDD_DIV_t107 r0 *1 0,0
RVDD_DIV_t107 VDD_DIV__t107 VDD_DIV 2.96681485045
* device instance VDD_DIV_t108 r0 *1 0,0
RVDD_DIV_t108 VDD_DIV__t108 VDD_DIV 8.48780839595
* device instance VDD_DIV_t109 r0 *1 0,0
RVDD_DIV_t109 VDD_DIV__t109 VDD_DIV 8.66307803231
* device instance VDD_DIV_t110 r0 *1 0,0
RVDD_DIV_t110 VDD_DIV__t110 VDD_DIV 4.65741433144
* device instance VDD_DIV_t111 r0 *1 0,0
RVDD_DIV_t111 VDD_DIV__t111 VDD_DIV 4.56977951325
* device instance VDD_DIV_t112 r0 *1 0,0
RVDD_DIV_t112 VDD_DIV__t112 VDD_DIV 4.39450987689
* device instance VDD_DIV_t113 r0 *1 0,0
RVDD_DIV_t113 VDD_DIV__t113 VDD_DIV 4.30687505871
* device instance VDD_DIV_t114 r0 *1 0,0
RVDD_DIV_t114 VDD_DIV__t114 VDD_DIV 4.21924024052
* device instance VDD_DIV_t115 r0 *1 0,0
RVDD_DIV_t115 VDD_DIV__t115 VDD_DIV 4.13160542234
* device instance VDD_DIV_t116 r0 *1 0,0
RVDD_DIV_t116 VDD_DIV__t116 VDD_DIV 6.2093031232
* device instance VDD_DIV_t117 r0 *1 0,0
RVDD_DIV_t117 VDD_DIV__t117 VDD_DIV 3.95633578598
* device instance VDD_DIV_t118 r0 *1 0,0
RVDD_DIV_t118 VDD_DIV__t118 VDD_DIV 3.78106614961
* device instance VDD_DIV_t119 r0 *1 0,0
RVDD_DIV_t119 VDD_DIV__t119 VDD_DIV 3.69343133143
* device instance VDD_DIV_t120 r0 *1 0,0
RVDD_DIV_t120 VDD_DIV__t120 VDD_DIV 3.43052687688
* device instance VDD_DIV_t121 r0 *1 0,0
RVDD_DIV_t121 VDD_DIV__t121 VDD_DIV 3.3428920587
* device instance VDD_DIV_t122 r0 *1 0,0
RVDD_DIV_t122 VDD_DIV__t122 VDD_DIV 3.16762242233
* device instance VDD_DIV_t123 r0 *1 0,0
RVDD_DIV_t123 VDD_DIV__t123 VDD_DIV 3.07998760415
* device instance VDD_DIV_t124 r0 *1 0,0
RVDD_DIV_t124 VDD_DIV__t124 VDD_DIV 4.04397060416
* device instance VDD_DIV_t125 r0 *1 0,0
RVDD_DIV_t125 VDD_DIV__t125 VDD_DIV 6.29693794138
* device instance VDD_DIV_t126 r0 *1 0,0
RVDD_DIV_t126 VDD_DIV__t126 VDD_DIV 6.47220757775
* device instance VDD_DIV_t127 r0 *1 0,0
RVDD_DIV_t127 VDD_DIV__t127 VDD_DIV 6.55984239593
* device instance VDD_DIV_t128 r0 *1 0,0
RVDD_DIV_t128 VDD_DIV__t128 VDD_DIV 6.64747721411
* device instance VDD_DIV_t129 r0 *1 0,0
RVDD_DIV_t129 VDD_DIV__t129 VDD_DIV 6.73511203229
* device instance VDD_DIV_t130 r0 *1 0,0
RVDD_DIV_t130 VDD_DIV__t130 VDD_DIV 6.82274685048
* device instance VDD_DIV_t131 r0 *1 0,0
RVDD_DIV_t131 VDD_DIV__t131 VDD_DIV 6.91038166866
* device instance VDD_DIV_t132 r0 *1 0,0
RVDD_DIV_t132 VDD_DIV__t132 VDD_DIV 7.08565130503
* device instance VDD_DIV_t133 r0 *1 0,0
RVDD_DIV_t133 VDD_DIV__t133 VDD_DIV 7.17328612321
* device instance VDD_DIV_t134 r0 *1 0,0
RVDD_DIV_t134 VDD_DIV__t134 VDD_DIV 8.40017357776
* device instance VDD_DIV_t135 r0 *1 0,0
RVDD_DIV_t135 VDD_DIV__t135 VDD_DIV 7.43619057776
* device instance VDD_DIV_t136 r0 *1 0,0
RVDD_DIV_t136 VDD_DIV__t136 VDD_DIV 7.52382539594
* device instance VDD_DIV_t137 r0 *1 0,0
RVDD_DIV_t137 VDD_DIV__t137 VDD_DIV 7.6990950323
* device instance VDD_DIV_t138 r0 *1 0,0
RVDD_DIV_t138 VDD_DIV__t138 VDD_DIV 7.78672985049
* device instance VDD_DIV_t139 r0 *1 0,0
RVDD_DIV_t139 VDD_DIV__t139 VDD_DIV 7.87436466867
* device instance VDD_DIV_t140 r0 *1 0,0
RVDD_DIV_t140 VDD_DIV__t140 VDD_DIV 8.04963430503
* device instance VDD_DIV_t141 r0 *1 0,0
RVDD_DIV_t141 VDD_DIV__t141 VDD_DIV 8.13726912322
* device instance VDD_DIV_t142 r0 *1 0,0
RVDD_DIV_t142 VDD_DIV__t142 VDD_DIV 0.713847513221
* device instance VDD_DIV_t143 r0 *1 0,0
RVDD_DIV_t143 VDD_DIV__t143 VDD_DIV 0.626212695039
* device instance VDD_DIV_t144 r0 *1 0,0
RVDD_DIV_t144 VDD_DIV__t144 VDD_DIV 0.538577876856
* device instance VDD_DIV_t145 r0 *1 0,0
RVDD_DIV_t145 VDD_DIV__t145 VDD_DIV 0.450943058674
* device instance VDD_DIV_t146 r0 *1 0,0
RVDD_DIV_t146 VDD_DIV__t146 VDD_DIV 0.363308240491
* device instance VDD_DIV_t147 r0 *1 0,0
RVDD_DIV_t147 VDD_DIV__t147 VDD_DIV 0.275673422309
* device instance VDD_DIV_t148 r0 *1 0,0
RVDD_DIV_t148 VDD_DIV__t148 VDD_DIV 0.188038604126
* device instance VDD_DIV_t149 r0 *1 0,0
RVDD_DIV_t149 VDD_DIV__t149 VDD_DIV 0.100403785943
* device instance VDD_DIV_t150 r0 *1 0,0
RVDD_DIV_t150 VDD_DIV__t150 VDD_DIV 0.0127689677609
* device instance VDD_DIV_t151 r0 *1 0,0
RVDD_DIV_t151 VDD_DIV__t151 VDD_DIV 0.0748658504217
* device instance VDD_DIV_t152 r0 *1 0,0
RVDD_DIV_t152 VDD_DIV__t152 VDD_DIV 0.162500668604
* device instance VDD_DIV_t153 r0 *1 0,0
RVDD_DIV_t153 VDD_DIV__t153 VDD_DIV 1.91519703226
* device instance VDD_DIV_t154 r0 *1 0,0
RVDD_DIV_t154 VDD_DIV__t154 VDD_DIV 0.337770304969
* device instance VDD_DIV_t155 r0 *1 0,0
RVDD_DIV_t155 VDD_DIV__t155 VDD_DIV 0.425405123152
* device instance VDD_DIV_t156 r0 *1 0,0
RVDD_DIV_t156 VDD_DIV__t156 VDD_DIV 0.513039941334
* device instance VDD_DIV_t157 r0 *1 0,0
RVDD_DIV_t157 VDD_DIV__t157 VDD_DIV 0.600674759517
* device instance VDD_DIV_t158 r0 *1 0,0
RVDD_DIV_t158 VDD_DIV__t158 VDD_DIV 0.688309577699
* device instance VDD_DIV_t159 r0 *1 0,0
RVDD_DIV_t159 VDD_DIV__t159 VDD_DIV 0.775944395882
* device instance VDD_DIV_t160 r0 *1 0,0
RVDD_DIV_t160 VDD_DIV__t160 VDD_DIV 0.863579214065
* device instance VDD_DIV_t161 r0 *1 0,0
RVDD_DIV_t161 VDD_DIV__t161 VDD_DIV 0.951214032247
* device instance VDD_DIV_t162 r0 *1 0,0
RVDD_DIV_t162 VDD_DIV__t162 VDD_DIV 1.03884885043
* device instance VDD_DIV_t163 r0 *1 0,0
RVDD_DIV_t163 VDD_DIV__t163 VDD_DIV 1.12648366861
* device instance VDD_DIV_t164 r0 *1 0,0
RVDD_DIV_t164 VDD_DIV__t164 VDD_DIV 1.21411848679
* device instance VDD_DIV_t165 r0 *1 0,0
RVDD_DIV_t165 VDD_DIV__t165 VDD_DIV 0.250135486787
* device instance VDD_DIV_t166 r0 *1 0,0
RVDD_DIV_t166 VDD_DIV__t166 VDD_DIV 2.90471796778
* device instance VDD_DIV_t167 r0 *1 0,0
RVDD_DIV_t167 VDD_DIV__t167 VDD_DIV 2.8170831496
* device instance VDD_DIV_t168 r0 *1 0,0
RVDD_DIV_t168 VDD_DIV__t168 VDD_DIV 2.72944833142
* device instance VDD_DIV_t169 r0 *1 0,0
RVDD_DIV_t169 VDD_DIV__t169 VDD_DIV 2.64181351324
* device instance VDD_DIV_t170 r0 *1 0,0
RVDD_DIV_t170 VDD_DIV__t170 VDD_DIV 2.55417869505
* device instance VDD_DIV_t171 r0 *1 0,0
RVDD_DIV_t171 VDD_DIV__t171 VDD_DIV 2.46654387687
* device instance VDD_DIV_t172 r0 *1 0,0
RVDD_DIV_t172 VDD_DIV__t172 VDD_DIV 2.37890905869
* device instance VDD_DIV_t173 r0 *1 0,0
RVDD_DIV_t173 VDD_DIV__t173 VDD_DIV 2.29127424051
* device instance VDD_DIV_t174 r0 *1 0,0
RVDD_DIV_t174 VDD_DIV__t174 VDD_DIV 2.20363942232
* device instance VDD_DIV_t175 r0 *1 0,0
RVDD_DIV_t175 VDD_DIV__t175 VDD_DIV 2.11600460414
* device instance VDD_DIV_t176 r0 *1 0,0
RVDD_DIV_t176 VDD_DIV__t176 VDD_DIV 2.02836978596
* device instance VDD_DIV_t177 r0 *1 0,0
RVDD_DIV_t177 VDD_DIV__t177 VDD_DIV 0.801482331404
* device instance VDD_DIV_t178 r0 *1 0,0
RVDD_DIV_t178 VDD_DIV__t178 VDD_DIV 1.85310014959
* device instance VDD_DIV_t179 r0 *1 0,0
RVDD_DIV_t179 VDD_DIV__t179 VDD_DIV 1.76546533141
* device instance VDD_DIV_t180 r0 *1 0,0
RVDD_DIV_t180 VDD_DIV__t180 VDD_DIV 1.67783051323
* device instance VDD_DIV_t181 r0 *1 0,0
RVDD_DIV_t181 VDD_DIV__t181 VDD_DIV 1.59019569505
* device instance VDD_DIV_t182 r0 *1 0,0
RVDD_DIV_t182 VDD_DIV__t182 VDD_DIV 1.50256087686
* device instance VDD_DIV_t183 r0 *1 0,0
RVDD_DIV_t183 VDD_DIV__t183 VDD_DIV 1.41492605868
* device instance VDD_DIV_t184 r0 *1 0,0
RVDD_DIV_t184 VDD_DIV__t184 VDD_DIV 1.3272912405
* device instance VDD_DIV_t185 r0 *1 0,0
RVDD_DIV_t185 VDD_DIV__t185 VDD_DIV 1.23965642232
* device instance VDD_DIV_t186 r0 *1 0,0
RVDD_DIV_t186 VDD_DIV__t186 VDD_DIV 1.15202160413
* device instance VDD_DIV_t187 r0 *1 0,0
RVDD_DIV_t187 VDD_DIV__t187 VDD_DIV 1.06438678595
* device instance VDD_DIV_t188 r0 *1 0,0
RVDD_DIV_t188 VDD_DIV__t188 VDD_DIV 0.976751967769
* device instance VDD_DIV_t189 r0 *1 0,0
RVDD_DIV_t189 VDD_DIV__t189 VDD_DIV 0.889117149586
* device instance VDD_DIV_t190 r0 *1 0,0
RVDD_DIV_t190 VDD_DIV__t190 VDD_DIV 1.94073496778
* device instance VDD_DIV_t191 r0 *1 0,0
RVDD_DIV_t191 VDD_DIV__t191 VDD_DIV 6.67301514963
* device instance VDD_DIV_t192 r0 *1 0,0
RVDD_DIV_t192 VDD_DIV__t192 VDD_DIV 6.58538033145
* device instance VDD_DIV_t193 r0 *1 0,0
RVDD_DIV_t193 VDD_DIV__t193 VDD_DIV 6.49774551327
* device instance VDD_DIV_t194 r0 *1 0,0
RVDD_DIV_t194 VDD_DIV__t194 VDD_DIV 6.41011069509
* device instance VDD_DIV_t195 r0 *1 0,0
RVDD_DIV_t195 VDD_DIV__t195 VDD_DIV 6.3224758769
* device instance VDD_DIV_t196 r0 *1 0,0
RVDD_DIV_t196 VDD_DIV__t196 VDD_DIV 6.23484105872
* device instance VDD_DIV_t197 r0 *1 0,0
RVDD_DIV_t197 VDD_DIV__t197 VDD_DIV 6.14720624054
* device instance VDD_DIV_t198 r0 *1 0,0
RVDD_DIV_t198 VDD_DIV__t198 VDD_DIV 6.05957142236
* device instance VDD_DIV_t199 r0 *1 0,0
RVDD_DIV_t199 VDD_DIV__t199 VDD_DIV 5.97193660417
* device instance VDD_DIV_t200 r0 *1 0,0
RVDD_DIV_t200 VDD_DIV__t200 VDD_DIV 5.88430178599
* device instance VDD_DIV_t201 r0 *1 0,0
RVDD_DIV_t201 VDD_DIV__t201 VDD_DIV 5.79666696781
* device instance VDD_DIV_t202 r0 *1 0,0
RVDD_DIV_t202 VDD_DIV__t202 VDD_DIV 1.30175330498
* device instance VDD_DIV_t203 r0 *1 0,0
RVDD_DIV_t203 VDD_DIV__t203 VDD_DIV 5.62139733144
* device instance VDD_DIV_t204 r0 *1 0,0
RVDD_DIV_t204 VDD_DIV__t204 VDD_DIV 5.53376251326
* device instance VDD_DIV_t205 r0 *1 0,0
RVDD_DIV_t205 VDD_DIV__t205 VDD_DIV 5.44612769508
* device instance VDD_DIV_t206 r0 *1 0,0
RVDD_DIV_t206 VDD_DIV__t206 VDD_DIV 5.3584928769
* device instance VDD_DIV_t207 r0 *1 0,0
RVDD_DIV_t207 VDD_DIV__t207 VDD_DIV 5.27085805871
* device instance VDD_DIV_t208 r0 *1 0,0
RVDD_DIV_t208 VDD_DIV__t208 VDD_DIV 5.18322324053
* device instance VDD_DIV_t209 r0 *1 0,0
RVDD_DIV_t209 VDD_DIV__t209 VDD_DIV 5.09558842235
* device instance VDD_DIV_t210 r0 *1 0,0
RVDD_DIV_t210 VDD_DIV__t210 VDD_DIV 5.00795360417
* device instance VDD_DIV_t211 r0 *1 0,0
RVDD_DIV_t211 VDD_DIV__t211 VDD_DIV 4.92031878598
* device instance VDD_DIV_t212 r0 *1 0,0
RVDD_DIV_t212 VDD_DIV__t212 VDD_DIV 8.3380766951
* device instance VDD_DIV_t213 r0 *1 0,0
RVDD_DIV_t213 VDD_DIV__t213 VDD_DIV 8.42571151328
* device instance VDD_DIV_t214 r0 *1 0,0
RVDD_DIV_t214 VDD_DIV__t214 VDD_DIV 5.70903214963
* device instance VDD_DIV_t215 r0 *1 0,0
RVDD_DIV_t215 VDD_DIV__t215 VDD_DIV 1.38938812316
* device instance VDD_DIV_t216 r0 *1 0,0
RVDD_DIV_t216 VDD_DIV__t216 VDD_DIV 1.47702294134
* device instance VDD_DIV_t217 r0 *1 0,0
RVDD_DIV_t217 VDD_DIV__t217 VDD_DIV 1.56465775952
* device instance VDD_DIV_t218 r0 *1 0,0
RVDD_DIV_t218 VDD_DIV__t218 VDD_DIV 1.65229257771
* device instance VDD_DIV_t219 r0 *1 0,0
RVDD_DIV_t219 VDD_DIV__t219 VDD_DIV 1.73992739589
* device instance VDD_DIV_t220 r0 *1 0,0
RVDD_DIV_t220 VDD_DIV__t220 VDD_DIV 1.82756221407
* device instance VDD_DIV_t221 r0 *1 0,0
RVDD_DIV_t221 VDD_DIV__t221 VDD_DIV 4.8326839678
* device instance VDD_DIV_t222 r0 *1 0,0
RVDD_DIV_t222 VDD_DIV__t222 VDD_DIV 8.25044187692
* device instance VDD_DIV_t223 r0 *1 0,0
RVDD_DIV_t223 VDD_DIV__t223 VDD_DIV 8.16280705874
* device instance VDD_DIV_t224 r0 *1 0,0
RVDD_DIV_t224 VDD_DIV__t224 VDD_DIV 8.07517224055
* device instance VDD_DIV_t225 r0 *1 0,0
RVDD_DIV_t225 VDD_DIV__t225 VDD_DIV 7.98753742237
* device instance VDD_DIV_t226 r0 *1 0,0
RVDD_DIV_t226 VDD_DIV__t226 VDD_DIV 6.76064996782
* device instance VDD_DIV_t227 r0 *1 0,0
RVDD_DIV_t227 VDD_DIV__t227 VDD_DIV 7.81226778601
* device instance VDD_DIV_t228 r0 *1 0,0
RVDD_DIV_t228 VDD_DIV__t228 VDD_DIV 7.72463296782
* device instance VDD_DIV_t229 r0 *1 0,0
RVDD_DIV_t229 VDD_DIV__t229 VDD_DIV 7.63699814964
* device instance VDD_DIV_t230 r0 *1 0,0
RVDD_DIV_t230 VDD_DIV__t230 VDD_DIV 7.54936333146
* device instance VDD_DIV_t231 r0 *1 0,0
RVDD_DIV_t231 VDD_DIV__t231 VDD_DIV 7.46172851328
* device instance VDD_DIV_t232 r0 *1 0,0
RVDD_DIV_t232 VDD_DIV__t232 VDD_DIV 7.37409369509
* device instance VDD_DIV_t233 r0 *1 0,0
RVDD_DIV_t233 VDD_DIV__t233 VDD_DIV 7.28645887691
* device instance VDD_DIV_t234 r0 *1 0,0
RVDD_DIV_t234 VDD_DIV__t234 VDD_DIV 7.19882405873
* device instance VDD_DIV_t235 r0 *1 0,0
RVDD_DIV_t235 VDD_DIV__t235 VDD_DIV 7.11118924055
* device instance VDD_DIV_t236 r0 *1 0,0
RVDD_DIV_t236 VDD_DIV__t236 VDD_DIV 7.02355442236
* device instance VDD_DIV_t237 r0 *1 0,0
RVDD_DIV_t237 VDD_DIV__t237 VDD_DIV 6.93591960418
* device instance VDD_DIV_t238 r0 *1 0,0
RVDD_DIV_t238 VDD_DIV__t238 VDD_DIV 6.848284786
* device instance VDD_DIV_t239 r0 *1 0,0
RVDD_DIV_t239 VDD_DIV__t239 VDD_DIV 7.89990260419
* device instance VDD_DIV_t240 r0 *1 0,0
RVDD_DIV_t240 VDD_DIV__t240 VDD_DIV 4.193702305
* device instance VDD_DIV_t241 r0 *1 0,0
RVDD_DIV_t241 VDD_DIV__t241 VDD_DIV 4.28133712318
* device instance VDD_DIV_t242 r0 *1 0,0
RVDD_DIV_t242 VDD_DIV__t242 VDD_DIV 4.36897194137
* device instance VDD_DIV_t243 r0 *1 0,0
RVDD_DIV_t243 VDD_DIV__t243 VDD_DIV 4.45660675955
* device instance VDD_DIV_t244 r0 *1 0,0
RVDD_DIV_t244 VDD_DIV__t244 VDD_DIV 4.54424157773
* device instance VDD_DIV_t245 r0 *1 0,0
RVDD_DIV_t245 VDD_DIV__t245 VDD_DIV 4.63187639591
* device instance VDD_DIV_t246 r0 *1 0,0
RVDD_DIV_t246 VDD_DIV__t246 VDD_DIV 4.7195112141
* device instance VDD_DIV_t247 r0 *1 0,0
RVDD_DIV_t247 VDD_DIV__t247 VDD_DIV 4.80714603228
* device instance VDD_DIV_t248 r0 *1 0,0
RVDD_DIV_t248 VDD_DIV__t248 VDD_DIV 4.89478085046
* device instance VDD_DIV_t249 r0 *1 0,0
RVDD_DIV_t249 VDD_DIV__t249 VDD_DIV 4.98241566864
* device instance VDD_DIV_t250 r0 *1 0,0
RVDD_DIV_t250 VDD_DIV__t250 VDD_DIV 5.07005048683
* device instance VDD_DIV_t251 r0 *1 0,0
RVDD_DIV_t251 VDD_DIV__t251 VDD_DIV 2.99235278597
* device instance VDD_DIV_t252 r0 *1 0,0
RVDD_DIV_t252 VDD_DIV__t252 VDD_DIV 5.24532012319
* device instance VDD_DIV_t253 r0 *1 0,0
RVDD_DIV_t253 VDD_DIV__t253 VDD_DIV 5.33295494137
* device instance VDD_DIV_t254 r0 *1 0,0
RVDD_DIV_t254 VDD_DIV__t254 VDD_DIV 5.42058975956
* device instance VDD_DIV_t255 r0 *1 0,0
RVDD_DIV_t255 VDD_DIV__t255 VDD_DIV 5.50822457774
* device instance VDD_DIV_t256 r0 *1 0,0
RVDD_DIV_t256 VDD_DIV__t256 VDD_DIV 5.59585939592
* device instance VDD_DIV_t257 r0 *1 0,0
RVDD_DIV_t257 VDD_DIV__t257 VDD_DIV 5.6834942141
* device instance VDD_DIV_t258 r0 *1 0,0
RVDD_DIV_t258 VDD_DIV__t258 VDD_DIV 5.77112903229
* device instance VDD_DIV_t259 r0 *1 0,0
RVDD_DIV_t259 VDD_DIV__t259 VDD_DIV 5.85876385047
* device instance VDD_DIV_t260 r0 *1 0,0
RVDD_DIV_t260 VDD_DIV__t260 VDD_DIV 5.94639866865
* device instance VDD_DIV_t261 r0 *1 0,0
RVDD_DIV_t261 VDD_DIV__t261 VDD_DIV 6.03403348683
* device instance VDD_DIV_t262 r0 *1 0,0
RVDD_DIV_t262 VDD_DIV__t262 VDD_DIV 6.12166830502
* device instance VDD_DIV_t263 r0 *1 0,0
RVDD_DIV_t263 VDD_DIV__t263 VDD_DIV 5.15768530501
* device instance VDD_DIV_t264 r0 *1 0,0
RVDD_DIV_t264 VDD_DIV__t264 VDD_DIV 2.00283185044
* device instance VDD_DIV_t265 r0 *1 0,0
RVDD_DIV_t265 VDD_DIV__t265 VDD_DIV 2.09046666862
* device instance VDD_DIV_t266 r0 *1 0,0
RVDD_DIV_t266 VDD_DIV__t266 VDD_DIV 2.1781014868
* device instance VDD_DIV_t267 r0 *1 0,0
RVDD_DIV_t267 VDD_DIV__t267 VDD_DIV 2.26573630499
* device instance VDD_DIV_t268 r0 *1 0,0
RVDD_DIV_t268 VDD_DIV__t268 VDD_DIV 2.35337112317
* device instance VDD_DIV_t269 r0 *1 0,0
RVDD_DIV_t269 VDD_DIV__t269 VDD_DIV 2.44100594135
* device instance VDD_DIV_t270 r0 *1 0,0
RVDD_DIV_t270 VDD_DIV__t270 VDD_DIV 2.52864075953
* device instance VDD_DIV_t271 r0 *1 0,0
RVDD_DIV_t271 VDD_DIV__t271 VDD_DIV 2.61627557772
* device instance VDD_DIV_t272 r0 *1 0,0
RVDD_DIV_t272 VDD_DIV__t272 VDD_DIV 2.7039103959
* device instance VDD_DIV_t273 r0 *1 0,0
RVDD_DIV_t273 VDD_DIV__t273 VDD_DIV 2.79154521408
* device instance VDD_DIV_t274 r0 *1 0,0
RVDD_DIV_t274 VDD_DIV__t274 VDD_DIV 2.87918003226
* device instance VDD_DIV_t275 r0 *1 0,0
RVDD_DIV_t275 VDD_DIV__t275 VDD_DIV 4.10606748682
* device instance VDD_DIV_t276 r0 *1 0,0
RVDD_DIV_t276 VDD_DIV__t276 VDD_DIV 3.05444966863
* device instance VDD_DIV_t277 r0 *1 0,0
RVDD_DIV_t277 VDD_DIV__t277 VDD_DIV 3.14208448681
* device instance VDD_DIV_t278 r0 *1 0,0
RVDD_DIV_t278 VDD_DIV__t278 VDD_DIV 3.22971930499
* device instance VDD_DIV_t279 r0 *1 0,0
RVDD_DIV_t279 VDD_DIV__t279 VDD_DIV 3.31735412318
* device instance VDD_DIV_t280 r0 *1 0,0
RVDD_DIV_t280 VDD_DIV__t280 VDD_DIV 3.40498894136
* device instance VDD_DIV_t281 r0 *1 0,0
RVDD_DIV_t281 VDD_DIV__t281 VDD_DIV 3.49262375954
* device instance VDD_DIV_t282 r0 *1 0,0
RVDD_DIV_t282 VDD_DIV__t282 VDD_DIV 3.58025857772
* device instance VDD_DIV_t283 r0 *1 0,0
RVDD_DIV_t283 VDD_DIV__t283 VDD_DIV 3.66789339591
* device instance VDD_DIV_t284 r0 *1 0,0
RVDD_DIV_t284 VDD_DIV__t284 VDD_DIV 3.75552821409
* device instance VDD_DIV_t285 r0 *1 0,0
RVDD_DIV_t285 VDD_DIV__t285 VDD_DIV 3.84316303227
* device instance VDD_DIV_t286 r0 *1 0,0
RVDD_DIV_t286 VDD_DIV__t286 VDD_DIV 3.93079785045
* device instance VDD_DIV_t287 r0 *1 0,0
RVDD_DIV_t287 VDD_DIV__t287 VDD_DIV 4.01843266864
* device instance VDD_DIV_t288 r0 *1 0,0
RVDD_DIV_t288 VDD_DIV__t288 VDD_DIV 2.96681485045
* device instance VDD_DIV_t289 r0 *1 0,0
RVDD_DIV_t289 VDD_DIV__t289 VDD_DIV 8.48780839595
* device instance VDD_DIV_t290 r0 *1 0,0
RVDD_DIV_t290 VDD_DIV__t290 VDD_DIV 8.57544321413
* device instance VDD_DIV_t291 r0 *1 0,0
RVDD_DIV_t291 VDD_DIV__t291 VDD_DIV 8.66307803231
* device instance VDD_DIV_t292 r0 *1 0,0
RVDD_DIV_t292 VDD_DIV__t292 VDD_DIV 4.74504914962
* device instance VDD_DIV_t293 r0 *1 0,0
RVDD_DIV_t293 VDD_DIV__t293 VDD_DIV 4.65741433144
* device instance VDD_DIV_t294 r0 *1 0,0
RVDD_DIV_t294 VDD_DIV__t294 VDD_DIV 4.56977951325
* device instance VDD_DIV_t295 r0 *1 0,0
RVDD_DIV_t295 VDD_DIV__t295 VDD_DIV 4.48214469507
* device instance VDD_DIV_t296 r0 *1 0,0
RVDD_DIV_t296 VDD_DIV__t296 VDD_DIV 4.39450987689
* device instance VDD_DIV_t297 r0 *1 0,0
RVDD_DIV_t297 VDD_DIV__t297 VDD_DIV 4.30687505871
* device instance VDD_DIV_t298 r0 *1 0,0
RVDD_DIV_t298 VDD_DIV__t298 VDD_DIV 4.21924024052
* device instance VDD_DIV_t299 r0 *1 0,0
RVDD_DIV_t299 VDD_DIV__t299 VDD_DIV 4.13160542234
* device instance VDD_DIV_t300 r0 *1 0,0
RVDD_DIV_t300 VDD_DIV__t300 VDD_DIV 6.2093031232
* device instance VDD_DIV_t301 r0 *1 0,0
RVDD_DIV_t301 VDD_DIV__t301 VDD_DIV 3.95633578598
* device instance VDD_DIV_t302 r0 *1 0,0
RVDD_DIV_t302 VDD_DIV__t302 VDD_DIV 3.86870096779
* device instance VDD_DIV_t303 r0 *1 0,0
RVDD_DIV_t303 VDD_DIV__t303 VDD_DIV 3.78106614961
* device instance VDD_DIV_t304 r0 *1 0,0
RVDD_DIV_t304 VDD_DIV__t304 VDD_DIV 3.69343133143
* device instance VDD_DIV_t305 r0 *1 0,0
RVDD_DIV_t305 VDD_DIV__t305 VDD_DIV 3.60579651325
* device instance VDD_DIV_t306 r0 *1 0,0
RVDD_DIV_t306 VDD_DIV__t306 VDD_DIV 3.51816169506
* device instance VDD_DIV_t307 r0 *1 0,0
RVDD_DIV_t307 VDD_DIV__t307 VDD_DIV 3.43052687688
* device instance VDD_DIV_t308 r0 *1 0,0
RVDD_DIV_t308 VDD_DIV__t308 VDD_DIV 3.3428920587
* device instance VDD_DIV_t309 r0 *1 0,0
RVDD_DIV_t309 VDD_DIV__t309 VDD_DIV 3.25525724051
* device instance VDD_DIV_t310 r0 *1 0,0
RVDD_DIV_t310 VDD_DIV__t310 VDD_DIV 3.16762242233
* device instance VDD_DIV_t311 r0 *1 0,0
RVDD_DIV_t311 VDD_DIV__t311 VDD_DIV 3.07998760415
* device instance VDD_DIV_t312 r0 *1 0,0
RVDD_DIV_t312 VDD_DIV__t312 VDD_DIV 4.04397060416
* device instance VDD_DIV_t313 r0 *1 0,0
RVDD_DIV_t313 VDD_DIV__t313 VDD_DIV 6.29693794138
* device instance VDD_DIV_t314 r0 *1 0,0
RVDD_DIV_t314 VDD_DIV__t314 VDD_DIV 6.38457275956
* device instance VDD_DIV_t315 r0 *1 0,0
RVDD_DIV_t315 VDD_DIV__t315 VDD_DIV 6.47220757775
* device instance VDD_DIV_t316 r0 *1 0,0
RVDD_DIV_t316 VDD_DIV__t316 VDD_DIV 6.55984239593
* device instance VDD_DIV_t317 r0 *1 0,0
RVDD_DIV_t317 VDD_DIV__t317 VDD_DIV 6.64747721411
* device instance VDD_DIV_t318 r0 *1 0,0
RVDD_DIV_t318 VDD_DIV__t318 VDD_DIV 6.73511203229
* device instance VDD_DIV_t319 r0 *1 0,0
RVDD_DIV_t319 VDD_DIV__t319 VDD_DIV 6.82274685048
* device instance VDD_DIV_t320 r0 *1 0,0
RVDD_DIV_t320 VDD_DIV__t320 VDD_DIV 6.91038166866
* device instance VDD_DIV_t321 r0 *1 0,0
RVDD_DIV_t321 VDD_DIV__t321 VDD_DIV 6.99801648684
* device instance VDD_DIV_t322 r0 *1 0,0
RVDD_DIV_t322 VDD_DIV__t322 VDD_DIV 7.08565130503
* device instance VDD_DIV_t323 r0 *1 0,0
RVDD_DIV_t323 VDD_DIV__t323 VDD_DIV 7.17328612321
* device instance VDD_DIV_t324 r0 *1 0,0
RVDD_DIV_t324 VDD_DIV__t324 VDD_DIV 8.40017357776
* device instance VDD_DIV_t325 r0 *1 0,0
RVDD_DIV_t325 VDD_DIV__t325 VDD_DIV 7.34855575957
* device instance VDD_DIV_t326 r0 *1 0,0
RVDD_DIV_t326 VDD_DIV__t326 VDD_DIV 7.43619057776
* device instance VDD_DIV_t327 r0 *1 0,0
RVDD_DIV_t327 VDD_DIV__t327 VDD_DIV 7.52382539594
* device instance VDD_DIV_t328 r0 *1 0,0
RVDD_DIV_t328 VDD_DIV__t328 VDD_DIV 7.61146021412
* device instance VDD_DIV_t329 r0 *1 0,0
RVDD_DIV_t329 VDD_DIV__t329 VDD_DIV 7.6990950323
* device instance VDD_DIV_t330 r0 *1 0,0
RVDD_DIV_t330 VDD_DIV__t330 VDD_DIV 7.78672985049
* device instance VDD_DIV_t331 r0 *1 0,0
RVDD_DIV_t331 VDD_DIV__t331 VDD_DIV 7.87436466867
* device instance VDD_DIV_t332 r0 *1 0,0
RVDD_DIV_t332 VDD_DIV__t332 VDD_DIV 7.96199948685
* device instance VDD_DIV_t333 r0 *1 0,0
RVDD_DIV_t333 VDD_DIV__t333 VDD_DIV 8.04963430503
* device instance VDD_DIV_t334 r0 *1 0,0
RVDD_DIV_t334 VDD_DIV__t334 VDD_DIV 8.13726912322
* device instance VDD_DIV_t335 r0 *1 0,0
RVDD_DIV_t335 VDD_DIV__t335 VDD_DIV 8.2249039414
* device instance VDD_DIV_t336 r0 *1 0,0
RVDD_DIV_t336 VDD_DIV__t336 VDD_DIV 8.31253875958
* device instance VDD_DIV_t337 r0 *1 0,0
RVDD_DIV_t337 VDD_DIV__t337 VDD_DIV 7.26092094139
* device instance VDD_DIV_t338 r0 *1 0,0
RVDD_DIV_t338 VDD_DIV__t338 VDD_DIV 9.86236851826
* device instance VDD_DIV_t339 r0 *1 0,0
RVDD_DIV_t339 VDD_DIV__t339 VDD_DIV 10.7100087424
* device instance VDD_DIV r0 *1 0,0
CVDD_DIV VDD_DIV vsubs 4.12344896e-13
* device instance VSS_t0 r0 *1 0,0
RVSS_t0 VSS__t0 VSS 0.828615492513
* device instance VSS_t1 r0 *1 0,0
RVSS_t1 VSS__t1 VSS 0.887581321543
* device instance VSS_t2 r0 *1 0,0
RVSS_t2 VSS__t2 VSS 0.946547150574
* device instance VSS_t3 r0 *1 0,0
RVSS_t3 VSS__t3 VSS 1.06447880863
* device instance VSS_t4 r0 *1 0,0
RVSS_t4 VSS__t4 VSS 2.17864178802
* device instance VSS_t5 r0 *1 0,0
RVSS_t5 VSS__t5 VSS 2.00174430093
* device instance VSS_t6 r0 *1 0,0
RVSS_t6 VSS__t6 VSS 1.9427784719
* device instance VSS_t7 r0 *1 0,0
RVSS_t7 VSS__t7 VSS 1.82484681384
* device instance VSS_t8 r0 *1 0,0
RVSS_t8 VSS__t8 VSS 2.35553927512
* device instance VSS_t9 r0 *1 0,0
RVSS_t9 VSS__t9 VSS 2.29657344609
* device instance VSS_t10 r0 *1 0,0
RVSS_t10 VSS__t10 VSS 5.6576257008
* device instance VSS_t11 r0 *1 0,0
RVSS_t11 VSS__t11 VSS 5.59865987177
* device instance VSS_t12 r0 *1 0,0
RVSS_t12 VSS__t12 VSS 5.53969404274
* device instance VSS_t13 r0 *1 0,0
RVSS_t13 VSS__t13 VSS 5.48072821371
* device instance VSS_t14 r0 *1 0,0
RVSS_t14 VSS__t14 VSS 5.42176238468
* device instance VSS_t15 r0 *1 0,0
RVSS_t15 VSS__t15 VSS 1.88381264287
* device instance VSS_t16 r0 *1 0,0
RVSS_t16 VSS__t16 VSS 0.52759857518
* device instance VSS_t17 r0 *1 0,0
RVSS_t17 VSS__t17 VSS 0.46863274615
* device instance VSS_t18 r0 *1 0,0
RVSS_t18 VSS__t18 VSS 0.35070108809
* device instance VSS_t19 r0 *1 0,0
RVSS_t19 VSS__t19 VSS 0.173803600999
* device instance VSS_t20 r0 *1 0,0
RVSS_t20 VSS__t20 VSS 0.114837771969
* device instance VSS_t21 r0 *1 0,0
RVSS_t21 VSS__t21 VSS 0.0558719429391
* device instance VSS_t22 r0 *1 0,0
RVSS_t22 VSS__t22 VSS 0.769649663483
* device instance VSS_t23 r0 *1 0,0
RVSS_t23 VSS__t23 VSS 0.0620597151212
* device instance VSS_t24 r0 *1 0,0
RVSS_t24 VSS__t24 VSS 0.121025544151
* device instance VSS_t25 r0 *1 0,0
RVSS_t25 VSS__t25 VSS 0.238957202212
* device instance VSS_t26 r0 *1 0,0
RVSS_t26 VSS__t26 VSS 0.297923031242
* device instance VSS_t27 r0 *1 0,0
RVSS_t27 VSS__t27 VSS 0.474820518332
* device instance VSS_t28 r0 *1 0,0
RVSS_t28 VSS__t28 VSS 0.533786347363
* device instance VSS_t29 r0 *1 0,0
RVSS_t29 VSS__t29 VSS 0.651718005423
* device instance VSS_t30 r0 *1 0,0
RVSS_t30 VSS__t30 VSS 0.00309388609109
* device instance VSS_t31 r0 *1 0,0
RVSS_t31 VSS__t31 VSS 3.82968500087
* device instance VSS_t32 r0 *1 0,0
RVSS_t32 VSS__t32 VSS 3.77071917184
* device instance VSS_t33 r0 *1 0,0
RVSS_t33 VSS__t33 VSS 3.71175334281
* device instance VSS_t34 r0 *1 0,0
RVSS_t34 VSS__t34 VSS 3.65278751378
* device instance VSS_t35 r0 *1 0,0
RVSS_t35 VSS__t35 VSS 3.59382168475
* device instance VSS_t36 r0 *1 0,0
RVSS_t36 VSS__t36 VSS 3.53485585572
* device instance VSS_t37 r0 *1 0,0
RVSS_t37 VSS__t37 VSS 3.41692419766
* device instance VSS_t38 r0 *1 0,0
RVSS_t38 VSS__t38 VSS 3.35795836863
* device instance VSS_t39 r0 *1 0,0
RVSS_t39 VSS__t39 VSS 5.36279655565
* device instance VSS_t40 r0 *1 0,0
RVSS_t40 VSS__t40 VSS 3.12209505251
* device instance VSS_t41 r0 *1 0,0
RVSS_t41 VSS__t41 VSS 3.00416339445
* device instance VSS_t42 r0 *1 0,0
RVSS_t42 VSS__t42 VSS 2.88623173639
* device instance VSS_t43 r0 *1 0,0
RVSS_t43 VSS__t43 VSS 2.82726590736
* device instance VSS_t44 r0 *1 0,0
RVSS_t44 VSS__t44 VSS 2.76830007833
* device instance VSS_t45 r0 *1 0,0
RVSS_t45 VSS__t45 VSS 2.7093342493
* device instance VSS_t46 r0 *1 0,0
RVSS_t46 VSS__t46 VSS 2.59140259124
* device instance VSS_t47 r0 *1 0,0
RVSS_t47 VSS__t47 VSS 2.53243676221
* device instance VSS_t48 r0 *1 0,0
RVSS_t48 VSS__t48 VSS 3.18106088154
* device instance VSS_t49 r0 *1 0,0
RVSS_t49 VSS__t49 VSS 5.24486489759
* device instance VSS_t50 r0 *1 0,0
RVSS_t50 VSS__t50 VSS 5.18589906856
* device instance VSS_t51 r0 *1 0,0
RVSS_t51 VSS__t51 VSS 5.00900158147
* device instance VSS_t52 r0 *1 0,0
RVSS_t52 VSS__t52 VSS 4.95003575244
* device instance VSS_t53 r0 *1 0,0
RVSS_t53 VSS__t53 VSS 4.83210409438
* device instance VSS_t54 r0 *1 0,0
RVSS_t54 VSS__t54 VSS 4.71417243632
* device instance VSS_t55 r0 *1 0,0
RVSS_t55 VSS__t55 VSS 4.59624077826
* device instance VSS_t56 r0 *1 0,0
RVSS_t56 VSS__t56 VSS 4.53727494923
* device instance VSS_t57 r0 *1 0,0
RVSS_t57 VSS__t57 VSS 4.41934329117
* device instance VSS_t58 r0 *1 0,0
RVSS_t58 VSS__t58 VSS 4.36037746214
* device instance VSS_t59 r0 *1 0,0
RVSS_t59 VSS__t59 VSS 4.18347997505
* device instance VSS_t60 r0 *1 0,0
RVSS_t60 VSS__t60 VSS 4.12451414602
* device instance VSS_t61 r0 *1 0,0
RVSS_t61 VSS__t61 VSS 4.00658248796
* device instance VSS_t62 r0 *1 0,0
RVSS_t62 VSS__t62 VSS 4.65520660729
* device instance VSS_t63 r0 *1 0,0
RVSS_t63 VSS__t63 VSS 3.77690694402
* device instance VSS_t64 r0 *1 0,0
RVSS_t64 VSS__t64 VSS 3.89483860208
* device instance VSS_t65 r0 *1 0,0
RVSS_t65 VSS__t65 VSS 3.95380443111
* device instance VSS_t66 r0 *1 0,0
RVSS_t66 VSS__t66 VSS 4.1307019182
* device instance VSS_t67 r0 *1 0,0
RVSS_t67 VSS__t67 VSS 4.18966774723
* device instance VSS_t68 r0 *1 0,0
RVSS_t68 VSS__t68 VSS 4.30759940529
* device instance VSS_t69 r0 *1 0,0
RVSS_t69 VSS__t69 VSS 0.704496062271
* device instance VSS_t70 r0 *1 0,0
RVSS_t70 VSS__t70 VSS 4.48449689238
* device instance VSS_t71 r0 *1 0,0
RVSS_t71 VSS__t71 VSS 4.54346272141
* device instance VSS_t72 r0 *1 0,0
RVSS_t72 VSS__t72 VSS 4.60242855044
* device instance VSS_t73 r0 *1 0,0
RVSS_t73 VSS__t73 VSS 4.7203602085
* device instance VSS_t74 r0 *1 0,0
RVSS_t74 VSS__t74 VSS 4.77932603753
* device instance VSS_t75 r0 *1 0,0
RVSS_t75 VSS__t75 VSS 4.95622352462
* device instance VSS_t76 r0 *1 0,0
RVSS_t76 VSS__t76 VSS 5.01518935365
* device instance VSS_t77 r0 *1 0,0
RVSS_t77 VSS__t77 VSS 4.42553106335
* device instance VSS_t78 r0 *1 0,0
RVSS_t78 VSS__t78 VSS 2.30276121827
* device instance VSS_t79 r0 *1 0,0
RVSS_t79 VSS__t79 VSS 2.3617270473
* device instance VSS_t80 r0 *1 0,0
RVSS_t80 VSS__t80 VSS 2.47965870536
* device instance VSS_t81 r0 *1 0,0
RVSS_t81 VSS__t81 VSS 2.59759036342
* device instance VSS_t82 r0 *1 0,0
RVSS_t82 VSS__t82 VSS 2.65655619245
* device instance VSS_t83 r0 *1 0,0
RVSS_t83 VSS__t83 VSS 2.71552202148
* device instance VSS_t84 r0 *1 0,0
RVSS_t84 VSS__t84 VSS 2.77448785051
* device instance VSS_t85 r0 *1 0,0
RVSS_t85 VSS__t85 VSS 2.89241950857
* device instance VSS_t86 r0 *1 0,0
RVSS_t86 VSS__t86 VSS 3.71794111499
* device instance VSS_t87 r0 *1 0,0
RVSS_t87 VSS__t87 VSS 3.12828282469
* device instance VSS_t88 r0 *1 0,0
RVSS_t88 VSS__t88 VSS 3.18724865372
* device instance VSS_t89 r0 *1 0,0
RVSS_t89 VSS__t89 VSS 3.30518031178
* device instance VSS_t90 r0 *1 0,0
RVSS_t90 VSS__t90 VSS 3.48207779887
* device instance VSS_t91 r0 *1 0,0
RVSS_t91 VSS__t91 VSS 3.5410436279
* device instance VSS_t92 r0 *1 0,0
RVSS_t92 VSS__t92 VSS 3.60000945693
* device instance VSS_t93 r0 *1 0,0
RVSS_t93 VSS__t93 VSS 3.65897528596
* device instance VSS_t94 r0 *1 0,0
RVSS_t94 VSS__t94 VSS 2.9513853376
* device instance VSS_t95 r0 *1 0,0
RVSS_t95 VSS__t95 VSS 1.89000041506
* device instance VSS_t96 r0 *1 0,0
RVSS_t96 VSS__t96 VSS 1.94896624409
* device instance VSS_t97 r0 *1 0,0
RVSS_t97 VSS__t97 VSS 2.06689790215
* device instance VSS_t98 r0 *1 0,0
RVSS_t98 VSS__t98 VSS 2.12586373118
* device instance VSS_t99 r0 *1 0,0
RVSS_t99 VSS__t99 VSS 1.12344463766
* device instance VSS_t100 r0 *1 0,0
RVSS_t100 VSS__t100 VSS 1.70691515578
* device instance VSS_t101 r0 *1 0,0
RVSS_t101 VSS__t101 VSS 1.58898349772
* device instance VSS_t102 r0 *1 0,0
RVSS_t102 VSS__t102 VSS 1.53001766869
* device instance VSS_t103 r0 *1 0,0
RVSS_t103 VSS__t103 VSS 1.3531201816
* device instance VSS_t104 r0 *1 0,0
RVSS_t104 VSS__t104 VSS 1.29415435257
* device instance VSS_t105 r0 *1 0,0
RVSS_t105 VSS__t105 VSS 1.17622269451
* device instance VSS_t106 r0 *1 0,0
RVSS_t106 VSS__t106 VSS 1.05829103645
* device instance VSS_t107 r0 *1 0,0
RVSS_t107 VSS__t107 VSS 0.999325207422
* device instance VSS_t108 r0 *1 0,0
RVSS_t108 VSS__t108 VSS 0.940359378391
* device instance VSS_t109 r0 *1 0,0
RVSS_t109 VSS__t109 VSS 0.881393549361
* device instance VSS_t110 r0 *1 0,0
RVSS_t110 VSS__t110 VSS 0.763461891301
* device instance VSS_t111 r0 *1 0,0
RVSS_t111 VSS__t111 VSS 5.13312101171
* device instance VSS_t112 r0 *1 0,0
RVSS_t112 VSS__t112 VSS 5.19208684075
* device instance VSS_t113 r0 *1 0,0
RVSS_t113 VSS__t113 VSS 5.25105266978
* device instance VSS_t114 r0 *1 0,0
RVSS_t114 VSS__t114 VSS 5.36898432784
* device instance VSS_t115 r0 *1 0,0
RVSS_t115 VSS__t115 VSS 5.42795015687
* device instance VSS_t116 r0 *1 0,0
RVSS_t116 VSS__t116 VSS 5.60484764396
* device instance VSS_t117 r0 *1 0,0
RVSS_t117 VSS__t117 VSS 5.66381347299
* device instance VSS_t118 r0 *1 0,0
RVSS_t118 VSS__t118 VSS 1.83103458603
* device instance VSS_t119 r0 *1 0,0
RVSS_t119 VSS__t119 VSS 1.76588098481
* device instance VSS_t120 r0 *1 0,0
RVSS_t120 VSS__t120 VSS 1.30034212475
* device instance VSS_t121 r0 *1 0,0
RVSS_t121 VSS__t121 VSS 1.35930795378
* device instance VSS_t122 r0 *1 0,0
RVSS_t122 VSS__t122 VSS 1.47723961185
* device instance VSS_t123 r0 *1 0,0
RVSS_t123 VSS__t123 VSS 1.65413709894
* device instance VSS_t124 r0 *1 0,0
RVSS_t124 VSS__t124 VSS 1.71310292797
* device instance VSS_t125 r0 *1 0,0
RVSS_t125 VSS__t125 VSS 1.772068757
* device instance VSS_t126 r0 *1 0,0
RVSS_t126 VSS__t126 VSS 5.78174513105
* device instance VSS_t127 r0 *1 0,0
RVSS_t127 VSS__t127 VSS 5.77555735886
* device instance VSS_t128 r0 *1 0,0
RVSS_t128 VSS__t128 VSS 5.71659152983
* device instance VSS_t129 r0 *1 0,0
RVSS_t129 VSS__t129 VSS 5.6576257008
* device instance VSS_t130 r0 *1 0,0
RVSS_t130 VSS__t130 VSS 5.59865987177
* device instance VSS_t131 r0 *1 0,0
RVSS_t131 VSS__t131 VSS 5.53969404274
* device instance VSS_t132 r0 *1 0,0
RVSS_t132 VSS__t132 VSS 5.48072821371
* device instance VSS_t133 r0 *1 0,0
RVSS_t133 VSS__t133 VSS 5.42176238468
* device instance VSS_t134 r0 *1 0,0
RVSS_t134 VSS__t134 VSS 5.36279655565
* device instance VSS_t135 r0 *1 0,0
RVSS_t135 VSS__t135 VSS 5.30383072662
* device instance VSS_t136 r0 *1 0,0
RVSS_t136 VSS__t136 VSS 5.24486489759
* device instance VSS_t137 r0 *1 0,0
RVSS_t137 VSS__t137 VSS 5.18589906856
* device instance VSS_t138 r0 *1 0,0
RVSS_t138 VSS__t138 VSS 5.12693323953
* device instance VSS_t139 r0 *1 0,0
RVSS_t139 VSS__t139 VSS 5.0679674105
* device instance VSS_t140 r0 *1 0,0
RVSS_t140 VSS__t140 VSS 5.00900158147
* device instance VSS_t141 r0 *1 0,0
RVSS_t141 VSS__t141 VSS 4.95003575244
* device instance VSS_t142 r0 *1 0,0
RVSS_t142 VSS__t142 VSS 4.89106992341
* device instance VSS_t143 r0 *1 0,0
RVSS_t143 VSS__t143 VSS 4.83210409438
* device instance VSS_t144 r0 *1 0,0
RVSS_t144 VSS__t144 VSS 4.77313826535
* device instance VSS_t145 r0 *1 0,0
RVSS_t145 VSS__t145 VSS 4.71417243632
* device instance VSS_t146 r0 *1 0,0
RVSS_t146 VSS__t146 VSS 4.65520660729
* device instance VSS_t147 r0 *1 0,0
RVSS_t147 VSS__t147 VSS 4.59624077826
* device instance VSS_t148 r0 *1 0,0
RVSS_t148 VSS__t148 VSS 4.53727494923
* device instance VSS_t149 r0 *1 0,0
RVSS_t149 VSS__t149 VSS 4.4783091202
* device instance VSS_t150 r0 *1 0,0
RVSS_t150 VSS__t150 VSS 4.41934329117
* device instance VSS_t151 r0 *1 0,0
RVSS_t151 VSS__t151 VSS 4.36037746214
* device instance VSS_t152 r0 *1 0,0
RVSS_t152 VSS__t152 VSS 4.30141163311
* device instance VSS_t153 r0 *1 0,0
RVSS_t153 VSS__t153 VSS 4.24244580408
* device instance VSS_t154 r0 *1 0,0
RVSS_t154 VSS__t154 VSS 4.18347997505
* device instance VSS_t155 r0 *1 0,0
RVSS_t155 VSS__t155 VSS 4.12451414602
* device instance VSS_t156 r0 *1 0,0
RVSS_t156 VSS__t156 VSS 4.06554831699
* device instance VSS_t157 r0 *1 0,0
RVSS_t157 VSS__t157 VSS 4.00658248796
* device instance VSS_t158 r0 *1 0,0
RVSS_t158 VSS__t158 VSS 3.94761665893
* device instance VSS_t159 r0 *1 0,0
RVSS_t159 VSS__t159 VSS 3.8886508299
* device instance VSS_t160 r0 *1 0,0
RVSS_t160 VSS__t160 VSS 3.82968500087
* device instance VSS_t161 r0 *1 0,0
RVSS_t161 VSS__t161 VSS 3.77071917184
* device instance VSS_t162 r0 *1 0,0
RVSS_t162 VSS__t162 VSS 3.71175334281
* device instance VSS_t163 r0 *1 0,0
RVSS_t163 VSS__t163 VSS 3.65278751378
* device instance VSS_t164 r0 *1 0,0
RVSS_t164 VSS__t164 VSS 3.59382168475
* device instance VSS_t165 r0 *1 0,0
RVSS_t165 VSS__t165 VSS 3.53485585572
* device instance VSS_t166 r0 *1 0,0
RVSS_t166 VSS__t166 VSS 3.47589002669
* device instance VSS_t167 r0 *1 0,0
RVSS_t167 VSS__t167 VSS 3.41692419766
* device instance VSS_t168 r0 *1 0,0
RVSS_t168 VSS__t168 VSS 3.35795836863
* device instance VSS_t169 r0 *1 0,0
RVSS_t169 VSS__t169 VSS 3.2989925396
* device instance VSS_t170 r0 *1 0,0
RVSS_t170 VSS__t170 VSS 3.24002671057
* device instance VSS_t171 r0 *1 0,0
RVSS_t171 VSS__t171 VSS 3.18106088154
* device instance VSS_t172 r0 *1 0,0
RVSS_t172 VSS__t172 VSS 3.12209505251
* device instance VSS_t173 r0 *1 0,0
RVSS_t173 VSS__t173 VSS 3.06312922348
* device instance VSS_t174 r0 *1 0,0
RVSS_t174 VSS__t174 VSS 3.00416339445
* device instance VSS_t175 r0 *1 0,0
RVSS_t175 VSS__t175 VSS 2.94519756542
* device instance VSS_t176 r0 *1 0,0
RVSS_t176 VSS__t176 VSS 2.88623173639
* device instance VSS_t177 r0 *1 0,0
RVSS_t177 VSS__t177 VSS 2.82726590736
* device instance VSS_t178 r0 *1 0,0
RVSS_t178 VSS__t178 VSS 2.76830007833
* device instance VSS_t179 r0 *1 0,0
RVSS_t179 VSS__t179 VSS 2.7093342493
* device instance VSS_t180 r0 *1 0,0
RVSS_t180 VSS__t180 VSS 2.65036842027
* device instance VSS_t181 r0 *1 0,0
RVSS_t181 VSS__t181 VSS 2.59140259124
* device instance VSS_t182 r0 *1 0,0
RVSS_t182 VSS__t182 VSS 2.53243676221
* device instance VSS_t183 r0 *1 0,0
RVSS_t183 VSS__t183 VSS 2.47347093318
* device instance VSS_t184 r0 *1 0,0
RVSS_t184 VSS__t184 VSS 2.41450510415
* device instance VSS_t185 r0 *1 0,0
RVSS_t185 VSS__t185 VSS 2.35553927512
* device instance VSS_t186 r0 *1 0,0
RVSS_t186 VSS__t186 VSS 2.29657344609
* device instance VSS_t187 r0 *1 0,0
RVSS_t187 VSS__t187 VSS 2.23760761705
* device instance VSS_t188 r0 *1 0,0
RVSS_t188 VSS__t188 VSS 2.17864178802
* device instance VSS_t189 r0 *1 0,0
RVSS_t189 VSS__t189 VSS 2.11967595899
* device instance VSS_t190 r0 *1 0,0
RVSS_t190 VSS__t190 VSS 2.06071012996
* device instance VSS_t191 r0 *1 0,0
RVSS_t191 VSS__t191 VSS 2.00174430093
* device instance VSS_t192 r0 *1 0,0
RVSS_t192 VSS__t192 VSS 1.9427784719
* device instance VSS_t193 r0 *1 0,0
RVSS_t193 VSS__t193 VSS 1.88381264287
* device instance VSS_t194 r0 *1 0,0
RVSS_t194 VSS__t194 VSS 1.82484681384
* device instance VSS_t195 r0 *1 0,0
RVSS_t195 VSS__t195 VSS 1.76588098481
* device instance VSS_t196 r0 *1 0,0
RVSS_t196 VSS__t196 VSS 1.70691515578
* device instance VSS_t197 r0 *1 0,0
RVSS_t197 VSS__t197 VSS 1.64794932675
* device instance VSS_t198 r0 *1 0,0
RVSS_t198 VSS__t198 VSS 1.58898349772
* device instance VSS_t199 r0 *1 0,0
RVSS_t199 VSS__t199 VSS 1.53001766869
* device instance VSS_t200 r0 *1 0,0
RVSS_t200 VSS__t200 VSS 1.47105183966
* device instance VSS_t201 r0 *1 0,0
RVSS_t201 VSS__t201 VSS 1.41208601063
* device instance VSS_t202 r0 *1 0,0
RVSS_t202 VSS__t202 VSS 1.3531201816
* device instance VSS_t203 r0 *1 0,0
RVSS_t203 VSS__t203 VSS 1.29415435257
* device instance VSS_t204 r0 *1 0,0
RVSS_t204 VSS__t204 VSS 1.23518852354
* device instance VSS_t205 r0 *1 0,0
RVSS_t205 VSS__t205 VSS 1.17622269451
* device instance VSS_t206 r0 *1 0,0
RVSS_t206 VSS__t206 VSS 1.11725686548
* device instance VSS_t207 r0 *1 0,0
RVSS_t207 VSS__t207 VSS 1.05829103645
* device instance VSS_t208 r0 *1 0,0
RVSS_t208 VSS__t208 VSS 0.999325207422
* device instance VSS_t209 r0 *1 0,0
RVSS_t209 VSS__t209 VSS 0.940359378391
* device instance VSS_t210 r0 *1 0,0
RVSS_t210 VSS__t210 VSS 0.881393549361
* device instance VSS_t211 r0 *1 0,0
RVSS_t211 VSS__t211 VSS 0.822427720331
* device instance VSS_t212 r0 *1 0,0
RVSS_t212 VSS__t212 VSS 0.763461891301
* device instance VSS_t213 r0 *1 0,0
RVSS_t213 VSS__t213 VSS 0.704496062271
* device instance VSS_t214 r0 *1 0,0
RVSS_t214 VSS__t214 VSS 0.645530233241
* device instance VSS_t215 r0 *1 0,0
RVSS_t215 VSS__t215 VSS 0.58656440421
* device instance VSS_t216 r0 *1 0,0
RVSS_t216 VSS__t216 VSS 0.52759857518
* device instance VSS_t217 r0 *1 0,0
RVSS_t217 VSS__t217 VSS 0.46863274615
* device instance VSS_t218 r0 *1 0,0
RVSS_t218 VSS__t218 VSS 0.40966691712
* device instance VSS_t219 r0 *1 0,0
RVSS_t219 VSS__t219 VSS 0.35070108809
* device instance VSS_t220 r0 *1 0,0
RVSS_t220 VSS__t220 VSS 0.29173525906
* device instance VSS_t221 r0 *1 0,0
RVSS_t221 VSS__t221 VSS 0.23276943003
* device instance VSS_t222 r0 *1 0,0
RVSS_t222 VSS__t222 VSS 0.173803600999
* device instance VSS_t223 r0 *1 0,0
RVSS_t223 VSS__t223 VSS 0.114837771969
* device instance VSS_t224 r0 *1 0,0
RVSS_t224 VSS__t224 VSS 0.0558719429391
* device instance VSS_t225 r0 *1 0,0
RVSS_t225 VSS__t225 VSS 0.00309388609109
* device instance VSS_t226 r0 *1 0,0
RVSS_t226 VSS__t226 VSS 0.0620597151212
* device instance VSS_t227 r0 *1 0,0
RVSS_t227 VSS__t227 VSS 0.121025544151
* device instance VSS_t228 r0 *1 0,0
RVSS_t228 VSS__t228 VSS 0.179991373182
* device instance VSS_t229 r0 *1 0,0
RVSS_t229 VSS__t229 VSS 0.238957202212
* device instance VSS_t230 r0 *1 0,0
RVSS_t230 VSS__t230 VSS 0.297923031242
* device instance VSS_t231 r0 *1 0,0
RVSS_t231 VSS__t231 VSS 0.356888860272
* device instance VSS_t232 r0 *1 0,0
RVSS_t232 VSS__t232 VSS 0.415854689302
* device instance VSS_t233 r0 *1 0,0
RVSS_t233 VSS__t233 VSS 0.474820518332
* device instance VSS_t234 r0 *1 0,0
RVSS_t234 VSS__t234 VSS 0.533786347363
* device instance VSS_t235 r0 *1 0,0
RVSS_t235 VSS__t235 VSS 0.592752176393
* device instance VSS_t236 r0 *1 0,0
RVSS_t236 VSS__t236 VSS 0.651718005423
* device instance VSS_t237 r0 *1 0,0
RVSS_t237 VSS__t237 VSS 0.710683834453
* device instance VSS_t238 r0 *1 0,0
RVSS_t238 VSS__t238 VSS 0.769649663483
* device instance VSS_t239 r0 *1 0,0
RVSS_t239 VSS__t239 VSS 0.828615492513
* device instance VSS_t240 r0 *1 0,0
RVSS_t240 VSS__t240 VSS 0.887581321543
* device instance VSS_t241 r0 *1 0,0
RVSS_t241 VSS__t241 VSS 0.946547150574
* device instance VSS_t242 r0 *1 0,0
RVSS_t242 VSS__t242 VSS 1.0055129796
* device instance VSS_t243 r0 *1 0,0
RVSS_t243 VSS__t243 VSS 1.06447880863
* device instance VSS_t244 r0 *1 0,0
RVSS_t244 VSS__t244 VSS 1.12344463766
* device instance VSS_t245 r0 *1 0,0
RVSS_t245 VSS__t245 VSS 1.18241046669
* device instance VSS_t246 r0 *1 0,0
RVSS_t246 VSS__t246 VSS 1.24137629572
* device instance VSS_t247 r0 *1 0,0
RVSS_t247 VSS__t247 VSS 1.30034212475
* device instance VSS_t248 r0 *1 0,0
RVSS_t248 VSS__t248 VSS 1.35930795378
* device instance VSS_t249 r0 *1 0,0
RVSS_t249 VSS__t249 VSS 1.41827378281
* device instance VSS_t250 r0 *1 0,0
RVSS_t250 VSS__t250 VSS 1.47723961185
* device instance VSS_t251 r0 *1 0,0
RVSS_t251 VSS__t251 VSS 1.53620544088
* device instance VSS_t252 r0 *1 0,0
RVSS_t252 VSS__t252 VSS 1.59517126991
* device instance VSS_t253 r0 *1 0,0
RVSS_t253 VSS__t253 VSS 1.65413709894
* device instance VSS_t254 r0 *1 0,0
RVSS_t254 VSS__t254 VSS 1.71310292797
* device instance VSS_t255 r0 *1 0,0
RVSS_t255 VSS__t255 VSS 1.772068757
* device instance VSS_t256 r0 *1 0,0
RVSS_t256 VSS__t256 VSS 1.83103458603
* device instance VSS_t257 r0 *1 0,0
RVSS_t257 VSS__t257 VSS 1.89000041506
* device instance VSS_t258 r0 *1 0,0
RVSS_t258 VSS__t258 VSS 1.94896624409
* device instance VSS_t259 r0 *1 0,0
RVSS_t259 VSS__t259 VSS 2.00793207312
* device instance VSS_t260 r0 *1 0,0
RVSS_t260 VSS__t260 VSS 2.06689790215
* device instance VSS_t261 r0 *1 0,0
RVSS_t261 VSS__t261 VSS 2.12586373118
* device instance VSS_t262 r0 *1 0,0
RVSS_t262 VSS__t262 VSS 2.18482956021
* device instance VSS_t263 r0 *1 0,0
RVSS_t263 VSS__t263 VSS 2.24379538924
* device instance VSS_t264 r0 *1 0,0
RVSS_t264 VSS__t264 VSS 2.30276121827
* device instance VSS_t265 r0 *1 0,0
RVSS_t265 VSS__t265 VSS 2.3617270473
* device instance VSS_t266 r0 *1 0,0
RVSS_t266 VSS__t266 VSS 2.42069287633
* device instance VSS_t267 r0 *1 0,0
RVSS_t267 VSS__t267 VSS 2.47965870536
* device instance VSS_t268 r0 *1 0,0
RVSS_t268 VSS__t268 VSS 2.53862453439
* device instance VSS_t269 r0 *1 0,0
RVSS_t269 VSS__t269 VSS 2.59759036342
* device instance VSS_t270 r0 *1 0,0
RVSS_t270 VSS__t270 VSS 2.65655619245
* device instance VSS_t271 r0 *1 0,0
RVSS_t271 VSS__t271 VSS 2.71552202148
* device instance VSS_t272 r0 *1 0,0
RVSS_t272 VSS__t272 VSS 2.77448785051
* device instance VSS_t273 r0 *1 0,0
RVSS_t273 VSS__t273 VSS 2.83345367954
* device instance VSS_t274 r0 *1 0,0
RVSS_t274 VSS__t274 VSS 2.89241950857
* device instance VSS_t275 r0 *1 0,0
RVSS_t275 VSS__t275 VSS 2.9513853376
* device instance VSS_t276 r0 *1 0,0
RVSS_t276 VSS__t276 VSS 3.01035116663
* device instance VSS_t277 r0 *1 0,0
RVSS_t277 VSS__t277 VSS 3.06931699566
* device instance VSS_t278 r0 *1 0,0
RVSS_t278 VSS__t278 VSS 3.12828282469
* device instance VSS_t279 r0 *1 0,0
RVSS_t279 VSS__t279 VSS 3.18724865372
* device instance VSS_t280 r0 *1 0,0
RVSS_t280 VSS__t280 VSS 3.24621448275
* device instance VSS_t281 r0 *1 0,0
RVSS_t281 VSS__t281 VSS 3.30518031178
* device instance VSS_t282 r0 *1 0,0
RVSS_t282 VSS__t282 VSS 3.36414614081
* device instance VSS_t283 r0 *1 0,0
RVSS_t283 VSS__t283 VSS 3.42311196984
* device instance VSS_t284 r0 *1 0,0
RVSS_t284 VSS__t284 VSS 3.48207779887
* device instance VSS_t285 r0 *1 0,0
RVSS_t285 VSS__t285 VSS 3.5410436279
* device instance VSS_t286 r0 *1 0,0
RVSS_t286 VSS__t286 VSS 3.60000945693
* device instance VSS_t287 r0 *1 0,0
RVSS_t287 VSS__t287 VSS 3.65897528596
* device instance VSS_t288 r0 *1 0,0
RVSS_t288 VSS__t288 VSS 3.71794111499
* device instance VSS_t289 r0 *1 0,0
RVSS_t289 VSS__t289 VSS 3.77690694402
* device instance VSS_t290 r0 *1 0,0
RVSS_t290 VSS__t290 VSS 3.83587277305
* device instance VSS_t291 r0 *1 0,0
RVSS_t291 VSS__t291 VSS 3.89483860208
* device instance VSS_t292 r0 *1 0,0
RVSS_t292 VSS__t292 VSS 3.95380443111
* device instance VSS_t293 r0 *1 0,0
RVSS_t293 VSS__t293 VSS 4.01277026014
* device instance VSS_t294 r0 *1 0,0
RVSS_t294 VSS__t294 VSS 4.07173608917
* device instance VSS_t295 r0 *1 0,0
RVSS_t295 VSS__t295 VSS 4.1307019182
* device instance VSS_t296 r0 *1 0,0
RVSS_t296 VSS__t296 VSS 4.18966774723
* device instance VSS_t297 r0 *1 0,0
RVSS_t297 VSS__t297 VSS 4.24863357626
* device instance VSS_t298 r0 *1 0,0
RVSS_t298 VSS__t298 VSS 4.30759940529
* device instance VSS_t299 r0 *1 0,0
RVSS_t299 VSS__t299 VSS 4.36656523432
* device instance VSS_t300 r0 *1 0,0
RVSS_t300 VSS__t300 VSS 4.42553106335
* device instance VSS_t301 r0 *1 0,0
RVSS_t301 VSS__t301 VSS 4.48449689238
* device instance VSS_t302 r0 *1 0,0
RVSS_t302 VSS__t302 VSS 4.54346272141
* device instance VSS_t303 r0 *1 0,0
RVSS_t303 VSS__t303 VSS 4.60242855044
* device instance VSS_t304 r0 *1 0,0
RVSS_t304 VSS__t304 VSS 4.66139437947
* device instance VSS_t305 r0 *1 0,0
RVSS_t305 VSS__t305 VSS 4.7203602085
* device instance VSS_t306 r0 *1 0,0
RVSS_t306 VSS__t306 VSS 4.77932603753
* device instance VSS_t307 r0 *1 0,0
RVSS_t307 VSS__t307 VSS 4.83829186656
* device instance VSS_t308 r0 *1 0,0
RVSS_t308 VSS__t308 VSS 4.89725769559
* device instance VSS_t309 r0 *1 0,0
RVSS_t309 VSS__t309 VSS 4.95622352462
* device instance VSS_t310 r0 *1 0,0
RVSS_t310 VSS__t310 VSS 5.01518935365
* device instance VSS_t311 r0 *1 0,0
RVSS_t311 VSS__t311 VSS 5.07415518268
* device instance VSS_t312 r0 *1 0,0
RVSS_t312 VSS__t312 VSS 5.13312101171
* device instance VSS_t313 r0 *1 0,0
RVSS_t313 VSS__t313 VSS 5.19208684075
* device instance VSS_t314 r0 *1 0,0
RVSS_t314 VSS__t314 VSS 5.25105266978
* device instance VSS_t315 r0 *1 0,0
RVSS_t315 VSS__t315 VSS 5.31001849881
* device instance VSS_t316 r0 *1 0,0
RVSS_t316 VSS__t316 VSS 5.36898432784
* device instance VSS_t317 r0 *1 0,0
RVSS_t317 VSS__t317 VSS 5.42795015687
* device instance VSS_t318 r0 *1 0,0
RVSS_t318 VSS__t318 VSS 5.4869159859
* device instance VSS_t319 r0 *1 0,0
RVSS_t319 VSS__t319 VSS 5.54588181493
* device instance VSS_t320 r0 *1 0,0
RVSS_t320 VSS__t320 VSS 5.60484764396
* device instance VSS_t321 r0 *1 0,0
RVSS_t321 VSS__t321 VSS 5.66381347299
* device instance VSS_t322 r0 *1 0,0
RVSS_t322 VSS__t322 VSS 5.72277930202
* device instance VSS_t323 r0 *1 0,0
RVSS_t323 VSS__t323 VSS 5.78174513105
* device instance VSS r0 *1 0,0
CVSS VSS vsubs 2.59891192e-13
* device instance XD0_XDFFM_CKBB_t0 r0 *1 0,0
RXD0_XDFFM_CKBB_t0 XD0_XDFFM_CKBB__t0 XD0_XDFFM_CKBB 46.818891639
* device instance XD0_XDFFM_CKBB_t1 r0 *1 0,0
RXD0_XDFFM_CKBB_t1 XD0_XDFFM_CKBB__t1 XD0_XDFFM_CKBB 52.2993375693
* device instance XD0_XDFFM_CKBB_t2 r0 *1 0,0
RXD0_XDFFM_CKBB_t2 XD0_XDFFM_CKBB__t2 XD0_XDFFM_CKBB 46.0359707918
* device instance XD0_XDFFM_CKBB_t3 r0 *1 0,0
RXD0_XDFFM_CKBB_t3 XD0_XDFFM_CKBB__t3 XD0_XDFFM_CKBB 47.9392783686
* device instance XD0_XDFFM_CKBB_t4 r0 *1 0,0
RXD0_XDFFM_CKBB_t4 XD0_XDFFM_CKBB__t4 XD0_XDFFM_CKBB 47.4938234038
* device instance XD0_XDFFM_CKBB_t5 r0 *1 0,0
RXD0_XDFFM_CKBB_t5 XD0_XDFFM_CKBB__t5 XD0_XDFFM_CKBB 49.7210982277
* device instance XD0_XDFFM_CKBB r0 *1 0,0
CXD0_XDFFM_CKBB XD0_XDFFM_CKBB vsubs 6.4238927e-14
* device instance XD0_XDFFM_CLKB_t0 r0 *1 0,0
RXD0_XDFFM_CLKB_t0 XD0_XDFFM_CLKB__t0 XD0_XDFFM_CLKB 35.6163282129
* device instance XD0_XDFFM_CLKB_t1 r0 *1 0,0
RXD0_XDFFM_CLKB_t1 XD0_XDFFM_CLKB__t1 XD0_XDFFM_CLKB 38.0072967871
* device instance XD0_XDFFM_CLKB_t2 r0 *1 0,0
RXD0_XDFFM_CLKB_t2 XD0_XDFFM_CLKB__t2 XD0_XDFFM_CLKB 38.6050389307
* device instance XD0_XDFFM_CLKB_t3 r0 *1 0,0
RXD0_XDFFM_CLKB_t3 XD0_XDFFM_CLKB__t3 XD0_XDFFM_CLKB 35.0185860693
* device instance XD0_XDFFM_CLKB_t4 r0 *1 0,0
RXD0_XDFFM_CLKB_t4 XD0_XDFFM_CLKB__t4 XD0_XDFFM_CLKB 37.4920018358
* device instance XD0_XDFFM_CLKB_t5 r0 *1 0,0
RXD0_XDFFM_CLKB_t5 XD0_XDFFM_CLKB__t5 XD0_XDFFM_CLKB 37.1519071679
* device instance XD0_XDFFM_CLKB_t6 r0 *1 0,0
RXD0_XDFFM_CLKB_t6 XD0_XDFFM_CLKB__t6 XD0_XDFFM_CLKB 34.7712444926
* device instance XD0_XDFFM_CLKB_t7 r0 *1 0,0
RXD0_XDFFM_CLKB_t7 XD0_XDFFM_CLKB__t7 XD0_XDFFM_CLKB 37.8320965037
* device instance XD0_XDFFM_CLKB r0 *1 0,0
CXD0_XDFFM_CLKB XD0_XDFFM_CLKB vsubs 6.5372278e-14
* device instance XD0_XDFFM_M_t0 r0 *1 0,0
RXD0_XDFFM_M_t0 XD0_XDFFM_M__t0 XD0_XDFFM_M 36.8220274115
* device instance XD0_XDFFM_M_t1 r0 *1 0,0
RXD0_XDFFM_M_t1 XD0_XDFFM_M__t1 XD0_XDFFM_M 36.216404823
* device instance XD0_XDFFM_M_t2 r0 *1 0,0
RXD0_XDFFM_M_t2 XD0_XDFFM_M__t2 XD0_XDFFM_M 38.0332725885
* device instance XD0_XDFFM_M_t3 r0 *1 0,0
RXD0_XDFFM_M_t3 XD0_XDFFM_M__t3 XD0_XDFFM_M 38.638895177
* device instance XD0_XDFFM_M_t4 r0 *1 0,0
RXD0_XDFFM_M_t4 XD0_XDFFM_M__t4 XD0_XDFFM_M 37.7722283693
* device instance XD0_XDFFM_M_t5 r0 *1 0,0
RXD0_XDFFM_M_t5 XD0_XDFFM_M__t5 XD0_XDFFM_M 36.7384932613
* device instance XD0_XDFFM_M_t6 r0 *1 0,0
RXD0_XDFFM_M_t6 XD0_XDFFM_M__t6 XD0_XDFFM_M 38.1168067387
* device instance XD0_XDFFM_M_t7 r0 *1 0,0
RXD0_XDFFM_M_t7 XD0_XDFFM_M__t7 XD0_XDFFM_M 37.0830716307
* device instance XD0_XDFFM_M r0 *1 0,0
CXD0_XDFFM_M XD0_XDFFM_M vsubs 6.6427168e-14
* device instance XD0_XDFFM_MB_t0 r0 *1 0,0
RXD0_XDFFM_MB_t0 XD0_XDFFM_MB__t0 XD0_XDFFM_MB 68.5887225255
* device instance XD0_XDFFM_MB_t1 r0 *1 0,0
RXD0_XDFFM_MB_t1 XD0_XDFFM_MB__t1 XD0_XDFFM_MB 67.4858774745
* device instance XD0_XDFFM_MB_t2 r0 *1 0,0
RXD0_XDFFM_MB_t2 XD0_XDFFM_MB__t2 XD0_XDFFM_MB 67.7235595976
* device instance XD0_XDFFM_MB_t3 r0 *1 0,0
RXD0_XDFFM_MB_t3 XD0_XDFFM_MB__t3 XD0_XDFFM_MB 68.3510404024
* device instance XD0_XDFFM_MB r0 *1 0,0
CXD0_XDFFM_MB XD0_XDFFM_MB vsubs 6.0164189e-14
* device instance XD0_XDFFM_MFB_t0 r0 *1 0,0
RXD0_XDFFM_MFB_t0 XD0_XDFFM_MFB__t0 XD0_XDFFM_MFB 68.5797561038
* device instance XD0_XDFFM_MFB_t1 r0 *1 0,0
RXD0_XDFFM_MFB_t1 XD0_XDFFM_MFB__t1 XD0_XDFFM_MFB 69.6965438962
* device instance XD0_XDFFM_MFB_t2 r0 *1 0,0
RXD0_XDFFM_MFB_t2 XD0_XDFFM_MFB__t2 XD0_XDFFM_MFB 69.455856872
* device instance XD0_XDFFM_MFB_t3 r0 *1 0,0
RXD0_XDFFM_MFB_t3 XD0_XDFFM_MFB__t3 XD0_XDFFM_MFB 68.820443128
* device instance XD0_XDFFM_MFB r0 *1 0,0
CXD0_XDFFM_MFB XD0_XDFFM_MFB vsubs 6.1114528e-14
* device instance XD0_XDFFM_S_t0 r0 *1 0,0
RXD0_XDFFM_S_t0 XD0_XDFFM_S__t0 XD0_XDFFM_S 48.6137480983
* device instance XD0_XDFFM_S_t1 r0 *1 0,0
RXD0_XDFFM_S_t1 XD0_XDFFM_S__t1 XD0_XDFFM_S 47.8319923931
* device instance XD0_XDFFM_S_t2 r0 *1 0,0
RXD0_XDFFM_S_t2 XD0_XDFFM_S__t2 XD0_XDFFM_S 50.1772595087
* device instance XD0_XDFFM_S_t3 r0 *1 0,0
RXD0_XDFFM_S_t3 XD0_XDFFM_S__t3 XD0_XDFFM_S 49.0225973464
* device instance XD0_XDFFM_S_t4 r0 *1 0,0
RXD0_XDFFM_S_t4 XD0_XDFFM_S__t4 XD0_XDFFM_S 49.4673893855
* device instance XD0_XDFFM_S_t5 r0 *1 0,0
RXD0_XDFFM_S_t5 XD0_XDFFM_S__t5 XD0_XDFFM_S 48.1330132681
* device instance XD0_XDFFM_S r0 *1 0,0
CXD0_XDFFM_S XD0_XDFFM_S vsubs 6.5064445e-14
* device instance XD0_XDFFM_SB_t0 r0 *1 0,0
RXD0_XDFFM_SB_t0 XD0_XDFFM_SB__t0 XD0_XDFFM_SB 48.3604843151
* device instance XD0_XDFFM_SB_t1 r0 *1 0,0
RXD0_XDFFM_SB_t1 XD0_XDFFM_SB__t1 XD0_XDFFM_SB 49.9104784245
* device instance XD0_XDFFM_SB_t2 r0 *1 0,0
RXD0_XDFFM_SB_t2 XD0_XDFFM_SB__t2 XD0_XDFFM_SB 47.5854872604
* device instance XD0_XDFFM_SB_t3 r0 *1 0,0
RXD0_XDFFM_SB_t3 XD0_XDFFM_SB__t3 XD0_XDFFM_SB 48.7657988667
* device instance XD0_XDFFM_SB_t4 r0 *1 0,0
RXD0_XDFFM_SB_t4 XD0_XDFFM_SB__t4 XD0_XDFFM_SB 47.8839056665
* device instance XD0_XDFFM_SB_t5 r0 *1 0,0
RXD0_XDFFM_SB_t5 XD0_XDFFM_SB__t5 XD0_XDFFM_SB 49.2067454668
* device instance XD0_XDFFM_SB r0 *1 0,0
CXD0_XDFFM_SB XD0_XDFFM_SB vsubs 6.4800083e-14
* device instance XD0_XDFFM_SFB_t0 r0 *1 0,0
RXD0_XDFFM_SFB_t0 XD0_XDFFM_SFB__t0 XD0_XDFFM_SFB 69.983986209
* device instance XD0_XDFFM_SFB_t1 r0 *1 0,0
RXD0_XDFFM_SFB_t1 XD0_XDFFM_SFB__t1 XD0_XDFFM_SFB 71.107863791
* device instance XD0_XDFFM_SFB_t2 r0 *1 0,0
RXD0_XDFFM_SFB_t2 XD0_XDFFM_SFB__t2 XD0_XDFFM_SFB 70.8656487949
* device instance XD0_XDFFM_SFB_t3 r0 *1 0,0
RXD0_XDFFM_SFB_t3 XD0_XDFFM_SFB__t3 XD0_XDFFM_SFB 70.2262012051
* device instance XD0_XDFFM_SFB r0 *1 0,0
CXD0_XDFFM_SFB XD0_XDFFM_SFB vsubs 6.2444973e-14
* device instance XD0_XDFFQ_CKBB_t0 r0 *1 0,0
RXD0_XDFFQ_CKBB_t0 XD0_XDFFQ_CKBB__t0 XD0_XDFFQ_CKBB 46.1144502729
* device instance XD0_XDFFQ_CKBB_t1 r0 *1 0,0
RXD0_XDFFQ_CKBB_t1 XD0_XDFFQ_CKBB__t1 XD0_XDFFQ_CKBB 51.7992659843
* device instance XD0_XDFFQ_CKBB_t2 r0 *1 0,0
RXD0_XDFFQ_CKBB_t2 XD0_XDFFQ_CKBB__t2 XD0_XDFFQ_CKBB 45.3023337427
* device instance XD0_XDFFQ_CKBB_t3 r0 *1 0,0
RXD0_XDFFQ_CKBB_t3 XD0_XDFFQ_CKBB__t3 XD0_XDFFQ_CKBB 47.2766170317
* device instance XD0_XDFFQ_CKBB_t4 r0 *1 0,0
RXD0_XDFFQ_CKBB_t4 XD0_XDFFQ_CKBB__t4 XD0_XDFFQ_CKBB 46.81455073
* device instance XD0_XDFFQ_CKBB_t5 r0 *1 0,0
RXD0_XDFFQ_CKBB_t5 XD0_XDFFQ_CKBB__t5 XD0_XDFFQ_CKBB 49.1248822383
* device instance XD0_XDFFQ_CKBB r0 *1 0,0
CXD0_XDFFQ_CKBB XD0_XDFFQ_CKBB vsubs 6.3696365e-14
* device instance XD0_XDFFQ_CLKB_t0 r0 *1 0,0
RXD0_XDFFQ_CLKB_t0 XD0_XDFFQ_CLKB__t0 XD0_XDFFQ_CLKB 37.931692178
* device instance XD0_XDFFQ_CLKB_t1 r0 *1 0,0
RXD0_XDFFQ_CLKB_t1 XD0_XDFFQ_CLKB__t1 XD0_XDFFQ_CLKB 38.5579632669
* device instance XD0_XDFFQ_CLKB_t2 r0 *1 0,0
RXD0_XDFFQ_CLKB_t2 XD0_XDFFQ_CLKB__t2 XD0_XDFFQ_CLKB 35.426607822
* device instance XD0_XDFFQ_CLKB_t3 r0 *1 0,0
RXD0_XDFFQ_CLKB_t3 XD0_XDFFQ_CLKB__t3 XD0_XDFFQ_CLKB 34.8003367331
* device instance XD0_XDFFQ_CLKB_t4 r0 *1 0,0
RXD0_XDFFQ_CLKB_t4 XD0_XDFFQ_CLKB__t4 XD0_XDFFQ_CLKB 37.3918033081
* device instance XD0_XDFFQ_CLKB_t5 r0 *1 0,0
RXD0_XDFFQ_CLKB_t5 XD0_XDFFQ_CLKB__t5 XD0_XDFFQ_CLKB 37.0354766541
* device instance XD0_XDFFQ_CLKB_t6 r0 *1 0,0
RXD0_XDFFQ_CLKB_t6 XD0_XDFFQ_CLKB__t6 XD0_XDFFQ_CLKB 34.5411900756
* device instance XD0_XDFFQ_CLKB_t7 r0 *1 0,0
RXD0_XDFFQ_CLKB_t7 XD0_XDFFQ_CLKB__t7 XD0_XDFFQ_CLKB 37.7481299622
* device instance XD0_XDFFQ_CLKB r0 *1 0,0
CXD0_XDFFQ_CLKB XD0_XDFFQ_CLKB vsubs 6.5549716e-14
* device instance XD0_XDFFQ_M_t0 r0 *1 0,0
RXD0_XDFFQ_M_t0 XD0_XDFFQ_M__t0 XD0_XDFFQ_M 37.6560315902
* device instance XD0_XDFFQ_M_t1 r0 *1 0,0
RXD0_XDFFQ_M_t1 XD0_XDFFQ_M__t1 XD0_XDFFQ_M 36.6605975081
* device instance XD0_XDFFQ_M_t2 r0 *1 0,0
RXD0_XDFFQ_M_t2 XD0_XDFFQ_M__t2 XD0_XDFFQ_M 36.0261450163
* device instance XD0_XDFFQ_M_t3 r0 *1 0,0
RXD0_XDFFQ_M_t3 XD0_XDFFQ_M__t3 XD0_XDFFQ_M 37.9295024919
* device instance XD0_XDFFQ_M_t4 r0 *1 0,0
RXD0_XDFFQ_M_t4 XD0_XDFFQ_M__t4 XD0_XDFFQ_M 38.5639549837
* device instance XD0_XDFFQ_M_t5 r0 *1 0,0
RXD0_XDFFQ_M_t5 XD0_XDFFQ_M__t5 XD0_XDFFQ_M 36.5730868196
* device instance XD0_XDFFQ_M_t6 r0 *1 0,0
RXD0_XDFFQ_M_t6 XD0_XDFFQ_M__t6 XD0_XDFFQ_M 38.0170131804
* device instance XD0_XDFFQ_M_t7 r0 *1 0,0
RXD0_XDFFQ_M_t7 XD0_XDFFQ_M__t7 XD0_XDFFQ_M 36.9340684098
* device instance XD0_XDFFQ_M r0 *1 0,0
CXD0_XDFFQ_M XD0_XDFFQ_M vsubs 6.6604606e-14
* device instance XD0_XDFFQ_MB_t0 r0 *1 0,0
RXD0_XDFFQ_MB_t0 XD0_XDFFQ_MB__t0 XD0_XDFFQ_MB 66.9303007775
* device instance XD0_XDFFQ_MB_t1 r0 *1 0,0
RXD0_XDFFQ_MB_t1 XD0_XDFFQ_MB__t1 XD0_XDFFQ_MB 65.7992492225
* device instance XD0_XDFFQ_MB_t2 r0 *1 0,0
RXD0_XDFFQ_MB_t2 XD0_XDFFQ_MB__t2 XD0_XDFFQ_MB 66.0430103335
* device instance XD0_XDFFQ_MB_t3 r0 *1 0,0
RXD0_XDFFQ_MB_t3 XD0_XDFFQ_MB__t3 XD0_XDFFQ_MB 66.6865396665
* device instance XD0_XDFFQ_MB r0 *1 0,0
CXD0_XDFFQ_MB XD0_XDFFQ_MB vsubs 5.8901626e-14
* device instance XD0_XDFFQ_MFB_t0 r0 *1 0,0
RXD0_XDFFQ_MFB_t0 XD0_XDFFQ_MFB__t0 XD0_XDFFQ_MFB 66.8928470772
* device instance XD0_XDFFQ_MFB_t1 r0 *1 0,0
RXD0_XDFFQ_MFB_t1 XD0_XDFFQ_MFB__t1 XD0_XDFFQ_MFB 68.0384529228
* device instance XD0_XDFFQ_MFB_t2 r0 *1 0,0
RXD0_XDFFQ_MFB_t2 XD0_XDFFQ_MFB__t2 XD0_XDFFQ_MFB 67.7915551113
* device instance XD0_XDFFQ_MFB_t3 r0 *1 0,0
RXD0_XDFFQ_MFB_t3 XD0_XDFFQ_MFB__t3 XD0_XDFFQ_MFB 67.1397448887
* device instance XD0_XDFFQ_MFB r0 *1 0,0
CXD0_XDFFQ_MFB XD0_XDFFQ_MFB vsubs 5.9851964e-14
* device instance XD0_XDFFQ_S_t0 r0 *1 0,0
RXD0_XDFFQ_S_t0 XD0_XDFFQ_S__t0 XD0_XDFFQ_S 47.9583519958
* device instance XD0_XDFFQ_S_t1 r0 *1 0,0
RXD0_XDFFQ_S_t1 XD0_XDFFQ_S__t1 XD0_XDFFQ_S 47.147807983
* device instance XD0_XDFFQ_S_t2 r0 *1 0,0
RXD0_XDFFQ_S_t2 XD0_XDFFQ_S__t2 XD0_XDFFQ_S 49.5794400212
* device instance XD0_XDFFQ_S_t3 r0 *1 0,0
RXD0_XDFFQ_S_t3 XD0_XDFFQ_S__t3 XD0_XDFFQ_S 48.3822571978
* device instance XD0_XDFFQ_S_t4 r0 *1 0,0
RXD0_XDFFQ_S_t4 XD0_XDFFQ_S__t4 XD0_XDFFQ_S 48.8434287913
* device instance XD0_XDFFQ_S_t5 r0 *1 0,0
RXD0_XDFFQ_S_t5 XD0_XDFFQ_S__t5 XD0_XDFFQ_S 47.4599140109
* device instance XD0_XDFFQ_S r0 *1 0,0
CXD0_XDFFQ_S XD0_XDFFQ_S vsubs 6.4521882e-14
* device instance XD0_XDFFQ_SB_t0 r0 *1 0,0
RXD0_XDFFQ_SB_t0 XD0_XDFFQ_SB__t0 XD0_XDFFQ_SB 47.7052698205
* device instance XD0_XDFFQ_SB_t1 r0 *1 0,0
RXD0_XDFFQ_SB_t1 XD0_XDFFQ_SB__t1 XD0_XDFFQ_SB 49.3119508974
* device instance XD0_XDFFQ_SB_t2 r0 *1 0,0
RXD0_XDFFQ_SB_t2 XD0_XDFFQ_SB__t2 XD0_XDFFQ_SB 46.9019292821
* device instance XD0_XDFFQ_SB_t3 r0 *1 0,0
RXD0_XDFFQ_SB_t3 XD0_XDFFQ_SB__t3 XD0_XDFFQ_SB 48.1254076883
* device instance XD0_XDFFQ_SB_t4 r0 *1 0,0
RXD0_XDFFQ_SB_t4 XD0_XDFFQ_SB__t4 XD0_XDFFQ_SB 47.2112615584
* device instance XD0_XDFFQ_SB_t5 r0 *1 0,0
RXD0_XDFFQ_SB_t5 XD0_XDFFQ_SB__t5 XD0_XDFFQ_SB 48.5824807533
* device instance XD0_XDFFQ_SB r0 *1 0,0
CXD0_XDFFQ_SB XD0_XDFFQ_SB vsubs 6.425752e-14
* device instance XD0_XDFFQ_SFB_t0 r0 *1 0,0
RXD0_XDFFQ_SFB_t0 XD0_XDFFQ_SFB__t0 XD0_XDFFQ_SFB 68.2972052275
* device instance XD0_XDFFQ_SFB_t1 r0 *1 0,0
RXD0_XDFFQ_SFB_t1 XD0_XDFFQ_SFB__t1 XD0_XDFFQ_SFB 69.4498447725
* device instance XD0_XDFFQ_SFB_t2 r0 *1 0,0
RXD0_XDFFQ_SFB_t2 XD0_XDFFQ_SFB__t2 XD0_XDFFQ_SFB 69.2014310775
* device instance XD0_XDFFQ_SFB_t3 r0 *1 0,0
RXD0_XDFFQ_SFB_t3 XD0_XDFFQ_SFB__t3 XD0_XDFFQ_SFB 68.5456189225
* device instance XD0_XDFFQ_SFB r0 *1 0,0
CXD0_XDFFQ_SFB XD0_XDFFQ_SFB vsubs 6.118241e-14
* device instance XD0_XN2_mid1_t0 r0 *1 0,0
RXD0_XN2_mid1_t0 XD0_XN2_mid1__t0 XD0_XN2_mid1 7.844
* device instance XD0_XN2_mid1_t1 r0 *1 0,0
RXD0_XN2_mid1_t1 XD0_XN2_mid1__t1 XD0_XN2_mid1 7.844
* device instance XD0_XN2_mid1 r0 *1 0,0
CXD0_XN2_mid1 XD0_XN2_mid1 vsubs 3.897636e-15
* device instance XD0_XN3_mid1_t0 r0 *1 0,0
RXD0_XN3_mid1_t0 XD0_XN3_mid1__t0 XD0_XN3_mid1 8.02
* device instance XD0_XN3_mid1_t1 r0 *1 0,0
RXD0_XN3_mid1_t1 XD0_XN3_mid1__t1 XD0_XN3_mid1 8.02
* device instance XD0_XN3_mid1 r0 *1 0,0
CXD0_XN3_mid1 XD0_XN3_mid1 vsubs 4.020565e-15
* device instance XD0_XN3_mid2_t0 r0 *1 0,0
RXD0_XN3_mid2_t0 XD0_XN3_mid2__t0 XD0_XN3_mid2 8.19595
* device instance XD0_XN3_mid2_t1 r0 *1 0,0
RXD0_XN3_mid2_t1 XD0_XN3_mid2__t1 XD0_XN3_mid2 8.19595
* device instance XD0_XN3_mid2 r0 *1 0,0
CXD0_XN3_mid2 XD0_XN3_mid2 vsubs 4.110213e-15
* device instance XD0_XNOR_midp_t0 r0 *1 0,0
RXD0_XNOR_midp_t0 XD0_XNOR_midp__t0 XD0_XNOR_midp 9.89835
* device instance XD0_XNOR_midp_t1 r0 *1 0,0
RXD0_XNOR_midp_t1 XD0_XNOR_midp__t1 XD0_XNOR_midp 9.89835
* device instance XD0_XNOR_midp r0 *1 0,0
CXD0_XNOR_midp XD0_XNOR_midp vsubs 4.770474e-15
* device instance XD0_dmodout_t0 r0 *1 0,0
RXD0_dmodout_t0 XD0_dmodout__t0 XD0_dmodout 70.1081083765
* device instance XD0_dmodout_t1 r0 *1 0,0
RXD0_dmodout_t1 XD0_dmodout__t1 XD0_dmodout 73.6402416235
* device instance XD0_dmodout_t2 r0 *1 0,0
RXD0_dmodout_t2 XD0_dmodout__t2 XD0_dmodout 70.8693439901
* device instance XD0_dmodout_t3 r0 *1 0,0
RXD0_dmodout_t3 XD0_dmodout__t3 XD0_dmodout 72.8790060099
* device instance XD0_dmodout r0 *1 0,0
CXD0_dmodout XD0_dmodout vsubs 6.3985113e-14
* device instance XD0_dq_t0 r0 *1 0,0
RXD0_dq_t0 XD0_dq__t0 XD0_dq 69.7459573681
* device instance XD0_dq_t1 r0 *1 0,0
RXD0_dq_t1 XD0_dq__t1 XD0_dq 72.8041426319
* device instance XD0_dq_t2 r0 *1 0,0
RXD0_dq_t2 XD0_dq__t2 XD0_dq 48.4833677558
* device instance XD0_dq_t3 r0 *1 0,0
RXD0_dq_t3 XD0_dq__t3 XD0_dq 47.9033671023
* device instance XD0_dq_t4 r0 *1 0,0
RXD0_dq_t4 XD0_dq__t4 XD0_dq 46.1633651419
* device instance XD0_dq r0 *1 0,0
CXD0_dq XD0_dq vsubs 6.3685258e-14
* device instance XD0_nm_t0 r0 *1 0,0
RXD0_nm_t0 XD0_nm__t0 XD0_nm 49.6340714114
* device instance XD0_nm_t1 r0 *1 0,0
RXD0_nm_t1 XD0_nm__t1 XD0_nm 47.6248285886
* device instance XD0_nm_t2 r0 *1 0,0
RXD0_nm_t2 XD0_nm__t2 XD0_nm 48.62945
* device instance XD0_nm_t3 r0 *1 0,0
RXD0_nm_t3 XD0_nm__t3 XD0_nm 72.372580059
* device instance XD0_nm_t4 r0 *1 0,0
RXD0_nm_t4 XD0_nm__t4 XD0_nm 73.515769941
* device instance XD0_nm r0 *1 0,0
CXD0_nm XD0_nm vsubs 6.5206771e-14
* device instance XD0_nt_t0 r0 *1 0,0
RXD0_nt_t0 XD0_nt__t0 XD0_nt 37.6054197929
* device instance XD0_nt_t1 r0 *1 0,0
RXD0_nt_t1 XD0_nt__t1 XD0_nt 36.6525982643
* device instance XD0_nt_t2 r0 *1 0,0
RXD0_nt_t2 XD0_nt__t2 XD0_nt 35.6997767357
* device instance XD0_nt_t3 r0 *1 0,0
RXD0_nt_t3 XD0_nt__t3 XD0_nt 34.7469552071
* device instance XD0_nt_t4 r0 *1 0,0
RXD0_nt_t4 XD0_nt__t4 XD0_nt 71.5391911092
* device instance XD0_nt_t5 r0 *1 0,0
RXD0_nt_t5 XD0_nt__t5 XD0_nt 73.1655588908
* device instance XD0_nt r0 *1 0,0
CXD0_nt XD0_nt vsubs 6.4864336e-14
* device instance XD0_t1_t0 r0 *1 0,0
RXD0_t1_t0 XD0_t1__t0 XD0_t1 69.022804889
* device instance XD0_t1_t1 r0 *1 0,0
RXD0_t1_t1 XD0_t1__t1 XD0_t1 66.662645111
* device instance XD0_t1_t2 r0 *1 0,0
RXD0_t1_t2 XD0_t1__t2 XD0_t1 67.1713002355
* device instance XD0_t1_t3 r0 *1 0,0
RXD0_t1_t3 XD0_t1__t3 XD0_t1 68.5141497645
* device instance XD0_t1 r0 *1 0,0
CXD0_t1 XD0_t1 vsubs 6.0580208e-14
* device instance XD1_XDFFM_CKBB_t0 r0 *1 0,0
RXD1_XDFFM_CKBB_t0 XD1_XDFFM_CKBB__t0 XD1_XDFFM_CKBB 55.655707202
* device instance XD1_XDFFM_CKBB_t1 r0 *1 0,0
RXD1_XDFFM_CKBB_t1 XD1_XDFFM_CKBB__t1 XD1_XDFFM_CKBB 61.5158486618
* device instance XD1_XDFFM_CKBB_t2 r0 *1 0,0
RXD1_XDFFM_CKBB_t2 XD1_XDFFM_CKBB__t2 XD1_XDFFM_CKBB 54.8185441363
* device instance XD1_XDFFM_CKBB_t3 r0 *1 0,0
RXD1_XDFFM_CKBB_t3 XD1_XDFFM_CKBB__t3 XD1_XDFFM_CKBB 56.3773995
* device instance XD1_XDFFM_CKBB_t4 r0 *1 0,0
RXD1_XDFFM_CKBB_t4 XD1_XDFFM_CKBB__t4 XD1_XDFFM_CKBB 56.8537164166
* device instance XD1_XDFFM_CKBB_t5 r0 *1 0,0
RXD1_XDFFM_CKBB_t5 XD1_XDFFM_CKBB__t5 XD1_XDFFM_CKBB 58.7589840834
* device instance XD1_XDFFM_CKBB r0 *1 0,0
CXD1_XDFFM_CKBB XD1_XDFFM_CKBB vsubs 7.7128747e-14
* device instance XD1_XDFFM_CLKB_t0 r0 *1 0,0
RXD1_XDFFM_CLKB_t0 XD1_XDFFM_CLKB__t0 XD1_XDFFM_CLKB 43.3132786824
* device instance XD1_XDFFM_CLKB_t1 r0 *1 0,0
RXD1_XDFFM_CLKB_t1 XD1_XDFFM_CLKB__t1 XD1_XDFFM_CLKB 45.9277963176
* device instance XD1_XDFFM_CLKB_t2 r0 *1 0,0
RXD1_XDFFM_CLKB_t2 XD1_XDFFM_CLKB__t2 XD1_XDFFM_CLKB 46.5814257264
* device instance XD1_XDFFM_CLKB_t3 r0 *1 0,0
RXD1_XDFFM_CLKB_t3 XD1_XDFFM_CLKB__t3 XD1_XDFFM_CLKB 42.6596492736
* device instance XD1_XDFFM_CLKB_t4 r0 *1 0,0
RXD1_XDFFM_CLKB_t4 XD1_XDFFM_CLKB__t4 XD1_XDFFM_CLKB 42.3891819321
* device instance XD1_XDFFM_CLKB_t5 r0 *1 0,0
RXD1_XDFFM_CLKB_t5 XD1_XDFFM_CLKB__t5 XD1_XDFFM_CLKB 45.3643226893
* device instance XD1_XDFFM_CLKB_t6 r0 *1 0,0
RXD1_XDFFM_CLKB_t6 XD1_XDFFM_CLKB__t6 XD1_XDFFM_CLKB 44.9924300947
* device instance XD1_XDFFM_CLKB_t7 r0 *1 0,0
RXD1_XDFFM_CLKB_t7 XD1_XDFFM_CLKB__t7 XD1_XDFFM_CLKB 45.736215284
* device instance XD1_XDFFM_CLKB r0 *1 0,0
CXD1_XDFFM_CLKB XD1_XDFFM_CLKB vsubs 8.0523758e-14
* device instance XD1_XDFFM_M_t0 r0 *1 0,0
RXD1_XDFFM_M_t0 XD1_XDFFM_M__t0 XD1_XDFFM_M 44.5759207019
* device instance XD1_XDFFM_M_t1 r0 *1 0,0
RXD1_XDFFM_M_t1 XD1_XDFFM_M__t1 XD1_XDFFM_M 43.9153539037
* device instance XD1_XDFFM_M_t2 r0 *1 0,0
RXD1_XDFFM_M_t2 XD1_XDFFM_M__t2 XD1_XDFFM_M 45.8970542981
* device instance XD1_XDFFM_M_t3 r0 *1 0,0
RXD1_XDFFM_M_t3 XD1_XDFFM_M__t3 XD1_XDFFM_M 46.5576210963
* device instance XD1_XDFFM_M_t4 r0 *1 0,0
RXD1_XDFFM_M_t4 XD1_XDFFM_M__t4 XD1_XDFFM_M 45.61232723
* device instance XD1_XDFFM_M_t5 r0 *1 0,0
RXD1_XDFFM_M_t5 XD1_XDFFM_M__t5 XD1_XDFFM_M 44.48480804
* device instance XD1_XDFFM_M_t6 r0 *1 0,0
RXD1_XDFFM_M_t6 XD1_XDFFM_M__t6 XD1_XDFFM_M 45.98816696
* device instance XD1_XDFFM_M_t7 r0 *1 0,0
RXD1_XDFFM_M_t7 XD1_XDFFM_M__t7 XD1_XDFFM_M 44.86064777
* device instance XD1_XDFFM_M r0 *1 0,0
CXD1_XDFFM_M XD1_XDFFM_M vsubs 8.1578648e-14
* device instance XD1_XDFFM_MB_t0 r0 *1 0,0
RXD1_XDFFM_MB_t0 XD1_XDFFM_MB__t0 XD1_XDFFM_MB 79.8358325628
* device instance XD1_XDFFM_MB_t1 r0 *1 0,0
RXD1_XDFFM_MB_t1 XD1_XDFFM_MB__t1 XD1_XDFFM_MB 78.6766674372
* device instance XD1_XDFFM_MB_t2 r0 *1 0,0
RXD1_XDFFM_MB_t2 XD1_XDFFM_MB__t2 XD1_XDFFM_MB 78.9264875074
* device instance XD1_XDFFM_MB_t3 r0 *1 0,0
RXD1_XDFFM_MB_t3 XD1_XDFFM_MB__t3 XD1_XDFFM_MB 79.5860124926
* device instance XD1_XDFFM_MB r0 *1 0,0
CXD1_XDFFM_MB XD1_XDFFM_MB vsubs 7.0792349e-14
* device instance XD1_XDFFM_MFB_t0 r0 *1 0,0
RXD1_XDFFM_MFB_t0 XD1_XDFFM_MFB__t0 XD1_XDFFM_MFB 79.7713632431
* device instance XD1_XDFFM_MFB_t1 r0 *1 0,0
RXD1_XDFFM_MFB_t1 XD1_XDFFM_MFB__t1 XD1_XDFFM_MFB 80.9429367569
* device instance XD1_XDFFM_MFB_t2 r0 *1 0,0
RXD1_XDFFM_MFB_t2 XD1_XDFFM_MFB__t2 XD1_XDFFM_MFB 80.6904424651
* device instance XD1_XDFFM_MFB_t3 r0 *1 0,0
RXD1_XDFFM_MFB_t3 XD1_XDFFM_MFB__t3 XD1_XDFFM_MFB 80.0238575349
* device instance XD1_XDFFM_MFB r0 *1 0,0
CXD1_XDFFM_MFB XD1_XDFFM_MFB vsubs 7.1742688e-14
* device instance XD1_XDFFM_S_t0 r0 *1 0,0
RXD1_XDFFM_S_t0 XD1_XDFFM_S__t0 XD1_XDFFM_S 57.5415488113
* device instance XD1_XDFFM_S_t1 r0 *1 0,0
RXD1_XDFFM_S_t1 XD1_XDFFM_S__t1 XD1_XDFFM_S 56.7059952453
* device instance XD1_XDFFM_S_t2 r0 *1 0,0
RXD1_XDFFM_S_t2 XD1_XDFFM_S__t2 XD1_XDFFM_S 59.2126559434
* device instance XD1_XDFFM_S_t3 r0 *1 0,0
RXD1_XDFFM_S_t3 XD1_XDFFM_S__t3 XD1_XDFFM_S 57.9785337223
* device instance XD1_XDFFM_S_t4 r0 *1 0,0
RXD1_XDFFM_S_t4 XD1_XDFFM_S__t4 XD1_XDFFM_S 58.4539348892
* device instance XD1_XDFFM_S_t5 r0 *1 0,0
RXD1_XDFFM_S_t5 XD1_XDFFM_S__t5 XD1_XDFFM_S 57.0277313885
* device instance XD1_XDFFM_S r0 *1 0,0
CXD1_XDFFM_S XD1_XDFFM_S vsubs 7.7954265e-14
* device instance XD1_XDFFM_SB_t0 r0 *1 0,0
RXD1_XDFFM_SB_t0 XD1_XDFFM_SB__t0 XD1_XDFFM_SB 57.2881570437
* device instance XD1_XDFFM_SB_t1 r0 *1 0,0
RXD1_XDFFM_SB_t1 XD1_XDFFM_SB__t1 XD1_XDFFM_SB 58.9467147817
* device instance XD1_XDFFM_SB_t2 r0 *1 0,0
RXD1_XDFFM_SB_t2 XD1_XDFFM_SB__t2 XD1_XDFFM_SB 56.4588781746
* device instance XD1_XDFFM_SB_t3 r0 *1 0,0
RXD1_XDFFM_SB_t3 XD1_XDFFM_SB__t3 XD1_XDFFM_SB 56.7781981989
* device instance XD1_XDFFM_SB_t4 r0 *1 0,0
RXD1_XDFFM_SB_t4 XD1_XDFFM_SB__t4 XD1_XDFFM_SB 57.7218603602
* device instance XD1_XDFFM_SB_t5 r0 *1 0,0
RXD1_XDFFM_SB_t5 XD1_XDFFM_SB__t5 XD1_XDFFM_SB 58.1936914409
* device instance XD1_XDFFM_SB r0 *1 0,0
CXD1_XDFFM_SB XD1_XDFFM_SB vsubs 7.7689903e-14
* device instance XD1_XDFFM_SFB_t0 r0 *1 0,0
RXD1_XDFFM_SFB_t0 XD1_XDFFM_SFB__t0 XD1_XDFFM_SFB 81.1764481154
* device instance XD1_XDFFM_SFB_t1 r0 *1 0,0
RXD1_XDFFM_SFB_t1 XD1_XDFFM_SFB__t1 XD1_XDFFM_SFB 82.3537518846
* device instance XD1_XDFFM_SFB_t2 r0 *1 0,0
RXD1_XDFFM_SFB_t2 XD1_XDFFM_SFB__t2 XD1_XDFFM_SFB 82.100022624
* device instance XD1_XDFFM_SFB_t3 r0 *1 0,0
RXD1_XDFFM_SFB_t3 XD1_XDFFM_SFB__t3 XD1_XDFFM_SFB 81.430177376
* device instance XD1_XDFFM_SFB r0 *1 0,0
CXD1_XDFFM_SFB XD1_XDFFM_SFB vsubs 7.3073134e-14
* device instance XD1_XDFFQ_CKBB_t0 r0 *1 0,0
RXD1_XDFFQ_CKBB_t0 XD1_XDFFQ_CKBB__t0 XD1_XDFFQ_CKBB 54.9527743575
* device instance XD1_XDFFQ_CKBB_t1 r0 *1 0,0
RXD1_XDFFQ_CKBB_t1 XD1_XDFFQ_CKBB__t1 XD1_XDFFQ_CKBB 61.0139891063
* device instance XD1_XDFFQ_CKBB_t2 r0 *1 0,0
RXD1_XDFFQ_CKBB_t2 XD1_XDFFQ_CKBB__t2 XD1_XDFFQ_CKBB 54.0868865362
* device instance XD1_XDFFQ_CKBB_t3 r0 *1 0,0
RXD1_XDFFQ_CKBB_t3 XD1_XDFFQ_CKBB__t3 XD1_XDFFQ_CKBB 56.1918896879
* device instance XD1_XDFFQ_CKBB_t4 r0 *1 0,0
RXD1_XDFFQ_CKBB_t4 XD1_XDFFQ_CKBB__t4 XD1_XDFFQ_CKBB 55.6992293758
* device instance XD1_XDFFQ_CKBB_t5 r0 *1 0,0
RXD1_XDFFQ_CKBB_t5 XD1_XDFFQ_CKBB__t5 XD1_XDFFQ_CKBB 58.1625309363
* device instance XD1_XDFFQ_CKBB r0 *1 0,0
CXD1_XDFFQ_CKBB XD1_XDFFQ_CKBB vsubs 7.6591093e-14
* device instance XD1_XDFFQ_CLKB_t0 r0 *1 0,0
RXD1_XDFFQ_CLKB_t0 XD1_XDFFQ_CLKB__t0 XD1_XDFFQ_CLKB 43.1247287371
* device instance XD1_XDFFQ_CLKB_t1 r0 *1 0,0
RXD1_XDFFQ_CLKB_t1 XD1_XDFFQ_CLKB__t1 XD1_XDFFQ_CLKB 45.8520462629
* device instance XD1_XDFFQ_CLKB_t2 r0 *1 0,0
RXD1_XDFFQ_CLKB_t2 XD1_XDFFQ_CLKB__t2 XD1_XDFFQ_CLKB 46.5338756444
* device instance XD1_XDFFQ_CLKB_t3 r0 *1 0,0
RXD1_XDFFQ_CLKB_t3 XD1_XDFFQ_CLKB__t3 XD1_XDFFQ_CLKB 42.4428993556
* device instance XD1_XDFFQ_CLKB_t4 r0 *1 0,0
RXD1_XDFFQ_CLKB_t4 XD1_XDFFQ_CLKB__t4 XD1_XDFFQ_CLKB 45.2642623134
* device instance XD1_XDFFQ_CLKB_t5 r0 *1 0,0
RXD1_XDFFQ_CLKB_t5 XD1_XDFFQ_CLKB__t5 XD1_XDFFQ_CLKB 44.8763249067
* device instance XD1_XDFFQ_CLKB_t6 r0 *1 0,0
RXD1_XDFFQ_CLKB_t6 XD1_XDFFQ_CLKB__t6 XD1_XDFFQ_CLKB 42.1607630599
* device instance XD1_XDFFQ_CLKB_t7 r0 *1 0,0
RXD1_XDFFQ_CLKB_t7 XD1_XDFFQ_CLKB__t7 XD1_XDFFQ_CLKB 45.6521997201
* device instance XD1_XDFFQ_CLKB r0 *1 0,0
CXD1_XDFFQ_CLKB XD1_XDFFQ_CLKB vsubs 8.070774e-14
* device instance XD1_XDFFQ_M_t0 r0 *1 0,0
RXD1_XDFFQ_M_t0 XD1_XDFFQ_M__t0 XD1_XDFFQ_M 44.4153438231
* device instance XD1_XDFFQ_M_t1 r0 *1 0,0
RXD1_XDFFQ_M_t1 XD1_XDFFQ_M__t1 XD1_XDFFQ_M 43.7263501462
* device instance XD1_XDFFQ_M_t2 r0 *1 0,0
RXD1_XDFFQ_M_t2 XD1_XDFFQ_M__t2 XD1_XDFFQ_M 45.7933311769
* device instance XD1_XDFFQ_M_t3 r0 *1 0,0
RXD1_XDFFQ_M_t3 XD1_XDFFQ_M__t3 XD1_XDFFQ_M 46.4823248538
* device instance XD1_XDFFQ_M_t4 r0 *1 0,0
RXD1_XDFFQ_M_t4 XD1_XDFFQ_M__t4 XD1_XDFFQ_M 45.4963511437
* device instance XD1_XDFFQ_M_t5 r0 *1 0,0
RXD1_XDFFQ_M_t5 XD1_XDFFQ_M__t5 XD1_XDFFQ_M 44.3203102125
* device instance XD1_XDFFQ_M_t6 r0 *1 0,0
RXD1_XDFFQ_M_t6 XD1_XDFFQ_M__t6 XD1_XDFFQ_M 45.8883647875
* device instance XD1_XDFFQ_M_t7 r0 *1 0,0
RXD1_XDFFQ_M_t7 XD1_XDFFQ_M__t7 XD1_XDFFQ_M 44.7123238563
* device instance XD1_XDFFQ_M r0 *1 0,0
CXD1_XDFFQ_M XD1_XDFFQ_M vsubs 8.176263e-14
* device instance XD1_XDFFQ_MB_t0 r0 *1 0,0
RXD1_XDFFQ_MB_t0 XD1_XDFFQ_MB__t0 XD1_XDFFQ_MB 78.1776722103
* device instance XD1_XDFFQ_MB_t1 r0 *1 0,0
RXD1_XDFFQ_MB_t1 XD1_XDFFQ_MB__t1 XD1_XDFFQ_MB 76.9905777897
* device instance XD1_XDFFQ_MB_t2 r0 *1 0,0
RXD1_XDFFQ_MB_t2 XD1_XDFFQ_MB__t2 XD1_XDFFQ_MB 77.2464171045
* device instance XD1_XDFFQ_MB_t3 r0 *1 0,0
RXD1_XDFFQ_MB_t3 XD1_XDFFQ_MB__t3 XD1_XDFFQ_MB 77.9218328955
* device instance XD1_XDFFQ_MB r0 *1 0,0
CXD1_XDFFQ_MB XD1_XDFFQ_MB vsubs 6.9533058e-14
* device instance XD1_XDFFQ_MFB_t0 r0 *1 0,0
RXD1_XDFFQ_MFB_t0 XD1_XDFFQ_MFB__t0 XD1_XDFFQ_MFB 78.0850340122
* device instance XD1_XDFFQ_MFB_t1 r0 *1 0,0
RXD1_XDFFQ_MFB_t1 XD1_XDFFQ_MFB__t1 XD1_XDFFQ_MFB 79.2850159878
* device instance XD1_XDFFQ_MFB_t2 r0 *1 0,0
RXD1_XDFFQ_MFB_t2 XD1_XDFFQ_MFB__t2 XD1_XDFFQ_MFB 79.0263991827
* device instance XD1_XDFFQ_MFB_t3 r0 *1 0,0
RXD1_XDFFQ_MFB_t3 XD1_XDFFQ_MFB__t3 XD1_XDFFQ_MFB 78.3436508173
* device instance XD1_XDFFQ_MFB r0 *1 0,0
CXD1_XDFFQ_MFB XD1_XDFFQ_MFB vsubs 7.0483397e-14
* device instance XD1_XDFFQ_S_t0 r0 *1 0,0
RXD1_XDFFQ_S_t0 XD1_XDFFQ_S__t0 XD1_XDFFQ_S 56.8866355339
* device instance XD1_XDFFQ_S_t1 r0 *1 0,0
RXD1_XDFFQ_S_t1 XD1_XDFFQ_S__t1 XD1_XDFFQ_S 56.0227421358
* device instance XD1_XDFFQ_S_t2 r0 *1 0,0
RXD1_XDFFQ_S_t2 XD1_XDFFQ_S__t2 XD1_XDFFQ_S 58.6144223303
* device instance XD1_XDFFQ_S_t3 r0 *1 0,0
RXD1_XDFFQ_S_t3 XD1_XDFFQ_S__t3 XD1_XDFFQ_S 57.3384418514
* device instance XD1_XDFFQ_S_t4 r0 *1 0,0
RXD1_XDFFQ_S_t4 XD1_XDFFQ_S__t4 XD1_XDFFQ_S 57.8299674055
* device instance XD1_XDFFQ_S_t5 r0 *1 0,0
RXD1_XDFFQ_S_t5 XD1_XDFFQ_S__t5 XD1_XDFFQ_S 56.3553907431
* device instance XD1_XDFFQ_S r0 *1 0,0
CXD1_XDFFQ_S XD1_XDFFQ_S vsubs 7.7416611e-14
* device instance XD1_XDFFQ_SB_t0 r0 *1 0,0
RXD1_XDFFQ_SB_t0 XD1_XDFFQ_SB__t0 XD1_XDFFQ_SB 56.6333860559
* device instance XD1_XDFFQ_SB_t1 r0 *1 0,0
RXD1_XDFFQ_SB_t1 XD1_XDFFQ_SB__t1 XD1_XDFFQ_SB 58.3478697206
* device instance XD1_XDFFQ_SB_t2 r0 *1 0,0
RXD1_XDFFQ_SB_t2 XD1_XDFFQ_SB__t2 XD1_XDFFQ_SB 55.7761442235
* device instance XD1_XDFFQ_SB_t3 r0 *1 0,0
RXD1_XDFFQ_SB_t3 XD1_XDFFQ_SB__t3 XD1_XDFFQ_SB 57.0817136809
* device instance XD1_XDFFQ_SB_t4 r0 *1 0,0
RXD1_XDFFQ_SB_t4 XD1_XDFFQ_SB__t4 XD1_XDFFQ_SB 56.1062315957
* device instance XD1_XDFFQ_SB_t5 r0 *1 0,0
RXD1_XDFFQ_SB_t5 XD1_XDFFQ_SB__t5 XD1_XDFFQ_SB 57.5694547234
* device instance XD1_XDFFQ_SB r0 *1 0,0
CXD1_XDFFQ_SB XD1_XDFFQ_SB vsubs 7.7152249e-14
* device instance XD1_XDFFQ_SFB_t0 r0 *1 0,0
RXD1_XDFFQ_SFB_t0 XD1_XDFFQ_SFB__t0 XD1_XDFFQ_SFB 79.4901978892
* device instance XD1_XDFFQ_SFB_t1 r0 *1 0,0
RXD1_XDFFQ_SFB_t1 XD1_XDFFQ_SFB__t1 XD1_XDFFQ_SFB 80.6958021108
* device instance XD1_XDFFQ_SFB_t2 r0 *1 0,0
RXD1_XDFFQ_SFB_t2 XD1_XDFFQ_SFB__t2 XD1_XDFFQ_SFB 80.4359736148
* device instance XD1_XDFFQ_SFB_t3 r0 *1 0,0
RXD1_XDFFQ_SFB_t3 XD1_XDFFQ_SFB__t3 XD1_XDFFQ_SFB 79.7500263852
* device instance XD1_XDFFQ_SFB r0 *1 0,0
CXD1_XDFFQ_SFB XD1_XDFFQ_SFB vsubs 7.1813843e-14
* device instance XD1_XN2_mid1_t0 r0 *1 0,0
RXD1_XN2_mid1_t0 XD1_XN2_mid1__t0 XD1_XN2_mid1 12.2436
* device instance XD1_XN2_mid1_t1 r0 *1 0,0
RXD1_XN2_mid1_t1 XD1_XN2_mid1__t1 XD1_XN2_mid1 12.2436
* device instance XD1_XN2_mid1 r0 *1 0,0
CXD1_XN2_mid1 XD1_XN2_mid1 vsubs 6.121664e-15
* device instance XD1_XN3_mid1_t0 r0 *1 0,0
RXD1_XN3_mid1_t0 XD1_XN3_mid1__t0 XD1_XN3_mid1 12.4196
* device instance XD1_XN3_mid1_t1 r0 *1 0,0
RXD1_XN3_mid1_t1 XD1_XN3_mid1__t1 XD1_XN3_mid1 12.4196
* device instance XD1_XN3_mid1 r0 *1 0,0
CXD1_XN3_mid1 XD1_XN3_mid1 vsubs 6.24132e-15
* device instance XD1_XN3_mid2_t0 r0 *1 0,0
RXD1_XN3_mid2_t0 XD1_XN3_mid2__t0 XD1_XN3_mid2 12.5956
* device instance XD1_XN3_mid2_t1 r0 *1 0,0
RXD1_XN3_mid2_t1 XD1_XN3_mid2__t1 XD1_XN3_mid2 12.5956
* device instance XD1_XN3_mid2 r0 *1 0,0
CXD1_XN3_mid2 XD1_XN3_mid2 vsubs 6.330968e-15
* device instance XD1_XNOR_midp_t0 r0 *1 0,0
RXD1_XNOR_midp_t0 XD1_XNOR_midp__t0 XD1_XNOR_midp 14.298
* device instance XD1_XNOR_midp_t1 r0 *1 0,0
RXD1_XNOR_midp_t1 XD1_XNOR_midp__t1 XD1_XNOR_midp 14.298
* device instance XD1_XNOR_midp r0 *1 0,0
CXD1_XNOR_midp XD1_XNOR_midp vsubs 7.073038e-15
* device instance XD1_dmodout_t0 r0 *1 0,0
RXD1_dmodout_t0 XD1_dmodout__t0 XD1_dmodout 81.2534115257
* device instance XD1_dmodout_t1 r0 *1 0,0
RXD1_dmodout_t1 XD1_dmodout__t1 XD1_dmodout 84.9340884743
* device instance XD1_dmodout_t2 r0 *1 0,0
RXD1_dmodout_t2 XD1_dmodout__t2 XD1_dmodout 84.1408391319
* device instance XD1_dmodout_t3 r0 *1 0,0
RXD1_dmodout_t3 XD1_dmodout__t3 XD1_dmodout 82.0466608681
* device instance XD1_dmodout r0 *1 0,0
CXD1_dmodout XD1_dmodout vsubs 7.461383e-14
* device instance XD1_dq_t0 r0 *1 0,0
RXD1_dq_t0 XD1_dq__t0 XD1_dq 81.9855976041
* device instance XD1_dq_t1 r0 *1 0,0
RXD1_dq_t1 XD1_dq__t1 XD1_dq 85.2034023959
* device instance XD1_dq_t2 r0 *1 0,0
RXD1_dq_t2 XD1_dq__t2 XD1_dq 56.7467888709
* device instance XD1_dq_t3 r0 *1 0,0
RXD1_dq_t3 XD1_dq__t3 XD1_dq 56.1365155484
* device instance XD1_dq_t4 r0 *1 0,0
RXD1_dq_t4 XD1_dq__t4 XD1_dq 54.3056955807
* device instance XD1_dq r0 *1 0,0
CXD1_dq XD1_dq vsubs 7.5424352e-14
* device instance XD1_nm_t0 r0 *1 0,0
RXD1_nm_t0 XD1_nm__t0 XD1_nm 57.8999726461
* device instance XD1_nm_t1 r0 *1 0,0
RXD1_nm_t1 XD1_nm__t1 XD1_nm 55.7849273539
* device instance XD1_nm_t2 r0 *1 0,0
RXD1_nm_t2 XD1_nm__t2 XD1_nm 56.84245
* device instance XD1_nm_t3 r0 *1 0,0
RXD1_nm_t3 XD1_nm__t3 XD1_nm 84.6619810807
* device instance XD1_nm_t4 r0 *1 0,0
RXD1_nm_t4 XD1_nm__t4 XD1_nm 85.8653689193
* device instance XD1_nm r0 *1 0,0
CXD1_nm XD1_nm vsubs 7.6989486e-14
* device instance XD1_nt_t0 r0 *1 0,0
RXD1_nt_t0 XD1_nt__t0 XD1_nt 44.4023095517
* device instance XD1_nt_t1 r0 *1 0,0
RXD1_nt_t1 XD1_nt__t1 XD1_nt 41.3694654483
* device instance XD1_nt_t2 r0 *1 0,0
RXD1_nt_t2 XD1_nt__t2 XD1_nt 43.3913615172
* device instance XD1_nt_t3 r0 *1 0,0
RXD1_nt_t3 XD1_nt__t3 XD1_nt 42.3804134828
* device instance XD1_nt_t4 r0 *1 0,0
RXD1_nt_t4 XD1_nt__t4 XD1_nt 84.908983143
* device instance XD1_nt_t5 r0 *1 0,0
RXD1_nt_t5 XD1_nt__t5 XD1_nt 86.634566857
* device instance XD1_nt r0 *1 0,0
CXD1_nt XD1_nt vsubs 7.7795061e-14
* device instance XD1_t1_t0 r0 *1 0,0
RXD1_t1_t0 XD1_t1__t0 XD1_t1 80.2944331466
* device instance XD1_t1_t1 r0 *1 0,0
RXD1_t1_t1 XD1_t1__t1 XD1_t1 77.8303168534
* device instance XD1_t1_t2 r0 *1 0,0
RXD1_t1_t2 XD1_t1__t2 XD1_t1 78.3613763994
* device instance XD1_t1_t3 r0 *1 0,0
RXD1_t1_t3 XD1_t1__t3 XD1_t1 79.7633736006
* device instance XD1_t1 r0 *1 0,0
CXD1_t1 XD1_t1 vsubs 7.1208368e-14
* device instance XD2_XDFFM_CKBB_t0 r0 *1 0,0
RXD2_XDFFM_CKBB_t0 XD2_XDFFM_CKBB__t0 XD2_XDFFM_CKBB 70.6852292078
* device instance XD2_XDFFM_CKBB_t1 r0 *1 0,0
RXD2_XDFFM_CKBB_t1 XD2_XDFFM_CKBB__t1 XD2_XDFFM_CKBB 64.5127983169
* device instance XD2_XDFFM_CKBB_t2 r0 *1 0,0
RXD2_XDFFM_CKBB_t2 XD2_XDFFM_CKBB__t2 XD2_XDFFM_CKBB 63.6310224753
* device instance XD2_XDFFM_CKBB_t3 r0 *1 0,0
RXD2_XDFFM_CKBB_t3 XD2_XDFFM_CKBB__t3 XD2_XDFFM_CKBB 65.7746499522
* device instance XD2_XDFFM_CKBB_t4 r0 *1 0,0
RXD2_XDFFM_CKBB_t4 XD2_XDFFM_CKBB__t4 XD2_XDFFM_CKBB 65.2729499044
* device instance XD2_XDFFM_CKBB_t5 r0 *1 0,0
RXD2_XDFFM_CKBB_t5 XD2_XDFFM_CKBB__t5 XD2_XDFFM_CKBB 67.7814501434
* device instance XD2_XDFFM_CKBB r0 *1 0,0
CXD2_XDFFM_CKBB XD2_XDFFM_CKBB vsubs 9.0018567e-14
* device instance XD2_XDFFM_CLKB_t0 r0 *1 0,0
RXD2_XDFFM_CLKB_t0 XD2_XDFFM_CLKB__t0 XD2_XDFFM_CLKB 54.5288825808
* device instance XD2_XDFFM_CLKB_t1 r0 *1 0,0
RXD2_XDFFM_CLKB_t1 XD2_XDFFM_CLKB__t1 XD2_XDFFM_CLKB 51.0310574461
* device instance XD2_XDFFM_CLKB_t2 r0 *1 0,0
RXD2_XDFFM_CLKB_t2 XD2_XDFFM_CLKB__t2 XD2_XDFFM_CLKB 53.8293175539
* device instance XD2_XDFFM_CLKB_t3 r0 *1 0,0
RXD2_XDFFM_CLKB_t3 XD2_XDFFM_CLKB__t3 XD2_XDFFM_CLKB 50.3314924192
* device instance XD2_XDFFM_CLKB_t4 r0 *1 0,0
RXD2_XDFFM_CLKB_t4 XD2_XDFFM_CLKB__t4 XD2_XDFFM_CLKB 50.0420172356
* device instance XD2_XDFFM_CLKB_t5 r0 *1 0,0
RXD2_XDFFM_CLKB_t5 XD2_XDFFM_CLKB__t5 XD2_XDFFM_CLKB 53.2262442548
* device instance XD2_XDFFM_CLKB_t6 r0 *1 0,0
RXD2_XDFFM_CLKB_t6 XD2_XDFFM_CLKB__t6 XD2_XDFFM_CLKB 52.8282158774
* device instance XD2_XDFFM_CLKB_t7 r0 *1 0,0
RXD2_XDFFM_CLKB_t7 XD2_XDFFM_CLKB__t7 XD2_XDFFM_CLKB 53.6242726322
* device instance XD2_XDFFM_CLKB r0 *1 0,0
CXD2_XDFFM_CLKB XD2_XDFFM_CLKB vsubs 9.5675237e-14
* device instance XD2_XDFFM_M_t0 r0 *1 0,0
RXD2_XDFFM_M_t0 XD2_XDFFM_M__t0 XD2_XDFFM_M 52.3403957821
* device instance XD2_XDFFM_M_t1 r0 *1 0,0
RXD2_XDFFM_M_t1 XD2_XDFFM_M__t1 XD2_XDFFM_M 51.6346415642
* device instance XD2_XDFFM_M_t2 r0 *1 0,0
RXD2_XDFFM_M_t2 XD2_XDFFM_M__t2 XD2_XDFFM_M 53.7519042179
* device instance XD2_XDFFM_M_t3 r0 *1 0,0
RXD2_XDFFM_M_t3 XD2_XDFFM_M__t3 XD2_XDFFM_M 54.4576584358
* device instance XD2_XDFFM_M_t4 r0 *1 0,0
RXD2_XDFFM_M_t4 XD2_XDFFM_M__t4 XD2_XDFFM_M 53.4476998136
* device instance XD2_XDFFM_M_t5 r0 *1 0,0
RXD2_XDFFM_M_t5 XD2_XDFFM_M__t5 XD2_XDFFM_M 52.2430503728
* device instance XD2_XDFFM_M_t6 r0 *1 0,0
RXD2_XDFFM_M_t6 XD2_XDFFM_M__t6 XD2_XDFFM_M 52.6446001864
* device instance XD2_XDFFM_M_t7 r0 *1 0,0
RXD2_XDFFM_M_t7 XD2_XDFFM_M__t7 XD2_XDFFM_M 53.8492496272
* device instance XD2_XDFFM_M r0 *1 0,0
CXD2_XDFFM_M XD2_XDFFM_M vsubs 9.6730127e-14
* device instance XD2_XDFFM_MB_t0 r0 *1 0,0
RXD2_XDFFM_MB_t0 XD2_XDFFM_MB__t0 XD2_XDFFM_MB 91.0786590614
* device instance XD2_XDFFM_MB_t1 r0 *1 0,0
RXD2_XDFFM_MB_t1 XD2_XDFFM_MB__t1 XD2_XDFFM_MB 89.8731909386
* device instance XD2_XDFFM_MB_t2 r0 *1 0,0
RXD2_XDFFM_MB_t2 XD2_XDFFM_MB__t2 XD2_XDFFM_MB 90.132990103
* device instance XD2_XDFFM_MB_t3 r0 *1 0,0
RXD2_XDFFM_MB_t3 XD2_XDFFM_MB__t3 XD2_XDFFM_MB 90.818859897
* device instance XD2_XDFFM_MB r0 *1 0,0
CXD2_XDFFM_MB XD2_XDFFM_MB vsubs 8.1420509e-14
* device instance XD2_XDFFM_MFB_t0 r0 *1 0,0
RXD2_XDFFM_MFB_t0 XD2_XDFFM_MFB__t0 XD2_XDFFM_MFB 90.9685285562
* device instance XD2_XDFFM_MFB_t1 r0 *1 0,0
RXD2_XDFFM_MFB_t1 XD2_XDFFM_MFB__t1 XD2_XDFFM_MFB 92.1851714438
* device instance XD2_XDFFM_MFB_t2 r0 *1 0,0
RXD2_XDFFM_MFB_t2 XD2_XDFFM_MFB__t2 XD2_XDFFM_MFB 91.2307360751
* device instance XD2_XDFFM_MFB_t3 r0 *1 0,0
RXD2_XDFFM_MFB_t3 XD2_XDFFM_MFB__t3 XD2_XDFFM_MFB 91.9229639249
* device instance XD2_XDFFM_MFB r0 *1 0,0
CXD2_XDFFM_MFB XD2_XDFFM_MFB vsubs 8.2370848e-14
* device instance XD2_XDFFM_S_t0 r0 *1 0,0
RXD2_XDFFM_S_t0 XD2_XDFFM_S__t0 XD2_XDFFM_S 66.4731378846
* device instance XD2_XDFFM_S_t1 r0 *1 0,0
RXD2_XDFFM_S_t1 XD2_XDFFM_S__t1 XD2_XDFFM_S 68.2329105769
* device instance XD2_XDFFM_S_t2 r0 *1 0,0
RXD2_XDFFM_S_t2 XD2_XDFFM_S__t2 XD2_XDFFM_S 65.5932515384
* device instance XD2_XDFFM_S_t3 r0 *1 0,0
RXD2_XDFFM_S_t3 XD2_XDFFM_S__t3 XD2_XDFFM_S 66.93330833
* device instance XD2_XDFFM_S_t4 r0 *1 0,0
RXD2_XDFFM_S_t4 XD2_XDFFM_S__t4 XD2_XDFFM_S 67.4339333201
* device instance XD2_XDFFM_S_t5 r0 *1 0,0
RXD2_XDFFM_S_t5 XD2_XDFFM_S__t5 XD2_XDFFM_S 65.9320583499
* device instance XD2_XDFFM_S r0 *1 0,0
CXD2_XDFFM_S XD2_XDFFM_S vsubs 9.0844085e-14
* device instance XD2_XDFFM_SB_t0 r0 *1 0,0
RXD2_XDFFM_SB_t0 XD2_XDFFM_SB__t0 XD2_XDFFM_SB 66.2196209297
* device instance XD2_XDFFM_SB_t1 r0 *1 0,0
RXD2_XDFFM_SB_t1 XD2_XDFFM_SB__t1 XD2_XDFFM_SB 67.9676953515
* device instance XD2_XDFFM_SB_t2 r0 *1 0,0
RXD2_XDFFM_SB_t2 XD2_XDFFM_SB__t2 XD2_XDFFM_SB 65.3455837188
* device instance XD2_XDFFM_SB_t3 r0 *1 0,0
RXD2_XDFFM_SB_t3 XD2_XDFFM_SB__t3 XD2_XDFFM_SB 66.6767323446
* device instance XD2_XDFFM_SB_t4 r0 *1 0,0
RXD2_XDFFM_SB_t4 XD2_XDFFM_SB__t4 XD2_XDFFM_SB 65.682138277
* device instance XD2_XDFFM_SB_t5 r0 *1 0,0
RXD2_XDFFM_SB_t5 XD2_XDFFM_SB__t5 XD2_XDFFM_SB 67.1740293784
* device instance XD2_XDFFM_SB r0 *1 0,0
CXD2_XDFFM_SB XD2_XDFFM_SB vsubs 9.0579723e-14
* device instance XD2_XDFFM_SFB_t0 r0 *1 0,0
RXD2_XDFFM_SFB_t0 XD2_XDFFM_SFB__t0 XD2_XDFFM_SFB 92.374144863
* device instance XD2_XDFFM_SFB_t1 r0 *1 0,0
RXD2_XDFFM_SFB_t1 XD2_XDFFM_SFB__t1 XD2_XDFFM_SFB 93.595505137
* device instance XD2_XDFFM_SFB_t2 r0 *1 0,0
RXD2_XDFFM_SFB_t2 XD2_XDFFM_SFB__t2 XD2_XDFFM_SFB 93.33228094
* device instance XD2_XDFFM_SFB_t3 r0 *1 0,0
RXD2_XDFFM_SFB_t3 XD2_XDFFM_SFB__t3 XD2_XDFFM_SFB 92.63736906
* device instance XD2_XDFFM_SFB r0 *1 0,0
CXD2_XDFFM_SFB XD2_XDFFM_SFB vsubs 8.3701294e-14
* device instance XD2_XDFFQ_CKBB_t0 r0 *1 0,0
RXD2_XDFFQ_CKBB_t0 XD2_XDFFQ_CKBB__t0 XD2_XDFFQ_CKBB 63.8115350596
* device instance XD2_XDFFQ_CKBB_t1 r0 *1 0,0
RXD2_XDFFQ_CKBB_t1 XD2_XDFFQ_CKBB__t1 XD2_XDFFQ_CKBB 70.1794873509
* device instance XD2_XDFFQ_CKBB_t2 r0 *1 0,0
RXD2_XDFFQ_CKBB_t2 XD2_XDFFQ_CKBB__t2 XD2_XDFFQ_CKBB 62.9018275895
* device instance XD2_XDFFQ_CKBB_t3 r0 *1 0,0
RXD2_XDFFQ_CKBB_t3 XD2_XDFFQ_CKBB__t3 XD2_XDFFQ_CKBB 64.5957656374
* device instance XD2_XDFFQ_CKBB_t4 r0 *1 0,0
RXD2_XDFFQ_CKBB_t4 XD2_XDFFQ_CKBB__t4 XD2_XDFFQ_CKBB 65.1133578187
* device instance XD2_XDFFQ_CKBB_t5 r0 *1 0,0
RXD2_XDFFQ_CKBB_t5 XD2_XDFFQ_CKBB__t5 XD2_XDFFQ_CKBB 67.1837265439
* device instance XD2_XDFFQ_CKBB r0 *1 0,0
CXD2_XDFFQ_CKBB XD2_XDFFQ_CKBB vsubs 8.9480913e-14
* device instance XD2_XDFFQ_CLKB_t0 r0 *1 0,0
RXD2_XDFFQ_CLKB_t0 XD2_XDFFQ_CLKB__t0 XD2_XDFFQ_CLKB 50.8439774259
* device instance XD2_XDFFQ_CLKB_t1 r0 *1 0,0
RXD2_XDFFQ_CLKB_t1 XD2_XDFFQ_CLKB__t1 XD2_XDFFQ_CLKB 53.7522725741
* device instance XD2_XDFFQ_CLKB_t2 r0 *1 0,0
RXD2_XDFFQ_CLKB_t2 XD2_XDFFQ_CLKB__t2 XD2_XDFFQ_CLKB 54.4793463611
* device instance XD2_XDFFQ_CLKB_t3 r0 *1 0,0
RXD2_XDFFQ_CLKB_t3 XD2_XDFFQ_CLKB__t3 XD2_XDFFQ_CLKB 50.1169036389
* device instance XD2_XDFFQ_CLKB_t4 r0 *1 0,0
RXD2_XDFFQ_CLKB_t4 XD2_XDFFQ_CLKB__t4 XD2_XDFFQ_CLKB 53.1254848266
* device instance XD2_XDFFQ_CLKB_t5 r0 *1 0,0
RXD2_XDFFQ_CLKB_t5 XD2_XDFFQ_CLKB__t5 XD2_XDFFQ_CLKB 52.7118049133
* device instance XD2_XDFFQ_CLKB_t6 r0 *1 0,0
RXD2_XDFFQ_CLKB_t6 XD2_XDFFQ_CLKB__t6 XD2_XDFFQ_CLKB 49.8160455201
* device instance XD2_XDFFQ_CLKB_t7 r0 *1 0,0
RXD2_XDFFQ_CLKB_t7 XD2_XDFFQ_CLKB__t7 XD2_XDFFQ_CLKB 53.5391647399
* device instance XD2_XDFFQ_CLKB r0 *1 0,0
CXD2_XDFFQ_CLKB XD2_XDFFQ_CLKB vsubs 9.585922e-14
* device instance XD2_XDFFQ_M_t0 r0 *1 0,0
RXD2_XDFFQ_M_t0 XD2_XDFFQ_M__t0 XD2_XDFFQ_M 52.1806478549
* device instance XD2_XDFFQ_M_t1 r0 *1 0,0
RXD2_XDFFQ_M_t1 XD2_XDFFQ_M__t1 XD2_XDFFQ_M 51.4472082098
* device instance XD2_XDFFQ_M_t2 r0 *1 0,0
RXD2_XDFFQ_M_t2 XD2_XDFFQ_M__t2 XD2_XDFFQ_M 53.6475271451
* device instance XD2_XDFFQ_M_t3 r0 *1 0,0
RXD2_XDFFQ_M_t3 XD2_XDFFQ_M__t3 XD2_XDFFQ_M 54.3809667902
* device instance XD2_XDFFQ_M_t4 r0 *1 0,0
RXD2_XDFFQ_M_t4 XD2_XDFFQ_M__t4 XD2_XDFFQ_M 53.331389367
* device instance XD2_XDFFQ_M_t5 r0 *1 0,0
RXD2_XDFFQ_M_t5 XD2_XDFFQ_M__t5 XD2_XDFFQ_M 52.0794837659
* device instance XD2_XDFFQ_M_t6 r0 *1 0,0
RXD2_XDFFQ_M_t6 XD2_XDFFQ_M__t6 XD2_XDFFQ_M 53.7486912341
* device instance XD2_XDFFQ_M_t7 r0 *1 0,0
RXD2_XDFFQ_M_t7 XD2_XDFFQ_M__t7 XD2_XDFFQ_M 52.496785633
* device instance XD2_XDFFQ_M r0 *1 0,0
CXD2_XDFFQ_M XD2_XDFFQ_M vsubs 9.691411e-14
* device instance XD2_XDFFQ_MB_t0 r0 *1 0,0
RXD2_XDFFQ_MB_t0 XD2_XDFFQ_MB__t0 XD2_XDFFQ_MB 89.4202487784
* device instance XD2_XDFFQ_MB_t1 r0 *1 0,0
RXD2_XDFFQ_MB_t1 XD2_XDFFQ_MB__t1 XD2_XDFFQ_MB 88.1875012216
* device instance XD2_XDFFQ_MB_t2 r0 *1 0,0
RXD2_XDFFQ_MB_t2 XD2_XDFFQ_MB__t2 XD2_XDFFQ_MB 88.4531795744
* device instance XD2_XDFFQ_MB_t3 r0 *1 0,0
RXD2_XDFFQ_MB_t3 XD2_XDFFQ_MB__t3 XD2_XDFFQ_MB 89.1545704256
* device instance XD2_XDFFQ_MB r0 *1 0,0
CXD2_XDFFQ_MB XD2_XDFFQ_MB vsubs 8.0161219e-14
* device instance XD2_XDFFQ_MFB_t0 r0 *1 0,0
RXD2_XDFFQ_MFB_t0 XD2_XDFFQ_MFB__t0 XD2_XDFFQ_MFB 89.2826461979
* device instance XD2_XDFFQ_MFB_t1 r0 *1 0,0
RXD2_XDFFQ_MFB_t1 XD2_XDFFQ_MFB__t1 XD2_XDFFQ_MFB 90.5269538021
* device instance XD2_XDFFQ_MFB_t2 r0 *1 0,0
RXD2_XDFFQ_MFB_t2 XD2_XDFFQ_MFB__t2 XD2_XDFFQ_MFB 90.2587840598
* device instance XD2_XDFFQ_MFB_t3 r0 *1 0,0
RXD2_XDFFQ_MFB_t3 XD2_XDFFQ_MFB__t3 XD2_XDFFQ_MFB 89.5508159402
* device instance XD2_XDFFQ_MFB r0 *1 0,0
CXD2_XDFFQ_MFB XD2_XDFFQ_MFB vsubs 8.1111557e-14
* device instance XD2_XDFFQ_S_t0 r0 *1 0,0
RXD2_XDFFQ_S_t0 XD2_XDFFQ_S__t0 XD2_XDFFQ_S 65.8185452192
* device instance XD2_XDFFQ_S_t1 r0 *1 0,0
RXD2_XDFFQ_S_t1 XD2_XDFFQ_S__t1 XD2_XDFFQ_S 64.9110808767
* device instance XD2_XDFFQ_S_t2 r0 *1 0,0
RXD2_XDFFQ_S_t2 XD2_XDFFQ_S__t2 XD2_XDFFQ_S 67.6334739041
* device instance XD2_XDFFQ_S_t3 r0 *1 0,0
RXD2_XDFFQ_S_t3 XD2_XDFFQ_S__t3 XD2_XDFFQ_S 66.2931386397
* device instance XD2_XDFFQ_S_t4 r0 *1 0,0
RXD2_XDFFQ_S_t4 XD2_XDFFQ_S__t4 XD2_XDFFQ_S 66.8094545587
* device instance XD2_XDFFQ_S_t5 r0 *1 0,0
RXD2_XDFFQ_S_t5 XD2_XDFFQ_S__t5 XD2_XDFFQ_S 65.2605068017
* device instance XD2_XDFFQ_S r0 *1 0,0
CXD2_XDFFQ_S XD2_XDFFQ_S vsubs 9.0306431e-14
* device instance XD2_XDFFQ_SB_t0 r0 *1 0,0
RXD2_XDFFQ_SB_t0 XD2_XDFFQ_SB__t0 XD2_XDFFQ_SB 65.5651358728
* device instance XD2_XDFFQ_SB_t1 r0 *1 0,0
RXD2_XDFFQ_SB_t1 XD2_XDFFQ_SB__t1 XD2_XDFFQ_SB 67.3677206358
* device instance XD2_XDFFQ_SB_t2 r0 *1 0,0
RXD2_XDFFQ_SB_t2 XD2_XDFFQ_SB__t2 XD2_XDFFQ_SB 64.6638434913
* device instance XD2_XDFFQ_SB_t3 r0 *1 0,0
RXD2_XDFFQ_SB_t3 XD2_XDFFQ_SB__t3 XD2_XDFFQ_SB 66.0365014287
* device instance XD2_XDFFQ_SB_t4 r0 *1 0,0
RXD2_XDFFQ_SB_t4 XD2_XDFFQ_SB__t4 XD2_XDFFQ_SB 65.0108928566
* device instance XD2_XDFFQ_SB_t5 r0 *1 0,0
RXD2_XDFFQ_SB_t5 XD2_XDFFQ_SB__t5 XD2_XDFFQ_SB 66.5493057147
* device instance XD2_XDFFQ_SB r0 *1 0,0
CXD2_XDFFQ_SB XD2_XDFFQ_SB vsubs 9.0042069e-14
* device instance XD2_XDFFQ_SFB_t0 r0 *1 0,0
RXD2_XDFFQ_SFB_t0 XD2_XDFFQ_SFB__t0 XD2_XDFFQ_SFB 90.6883282601
* device instance XD2_XDFFQ_SFB_t1 r0 *1 0,0
RXD2_XDFFQ_SFB_t1 XD2_XDFFQ_SFB__t1 XD2_XDFFQ_SFB 91.9372217399
* device instance XD2_XDFFQ_SFB_t2 r0 *1 0,0
RXD2_XDFFQ_SFB_t2 XD2_XDFFQ_SFB__t2 XD2_XDFFQ_SFB 91.6680636624
* device instance XD2_XDFFQ_SFB_t3 r0 *1 0,0
RXD2_XDFFQ_SFB_t3 XD2_XDFFQ_SFB__t3 XD2_XDFFQ_SFB 90.9574863376
* device instance XD2_XDFFQ_SFB r0 *1 0,0
CXD2_XDFFQ_SFB XD2_XDFFQ_SFB vsubs 8.2442003e-14
* device instance XD2_XN2_mid1_t0 r0 *1 0,0
RXD2_XN2_mid1_t0 XD2_XN2_mid1__t0 XD2_XN2_mid1 16.64345
* device instance XD2_XN2_mid1_t1 r0 *1 0,0
RXD2_XN2_mid1_t1 XD2_XN2_mid1__t1 XD2_XN2_mid1 16.64345
* device instance XD2_XN2_mid1 r0 *1 0,0
CXD2_XN2_mid1 XD2_XN2_mid1 vsubs 8.345691e-15
* device instance XD2_XN3_mid1_t0 r0 *1 0,0
RXD2_XN3_mid1_t0 XD2_XN3_mid1__t0 XD2_XN3_mid1 16.81945
* device instance XD2_XN3_mid1_t1 r0 *1 0,0
RXD2_XN3_mid1_t1 XD2_XN3_mid1__t1 XD2_XN3_mid1 16.81945
* device instance XD2_XN3_mid1 r0 *1 0,0
CXD2_XN3_mid1 XD2_XN3_mid1 vsubs 8.465347e-15
* device instance XD2_XN3_mid2_t0 r0 *1 0,0
RXD2_XN3_mid2_t0 XD2_XN3_mid2__t0 XD2_XN3_mid2 16.99545
* device instance XD2_XN3_mid2_t1 r0 *1 0,0
RXD2_XN3_mid2_t1 XD2_XN3_mid2__t1 XD2_XN3_mid2 16.99545
* device instance XD2_XN3_mid2 r0 *1 0,0
CXD2_XN3_mid2 XD2_XN3_mid2 vsubs 8.554995e-15
* device instance XD2_XNOR_midp_t0 r0 *1 0,0
RXD2_XNOR_midp_t0 XD2_XNOR_midp__t0 XD2_XNOR_midp 18.69785
* device instance XD2_XNOR_midp_t1 r0 *1 0,0
RXD2_XNOR_midp_t1 XD2_XNOR_midp__t1 XD2_XNOR_midp 18.69785
* device instance XD2_XNOR_midp r0 *1 0,0
CXD2_XNOR_midp XD2_XNOR_midp vsubs 9.372331e-15
* device instance XD2_dmodout_t0 r0 *1 0,0
RXD2_dmodout_t0 XD2_dmodout__t0 XD2_dmodout 92.4122727504
* device instance XD2_dmodout_t1 r0 *1 0,0
RXD2_dmodout_t1 XD2_dmodout__t1 XD2_dmodout 96.2148272496
* device instance XD2_dmodout_t2 r0 *1 0,0
RXD2_dmodout_t2 XD2_dmodout__t2 XD2_dmodout 95.3953111937
* device instance XD2_dmodout_t3 r0 *1 0,0
RXD2_dmodout_t3 XD2_dmodout__t3 XD2_dmodout 93.2317888063
* device instance XD2_dmodout r0 *1 0,0
CXD2_dmodout XD2_dmodout vsubs 8.524199e-14
* device instance XD2_dq_t0 r0 *1 0,0
RXD2_dq_t0 XD2_dq__t0 XD2_dq 94.2404455564
* device instance XD2_dq_t1 r0 *1 0,0
RXD2_dq_t1 XD2_dq__t1 XD2_dq 97.5881044436
* device instance XD2_dq_t2 r0 *1 0,0
RXD2_dq_t2 XD2_dq__t2 XD2_dq 64.3661172156
* device instance XD2_dq_t3 r0 *1 0,0
RXD2_dq_t3 XD2_dq__t3 XD2_dq 65.001018039
* device instance XD2_dq_t4 r0 *1 0,0
RXD2_dq_t4 XD2_dq__t4 XD2_dq 62.4614147454
* device instance XD2_dq r0 *1 0,0
CXD2_dq XD2_dq vsubs 8.7164526e-14
* device instance XD2_nm_t0 r0 *1 0,0
RXD2_nm_t0 XD2_nm__t0 XD2_nm 66.1564911125
* device instance XD2_nm_t1 r0 *1 0,0
RXD2_nm_t1 XD2_nm__t1 XD2_nm 63.9547755542
* device instance XD2_nm_t2 r0 *1 0,0
RXD2_nm_t2 XD2_nm__t2 XD2_nm 65.0556333333
* device instance XD2_nm_t3 r0 *1 0,0
RXD2_nm_t3 XD2_nm__t3 XD2_nm 96.9570998843
* device instance XD2_nm_t4 r0 *1 0,0
RXD2_nm_t4 XD2_nm__t4 XD2_nm 98.2098001157
* device instance XD2_nm r0 *1 0,0
CXD2_nm XD2_nm vsubs 8.8767293e-14
* device instance XD2_nt_t0 r0 *1 0,0
RXD2_nt_t0 XD2_nt__t0 XD2_nt 51.182797785
* device instance XD2_nt_t1 r0 *1 0,0
RXD2_nt_t1 XD2_nt__t1 XD2_nt 50.1247659283
* device instance XD2_nt_t2 r0 *1 0,0
RXD2_nt_t2 XD2_nt__t2 XD2_nt 49.0667340717
* device instance XD2_nt_t3 r0 *1 0,0
RXD2_nt_t3 XD2_nt__t3 XD2_nt 48.008702215
* device instance XD2_nt_t4 r0 *1 0,0
RXD2_nt_t4 XD2_nt__t4 XD2_nt 98.2885245361
* device instance XD2_nt_t5 r0 *1 0,0
RXD2_nt_t5 XD2_nt__t5 XD2_nt 100.094475464
* device instance XD2_nt r0 *1 0,0
CXD2_nt XD2_nt vsubs 9.0722514e-14
* device instance XD2_t1_t0 r0 *1 0,0
RXD2_t1_t0 XD2_t1__t0 XD2_t1 91.5564362298
* device instance XD2_t1_t1 r0 *1 0,0
RXD2_t1_t1 XD2_t1__t1 XD2_t1 89.0079637702
* device instance XD2_t1_t2 r0 *1 0,0
RXD2_t1_t2 XD2_t1__t2 XD2_t1 89.5572035244
* device instance XD2_t1_t3 r0 *1 0,0
RXD2_t1_t3 XD2_t1__t3 XD2_t1 91.0071964756
* device instance XD2_t1 r0 *1 0,0
CXD2_t1 XD2_t1 vsubs 8.1836528e-14
* device instance XD3_XDFFM_CKBB_t0 r0 *1 0,0
RXD3_XDFFM_CKBB_t0 XD3_XDFFM_CKBB__t0 XD3_XDFFM_CKBB 73.3846355942
* device instance XD3_XDFFM_CKBB_t1 r0 *1 0,0
RXD3_XDFFM_CKBB_t1 XD3_XDFFM_CKBB__t1 XD3_XDFFM_CKBB 79.8183860146
* device instance XD3_XDFFM_CKBB_t2 r0 *1 0,0
RXD3_XDFFM_CKBB_t2 XD3_XDFFM_CKBB__t2 XD3_XDFFM_CKBB 72.4655283912
* device instance XD3_XDFFM_CKBB_t3 r0 *1 0,0
RXD3_XDFFM_CKBB_t3 XD3_XDFFM_CKBB__t3 XD3_XDFFM_CKBB 74.6999096949
* device instance XD3_XDFFM_CKBB_t4 r0 *1 0,0
RXD3_XDFFM_CKBB_t4 XD3_XDFFM_CKBB__t4 XD3_XDFFM_CKBB 74.1769693898
* device instance XD3_XDFFM_CKBB_t5 r0 *1 0,0
RXD3_XDFFM_CKBB_t5 XD3_XDFFM_CKBB__t5 XD3_XDFFM_CKBB 76.7916709153
* device instance XD3_XDFFM_CKBB r0 *1 0,0
CXD3_XDFFM_CKBB XD3_XDFFM_CKBB vsubs 1.02908387e-13
* device instance XD3_XDFFM_CLKB_t0 r0 *1 0,0
RXD3_XDFFM_CLKB_t0 XD3_XDFFM_CLKB__t0 XD3_XDFFM_CLKB 62.453975543
* device instance XD3_XDFFM_CLKB_t1 r0 *1 0,0
RXD3_XDFFM_CLKB_t1 XD3_XDFFM_CLKB__t1 XD3_XDFFM_CLKB 58.7640579713
* device instance XD3_XDFFM_CLKB_t2 r0 *1 0,0
RXD3_XDFFM_CLKB_t2 XD3_XDFFM_CLKB__t2 XD3_XDFFM_CLKB 61.7159920287
* device instance XD3_XDFFM_CLKB_t3 r0 *1 0,0
RXD3_XDFFM_CLKB_t3 XD3_XDFFM_CLKB__t3 XD3_XDFFM_CLKB 58.026074457
* device instance XD3_XDFFM_CLKB_t4 r0 *1 0,0
RXD3_XDFFM_CLKB_t4 XD3_XDFFM_CLKB__t4 XD3_XDFFM_CLKB 61.0797993439
* device instance XD3_XDFFM_CLKB_t5 r0 *1 0,0
RXD3_XDFFM_CLKB_t5 XD3_XDFFM_CLKB__t5 XD3_XDFFM_CLKB 60.659912172
* device instance XD3_XDFFM_CLKB_t6 r0 *1 0,0
RXD3_XDFFM_CLKB_t6 XD3_XDFFM_CLKB__t6 XD3_XDFFM_CLKB 57.7207019683
* device instance XD3_XDFFM_CLKB_t7 r0 *1 0,0
RXD3_XDFFM_CLKB_t7 XD3_XDFFM_CLKB__t7 XD3_XDFFM_CLKB 61.4996865159
* device instance XD3_XDFFM_CLKB r0 *1 0,0
CXD3_XDFFM_CLKB XD3_XDFFM_CLKB vsubs 1.10826717e-13
* device instance XD3_XDFFM_M_t0 r0 *1 0,0
RXD3_XDFFM_M_t0 XD3_XDFFM_M__t0 XD3_XDFFM_M 60.1124211973
* device instance XD3_XDFFM_M_t1 r0 *1 0,0
RXD3_XDFFM_M_t1 XD3_XDFFM_M__t1 XD3_XDFFM_M 59.3688548946
* device instance XD3_XDFFM_M_t2 r0 *1 0,0
RXD3_XDFFM_M_t2 XD3_XDFFM_M__t2 XD3_XDFFM_M 61.5995538027
* device instance XD3_XDFFM_M_t3 r0 *1 0,0
RXD3_XDFFM_M_t3 XD3_XDFFM_M__t3 XD3_XDFFM_M 62.3431201054
* device instance XD3_XDFFM_M_t4 r0 *1 0,0
RXD3_XDFFM_M_t4 XD3_XDFFM_M__t4 XD3_XDFFM_M 61.279051086
* device instance XD3_XDFFM_M_t5 r0 *1 0,0
RXD3_XDFFM_M_t5 XD3_XDFFM_M__t5 XD3_XDFFM_M 60.009860328
* device instance XD3_XDFFM_M_t6 r0 *1 0,0
RXD3_XDFFM_M_t6 XD3_XDFFM_M__t6 XD3_XDFFM_M 61.702114672
* device instance XD3_XDFFM_M_t7 r0 *1 0,0
RXD3_XDFFM_M_t7 XD3_XDFFM_M__t7 XD3_XDFFM_M 60.432923914
* device instance XD3_XDFFM_M r0 *1 0,0
CXD3_XDFFM_M XD3_XDFFM_M vsubs 1.11881607e-13
* device instance XD3_XDFFM_MB_t0 r0 *1 0,0
RXD3_XDFFM_MB_t0 XD3_XDFFM_MB__t0 XD3_XDFFM_MB 102.317876844
* device instance XD3_XDFFM_MB_t1 r0 *1 0,0
RXD3_XDFFM_MB_t1 XD3_XDFFM_MB__t1 XD3_XDFFM_MB 101.073673156
* device instance XD3_XDFFM_MB_t2 r0 *1 0,0
RXD3_XDFFM_MB_t2 XD3_XDFFM_MB__t2 XD3_XDFFM_MB 101.341820503
* device instance XD3_XDFFM_MB_t3 r0 *1 0,0
RXD3_XDFFM_MB_t3 XD3_XDFFM_MB__t3 XD3_XDFFM_MB 102.049729497
* device instance XD3_XDFFM_MB r0 *1 0,0
CXD3_XDFFM_MB XD3_XDFFM_MB vsubs 9.2048669e-14
* device instance XD3_XDFFM_MFB_t0 r0 *1 0,0
RXD3_XDFFM_MFB_t0 XD3_XDFFM_MFB__t0 XD3_XDFFM_MFB 102.169517217
* device instance XD3_XDFFM_MFB_t1 r0 *1 0,0
RXD3_XDFFM_MFB_t1 XD3_XDFFM_MFB__t1 XD3_XDFFM_MFB 103.423882783
* device instance XD3_XDFFM_MFB_t2 r0 *1 0,0
RXD3_XDFFM_MFB_t2 XD3_XDFFM_MFB__t2 XD3_XDFFM_MFB 103.153545377
* device instance XD3_XDFFM_MFB_t3 r0 *1 0,0
RXD3_XDFFM_MFB_t3 XD3_XDFFM_MFB__t3 XD3_XDFFM_MFB 102.439854623
* device instance XD3_XDFFM_MFB r0 *1 0,0
CXD3_XDFFM_MFB XD3_XDFFM_MFB vsubs 9.2999008e-14
* device instance XD3_XDFFM_S_t0 r0 *1 0,0
RXD3_XDFFM_S_t0 XD3_XDFFM_S__t0 XD3_XDFFM_S 75.4072680064
* device instance XD3_XDFFM_S_t1 r0 *1 0,0
RXD3_XDFFM_S_t1 XD3_XDFFM_S__t1 XD3_XDFFM_S 74.4902220255
* device instance XD3_XDFFM_S_t2 r0 *1 0,0
RXD3_XDFFM_S_t2 XD3_XDFFM_S__t2 XD3_XDFFM_S 77.2413599682
* device instance XD3_XDFFM_S_t3 r0 *1 0,0
RXD3_XDFFM_S_t3 XD3_XDFFM_S__t3 XD3_XDFFM_S 75.8868725136
* device instance XD3_XDFFM_S_t4 r0 *1 0,0
RXD3_XDFFM_S_t4 XD3_XDFFM_S__t4 XD3_XDFFM_S 76.4086400545
* device instance XD3_XDFFM_S_t5 r0 *1 0,0
RXD3_XDFFM_S_t5 XD3_XDFFM_S__t5 XD3_XDFFM_S 74.8433374319
* device instance XD3_XDFFM_S r0 *1 0,0
CXD3_XDFFM_S XD3_XDFFM_S vsubs 1.03733905e-13
* device instance XD3_XDFFM_SB_t0 r0 *1 0,0
RXD3_XDFFM_SB_t0 XD3_XDFFM_SB__t0 XD3_XDFFM_SB 75.1536259377
* device instance XD3_XDFFM_SB_t1 r0 *1 0,0
RXD3_XDFFM_SB_t1 XD3_XDFFM_SB__t1 XD3_XDFFM_SB 76.9767703114
* device instance XD3_XDFFM_SB_t2 r0 *1 0,0
RXD3_XDFFM_SB_t2 XD3_XDFFM_SB__t2 XD3_XDFFM_SB 74.2420537509
* device instance XD3_XDFFM_SB_t3 r0 *1 0,0
RXD3_XDFFM_SB_t3 XD3_XDFFM_SB__t3 XD3_XDFFM_SB 75.6303677136
* device instance XD3_XDFFM_SB_t4 r0 *1 0,0
RXD3_XDFFM_SB_t4 XD3_XDFFM_SB__t4 XD3_XDFFM_SB 74.593061432
* device instance XD3_XDFFM_SB_t5 r0 *1 0,0
RXD3_XDFFM_SB_t5 XD3_XDFFM_SB__t5 XD3_XDFFM_SB 76.1490208544
* device instance XD3_XDFFM_SB r0 *1 0,0
CXD3_XDFFM_SB XD3_XDFFM_SB vsubs 1.03469543e-13
* device instance XD3_XDFFM_SFB_t0 r0 *1 0,0
RXD3_XDFFM_SFB_t0 XD3_XDFFM_SFB__t0 XD3_XDFFM_SFB 103.575545005
* device instance XD3_XDFFM_SFB_t1 r0 *1 0,0
RXD3_XDFFM_SFB_t1 XD3_XDFFM_SFB__t1 XD3_XDFFM_SFB 104.833854995
* device instance XD3_XDFFM_SFB_t2 r0 *1 0,0
RXD3_XDFFM_SFB_t2 XD3_XDFFM_SFB__t2 XD3_XDFFM_SFB 104.562667497
* device instance XD3_XDFFM_SFB_t3 r0 *1 0,0
RXD3_XDFFM_SFB_t3 XD3_XDFFM_SFB__t3 XD3_XDFFM_SFB 103.846732503
* device instance XD3_XDFFM_SFB r0 *1 0,0
CXD3_XDFFM_SFB XD3_XDFFM_SFB vsubs 9.4329454e-14
* device instance XD3_XDFFQ_CKBB_t0 r0 *1 0,0
RXD3_XDFFQ_CKBB_t0 XD3_XDFFQ_CKBB__t0 XD3_XDFFQ_CKBB 72.6852654819
* device instance XD3_XDFFQ_CKBB_t1 r0 *1 0,0
RXD3_XDFFQ_CKBB_t1 XD3_XDFFQ_CKBB__t1 XD3_XDFFQ_CKBB 79.3079696286
* device instance XD3_XDFFQ_CKBB_t2 r0 *1 0,0
RXD3_XDFFQ_CKBB_t2 XD3_XDFFQ_CKBB__t2 XD3_XDFFQ_CKBB 71.7391648895
* device instance XD3_XDFFQ_CKBB_t3 r0 *1 0,0
RXD3_XDFFQ_CKBB_t3 XD3_XDFFQ_CKBB__t3 XD3_XDFFQ_CKBB 74.0391680538
* device instance XD3_XDFFQ_CKBB_t4 r0 *1 0,0
RXD3_XDFFQ_CKBB_t4 XD3_XDFFQ_CKBB__t4 XD3_XDFFQ_CKBB 73.5008694408
* device instance XD3_XDFFQ_CKBB_t5 r0 *1 0,0
RXD3_XDFFQ_CKBB_t5 XD3_XDFFQ_CKBB__t5 XD3_XDFFQ_CKBB 76.1923625054
* device instance XD3_XDFFQ_CKBB r0 *1 0,0
CXD3_XDFFQ_CKBB XD3_XDFFQ_CKBB vsubs 1.02370733e-13
* device instance XD3_XDFFQ_CLKB_t0 r0 *1 0,0
RXD3_XDFFQ_CLKB_t0 XD3_XDFFQ_CLKB__t0 XD3_XDFFQ_CLKB 61.6372459687
* device instance XD3_XDFFQ_CLKB_t1 r0 *1 0,0
RXD3_XDFFQ_CLKB_t1 XD3_XDFFQ_CLKB__t1 XD3_XDFFQ_CLKB 62.4018752031
* device instance XD3_XDFFQ_CLKB_t2 r0 *1 0,0
RXD3_XDFFQ_CLKB_t2 XD3_XDFFQ_CLKB__t2 XD3_XDFFQ_CLKB 58.5787290313
* device instance XD3_XDFFQ_CLKB_t3 r0 *1 0,0
RXD3_XDFFQ_CLKB_t3 XD3_XDFFQ_CLKB__t3 XD3_XDFFQ_CLKB 57.8140997969
* device instance XD3_XDFFQ_CLKB_t4 r0 *1 0,0
RXD3_XDFFQ_CLKB_t4 XD3_XDFFQ_CLKB__t4 XD3_XDFFQ_CLKB 60.9780828357
* device instance XD3_XDFFQ_CLKB_t5 r0 *1 0,0
RXD3_XDFFQ_CLKB_t5 XD3_XDFFQ_CLKB__t5 XD3_XDFFQ_CLKB 60.5430351678
* device instance XD3_XDFFQ_CLKB_t6 r0 *1 0,0
RXD3_XDFFQ_CLKB_t6 XD3_XDFFQ_CLKB__t6 XD3_XDFFQ_CLKB 57.497701493
* device instance XD3_XDFFQ_CLKB_t7 r0 *1 0,0
RXD3_XDFFQ_CLKB_t7 XD3_XDFFQ_CLKB__t7 XD3_XDFFQ_CLKB 61.4131305035
* device instance XD3_XDFFQ_CLKB r0 *1 0,0
CXD3_XDFFQ_CLKB XD3_XDFFQ_CLKB vsubs 1.110107e-13
* device instance XD3_XDFFQ_M_t0 r0 *1 0,0
RXD3_XDFFQ_M_t0 XD3_XDFFQ_M__t0 XD3_XDFFQ_M 59.9535971356
* device instance XD3_XDFFQ_M_t1 r0 *1 0,0
RXD3_XDFFQ_M_t1 XD3_XDFFQ_M__t1 XD3_XDFFQ_M 59.1832442712
* device instance XD3_XDFFQ_M_t2 r0 *1 0,0
RXD3_XDFFQ_M_t2 XD3_XDFFQ_M__t2 XD3_XDFFQ_M 61.4943028644
* device instance XD3_XDFFQ_M_t3 r0 *1 0,0
RXD3_XDFFQ_M_t3 XD3_XDFFQ_M__t3 XD3_XDFFQ_M 62.2646557288
* device instance XD3_XDFFQ_M_t4 r0 *1 0,0
RXD3_XDFFQ_M_t4 XD3_XDFFQ_M__t4 XD3_XDFFQ_M 61.162254216
* device instance XD3_XDFFQ_M_t5 r0 *1 0,0
RXD3_XDFFQ_M_t5 XD3_XDFFQ_M__t5 XD3_XDFFQ_M 59.8473415681
* device instance XD3_XDFFQ_M_t6 r0 *1 0,0
RXD3_XDFFQ_M_t6 XD3_XDFFQ_M__t6 XD3_XDFFQ_M 61.6005584319
* device instance XD3_XDFFQ_M_t7 r0 *1 0,0
RXD3_XDFFQ_M_t7 XD3_XDFFQ_M__t7 XD3_XDFFQ_M 60.285645784
* device instance XD3_XDFFQ_M r0 *1 0,0
CXD3_XDFFQ_M XD3_XDFFQ_M vsubs 1.1206559e-13
* device instance XD3_XDFFQ_MB_t0 r0 *1 0,0
RXD3_XDFFQ_MB_t0 XD3_XDFFQ_MB__t0 XD3_XDFFQ_MB 100.65907644
* device instance XD3_XDFFQ_MB_t1 r0 *1 0,0
RXD3_XDFFQ_MB_t1 XD3_XDFFQ_MB__t1 XD3_XDFFQ_MB 99.3884235599
* device instance XD3_XDFFQ_MB_t2 r0 *1 0,0
RXD3_XDFFQ_MB_t2 XD3_XDFFQ_MB__t2 XD3_XDFFQ_MB 99.6622711634
* device instance XD3_XDFFQ_MB_t3 r0 *1 0,0
RXD3_XDFFQ_MB_t3 XD3_XDFFQ_MB__t3 XD3_XDFFQ_MB 100.385228837
* device instance XD3_XDFFQ_MB r0 *1 0,0
CXD3_XDFFQ_MB XD3_XDFFQ_MB vsubs 9.0789379e-14
* device instance XD3_XDFFQ_MFB_t0 r0 *1 0,0
RXD3_XDFFQ_MFB_t0 XD3_XDFFQ_MFB__t0 XD3_XDFFQ_MFB 100.48410951
* device instance XD3_XDFFQ_MFB_t1 r0 *1 0,0
RXD3_XDFFQ_MFB_t1 XD3_XDFFQ_MFB__t1 XD3_XDFFQ_MFB 101.76524049
* device instance XD3_XDFFQ_MFB_t2 r0 *1 0,0
RXD3_XDFFQ_MFB_t2 XD3_XDFFQ_MFB__t2 XD3_XDFFQ_MFB 101.489134675
* device instance XD3_XDFFQ_MFB_t3 r0 *1 0,0
RXD3_XDFFQ_MFB_t3 XD3_XDFFQ_MFB__t3 XD3_XDFFQ_MFB 100.760215325
* device instance XD3_XDFFQ_MFB r0 *1 0,0
CXD3_XDFFQ_MFB XD3_XDFFQ_MFB vsubs 9.1739717e-14
* device instance XD3_XDFFQ_S_t0 r0 *1 0,0
RXD3_XDFFQ_S_t0 XD3_XDFFQ_S__t0 XD3_XDFFQ_S 74.7530107969
* device instance XD3_XDFFQ_S_t1 r0 *1 0,0
RXD3_XDFFQ_S_t1 XD3_XDFFQ_S__t1 XD3_XDFFQ_S 73.8092931877
* device instance XD3_XDFFQ_S_t2 r0 *1 0,0
RXD3_XDFFQ_S_t2 XD3_XDFFQ_S__t2 XD3_XDFFQ_S 76.6404460154
* device instance XD3_XDFFQ_S_t3 r0 *1 0,0
RXD3_XDFFQ_S_t3 XD3_XDFFQ_S__t3 XD3_XDFFQ_S 75.2465642592
* device instance XD3_XDFFQ_S_t4 r0 *1 0,0
RXD3_XDFFQ_S_t4 XD3_XDFFQ_S__t4 XD3_XDFFQ_S 75.7835070369
* device instance XD3_XDFFQ_S_t5 r0 *1 0,0
RXD3_XDFFQ_S_t5 XD3_XDFFQ_S__t5 XD3_XDFFQ_S 74.1726787039
* device instance XD3_XDFFQ_S r0 *1 0,0
CXD3_XDFFQ_S XD3_XDFFQ_S vsubs 1.03196251e-13
* device instance XD3_XDFFQ_SB_t0 r0 *1 0,0
RXD3_XDFFQ_SB_t0 XD3_XDFFQ_SB__t0 XD3_XDFFQ_SB 74.4994617738
* device instance XD3_XDFFQ_SB_t1 r0 *1 0,0
RXD3_XDFFQ_SB_t1 XD3_XDFFQ_SB__t1 XD3_XDFFQ_SB 76.3753911309
* device instance XD3_XDFFQ_SB_t2 r0 *1 0,0
RXD3_XDFFQ_SB_t2 XD3_XDFFQ_SB__t2 XD3_XDFFQ_SB 73.5614970953
* device instance XD3_XDFFQ_SB_t3 r0 *1 0,0
RXD3_XDFFQ_SB_t3 XD3_XDFFQ_SB__t3 XD3_XDFFQ_SB 74.9900065195
* device instance XD3_XDFFQ_SB_t4 r0 *1 0,0
RXD3_XDFFQ_SB_t4 XD3_XDFFQ_SB__t4 XD3_XDFFQ_SB 73.9226674025
* device instance XD3_XDFFQ_SB_t5 r0 *1 0,0
RXD3_XDFFQ_SB_t5 XD3_XDFFQ_SB__t5 XD3_XDFFQ_SB 75.523676078
* device instance XD3_XDFFQ_SB r0 *1 0,0
CXD3_XDFFQ_SB XD3_XDFFQ_SB vsubs 1.02931889e-13
* device instance XD3_XDFFQ_SFB_t0 r0 *1 0,0
RXD3_XDFFQ_SFB_t0 XD3_XDFFQ_SFB__t0 XD3_XDFFQ_SFB 101.890207304
* device instance XD3_XDFFQ_SFB_t1 r0 *1 0,0
RXD3_XDFFQ_SFB_t1 XD3_XDFFQ_SFB__t1 XD3_XDFFQ_SFB 103.175142696
* device instance XD3_XDFFQ_SFB_t2 r0 *1 0,0
RXD3_XDFFQ_SFB_t2 XD3_XDFFQ_SFB__t2 XD3_XDFFQ_SFB 102.898216965
* device instance XD3_XDFFQ_SFB_t3 r0 *1 0,0
RXD3_XDFFQ_SFB_t3 XD3_XDFFQ_SFB__t3 XD3_XDFFQ_SFB 102.167133035
* device instance XD3_XDFFQ_SFB r0 *1 0,0
CXD3_XDFFQ_SFB XD3_XDFFQ_SFB vsubs 9.3070163e-14
* device instance XD3_XN2_mid1_t0 r0 *1 0,0
RXD3_XN2_mid1_t0 XD3_XN2_mid1__t0 XD3_XN2_mid1 21.04335
* device instance XD3_XN2_mid1_t1 r0 *1 0,0
RXD3_XN2_mid1_t1 XD3_XN2_mid1__t1 XD3_XN2_mid1 21.04335
* device instance XD3_XN2_mid1 r0 *1 0,0
CXD3_XN2_mid1 XD3_XN2_mid1 vsubs 1.0569718e-14
* device instance XD3_XN3_mid1_t0 r0 *1 0,0
RXD3_XN3_mid1_t0 XD3_XN3_mid1__t0 XD3_XN3_mid1 21.21935
* device instance XD3_XN3_mid1_t1 r0 *1 0,0
RXD3_XN3_mid1_t1 XD3_XN3_mid1__t1 XD3_XN3_mid1 21.21935
* device instance XD3_XN3_mid1 r0 *1 0,0
CXD3_XN3_mid1 XD3_XN3_mid1 vsubs 1.0689374e-14
* device instance XD3_XN3_mid2_t0 r0 *1 0,0
RXD3_XN3_mid2_t0 XD3_XN3_mid2__t0 XD3_XN3_mid2 21.39535
* device instance XD3_XN3_mid2_t1 r0 *1 0,0
RXD3_XN3_mid2_t1 XD3_XN3_mid2__t1 XD3_XN3_mid2 21.39535
* device instance XD3_XN3_mid2 r0 *1 0,0
CXD3_XN3_mid2 XD3_XN3_mid2 vsubs 1.0779022e-14
* device instance XD3_XNOR_midp_t0 r0 *1 0,0
RXD3_XNOR_midp_t0 XD3_XNOR_midp__t0 XD3_XNOR_midp 23.0978
* device instance XD3_XNOR_midp_t1 r0 *1 0,0
RXD3_XNOR_midp_t1 XD3_XNOR_midp__t1 XD3_XNOR_midp 23.0978
* device instance XD3_XNOR_midp r0 *1 0,0
CXD3_XNOR_midp XD3_XNOR_midp vsubs 1.1671623e-14
* device instance XD3_dmodout_t0 r0 *1 0,0
RXD3_dmodout_t0 XD3_dmodout__t0 XD3_dmodout 103.581273775
* device instance XD3_dmodout_t1 r0 *1 0,0
RXD3_dmodout_t1 XD3_dmodout__t1 XD3_dmodout 107.485626225
* device instance XD3_dmodout_t2 r0 *1 0,0
RXD3_dmodout_t2 XD3_dmodout__t2 XD3_dmodout 106.644170956
* device instance XD3_dmodout_t3 r0 *1 0,0
RXD3_dmodout_t3 XD3_dmodout__t3 XD3_dmodout 104.422729044
* device instance XD3_dmodout r0 *1 0,0
CXD3_dmodout XD3_dmodout vsubs 9.587015e-14
* device instance XD3_dq_t0 r0 *1 0,0
RXD3_dq_t0 XD3_dq__t0 XD3_dq 106.506470597
* device instance XD3_dq_t1 r0 *1 0,0
RXD3_dq_t1 XD3_dq__t1 XD3_dq 109.961829403
* device instance XD3_dq_t2 r0 *1 0,0
RXD3_dq_t2 XD3_dq__t2 XD3_dq 73.2483111168
* device instance XD3_dq_t3 r0 *1 0,0
RXD3_dq_t3 XD3_dq__t3 XD3_dq 70.6270044365
* device instance XD3_dq_t4 r0 *1 0,0
RXD3_dq_t4 XD3_dq__t4 XD3_dq 72.5929844467
* device instance XD3_dq r0 *1 0,0
CXD3_dq XD3_dq vsubs 9.89047e-14
* device instance XD3_nm_t0 r0 *1 0,0
RXD3_nm_t0 XD3_nm__t0 XD3_nm 74.4058886399
* device instance XD3_nm_t1 r0 *1 0,0
RXD3_nm_t1 XD3_nm__t1 XD3_nm 72.1318780268
* device instance XD3_nm_t2 r0 *1 0,0
RXD3_nm_t2 XD3_nm__t2 XD3_nm 73.2688833333
* device instance XD3_nm_t3 r0 *1 0,0
RXD3_nm_t3 XD3_nm__t3 XD3_nm 109.256408188
* device instance XD3_nm_t4 r0 *1 0,0
RXD3_nm_t4 XD3_nm__t4 XD3_nm 110.550241812
* device instance XD3_nm r0 *1 0,0
CXD3_nm XD3_nm vsubs 1.00545099e-13
* device instance XD3_nt_t0 r0 *1 0,0
RXD3_nt_t0 XD3_nt__t0 XD3_nt 57.9510935088
* device instance XD3_nt_t1 r0 *1 0,0
RXD3_nt_t1 XD3_nt__t1 XD3_nt 54.6602564912
* device instance XD3_nt_t2 r0 *1 0,0
RXD3_nt_t2 XD3_nt__t2 XD3_nt 55.7572021637
* device instance XD3_nt_t3 r0 *1 0,0
RXD3_nt_t3 XD3_nt__t3 XD3_nt 56.8541478363
* device instance XD3_nt_t4 r0 *1 0,0
RXD3_nt_t4 XD3_nt__t4 XD3_nt 111.675163607
* device instance XD3_nt_t5 r0 *1 0,0
RXD3_nt_t5 XD3_nt__t5 XD3_nt 113.547536393
* device instance XD3_nt r0 *1 0,0
CXD3_nt XD3_nt vsubs 1.03649966e-13
* device instance XD3_t1_t0 r0 *1 0,0
RXD3_t1_t0 XD3_t1__t0 XD3_t1 102.811246297
* device instance XD3_t1_t1 r0 *1 0,0
RXD3_t1_t1 XD3_t1__t1 XD3_t1 100.192953703
* device instance XD3_t1_t2 r0 *1 0,0
RXD3_t1_t2 XD3_t1__t2 XD3_t1 100.7572409
* device instance XD3_t1_t3 r0 *1 0,0
RXD3_t1_t3 XD3_t1__t3 XD3_t1 102.2469591
* device instance XD3_t1 r0 *1 0,0
CXD3_t1 XD3_t1 vsubs 9.2464689e-14
* device instance XD4_XDFFM_CKBB_t0 r0 *1 0,0
RXD4_XDFFM_CKBB_t0 XD4_XDFFM_CKBB__t0 XD4_XDFFM_CKBB 82.2678077854
* device instance XD4_XDFFM_CKBB_t1 r0 *1 0,0
RXD4_XDFFM_CKBB_t1 XD4_XDFFM_CKBB__t1 XD4_XDFFM_CKBB 88.9234388698
* device instance XD4_XDFFM_CKBB_t2 r0 *1 0,0
RXD4_XDFFM_CKBB_t2 XD4_XDFFM_CKBB__t2 XD4_XDFFM_CKBB 81.3170033448
* device instance XD4_XDFFM_CKBB_t3 r0 *1 0,0
RXD4_XDFFM_CKBB_t3 XD4_XDFFM_CKBB__t3 XD4_XDFFM_CKBB 83.6284417263
* device instance XD4_XDFFM_CKBB_t4 r0 *1 0,0
RXD4_XDFFM_CKBB_t4 XD4_XDFFM_CKBB__t4 XD4_XDFFM_CKBB 83.087466786
* device instance XD4_XDFFM_CKBB_t5 r0 *1 0,0
RXD4_XDFFM_CKBB_t5 XD4_XDFFM_CKBB__t5 XD4_XDFFM_CKBB 85.7923414877
* device instance XD4_XDFFM_CKBB r0 *1 0,0
CXD4_XDFFM_CKBB XD4_XDFFM_CKBB vsubs 1.15798207e-13
* device instance XD4_XDFFM_CLKB_t0 r0 *1 0,0
RXD4_XDFFM_CLKB_t0 XD4_XDFFM_CLKB__t0 XD4_XDFFM_CLKB 66.5087458255
* device instance XD4_XDFFM_CLKB_t1 r0 *1 0,0
RXD4_XDFFM_CLKB_t1 XD4_XDFFM_CLKB__t1 XD4_XDFFM_CLKB 69.5911041745
* device instance XD4_XDFFM_CLKB_t2 r0 *1 0,0
RXD4_XDFFM_CLKB_t2 XD4_XDFFM_CLKB__t2 XD4_XDFFM_CLKB 70.3616937617
* device instance XD4_XDFFM_CLKB_t3 r0 *1 0,0
RXD4_XDFFM_CLKB_t3 XD4_XDFFM_CLKB__t3 XD4_XDFFM_CLKB 65.7381562383
* device instance XD4_XDFFM_CLKB_t4 r0 *1 0,0
RXD4_XDFFM_CLKB_t4 XD4_XDFFM_CLKB__t4 XD4_XDFFM_CLKB 68.9268028062
* device instance XD4_XDFFM_CLKB_t5 r0 *1 0,0
RXD4_XDFFM_CLKB_t5 XD4_XDFFM_CLKB__t5 XD4_XDFFM_CLKB 68.4883639031
* device instance XD4_XDFFM_CLKB_t6 r0 *1 0,0
RXD4_XDFFM_CLKB_t6 XD4_XDFFM_CLKB__t6 XD4_XDFFM_CLKB 65.4192915815
* device instance XD4_XDFFM_CLKB_t7 r0 *1 0,0
RXD4_XDFFM_CLKB_t7 XD4_XDFFM_CLKB__t7 XD4_XDFFM_CLKB 69.3652417092
* device instance XD4_XDFFM_CLKB r0 *1 0,0
CXD4_XDFFM_CLKB XD4_XDFFM_CLKB vsubs 1.25978197e-13
* device instance XD4_XDFFM_M_t0 r0 *1 0,0
RXD4_XDFFM_M_t0 XD4_XDFFM_M__t0 XD4_XDFFM_M 67.8902158447
* device instance XD4_XDFFM_M_t1 r0 *1 0,0
RXD4_XDFFM_M_t1 XD4_XDFFM_M__t1 XD4_XDFFM_M 67.1145441893
* device instance XD4_XDFFM_M_t2 r0 *1 0,0
RXD4_XDFFM_M_t2 XD4_XDFFM_M__t2 XD4_XDFFM_M 69.4415591553
* device instance XD4_XDFFM_M_t3 r0 *1 0,0
RXD4_XDFFM_M_t3 XD4_XDFFM_M__t3 XD4_XDFFM_M 70.2172308107
* device instance XD4_XDFFM_M_t4 r0 *1 0,0
RXD4_XDFFM_M_t4 XD4_XDFFM_M__t4 XD4_XDFFM_M 69.1072179246
* device instance XD4_XDFFM_M_t5 r0 *1 0,0
RXD4_XDFFM_M_t5 XD4_XDFFM_M__t5 XD4_XDFFM_M 67.7832266508
* device instance XD4_XDFFM_M_t6 r0 *1 0,0
RXD4_XDFFM_M_t6 XD4_XDFFM_M__t6 XD4_XDFFM_M 69.5485483492
* device instance XD4_XDFFM_M_t7 r0 *1 0,0
RXD4_XDFFM_M_t7 XD4_XDFFM_M__t7 XD4_XDFFM_M 68.2245570754
* device instance XD4_XDFFM_M r0 *1 0,0
CXD4_XDFFM_M XD4_XDFFM_M vsubs 1.27033087e-13
* device instance XD4_XDFFM_MB_t0 r0 *1 0,0
RXD4_XDFFM_MB_t0 XD4_XDFFM_MB__t0 XD4_XDFFM_MB 113.554243073
* device instance XD4_XDFFM_MB_t1 r0 *1 0,0
RXD4_XDFFM_MB_t1 XD4_XDFFM_MB__t1 XD4_XDFFM_MB 112.277156927
* device instance XD4_XDFFM_MB_t2 r0 *1 0,0
RXD4_XDFFM_MB_t2 XD4_XDFFM_MB__t2 XD4_XDFFM_MB 112.55239101
* device instance XD4_XDFFM_MB_t3 r0 *1 0,0
RXD4_XDFFM_MB_t3 XD4_XDFFM_MB__t3 XD4_XDFFM_MB 113.27900899
* device instance XD4_XDFFM_MB r0 *1 0,0
CXD4_XDFFM_MB XD4_XDFFM_MB vsubs 1.0267683e-13
* device instance XD4_XDFFM_MFB_t0 r0 *1 0,0
RXD4_XDFFM_MFB_t0 XD4_XDFFM_MFB__t0 XD4_XDFFM_MFB 113.373423964
* device instance XD4_XDFFM_MFB_t1 r0 *1 0,0
RXD4_XDFFM_MFB_t1 XD4_XDFFM_MFB__t1 XD4_XDFFM_MFB 114.659826036
* device instance XD4_XDFFM_MFB_t2 r0 *1 0,0
RXD4_XDFFM_MFB_t2 XD4_XDFFM_MFB__t2 XD4_XDFFM_MFB 113.65066579
* device instance XD4_XDFFM_MFB_t3 r0 *1 0,0
RXD4_XDFFM_MFB_t3 XD4_XDFFM_MFB__t3 XD4_XDFFM_MFB 114.38258421
* device instance XD4_XDFFM_MFB r0 *1 0,0
CXD4_XDFFM_MFB XD4_XDFFM_MFB vsubs 1.03627168e-13
* device instance XD4_XDFFM_S_t0 r0 *1 0,0
RXD4_XDFFM_S_t0 XD4_XDFFM_S__t0 XD4_XDFFM_S 84.3433191474
* device instance XD4_XDFFM_S_t1 r0 *1 0,0
RXD4_XDFFM_S_t1 XD4_XDFFM_S__t1 XD4_XDFFM_S 83.3946765894
* device instance XD4_XDFFM_S_t2 r0 *1 0,0
RXD4_XDFFM_S_t2 XD4_XDFFM_S__t2 XD4_XDFFM_S 86.2406042632
* device instance XD4_XDFFM_S_t3 r0 *1 0,0
RXD4_XDFFM_S_t3 XD4_XDFFM_S__t3 XD4_XDFFM_S 84.8394483012
* device instance XD4_XDFFM_S_t4 r0 *1 0,0
RXD4_XDFFM_S_t4 XD4_XDFFM_S__t4 XD4_XDFFM_S 85.3791932049
* device instance XD4_XDFFM_S_t5 r0 *1 0,0
RXD4_XDFFM_S_t5 XD4_XDFFM_S__t5 XD4_XDFFM_S 83.7599584939
* device instance XD4_XDFFM_S r0 *1 0,0
CXD4_XDFFM_S XD4_XDFFM_S vsubs 1.16623725e-13
* device instance XD4_XDFFM_SB_t0 r0 *1 0,0
RXD4_XDFFM_SB_t0 XD4_XDFFM_SB__t0 XD4_XDFFM_SB 84.0895661854
* device instance XD4_XDFFM_SB_t1 r0 *1 0,0
RXD4_XDFFM_SB_t1 XD4_XDFFM_SB__t1 XD4_XDFFM_SB 85.9765690731
* device instance XD4_XDFFM_SB_t2 r0 *1 0,0
RXD4_XDFFM_SB_t2 XD4_XDFFM_SB__t2 XD4_XDFFM_SB 83.1460647415
* device instance XD4_XDFFM_SB_t3 r0 *1 0,0
RXD4_XDFFM_SB_t3 XD4_XDFFM_SB__t3 XD4_XDFFM_SB 84.5830065957
* device instance XD4_XDFFM_SB_t4 r0 *1 0,0
RXD4_XDFFM_SB_t4 XD4_XDFFM_SB__t4 XD4_XDFFM_SB 83.5093670216
* device instance XD4_XDFFM_SB_t5 r0 *1 0,0
RXD4_XDFFM_SB_t5 XD4_XDFFM_SB__t5 XD4_XDFFM_SB 85.1198263827
* device instance XD4_XDFFM_SB r0 *1 0,0
CXD4_XDFFM_SB XD4_XDFFM_SB vsubs 1.16359363e-13
* device instance XD4_XDFFM_SFB_t0 r0 *1 0,0
RXD4_XDFFM_SFB_t0 XD4_XDFFM_SFB__t0 XD4_XDFFM_SFB 114.779753283
* device instance XD4_XDFFM_SFB_t1 r0 *1 0,0
RXD4_XDFFM_SFB_t1 XD4_XDFFM_SFB__t1 XD4_XDFFM_SFB 116.069496717
* device instance XD4_XDFFM_SFB_t2 r0 *1 0,0
RXD4_XDFFM_SFB_t2 XD4_XDFFM_SFB__t2 XD4_XDFFM_SFB 115.79153477
* device instance XD4_XDFFM_SFB_t3 r0 *1 0,0
RXD4_XDFFM_SFB_t3 XD4_XDFFM_SFB__t3 XD4_XDFFM_SFB 115.05771523
* device instance XD4_XDFFM_SFB r0 *1 0,0
CXD4_XDFFM_SFB XD4_XDFFM_SFB vsubs 1.04957614e-13
* device instance XD4_XDFFQ_CKBB_t0 r0 *1 0,0
RXD4_XDFFQ_CKBB_t0 XD4_XDFFQ_CKBB__t0 XD4_XDFFQ_CKBB 81.5704351999
* device instance XD4_XDFFQ_CKBB_t1 r0 *1 0,0
RXD4_XDFFQ_CKBB_t1 XD4_XDFFQ_CKBB__t1 XD4_XDFFQ_CKBB 88.4080870003
* device instance XD4_XDFFQ_CKBB_t2 r0 *1 0,0
RXD4_XDFFQ_CKBB_t2 XD4_XDFFQ_CKBB__t2 XD4_XDFFQ_CKBB 80.5936277998
* device instance XD4_XDFFQ_CKBB_t3 r0 *1 0,0
RXD4_XDFFQ_CKBB_t3 XD4_XDFFQ_CKBB__t3 XD4_XDFFQ_CKBB 82.4125105448
* device instance XD4_XDFFQ_CKBB_t4 r0 *1 0,0
RXD4_XDFFQ_CKBB_t4 XD4_XDFFQ_CKBB__t4 XD4_XDFFQ_CKBB 82.9682802724
* device instance XD4_XDFFQ_CKBB_t5 r0 *1 0,0
RXD4_XDFFQ_CKBB_t5 XD4_XDFFQ_CKBB__t5 XD4_XDFFQ_CKBB 85.1913591829
* device instance XD4_XDFFQ_CKBB r0 *1 0,0
CXD4_XDFFQ_CKBB XD4_XDFFQ_CKBB vsubs 1.15260553e-13
* device instance XD4_XDFFQ_CLKB_t0 r0 *1 0,0
RXD4_XDFFQ_CLKB_t0 XD4_XDFFQ_CLKB__t0 XD4_XDFFQ_CLKB 69.5105034196
* device instance XD4_XDFFQ_CLKB_t1 r0 *1 0,0
RXD4_XDFFQ_CLKB_t1 XD4_XDFFQ_CLKB__t1 XD4_XDFFQ_CLKB 70.3068051295
* device instance XD4_XDFFQ_CLKB_t2 r0 *1 0,0
RXD4_XDFFQ_CLKB_t2 XD4_XDFFQ_CLKB__t2 XD4_XDFFQ_CLKB 66.3252965804
* device instance XD4_XDFFQ_CLKB_t3 r0 *1 0,0
RXD4_XDFFQ_CLKB_t3 XD4_XDFFQ_CLKB__t3 XD4_XDFFQ_CLKB 65.5289948705
* device instance XD4_XDFFQ_CLKB_t4 r0 *1 0,0
RXD4_XDFFQ_CLKB_t4 XD4_XDFFQ_CLKB__t4 XD4_XDFFQ_CLKB 65.1994907148
* device instance XD4_XDFFQ_CLKB_t5 r0 *1 0,0
RXD4_XDFFQ_CLKB_t5 XD4_XDFFQ_CLKB__t5 XD4_XDFFQ_CLKB 68.8240364284
* device instance XD4_XDFFQ_CLKB_t6 r0 *1 0,0
RXD4_XDFFQ_CLKB_t6 XD4_XDFFQ_CLKB__t6 XD4_XDFFQ_CLKB 68.3709682142
* device instance XD4_XDFFQ_CLKB_t7 r0 *1 0,0
RXD4_XDFFQ_CLKB_t7 XD4_XDFFQ_CLKB__t7 XD4_XDFFQ_CLKB 69.2771046426
* device instance XD4_XDFFQ_CLKB r0 *1 0,0
CXD4_XDFFQ_CLKB XD4_XDFFQ_CLKB vsubs 1.2616218e-13
* device instance XD4_XDFFQ_M_t0 r0 *1 0,0
RXD4_XDFFQ_M_t0 XD4_XDFFQ_M__t0 XD4_XDFFQ_M 67.7323765543
* device instance XD4_XDFFQ_M_t1 r0 *1 0,0
RXD4_XDFFQ_M_t1 XD4_XDFFQ_M__t1 XD4_XDFFQ_M 66.9308781086
* device instance XD4_XDFFQ_M_t2 r0 *1 0,0
RXD4_XDFFQ_M_t2 XD4_XDFFQ_M__t2 XD4_XDFFQ_M 69.3353734457
* device instance XD4_XDFFQ_M_t3 r0 *1 0,0
RXD4_XDFFQ_M_t3 XD4_XDFFQ_M__t3 XD4_XDFFQ_M 70.1368718914
* device instance XD4_XDFFQ_M_t4 r0 *1 0,0
RXD4_XDFFQ_M_t4 XD4_XDFFQ_M__t4 XD4_XDFFQ_M 68.9898999777
* device instance XD4_XDFFQ_M_t5 r0 *1 0,0
RXD4_XDFFQ_M_t5 XD4_XDFFQ_M__t5 XD4_XDFFQ_M 67.6218250445
* device instance XD4_XDFFQ_M_t6 r0 *1 0,0
RXD4_XDFFQ_M_t6 XD4_XDFFQ_M__t6 XD4_XDFFQ_M 69.4459249555
* device instance XD4_XDFFQ_M_t7 r0 *1 0,0
RXD4_XDFFQ_M_t7 XD4_XDFFQ_M__t7 XD4_XDFFQ_M 68.0778500223
* device instance XD4_XDFFQ_M r0 *1 0,0
CXD4_XDFFQ_M XD4_XDFFQ_M vsubs 1.2721707e-13
* device instance XD4_XDFFQ_MB_t0 r0 *1 0,0
RXD4_XDFFQ_MB_t0 XD4_XDFFQ_MB__t0 XD4_XDFFQ_MB 111.894988956
* device instance XD4_XDFFQ_MB_t1 r0 *1 0,0
RXD4_XDFFQ_MB_t1 XD4_XDFFQ_MB__t1 XD4_XDFFQ_MB 110.592361044
* device instance XD4_XDFFQ_MB_t2 r0 *1 0,0
RXD4_XDFFQ_MB_t2 XD4_XDFFQ_MB__t2 XD4_XDFFQ_MB 110.873099818
* device instance XD4_XDFFQ_MB_t3 r0 *1 0,0
RXD4_XDFFQ_MB_t3 XD4_XDFFQ_MB__t3 XD4_XDFFQ_MB 111.614250182
* device instance XD4_XDFFQ_MB r0 *1 0,0
CXD4_XDFFQ_MB XD4_XDFFQ_MB vsubs 1.01417539e-13
* device instance XD4_XDFFQ_MFB_t0 r0 *1 0,0
RXD4_XDFFQ_MFB_t0 XD4_XDFFQ_MFB__t0 XD4_XDFFQ_MFB 111.688496073
* device instance XD4_XDFFQ_MFB_t1 r0 *1 0,0
RXD4_XDFFQ_MFB_t1 XD4_XDFFQ_MFB__t1 XD4_XDFFQ_MFB 113.000703927
* device instance XD4_XDFFQ_MFB_t2 r0 *1 0,0
RXD4_XDFFQ_MFB_t2 XD4_XDFFQ_MFB__t2 XD4_XDFFQ_MFB 112.71790051
* device instance XD4_XDFFQ_MFB_t3 r0 *1 0,0
RXD4_XDFFQ_MFB_t3 XD4_XDFFQ_MFB__t3 XD4_XDFFQ_MFB 111.97129949
* device instance XD4_XDFFQ_MFB r0 *1 0,0
CXD4_XDFFQ_MFB XD4_XDFFQ_MFB vsubs 1.02367878e-13
* device instance XD4_XDFFQ_S_t0 r0 *1 0,0
RXD4_XDFFQ_S_t0 XD4_XDFFQ_S__t0 XD4_XDFFQ_S 83.6893822588
* device instance XD4_XDFFQ_S_t1 r0 *1 0,0
RXD4_XDFFQ_S_t1 XD4_XDFFQ_S__t1 XD4_XDFFQ_S 82.7150290354
* device instance XD4_XDFFQ_S_t2 r0 *1 0,0
RXD4_XDFFQ_S_t2 XD4_XDFFQ_S__t2 XD4_XDFFQ_S 85.6380887058
* device instance XD4_XDFFQ_S_t3 r0 *1 0,0
RXD4_XDFFQ_S_t3 XD4_XDFFQ_S__t3 XD4_XDFFQ_S 84.1989577953
* device instance XD4_XDFFQ_S_t4 r0 *1 0,0
RXD4_XDFFQ_S_t4 XD4_XDFFQ_S__t4 XD4_XDFFQ_S 84.753331181
* device instance XD4_XDFFQ_S_t5 r0 *1 0,0
RXD4_XDFFQ_S_t5 XD4_XDFFQ_S__t5 XD4_XDFFQ_S 83.0902110237
* device instance XD4_XDFFQ_S r0 *1 0,0
CXD4_XDFFQ_S XD4_XDFFQ_S vsubs 1.16086071e-13
* device instance XD4_XDFFQ_SB_t0 r0 *1 0,0
RXD4_XDFFQ_SB_t0 XD4_XDFFQ_SB__t0 XD4_XDFFQ_SB 83.4357104815
* device instance XD4_XDFFQ_SB_t1 r0 *1 0,0
RXD4_XDFFQ_SB_t1 XD4_XDFFQ_SB__t1 XD4_XDFFQ_SB 85.3736475924
* device instance XD4_XDFFQ_SB_t2 r0 *1 0,0
RXD4_XDFFQ_SB_t2 XD4_XDFFQ_SB__t2 XD4_XDFFQ_SB 82.4667419261
* device instance XD4_XDFFQ_SB_t3 r0 *1 0,0
RXD4_XDFFQ_SB_t3 XD4_XDFFQ_SB__t3 XD4_XDFFQ_SB 83.9424698984
* device instance XD4_XDFFQ_SB_t4 r0 *1 0,0
RXD4_XDFFQ_SB_t4 XD4_XDFFQ_SB__t4 XD4_XDFFQ_SB 82.8398505078
* device instance XD4_XDFFQ_SB_t5 r0 *1 0,0
RXD4_XDFFQ_SB_t5 XD4_XDFFQ_SB__t5 XD4_XDFFQ_SB 84.4937795938
* device instance XD4_XDFFQ_SB r0 *1 0,0
CXD4_XDFFQ_SB XD4_XDFFQ_SB vsubs 1.15821709e-13
* device instance XD4_XDFFQ_SFB_t0 r0 *1 0,0
RXD4_XDFFQ_SFB_t0 XD4_XDFFQ_SFB__t0 XD4_XDFFQ_SFB 113.094895727
* device instance XD4_XDFFQ_SFB_t1 r0 *1 0,0
RXD4_XDFFQ_SFB_t1 XD4_XDFFQ_SFB__t1 XD4_XDFFQ_SFB 114.410304273
* device instance XD4_XDFFQ_SFB_t2 r0 *1 0,0
RXD4_XDFFQ_SFB_t2 XD4_XDFFQ_SFB__t2 XD4_XDFFQ_SFB 114.126811052
* device instance XD4_XDFFQ_SFB_t3 r0 *1 0,0
RXD4_XDFFQ_SFB_t3 XD4_XDFFQ_SFB__t3 XD4_XDFFQ_SFB 113.378388948
* device instance XD4_XDFFQ_SFB r0 *1 0,0
CXD4_XDFFQ_SFB XD4_XDFFQ_SFB vsubs 1.03698323e-13
* device instance XD4_XN2_mid1_t0 r0 *1 0,0
RXD4_XN2_mid1_t0 XD4_XN2_mid1__t0 XD4_XN2_mid1 25.4433
* device instance XD4_XN2_mid1_t1 r0 *1 0,0
RXD4_XN2_mid1_t1 XD4_XN2_mid1__t1 XD4_XN2_mid1 25.4433
* device instance XD4_XN2_mid1 r0 *1 0,0
CXD4_XN2_mid1 XD4_XN2_mid1 vsubs 1.2793745e-14
* device instance XD4_XN3_mid1_t0 r0 *1 0,0
RXD4_XN3_mid1_t0 XD4_XN3_mid1__t0 XD4_XN3_mid1 25.6193
* device instance XD4_XN3_mid1_t1 r0 *1 0,0
RXD4_XN3_mid1_t1 XD4_XN3_mid1__t1 XD4_XN3_mid1 25.6193
* device instance XD4_XN3_mid1 r0 *1 0,0
CXD4_XN3_mid1 XD4_XN3_mid1 vsubs 1.2913401e-14
* device instance XD4_XN3_mid2_t0 r0 *1 0,0
RXD4_XN3_mid2_t0 XD4_XN3_mid2__t0 XD4_XN3_mid2 25.7953
* device instance XD4_XN3_mid2_t1 r0 *1 0,0
RXD4_XN3_mid2_t1 XD4_XN3_mid2__t1 XD4_XN3_mid2 25.7953
* device instance XD4_XN3_mid2 r0 *1 0,0
CXD4_XN3_mid2 XD4_XN3_mid2 vsubs 1.3003049e-14
* device instance XD4_XNOR_midp_t0 r0 *1 0,0
RXD4_XNOR_midp_t0 XD4_XNOR_midp__t0 XD4_XNOR_midp 27.4977
* device instance XD4_XNOR_midp_t1 r0 *1 0,0
RXD4_XNOR_midp_t1 XD4_XNOR_midp__t1 XD4_XNOR_midp 27.4977
* device instance XD4_XNOR_midp r0 *1 0,0
CXD4_XNOR_midp XD4_XNOR_midp vsubs 1.3970916e-14
* device instance XD4_dmodout_t0 r0 *1 0,0
RXD4_dmodout_t0 XD4_dmodout__t0 XD4_dmodout 114.758048201
* device instance XD4_dmodout_t1 r0 *1 0,0
RXD4_dmodout_t1 XD4_dmodout__t1 XD4_dmodout 118.748701799
* device instance XD4_dmodout_t2 r0 *1 0,0
RXD4_dmodout_t2 XD4_dmodout__t2 XD4_dmodout 117.888647144
* device instance XD4_dmodout_t3 r0 *1 0,0
RXD4_dmodout_t3 XD4_dmodout__t3 XD4_dmodout 115.618102856
* device instance XD4_dmodout r0 *1 0,0
CXD4_dmodout XD4_dmodout vsubs 1.0649831e-13
* device instance XD4_dq_t0 r0 *1 0,0
RXD4_dq_t0 XD4_dq__t0 XD4_dq 118.781011161
* device instance XD4_dq_t1 r0 *1 0,0
RXD4_dq_t1 XD4_dq__t1 XD4_dq 122.327138839
* device instance XD4_dq_t2 r0 *1 0,0
RXD4_dq_t2 XD4_dq__t2 XD4_dq 78.8001199359
* device instance XD4_dq_t3 r0 *1 0,0
RXD4_dq_t3 XD4_dq__t3 XD4_dq 80.817744304
* device instance XD4_dq_t4 r0 *1 0,0
RXD4_dq_t4 XD4_dq__t4 XD4_dq 81.4902857601
* device instance XD4_dq r0 *1 0,0
CXD4_dq XD4_dq vsubs 1.10644874e-13
* device instance XD4_nm_t0 r0 *1 0,0
RXD4_nm_t0 XD4_nm__t0 XD4_nm 82.6497829103
* device instance XD4_nm_t1 r0 *1 0,0
RXD4_nm_t1 XD4_nm__t1 XD4_nm 80.314550423
* device instance XD4_nm_t2 r0 *1 0,0
RXD4_nm_t2 XD4_nm__t2 XD4_nm 81.4821666667
* device instance XD4_nm_t3 r0 *1 0,0
RXD4_nm_t3 XD4_nm__t3 XD4_nm 121.55891662
* device instance XD4_nm_t4 r0 *1 0,0
RXD4_nm_t4 XD4_nm__t4 XD4_nm 122.88758338
* device instance XD4_nm r0 *1 0,0
CXD4_nm XD4_nm vsubs 1.12322905e-13
* device instance XD4_nt_t0 r0 *1 0,0
RXD4_nt_t0 XD4_nt__t0 XD4_nt 64.7100937103
* device instance XD4_nt_t1 r0 *1 0,0
RXD4_nt_t1 XD4_nt__t1 XD4_nt 61.3211562897
* device instance XD4_nt_t2 r0 *1 0,0
RXD4_nt_t2 XD4_nt__t2 XD4_nt 62.4508020966
* device instance XD4_nt_t3 r0 *1 0,0
RXD4_nt_t3 XD4_nt__t3 XD4_nt 63.5804479034
* device instance XD4_nt_t4 r0 *1 0,0
RXD4_nt_t4 XD4_nt__t4 XD4_nt 125.067155734
* device instance XD4_nt_t5 r0 *1 0,0
RXD4_nt_t5 XD4_nt__t5 XD4_nt 126.995344266
* device instance XD4_nt r0 *1 0,0
CXD4_nt XD4_nt vsubs 1.16577419e-13
* device instance XD4_t1_t0 r0 *1 0,0
RXD4_t1_t0 XD4_t1__t0 XD4_t1 114.060567851
* device instance XD4_t1_t1 r0 *1 0,0
RXD4_t1_t1 XD4_t1__t1 XD4_t1 111.383532149
* device instance XD4_t1_t2 r0 *1 0,0
RXD4_t1_t2 XD4_t1__t2 XD4_t1 111.960479499
* device instance XD4_t1_t3 r0 *1 0,0
RXD4_t1_t3 XD4_t1__t3 XD4_t1 113.483620501
* device instance XD4_t1 r0 *1 0,0
CXD4_t1 XD4_t1 vsubs 1.03092849e-13
* device instance XD5_XDFFM_CKBB_t0 r0 *1 0,0
RXD5_XDFFM_CKBB_t0 XD5_XDFFM_CKBB__t0 XD5_XDFFM_CKBB 91.1599100129
* device instance XD5_XDFFM_CKBB_t1 r0 *1 0,0
RXD5_XDFFM_CKBB_t1 XD5_XDFFM_CKBB__t1 XD5_XDFFM_CKBB 98.0062833011
* device instance XD5_XDFFM_CKBB_t2 r0 *1 0,0
RXD5_XDFFM_CKBB_t2 XD5_XDFFM_CKBB__t2 XD5_XDFFM_CKBB 90.181856686
* device instance XD5_XDFFM_CKBB_t3 r0 *1 0,0
RXD5_XDFFM_CKBB_t3 XD5_XDFFM_CKBB__t3 XD5_XDFFM_CKBB 92.5595380496
* device instance XD5_XDFFM_CKBB_t4 r0 *1 0,0
RXD5_XDFFM_CKBB_t4 XD5_XDFFM_CKBB__t4 XD5_XDFFM_CKBB 92.0030594326
* device instance XD5_XDFFM_CKBB_t5 r0 *1 0,0
RXD5_XDFFM_CKBB_t5 XD5_XDFFM_CKBB__t5 XD5_XDFFM_CKBB 94.7854525177
* device instance XD5_XDFFM_CKBB r0 *1 0,0
CXD5_XDFFM_CKBB XD5_XDFFM_CKBB vsubs 1.2867821e-13
* device instance XD5_XDFFM_CLKB_t0 r0 *1 0,0
RXD5_XDFFM_CLKB_t0 XD5_XDFFM_CLKB__t0 XD5_XDFFM_CLKB 74.2626436686
* device instance XD5_XDFFM_CLKB_t1 r0 *1 0,0
RXD5_XDFFM_CLKB_t1 XD5_XDFFM_CLKB__t1 XD5_XDFFM_CLKB 78.2556907471
* device instance XD5_XDFFM_CLKB_t2 r0 *1 0,0
RXD5_XDFFM_CLKB_t2 XD5_XDFFM_CLKB__t2 XD5_XDFFM_CLKB 77.4570813314
* device instance XD5_XDFFM_CLKB_t3 r0 *1 0,0
RXD5_XDFFM_CLKB_t3 XD5_XDFFM_CLKB__t3 XD5_XDFFM_CLKB 73.4640342529
* device instance XD5_XDFFM_CLKB_t4 r0 *1 0,0
RXD5_XDFFM_CLKB_t4 XD5_XDFFM_CLKB__t4 XD5_XDFFM_CLKB 76.7686249386
* device instance XD5_XDFFM_CLKB_t5 r0 *1 0,0
RXD5_XDFFM_CLKB_t5 XD5_XDFFM_CLKB__t5 XD5_XDFFM_CLKB 76.3142437193
* device instance XD5_XDFFM_CLKB_t6 r0 *1 0,0
RXD5_XDFFM_CLKB_t6 XD5_XDFFM_CLKB__t6 XD5_XDFFM_CLKB 73.1335751843
* device instance XD5_XDFFM_CLKB_t7 r0 *1 0,0
RXD5_XDFFM_CLKB_t7 XD5_XDFFM_CLKB__t7 XD5_XDFFM_CLKB 77.2230061578
* device instance XD5_XDFFM_CLKB r0 *1 0,0
CXD5_XDFFM_CLKB XD5_XDFFM_CLKB vsubs 1.41116587e-13
* device instance XD5_XDFFM_M_t0 r0 *1 0,0
RXD5_XDFFM_M_t0 XD5_XDFFM_M__t0 XD5_XDFFM_M 75.6725659472
* device instance XD5_XDFFM_M_t1 r0 *1 0,0
RXD5_XDFFM_M_t1 XD5_XDFFM_M__t1 XD5_XDFFM_M 74.8692943945
* device instance XD5_XDFFM_M_t2 r0 *1 0,0
RXD5_XDFFM_M_t2 XD5_XDFFM_M__t2 XD5_XDFFM_M 77.2791090528
* device instance XD5_XDFFM_M_t3 r0 *1 0,0
RXD5_XDFFM_M_t3 XD5_XDFFM_M__t3 XD5_XDFFM_M 78.0823806055
* device instance XD5_XDFFM_M_t4 r0 *1 0,0
RXD5_XDFFM_M_t4 XD5_XDFFM_M__t4 XD5_XDFFM_M 76.9328713145
* device instance XD5_XDFFM_M_t5 r0 *1 0,0
RXD5_XDFFM_M_t5 XD5_XDFFM_M__t5 XD5_XDFFM_M 75.561769871
* device instance XD5_XDFFM_M_t6 r0 *1 0,0
RXD5_XDFFM_M_t6 XD5_XDFFM_M__t6 XD5_XDFFM_M 77.389905129
* device instance XD5_XDFFM_M_t7 r0 *1 0,0
RXD5_XDFFM_M_t7 XD5_XDFFM_M__t7 XD5_XDFFM_M 76.0188036855
* device instance XD5_XDFFM_M r0 *1 0,0
CXD5_XDFFM_M XD5_XDFFM_M vsubs 1.42171477e-13
* device instance XD5_XDFFM_MB_t0 r0 *1 0,0
RXD5_XDFFM_MB_t0 XD5_XDFFM_MB__t0 XD5_XDFFM_MB 124.788299163
* device instance XD5_XDFFM_MB_t1 r0 *1 0,0
RXD5_XDFFM_MB_t1 XD5_XDFFM_MB__t1 XD5_XDFFM_MB 123.482950837
* device instance XD5_XDFFM_MB_t2 r0 *1 0,0
RXD5_XDFFM_MB_t2 XD5_XDFFM_MB__t2 XD5_XDFFM_MB 123.764275907
* device instance XD5_XDFFM_MB_t3 r0 *1 0,0
RXD5_XDFFM_MB_t3 XD5_XDFFM_MB__t3 XD5_XDFFM_MB 124.506974093
* device instance XD5_XDFFM_MB r0 *1 0,0
CXD5_XDFFM_MB XD5_XDFFM_MB vsubs 1.13298445e-13
* device instance XD5_XDFFM_MFB_t0 r0 *1 0,0
RXD5_XDFFM_MFB_t0 XD5_XDFFM_MFB__t0 XD5_XDFFM_MFB 124.579601198
* device instance XD5_XDFFM_MFB_t1 r0 *1 0,0
RXD5_XDFFM_MFB_t1 XD5_XDFFM_MFB__t1 XD5_XDFFM_MFB 125.893548802
* device instance XD5_XDFFM_MFB_t2 r0 *1 0,0
RXD5_XDFFM_MFB_t2 XD5_XDFFM_MFB__t2 XD5_XDFFM_MFB 125.610370439
* device instance XD5_XDFFM_MFB_t3 r0 *1 0,0
RXD5_XDFFM_MFB_t3 XD5_XDFFM_MFB__t3 XD5_XDFFM_MFB 124.862779561
* device instance XD5_XDFFM_MFB r0 *1 0,0
CXD5_XDFFM_MFB XD5_XDFFM_MFB vsubs 1.14248784e-13
* device instance XD5_XDFFM_S_t0 r0 *1 0,0
RXD5_XDFFM_S_t0 XD5_XDFFM_S__t0 XD5_XDFFM_S 93.2808540179
* device instance XD5_XDFFM_S_t1 r0 *1 0,0
RXD5_XDFFM_S_t1 XD5_XDFFM_S__t1 XD5_XDFFM_S 92.3050160718
* device instance XD5_XDFFM_S_t2 r0 *1 0,0
RXD5_XDFFM_S_t2 XD5_XDFFM_S__t2 XD5_XDFFM_S 95.2325299103
* device instance XD5_XDFFM_S_t3 r0 *1 0,0
RXD5_XDFFM_S_t3 XD5_XDFFM_S__t3 XD5_XDFFM_S 93.7912060473
* device instance XD5_XDFFM_S_t4 r0 *1 0,0
RXD5_XDFFM_S_t4 XD5_XDFFM_S__t4 XD5_XDFFM_S 94.346424189
* device instance XD5_XDFFM_S_t5 r0 *1 0,0
RXD5_XDFFM_S_t5 XD5_XDFFM_S__t5 XD5_XDFFM_S 92.6807697637
* device instance XD5_XDFFM_S r0 *1 0,0
CXD5_XDFFM_S XD5_XDFFM_S vsubs 1.29503727e-13
* device instance XD5_XDFFM_SB_t0 r0 *1 0,0
RXD5_XDFFM_SB_t0 XD5_XDFFM_SB__t0 XD5_XDFFM_SB 93.0270022866
* device instance XD5_XDFFM_SB_t1 r0 *1 0,0
RXD5_XDFFM_SB_t1 XD5_XDFFM_SB__t1 XD5_XDFFM_SB 94.9689885672
* device instance XD5_XDFFM_SB_t2 r0 *1 0,0
RXD5_XDFFM_SB_t2 XD5_XDFFM_SB__t2 XD5_XDFFM_SB 92.0560091462
* device instance XD5_XDFFM_SB_t3 r0 *1 0,0
RXD5_XDFFM_SB_t3 XD5_XDFFM_SB__t3 XD5_XDFFM_SB 93.5348205381
* device instance XD5_XDFFM_SB_t4 r0 *1 0,0
RXD5_XDFFM_SB_t4 XD5_XDFFM_SB__t4 XD5_XDFFM_SB 92.4298973094
* device instance XD5_XDFFM_SB_t5 r0 *1 0,0
RXD5_XDFFM_SB_t5 XD5_XDFFM_SB__t5 XD5_XDFFM_SB 94.0872821524
* device instance XD5_XDFFM_SB r0 *1 0,0
CXD5_XDFFM_SB XD5_XDFFM_SB vsubs 1.29239366e-13
* device instance XD5_XDFFM_SFB_t0 r0 *1 0,0
RXD5_XDFFM_SFB_t0 XD5_XDFFM_SFB__t0 XD5_XDFFM_SFB 125.986145157
* device instance XD5_XDFFM_SFB_t1 r0 *1 0,0
RXD5_XDFFM_SFB_t1 XD5_XDFFM_SFB__t1 XD5_XDFFM_SFB 127.302954843
* device instance XD5_XDFFM_SFB_t2 r0 *1 0,0
RXD5_XDFFM_SFB_t2 XD5_XDFFM_SFB__t2 XD5_XDFFM_SFB 127.019159652
* device instance XD5_XDFFM_SFB_t3 r0 *1 0,0
RXD5_XDFFM_SFB_t3 XD5_XDFFM_SFB__t3 XD5_XDFFM_SFB 126.269940348
* device instance XD5_XDFFM_SFB r0 *1 0,0
CXD5_XDFFM_SFB XD5_XDFFM_SFB vsubs 1.1557923e-13
* device instance XD5_XDFFQ_CKBB_t0 r0 *1 0,0
RXD5_XDFFQ_CKBB_t0 XD5_XDFFQ_CKBB__t0 XD5_XDFFQ_CKBB 90.464539023
* device instance XD5_XDFFQ_CKBB_t1 r0 *1 0,0
RXD5_XDFFQ_CKBB_t1 XD5_XDFFQ_CKBB__t1 XD5_XDFFQ_CKBB 97.4859857758
* device instance XD5_XDFFQ_CKBB_t2 r0 *1 0,0
RXD5_XDFFQ_CKBB_t2 XD5_XDFFQ_CKBB__t2 XD5_XDFFQ_CKBB 89.4614752012
* device instance XD5_XDFFQ_CKBB_t3 r0 *1 0,0
RXD5_XDFFQ_CKBB_t3 XD5_XDFFQ_CKBB__t3 XD5_XDFFQ_CKBB 91.8999579405
* device instance XD5_XDFFQ_CKBB_t4 r0 *1 0,0
RXD5_XDFFQ_CKBB_t4 XD5_XDFFQ_CKBB__t4 XD5_XDFFQ_CKBB 91.3292492142
* device instance XD5_XDFFQ_CKBB_t5 r0 *1 0,0
RXD5_XDFFQ_CKBB_t5 XD5_XDFFQ_CKBB__t5 XD5_XDFFQ_CKBB 94.1827928453
* device instance XD5_XDFFQ_CKBB r0 *1 0,0
CXD5_XDFFQ_CKBB XD5_XDFFQ_CKBB vsubs 1.28140556e-13
* device instance XD5_XDFFQ_CLKB_t0 r0 *1 0,0
RXD5_XDFFQ_CLKB_t0 XD5_XDFFQ_CLKB__t0 XD5_XDFFQ_CLKB 74.0811037578
* device instance XD5_XDFFQ_CLKB_t1 r0 *1 0,0
RXD5_XDFFQ_CLKB_t1 XD5_XDFFQ_CLKB__t1 XD5_XDFFQ_CLKB 77.3745962422
* device instance XD5_XDFFQ_CLKB_t2 r0 *1 0,0
RXD5_XDFFQ_CLKB_t2 XD5_XDFFQ_CLKB__t2 XD5_XDFFQ_CLKB 78.1979693633
* device instance XD5_XDFFQ_CLKB_t3 r0 *1 0,0
RXD5_XDFFQ_CLKB_t3 XD5_XDFFQ_CLKB__t3 XD5_XDFFQ_CLKB 73.2577306367
* device instance XD5_XDFFQ_CLKB_t4 r0 *1 0,0
RXD5_XDFFQ_CLKB_t4 XD5_XDFFQ_CLKB__t4 XD5_XDFFQ_CLKB 76.6647918274
* device instance XD5_XDFFQ_CLKB_t5 r0 *1 0,0
RXD5_XDFFQ_CLKB_t5 XD5_XDFFQ_CLKB__t5 XD5_XDFFQ_CLKB 76.1963209137
* device instance XD5_XDFFQ_CLKB_t6 r0 *1 0,0
RXD5_XDFFQ_CLKB_t6 XD5_XDFFQ_CLKB__t6 XD5_XDFFQ_CLKB 72.9170245177
* device instance XD5_XDFFQ_CLKB_t7 r0 *1 0,0
RXD5_XDFFQ_CLKB_t7 XD5_XDFFQ_CLKB__t7 XD5_XDFFQ_CLKB 77.1332627412
* device instance XD5_XDFFQ_CLKB r0 *1 0,0
CXD5_XDFFQ_CLKB XD5_XDFFQ_CLKB vsubs 1.4130057e-13
* device instance XD5_XDFFQ_M_t0 r0 *1 0,0
RXD5_XDFFQ_M_t0 XD5_XDFFQ_M__t0 XD5_XDFFQ_M 75.5156826822
* device instance XD5_XDFFQ_M_t1 r0 *1 0,0
RXD5_XDFFQ_M_t1 XD5_XDFFQ_M__t1 XD5_XDFFQ_M 74.6875528644
* device instance XD5_XDFFQ_M_t2 r0 *1 0,0
RXD5_XDFFQ_M_t2 XD5_XDFFQ_M__t2 XD5_XDFFQ_M 77.1719423178
* device instance XD5_XDFFQ_M_t3 r0 *1 0,0
RXD5_XDFFQ_M_t3 XD5_XDFFQ_M__t3 XD5_XDFFQ_M 78.0000721356
* device instance XD5_XDFFQ_M_t4 r0 *1 0,0
RXD5_XDFFQ_M_t4 XD5_XDFFQ_M__t4 XD5_XDFFQ_M 76.8149898101
* device instance XD5_XDFFQ_M_t5 r0 *1 0,0
RXD5_XDFFQ_M_t5 XD5_XDFFQ_M__t5 XD5_XDFFQ_M 75.4014578797
* device instance XD5_XDFFQ_M_t6 r0 *1 0,0
RXD5_XDFFQ_M_t6 XD5_XDFFQ_M__t6 XD5_XDFFQ_M 77.2861671203
* device instance XD5_XDFFQ_M_t7 r0 *1 0,0
RXD5_XDFFQ_M_t7 XD5_XDFFQ_M__t7 XD5_XDFFQ_M 75.8726351899
* device instance XD5_XDFFQ_M r0 *1 0,0
CXD5_XDFFQ_M XD5_XDFFQ_M vsubs 1.4235546e-13
* device instance XD5_XDFFQ_MB_t0 r0 *1 0,0
RXD5_XDFFQ_MB_t0 XD5_XDFFQ_MB__t0 XD5_XDFFQ_MB 123.128606611
* device instance XD5_XDFFQ_MB_t1 r0 *1 0,0
RXD5_XDFFQ_MB_t1 XD5_XDFFQ_MB__t1 XD5_XDFFQ_MB 121.798643389
* device instance XD5_XDFFQ_MB_t2 r0 *1 0,0
RXD5_XDFFQ_MB_t2 XD5_XDFFQ_MB__t2 XD5_XDFFQ_MB 122.085273394
* device instance XD5_XDFFQ_MB_t3 r0 *1 0,0
RXD5_XDFFQ_MB_t3 XD5_XDFFQ_MB__t3 XD5_XDFFQ_MB 122.841976606
* device instance XD5_XDFFQ_MB r0 *1 0,0
CXD5_XDFFQ_MB XD5_XDFFQ_MB vsubs 1.12039154e-13
* device instance XD5_XDFFQ_MFB_t0 r0 *1 0,0
RXD5_XDFFQ_MFB_t0 XD5_XDFFQ_MFB__t0 XD5_XDFFQ_MFB 122.895157064
* device instance XD5_XDFFQ_MFB_t1 r0 *1 0,0
RXD5_XDFFQ_MFB_t1 XD5_XDFFQ_MFB__t1 XD5_XDFFQ_MFB 124.233942936
* device instance XD5_XDFFQ_MFB_t2 r0 *1 0,0
RXD5_XDFFQ_MFB_t2 XD5_XDFFQ_MFB__t2 XD5_XDFFQ_MFB 123.945411498
* device instance XD5_XDFFQ_MFB_t3 r0 *1 0,0
RXD5_XDFFQ_MFB_t3 XD5_XDFFQ_MFB__t3 XD5_XDFFQ_MFB 123.183688502
* device instance XD5_XDFFQ_MFB r0 *1 0,0
CXD5_XDFFQ_MFB XD5_XDFFQ_MFB vsubs 1.12989493e-13
* device instance XD5_XDFFQ_S_t0 r0 *1 0,0
RXD5_XDFFQ_S_t0 XD5_XDFFQ_S__t0 XD5_XDFFQ_S 92.6272556323
* device instance XD5_XDFFQ_S_t1 r0 *1 0,0
RXD5_XDFFQ_S_t1 XD5_XDFFQ_S__t1 XD5_XDFFQ_S 91.6266725291
* device instance XD5_XDFFQ_S_t2 r0 *1 0,0
RXD5_XDFFQ_S_t2 XD5_XDFFQ_S__t2 XD5_XDFFQ_S 94.6284218386
* device instance XD5_XDFFQ_S_t3 r0 *1 0,0
RXD5_XDFFQ_S_t3 XD5_XDFFQ_S__t3 XD5_XDFFQ_S 93.1505490943
* device instance XD5_XDFFQ_S_t4 r0 *1 0,0
RXD5_XDFFQ_S_t4 XD5_XDFFQ_S__t4 XD5_XDFFQ_S 93.7198463771
* device instance XD5_XDFFQ_S_t5 r0 *1 0,0
RXD5_XDFFQ_S_t5 XD5_XDFFQ_S__t5 XD5_XDFFQ_S 92.0119545286
* device instance XD5_XDFFQ_S r0 *1 0,0
CXD5_XDFFQ_S XD5_XDFFQ_S vsubs 1.28966074e-13
* device instance XD5_XDFFQ_SB_t0 r0 *1 0,0
RXD5_XDFFQ_SB_t0 XD5_XDFFQ_SB__t0 XD5_XDFFQ_SB 92.3734753159
* device instance XD5_XDFFQ_SB_t1 r0 *1 0,0
RXD5_XDFFQ_SB_t1 XD5_XDFFQ_SB__t1 XD5_XDFFQ_SB 94.3645234205
* device instance XD5_XDFFQ_SB_t2 r0 *1 0,0
RXD5_XDFFQ_SB_t2 XD5_XDFFQ_SB__t2 XD5_XDFFQ_SB 91.3779512636
* device instance XD5_XDFFQ_SB_t3 r0 *1 0,0
RXD5_XDFFQ_SB_t3 XD5_XDFFQ_SB__t3 XD5_XDFFQ_SB 92.8941229524
* device instance XD5_XDFFQ_SB_t4 r0 *1 0,0
RXD5_XDFFQ_SB_t4 XD5_XDFFQ_SB__t4 XD5_XDFFQ_SB 91.7612852378
* device instance XD5_XDFFQ_SB_t5 r0 *1 0,0
RXD5_XDFFQ_SB_t5 XD5_XDFFQ_SB__t5 XD5_XDFFQ_SB 93.4605418098
* device instance XD5_XDFFQ_SB r0 *1 0,0
CXD5_XDFFQ_SB XD5_XDFFQ_SB vsubs 1.28701712e-13
* device instance XD5_XDFFQ_SFB_t0 r0 *1 0,0
RXD5_XDFFQ_SFB_t0 XD5_XDFFQ_SFB__t0 XD5_XDFFQ_SFB 124.301794465
* device instance XD5_XDFFQ_SFB_t1 r0 *1 0,0
RXD5_XDFFQ_SFB_t1 XD5_XDFFQ_SFB__t1 XD5_XDFFQ_SFB 125.643305535
* device instance XD5_XDFFQ_SFB_t2 r0 *1 0,0
RXD5_XDFFQ_SFB_t2 XD5_XDFFQ_SFB__t2 XD5_XDFFQ_SFB 125.35418677
* device instance XD5_XDFFQ_SFB_t3 r0 *1 0,0
RXD5_XDFFQ_SFB_t3 XD5_XDFFQ_SFB__t3 XD5_XDFFQ_SFB 124.59091323
* device instance XD5_XDFFQ_SFB r0 *1 0,0
CXD5_XDFFQ_SFB XD5_XDFFQ_SFB vsubs 1.14319939e-13
* device instance XD5_XN2_mid1_t0 r0 *1 0,0
RXD5_XN2_mid1_t0 XD5_XN2_mid1__t0 XD5_XN2_mid1 29.84325
* device instance XD5_XN2_mid1_t1 r0 *1 0,0
RXD5_XN2_mid1_t1 XD5_XN2_mid1__t1 XD5_XN2_mid1 29.84325
* device instance XD5_XN2_mid1 r0 *1 0,0
CXD5_XN2_mid1 XD5_XN2_mid1 vsubs 1.5012307e-14
* device instance XD5_XN3_mid1_t0 r0 *1 0,0
RXD5_XN3_mid1_t0 XD5_XN3_mid1__t0 XD5_XN3_mid1 30.01925
* device instance XD5_XN3_mid1_t1 r0 *1 0,0
RXD5_XN3_mid1_t1 XD5_XN3_mid1__t1 XD5_XN3_mid1 30.01925
* device instance XD5_XN3_mid1 r0 *1 0,0
CXD5_XN3_mid1 XD5_XN3_mid1 vsubs 1.5134156e-14
* device instance XD5_XN3_mid2_t0 r0 *1 0,0
RXD5_XN3_mid2_t0 XD5_XN3_mid2__t0 XD5_XN3_mid2 30.19525
* device instance XD5_XN3_mid2_t1 r0 *1 0,0
RXD5_XN3_mid2_t1 XD5_XN3_mid2__t1 XD5_XN3_mid2 30.19525
* device instance XD5_XN3_mid2 r0 *1 0,0
CXD5_XN3_mid2 XD5_XN3_mid2 vsubs 1.5223804e-14
* device instance XD5_XNOR_midp_t0 r0 *1 0,0
RXD5_XNOR_midp_t0 XD5_XNOR_midp__t0 XD5_XNOR_midp 31.8977
* device instance XD5_XNOR_midp_t1 r0 *1 0,0
RXD5_XNOR_midp_t1 XD5_XNOR_midp__t1 XD5_XNOR_midp 31.8977
* device instance XD5_XNOR_midp r0 *1 0,0
CXD5_XNOR_midp XD5_XNOR_midp vsubs 1.6270208e-14
* device instance XD5_dmodout_t0 r0 *1 0,0
RXD5_dmodout_t0 XD5_dmodout__t0 XD5_dmodout 125.940951771
* device instance XD5_dmodout_t1 r0 *1 0,0
RXD5_dmodout_t1 XD5_dmodout__t1 XD5_dmodout 130.005698229
* device instance XD5_dmodout_t2 r0 *1 0,0
RXD5_dmodout_t2 XD5_dmodout__t2 XD5_dmodout 129.129675285
* device instance XD5_dmodout_t3 r0 *1 0,0
RXD5_dmodout_t3 XD5_dmodout__t3 XD5_dmodout 126.816974715
* device instance XD5_dmodout r0 *1 0,0
CXD5_dmodout XD5_dmodout vsubs 1.17119926e-13
* device instance XD5_dq_t0 r0 *1 0,0
RXD5_dq_t0 XD5_dq__t0 XD5_dq 131.062167014
* device instance XD5_dq_t1 r0 *1 0,0
RXD5_dq_t1 XD5_dq__t1 XD5_dq 134.685832986
* device instance XD5_dq_t2 r0 *1 0,0
RXD5_dq_t2 XD5_dq__t2 XD5_dq 86.9790903458
* device instance XD5_dq_t3 r0 *1 0,0
RXD5_dq_t3 XD5_dq__t3 XD5_dq 89.7280783244
* device instance XD5_dq_t4 r0 *1 0,0
RXD5_dq_t4 XD5_dq__t4 XD5_dq 89.0408313298
* device instance XD5_dq r0 *1 0,0
CXD5_dq XD5_dq vsubs 1.2237523e-13
* device instance XD5_nm_t0 r0 *1 0,0
RXD5_nm_t0 XD5_nm__t0 XD5_nm 90.8893217853
* device instance XD5_nm_t1 r0 *1 0,0
RXD5_nm_t1 XD5_nm__t1 XD5_nm 88.5015782147
* device instance XD5_nm_t2 r0 *1 0,0
RXD5_nm_t2 XD5_nm__t2 XD5_nm 89.69545
* device instance XD5_nm_t3 r0 *1 0,0
RXD5_nm_t3 XD5_nm__t3 XD5_nm 133.863903122
* device instance XD5_nm_t4 r0 *1 0,0
RXD5_nm_t4 XD5_nm__t4 XD5_nm 135.222446878
* device instance XD5_nm r0 *1 0,0
CXD5_nm XD5_nm vsubs 1.24095246e-13
* device instance XD5_nt_t0 r0 *1 0,0
RXD5_nt_t0 XD5_nt__t0 XD5_nt 71.4618658949
* device instance XD5_nt_t1 r0 *1 0,0
RXD5_nt_t1 XD5_nt__t1 XD5_nt 67.9893341051
* device instance XD5_nt_t2 r0 *1 0,0
RXD5_nt_t2 XD5_nt__t2 XD5_nt 70.3043552983
* device instance XD5_nt_t3 r0 *1 0,0
RXD5_nt_t3 XD5_nt__t3 XD5_nt 69.1468447017
* device instance XD5_nt_t4 r0 *1 0,0
RXD5_nt_t4 XD5_nt__t4 XD5_nt 138.463324577
* device instance XD5_nt_t5 r0 *1 0,0
RXD5_nt_t5 XD5_nt__t5 XD5_nt 140.439075423
* device instance XD5_nt r0 *1 0,0
CXD5_nt XD5_nt vsubs 1.29501599e-13
* device instance XD5_t1_t0 r0 *1 0,0
RXD5_t1_t0 XD5_t1__t0 XD5_t1 125.30557163
* device instance XD5_t1_t1 r0 *1 0,0
RXD5_t1_t1 XD5_t1__t1 XD5_t1 122.57842837
* device instance XD5_t1_t2 r0 *1 0,0
RXD5_t1_t2 XD5_t1__t2 XD5_t1 123.166174762
* device instance XD5_t1_t3 r0 *1 0,0
RXD5_t1_t3 XD5_t1__t3 XD5_t1 124.717825238
* device instance XD5_t1 r0 *1 0,0
CXD5_t1 XD5_t1 vsubs 1.1371718e-13
* device instance XFRT_CKBB_t0 r0 *1 0,0
RXFRT_CKBB_t0 XFRT_CKBB__t0 XFRT_CKBB 104.208886589
* device instance XFRT_CKBB_t1 r0 *1 0,0
RXFRT_CKBB_t1 XFRT_CKBB__t1 XFRT_CKBB 97.0974653645
* device instance XFRT_CKBB_t2 r0 *1 0,0
RXFRT_CKBB_t2 XFRT_CKBB__t2 XFRT_CKBB 96.0815480468
* device instance XFRT_CKBB_t3 r0 *1 0,0
RXFRT_CKBB_t3 XFRT_CKBB__t3 XFRT_CKBB 98.5512780778
* device instance XFRT_CKBB_t4 r0 *1 0,0
RXFRT_CKBB_t4 XFRT_CKBB__t4 XFRT_CKBB 97.9732561557
* device instance XFRT_CKBB_t5 r0 *1 0,0
RXFRT_CKBB_t5 XFRT_CKBB__t5 XFRT_CKBB 100.863365766
* device instance XFRT_CKBB r0 *1 0,0
CXFRT_CKBB XFRT_CKBB vsubs 1.37673855e-13
* device instance XFRT_CLKB_t0 r0 *1 0,0
RXFRT_CLKB_t0 XFRT_CLKB__t0 XFRT_CLKB 79.7962446385
* device instance XFRT_CLKB_t1 r0 *1 0,0
RXFRT_CLKB_t1 XFRT_CLKB__t1 XFRT_CLKB 83.1433803615
* device instance XFRT_CLKB_t2 r0 *1 0,0
RXFRT_CLKB_t2 XFRT_CLKB__t2 XFRT_CLKB 83.9801642923
* device instance XFRT_CLKB_t3 r0 *1 0,0
RXFRT_CLKB_t3 XFRT_CLKB__t3 XFRT_CLKB 78.9594607077
* device instance XFRT_CLKB_t4 r0 *1 0,0
RXFRT_CLKB_t4 XFRT_CLKB__t4 XFRT_CLKB 82.422014904
* device instance XFRT_CLKB_t5 r0 *1 0,0
RXFRT_CLKB_t5 XFRT_CLKB__t5 XFRT_CLKB 81.945913702
* device instance XFRT_CLKB_t6 r0 *1 0,0
RXFRT_CLKB_t6 XFRT_CLKB__t6 XFRT_CLKB 78.6132052881
* device instance XFRT_CLKB_t7 r0 *1 0,0
RXFRT_CLKB_t7 XFRT_CLKB__t7 XFRT_CLKB 82.898116106
* device instance XFRT_CLKB r0 *1 0,0
CXFRT_CLKB XFRT_CLKB vsubs 1.52375528e-13
* device instance XFRT_M_t0 r0 *1 0,0
RXFRT_M_t0 XFRT_M__t0 XFRT_M 81.2445390189
* device instance XFRT_M_t1 r0 *1 0,0
RXFRT_M_t1 XFRT_M__t1 XFRT_M 80.4032905377
* device instance XFRT_M_t2 r0 *1 0,0
RXFRT_M_t2 XFRT_M__t2 XFRT_M 82.9270359811
* device instance XFRT_M_t3 r0 *1 0,0
RXFRT_M_t3 XFRT_M__t3 XFRT_M 83.7682844623
* device instance XFRT_M_t4 r0 *1 0,0
RXFRT_M_t4 XFRT_M__t4 XFRT_M 82.5644288772
* device instance XFRT_M_t5 r0 *1 0,0
RXFRT_M_t5 XFRT_M__t5 XFRT_M 81.1285047456
* device instance XFRT_M_t6 r0 *1 0,0
RXFRT_M_t6 XFRT_M__t6 XFRT_M 83.0430702544
* device instance XFRT_M_t7 r0 *1 0,0
RXFRT_M_t7 XFRT_M__t7 XFRT_M 81.6071461228
* device instance XFRT_M r0 *1 0,0
CXFRT_M XFRT_M vsubs 1.5343369e-13
* device instance XFRT_MB_t0 r0 *1 0,0
RXFRT_MB_t0 XFRT_MB__t0 XFRT_MB 131.62738497
* device instance XFRT_MB_t1 r0 *1 0,0
RXFRT_MB_t1 XFRT_MB__t1 XFRT_MB 130.28381503
* device instance XFRT_MB_t2 r0 *1 0,0
RXFRT_MB_t2 XFRT_MB__t2 XFRT_MB 130.573377517
* device instance XFRT_MB_t3 r0 *1 0,0
RXFRT_MB_t3 XFRT_MB__t3 XFRT_MB 131.337822483
* device instance XFRT_MB r0 *1 0,0
CXFRT_MB XFRT_MB vsubs 1.20032987e-13
* device instance XFRT_MFB_t0 r0 *1 0,0
RXFRT_MFB_t0 XFRT_MFB__t0 XFRT_MFB 131.38058703
* device instance XFRT_MFB_t1 r0 *1 0,0
RXFRT_MFB_t1 XFRT_MFB__t1 XFRT_MFB 132.73246297
* device instance XFRT_MFB_t2 r0 *1 0,0
RXFRT_MFB_t2 XFRT_MFB__t2 XFRT_MFB 132.441110397
* device instance XFRT_MFB_t3 r0 *1 0,0
RXFRT_MFB_t3 XFRT_MFB__t3 XFRT_MFB 131.671939603
* device instance XFRT_MFB r0 *1 0,0
CXFRT_MFB XFRT_MFB vsubs 1.20983325e-13
* device instance XFRT_S_t0 r0 *1 0,0
RXFRT_S_t0 XFRT_S__t0 XFRT_S 99.2816070644
* device instance XFRT_S_t1 r0 *1 0,0
RXFRT_S_t1 XFRT_S__t1 XFRT_S 101.308564678
* device instance XFRT_S_t2 r0 *1 0,0
RXFRT_S_t2 XFRT_S__t2 XFRT_S 98.2681282578
* device instance XFRT_S_t3 r0 *1 0,0
RXFRT_S_t3 XFRT_S__t3 XFRT_S 99.8116448311
* device instance XFRT_S_t4 r0 *1 0,0
RXFRT_S_t4 XFRT_S__t4 XFRT_S 100.388279325
* device instance XFRT_S_t5 r0 *1 0,0
RXFRT_S_t5 XFRT_S__t5 XFRT_S 98.6583758443
* device instance XFRT_S r0 *1 0,0
CXFRT_S XFRT_S vsubs 1.38501565e-13
* device instance XFRT_SB_t0 r0 *1 0,0
RXFRT_SB_t0 XFRT_SB__t0 XFRT_SB 99.0277439187
* device instance XFRT_SB_t1 r0 *1 0,0
RXFRT_SB_t1 XFRT_SB__t1 XFRT_SB 101.045080406
* device instance XFRT_SB_t2 r0 *1 0,0
RXFRT_SB_t2 XFRT_SB__t2 XFRT_SB 98.0190756749
* device instance XFRT_SB_t3 r0 *1 0,0
RXFRT_SB_t3 XFRT_SB__t3 XFRT_SB 99.5552658164
* device instance XFRT_SB_t4 r0 *1 0,0
RXFRT_SB_t4 XFRT_SB__t4 XFRT_SB 98.4074709182
* device instance XFRT_SB_t5 r0 *1 0,0
RXFRT_SB_t5 XFRT_SB__t5 XFRT_SB 100.129163265
* device instance XFRT_SB r0 *1 0,0
CXFRT_SB XFRT_SB vsubs 1.38237203e-13
* device instance XFRT_SFB_t0 r0 *1 0,0
RXFRT_SFB_t0 XFRT_SFB__t0 XFRT_SFB 132.787356185
* device instance XFRT_SFB_t1 r0 *1 0,0
RXFRT_SFB_t1 XFRT_SFB__t1 XFRT_SFB 134.141693815
* device instance XFRT_SFB_t2 r0 *1 0,0
RXFRT_SFB_t2 XFRT_SFB__t2 XFRT_SFB 133.849810705
* device instance XFRT_SFB_t3 r0 *1 0,0
RXFRT_SFB_t3 XFRT_SFB__t3 XFRT_SFB 133.079239295
* device instance XFRT_SFB r0 *1 0,0
CXFRT_SFB XFRT_SFB vsubs 1.22313771e-13
* device instance ck1_t0 r0 *1 0,0
Rck1_t0 ck1__t0 ck1 77.2343313812
* device instance ck1_t1 r0 *1 0,0
Rck1_t1 ck1__t1 ck1 42.7261995524
* device instance ck1_t2 r0 *1 0,0
Rck1_t2 ck1__t2 ck1 57.3660130555
* device instance ck1_t3 r0 *1 0,0
Rck1_t3 ck1__t3 ck1 91.8741448843
* device instance ck1_t4 r0 *1 0,0
Rck1_t4 ck1__t4 ck1 55.2746111265
* device instance ck1_t5 r0 *1 0,0
Rck1_t5 ck1__t5 ck1 77.5083771512
* device instance ck1_t6 r0 *1 0,0
Rck1_t6 ck1__t6 ck1 57.8744400762
* device instance ck1_t7 r0 *1 0,0
Rck1_t7 ck1__t7 ck1 49.5448910141
* device instance ck1_t8 r0 *1 0,0
Rck1_t8 ck1__t8 ck1 69.1788280891
* device instance ck1_t9 r0 *1 0,0
Rck1_t9 ck1__t9 ck1 70.3687636694
* device instance ck1 r0 *1 0,0
Cck1 ck1 vsubs 1.54254597e-13
* device instance ck2_t0 r0 *1 0,0
Rck2_t0 ck2__t0 ck2 79.4375467163
* device instance ck2_t1 r0 *1 0,0
Rck2_t1 ck2__t1 ck2 93.2459207865
* device instance ck2_t2 r0 *1 0,0
Rck2_t2 ck2__t2 ck2 46.889236408
* device instance ck2_t3 r0 *1 0,0
Rck2_t3 ck2__t3 ck2 60.6976104782
* device instance ck2_t4 r0 *1 0,0
Rck2_t4 ck2__t4 ck2 58.724985611
* device instance ck2_t5 r0 *1 0,0
Rck2_t5 ck2__t5 ck2 79.6960285954
* device instance ck2_t6 r0 *1 0,0
Rck2_t6 ck2__t6 ck2 71.8395399003
* device instance ck2_t7 r0 *1 0,0
Rck2_t7 ck2__t7 ck2 53.3206736904
* device instance ck2_t8 r0 *1 0,0
Rck2_t8 ck2__t8 ck2 61.1771623856
* device instance ck2_t9 r0 *1 0,0
Rck2_t9 ck2__t9 ck2 72.9618954282
* device instance ck2 r0 *1 0,0
Cck2 ck2 vsubs 1.60746216e-13
* device instance ck3_t0 r0 *1 0,0
Rck3_t0 ck3__t0 ck3 81.7649176033
* device instance ck3_t1 r0 *1 0,0
Rck3_t1 ck3__t1 ck3 50.8292141365
* device instance ck3_t2 r0 *1 0,0
Rck3_t2 ck3__t2 ck3 63.9534519709
* device instance ck3_t3 r0 *1 0,0
Rck3_t3 ck3__t3 ck3 94.8891554376
* device instance ck3_t4 r0 *1 0,0
Rck3_t4 ck3__t4 ck3 62.0785608517
* device instance ck3_t5 r0 *1 0,0
Rck3_t5 ck3__t5 ck3 56.9420056993
* device instance ck3_t6 r0 *1 0,0
Rck3_t6 ck3__t6 ck3 82.0105929913
* device instance ck3_t7 r0 *1 0,0
Rck3_t7 ck3__t7 ck3 64.4092444671
* device instance ck3_t8 r0 *1 0,0
Rck3_t8 ck3__t8 ck3 74.5433542235
* device instance ck3_t9 r0 *1 0,0
Rck3_t9 ck3__t9 ck3 75.6101026189
* device instance ck3 r0 *1 0,0
Cck3 ck3 vsubs 1.67239471e-13
* device instance ck4_t0 r0 *1 0,0
Rck4_t0 ck4__t0 ck4 54.6005869112
* device instance ck4_t1 r0 *1 0,0
Rck4_t1 ck4__t1 ck4 67.1520314038
* device instance ck4_t2 r0 *1 0,0
Rck4_t2 ck4__t2 ck4 84.1861346438
* device instance ck4_t3 r0 *1 0,0
Rck4_t3 ck4__t3 ck4 96.7375791363
* device instance ck4_t4 r0 *1 0,0
Rck4_t4 ck4__t4 ck4 65.3589679049
* device instance ck4_t5 r0 *1 0,0
Rck4_t5 ck4__t5 ck4 84.4210877919
* device instance ck4_t6 r0 *1 0,0
Rck4_t6 ck4__t6 ck4 77.279748684
* device instance ck4_t7 r0 *1 0,0
Rck4_t7 ck4__t7 ck4 60.4465922155
* device instance ck4_t8 r0 *1 0,0
Rck4_t8 ck4__t8 ck4 67.5879313234
* device instance ck4_t9 r0 *1 0,0
Rck4_t9 ck4__t9 ck4 78.2999399852
* device instance ck4 r0 *1 0,0
Cck4 ck4 vsubs 1.73732726e-13
* device instance ck5_t0 r0 *1 0,0
Rck5_t0 ck5__t0 ck5 86.6800117189
* device instance ck5_t1 r0 *1 0,0
Rck5_t1 ck5__t1 ck5 58.2414179287
* device instance ck5_t2 r0 *1 0,0
Rck5_t2 ck5__t2 ck5 70.3062759003
* device instance ck5_t3 r0 *1 0,0
Rck5_t3 ck5__t3 ck5 98.7448696905
* device instance ck5_t4 r0 *1 0,0
Rck5_t4 ck5__t4 ck5 68.5827247615
* device instance ck5_t5 r0 *1 0,0
Rck5_t5 ck5__t5 ck5 63.8607889692
* device instance ck5_t6 r0 *1 0,0
Rck5_t6 ck5__t6 ck5 80.0413681946
* device instance ck5_t7 r0 *1 0,0
Rck5_t7 ck5__t7 ck5 70.7252771254
* device instance ck5_t8 r0 *1 0,0
Rck5_t8 ck5__t8 ck5 86.9058563509
* device instance ck5_t9 r0 *1 0,0
Rck5_t9 ck5__t9 ck5 81.0220093598
* device instance ck5 r0 *1 0,0
Cck5 ck5 vsubs 1.80224833e-13
* device instance mod0_t0 r0 *1 0,0
Rmod0_t0 mod0__t0 mod0 83.7454644687
* device instance mod0_t1 r0 *1 0,0
Rmod0_t1 mod0__t1 mod0 63.9995537069
* device instance mod0_t2 r0 *1 0,0
Rmod0_t2 mod0__t2 mod0 43.0195235225
* device instance mod0_t3 r0 *1 0,0
Rmod0_t3 mod0__t3 mod0 118.300808302
* device instance mod0_t4 r0 *1 0,0
Rmod0_t4 mod0__t4 mod0 96.7515937286
* device instance mod0_t5 r0 *1 0,0
Rmod0_t5 mod0__t5 mod0 73.579937673
* device instance mod0_t6 r0 *1 0,0
Rmod0_t6 mod0__t6 mod0 84.814680003
* device instance mod0_t7 r0 *1 0,0
Rmod0_t7 mod0__t7 mod0 53.9191385955
* device instance mod0 r0 *1 0,0
Cmod0 mod0 vsubs 1.45579958e-13
* device instance mod1_t0 r0 *1 0,0
Rmod1_t0 mod1__t0 mod1 86.9784417649
* device instance mod1_t1 r0 *1 0,0
Rmod1_t1 mod1__t1 mod1 48.4715006715
* device instance mod1_t2 r0 *1 0,0
Rmod1_t2 mod1__t2 mod1 68.3084097196
* device instance mod1_t3 r0 *1 0,0
Rmod1_t3 mod1__t3 mod1 119.650997844
* device instance mod1_t4 r0 *1 0,0
Rmod1_t4 mod1__t4 mod1 77.3667954183
* device instance mod1_t5 r0 *1 0,0
Rmod1_t5 mod1__t5 mod1 87.9893998578
* device instance mod1_t6 r0 *1 0,0
Rmod1_t6 mod1__t6 mod1 99.2759170749
* device instance mod1_t7 r0 *1 0,0
Rmod1_t7 mod1__t7 mod1 58.777237649
* device instance mod1 r0 *1 0,0
Cmod1 mod1 vsubs 1.51979179e-13
* device instance mod2_t0 r0 *1 0,0
Rmod2_t0 mod2__t0 mod2 90.2734970466
* device instance mod2_t1 r0 *1 0,0
Rmod2_t1 mod2__t1 mod2 72.4901155712
* device instance mod2_t2 r0 *1 0,0
Rmod2_t2 mod2__t2 mod2 53.5952727537
* device instance mod2_t3 r0 *1 0,0
Rmod2_t3 mod2__t3 mod2 121.394414628
* device instance mod2_t4 r0 *1 0,0
Rmod2_t4 mod2__t4 mod2 101.986958175
* device instance mod2_t5 r0 *1 0,0
Rmod2_t5 mod2__t5 mod2 81.1183133183
* device instance mod2_t6 r0 *1 0,0
Rmod2_t6 mod2__t6 mod2 91.2364441577
* device instance mod2_t7 r0 *1 0,0
Rmod2_t7 mod2__t7 mod2 63.4115843493
* device instance mod2 r0 *1 0,0
Cmod2 mod2 vsubs 1.5838115e-13
* device instance mod3_t0 r0 *1 0,0
Rmod3_t0 mod3__t0 mod3 58.4704434509
* device instance mod3_t1 r0 *1 0,0
Rmod3_t1 mod3__t1 mod3 76.5755240396
* device instance mod3_t2 r0 *1 0,0
Rmod3_t2 mod3__t2 mod3 93.6155998877
* device instance mod3_t3 r0 *1 0,0
Rmod3_t3 mod3__t3 mod3 123.435732622
* device instance mod3_t4 r0 *1 0,0
Rmod3_t4 mod3__t4 mod3 104.839464502
* device instance mod3_t5 r0 *1 0,0
Rmod3_t5 mod3__t5 mod3 94.5382979603
* device instance mod3_t6 r0 *1 0,0
Rmod3_t6 mod3__t6 mod3 84.8430823915
* device instance mod3_t7 r0 *1 0,0
Rmod3_t7 mod3__t7 mod3 67.8764551462
* device instance mod3 r0 *1 0,0
Cmod3 mod3 vsubs 1.64783121e-13
* device instance mod4_t0 r0 *1 0,0
Rmod4_t0 mod4__t0 mod4 96.9941840369
* device instance mod4_t1 r0 *1 0,0
Rmod4_t1 mod4__t1 mod4 63.1527843763
* device instance mod4_t2 r0 *1 0,0
Rmod4_t2 mod4__t2 mod4 80.5862326863
* device instance mod4_t3 r0 *1 0,0
Rmod4_t3 mod4__t3 mod4 125.7080989
* device instance mod4_t4 r0 *1 0,0
Rmod4_t4 mod4__t4 mod4 97.8826533854
* device instance mod4_t5 r0 *1 0,0
Rmod4_t5 mod4__t5 mod4 88.5470948583
* device instance mod4_t6 r0 *1 0,0
Rmod4_t6 mod4__t6 mod4 107.80168432
* device instance mod4_t7 r0 *1 0,0
Rmod4_t7 mod4__t7 mod4 72.2098674359
* device instance mod4 r0 *1 0,0
Cmod4 mod4 vsubs 1.71183978e-13
* device instance net1_t0 r0 *1 0,0
Rnet1_t0 net1__t0 net1 81.645796476
* device instance net1_t1 r0 *1 0,0
Rnet1_t1 net1__t1 net1 131.261103524
* device instance net1_t2 r0 *1 0,0
Rnet1_t2 net1__t2 net1 120.568149419
* device instance net1_t3 r0 *1 0,0
Rnet1_t3 net1__t3 net1 92.3387505812
* device instance net1 r0 *1 0,0
Cnet1 net1 vsubs 9.8780259e-14
* device instance cc_CKIN_CKIN_VCO r0 *1 0,0
Ccc_CKIN_CKIN_VCO CKIN CKIN_VCO 6.05e-18
* device instance cc_CKIN_DIVOUT r0 *1 0,0
Ccc_CKIN_DIVOUT CKIN DIVOUT 2.4201e-17
* device instance cc_CKIN_FB r0 *1 0,0
Ccc_CKIN_FB CKIN FB 6.05e-18
* device instance cc_CKIN_P0 r0 *1 0,0
Ccc_CKIN_P0 CKIN P0 6.05e-18
* device instance cc_CKIN_P1 r0 *1 0,0
Ccc_CKIN_P1 CKIN P1 6.05e-18
* device instance cc_CKIN_P2 r0 *1 0,0
Ccc_CKIN_P2 CKIN P2 6.05e-18
* device instance cc_CKIN_P3 r0 *1 0,0
Ccc_CKIN_P3 CKIN P3 6.05e-18
* device instance cc_CKIN_P4 r0 *1 0,0
Ccc_CKIN_P4 CKIN P4 6.05e-18
* device instance cc_CKIN_P5 r0 *1 0,0
Ccc_CKIN_P5 CKIN P5 6.05e-18
* device instance cc_CKIN_VDD_DIV r0 *1 0,0
Ccc_CKIN_VDD_DIV CKIN VDD_DIV 1.08905e-16
* device instance cc_CKIN_VSS r0 *1 0,0
Ccc_CKIN_VSS CKIN VSS 7.44181e-16
* device instance cc_CKIN_XD0_XDFFM_CKBB r0 *1 0,0
Ccc_CKIN_XD0_XDFFM_CKBB CKIN XD0_XDFFM_CKBB 1.8151e-17
* device instance cc_CKIN_XD0_XDFFM_CLKB r0 *1 0,0
Ccc_CKIN_XD0_XDFFM_CLKB CKIN XD0_XDFFM_CLKB 2.4201e-17
* device instance cc_CKIN_XD0_XDFFM_M r0 *1 0,0
Ccc_CKIN_XD0_XDFFM_M CKIN XD0_XDFFM_M 2.4201e-17
* device instance cc_CKIN_XD0_XDFFM_MB r0 *1 0,0
Ccc_CKIN_XD0_XDFFM_MB CKIN XD0_XDFFM_MB 1.21e-17
* device instance cc_CKIN_XD0_XDFFM_MFB r0 *1 0,0
Ccc_CKIN_XD0_XDFFM_MFB CKIN XD0_XDFFM_MFB 1.21e-17
* device instance cc_CKIN_XD0_XDFFM_S r0 *1 0,0
Ccc_CKIN_XD0_XDFFM_S CKIN XD0_XDFFM_S 1.8151e-17
* device instance cc_CKIN_XD0_XDFFM_SB r0 *1 0,0
Ccc_CKIN_XD0_XDFFM_SB CKIN XD0_XDFFM_SB 1.8151e-17
* device instance cc_CKIN_XD0_XDFFM_SFB r0 *1 0,0
Ccc_CKIN_XD0_XDFFM_SFB CKIN XD0_XDFFM_SFB 1.21e-17
* device instance cc_CKIN_XD0_XDFFQ_CKBB r0 *1 0,0
Ccc_CKIN_XD0_XDFFQ_CKBB CKIN XD0_XDFFQ_CKBB 3.6302e-17
* device instance cc_CKIN_XD0_XDFFQ_CLKB r0 *1 0,0
Ccc_CKIN_XD0_XDFFQ_CLKB CKIN XD0_XDFFQ_CLKB 4.8402e-17
* device instance cc_CKIN_XD0_XDFFQ_M r0 *1 0,0
Ccc_CKIN_XD0_XDFFQ_M CKIN XD0_XDFFQ_M 4.8402e-17
* device instance cc_CKIN_XD0_XDFFQ_MB r0 *1 0,0
Ccc_CKIN_XD0_XDFFQ_MB CKIN XD0_XDFFQ_MB 2.4201e-17
* device instance cc_CKIN_XD0_XDFFQ_MFB r0 *1 0,0
Ccc_CKIN_XD0_XDFFQ_MFB CKIN XD0_XDFFQ_MFB 2.4201e-17
* device instance cc_CKIN_XD0_XDFFQ_S r0 *1 0,0
Ccc_CKIN_XD0_XDFFQ_S CKIN XD0_XDFFQ_S 3.6302e-17
* device instance cc_CKIN_XD0_XDFFQ_SB r0 *1 0,0
Ccc_CKIN_XD0_XDFFQ_SB CKIN XD0_XDFFQ_SB 3.6302e-17
* device instance cc_CKIN_XD0_XDFFQ_SFB r0 *1 0,0
Ccc_CKIN_XD0_XDFFQ_SFB CKIN XD0_XDFFQ_SFB 2.4201e-17
* device instance cc_CKIN_XD0_XN2_mid1 r0 *1 0,0
Ccc_CKIN_XD0_XN2_mid1 CKIN XD0_XN2_mid1 1.21e-17
* device instance cc_CKIN_XD0_XNOR_midp r0 *1 0,0
Ccc_CKIN_XD0_XNOR_midp CKIN XD0_XNOR_midp 1.21e-17
* device instance cc_CKIN_XD0_dmodout r0 *1 0,0
Ccc_CKIN_XD0_dmodout CKIN XD0_dmodout 1.8151e-17
* device instance cc_CKIN_XD0_dq r0 *1 0,0
Ccc_CKIN_XD0_dq CKIN XD0_dq 1.8151e-17
* device instance cc_CKIN_XD0_nm r0 *1 0,0
Ccc_CKIN_XD0_nm CKIN XD0_nm 3.0251e-17
* device instance cc_CKIN_XD0_nt r0 *1 0,0
Ccc_CKIN_XD0_nt CKIN XD0_nt 2.4201e-17
* device instance cc_CKIN_XD0_t1 r0 *1 0,0
Ccc_CKIN_XD0_t1 CKIN XD0_t1 1.21e-17
* device instance cc_CKIN_XD1_XDFFM_CKBB r0 *1 0,0
Ccc_CKIN_XD1_XDFFM_CKBB CKIN XD1_XDFFM_CKBB 1.8151e-17
* device instance cc_CKIN_XD1_XDFFM_CLKB r0 *1 0,0
Ccc_CKIN_XD1_XDFFM_CLKB CKIN XD1_XDFFM_CLKB 2.4201e-17
* device instance cc_CKIN_XD1_XDFFM_M r0 *1 0,0
Ccc_CKIN_XD1_XDFFM_M CKIN XD1_XDFFM_M 2.4201e-17
* device instance cc_CKIN_XD1_XDFFM_MB r0 *1 0,0
Ccc_CKIN_XD1_XDFFM_MB CKIN XD1_XDFFM_MB 1.21e-17
* device instance cc_CKIN_XD1_XDFFM_MFB r0 *1 0,0
Ccc_CKIN_XD1_XDFFM_MFB CKIN XD1_XDFFM_MFB 1.21e-17
* device instance cc_CKIN_XD1_XDFFM_S r0 *1 0,0
Ccc_CKIN_XD1_XDFFM_S CKIN XD1_XDFFM_S 1.8151e-17
* device instance cc_CKIN_XD1_XDFFM_SB r0 *1 0,0
Ccc_CKIN_XD1_XDFFM_SB CKIN XD1_XDFFM_SB 1.8151e-17
* device instance cc_CKIN_XD1_XDFFM_SFB r0 *1 0,0
Ccc_CKIN_XD1_XDFFM_SFB CKIN XD1_XDFFM_SFB 1.21e-17
* device instance cc_CKIN_XD1_XDFFQ_CKBB r0 *1 0,0
Ccc_CKIN_XD1_XDFFQ_CKBB CKIN XD1_XDFFQ_CKBB 1.8151e-17
* device instance cc_CKIN_XD1_XDFFQ_CLKB r0 *1 0,0
Ccc_CKIN_XD1_XDFFQ_CLKB CKIN XD1_XDFFQ_CLKB 2.4201e-17
* device instance cc_CKIN_XD1_XDFFQ_M r0 *1 0,0
Ccc_CKIN_XD1_XDFFQ_M CKIN XD1_XDFFQ_M 2.4201e-17
* device instance cc_CKIN_XD1_XDFFQ_MB r0 *1 0,0
Ccc_CKIN_XD1_XDFFQ_MB CKIN XD1_XDFFQ_MB 1.21e-17
* device instance cc_CKIN_XD1_XDFFQ_MFB r0 *1 0,0
Ccc_CKIN_XD1_XDFFQ_MFB CKIN XD1_XDFFQ_MFB 1.21e-17
* device instance cc_CKIN_XD1_XDFFQ_S r0 *1 0,0
Ccc_CKIN_XD1_XDFFQ_S CKIN XD1_XDFFQ_S 1.8151e-17
* device instance cc_CKIN_XD1_XDFFQ_SB r0 *1 0,0
Ccc_CKIN_XD1_XDFFQ_SB CKIN XD1_XDFFQ_SB 1.8151e-17
* device instance cc_CKIN_XD1_XDFFQ_SFB r0 *1 0,0
Ccc_CKIN_XD1_XDFFQ_SFB CKIN XD1_XDFFQ_SFB 1.21e-17
* device instance cc_CKIN_XD1_XN2_mid1 r0 *1 0,0
Ccc_CKIN_XD1_XN2_mid1 CKIN XD1_XN2_mid1 1.21e-17
* device instance cc_CKIN_XD1_XN3_mid1 r0 *1 0,0
Ccc_CKIN_XD1_XN3_mid1 CKIN XD1_XN3_mid1 1.21e-17
* device instance cc_CKIN_XD1_XN3_mid2 r0 *1 0,0
Ccc_CKIN_XD1_XN3_mid2 CKIN XD1_XN3_mid2 1.21e-17
* device instance cc_CKIN_XD1_dmodout r0 *1 0,0
Ccc_CKIN_XD1_dmodout CKIN XD1_dmodout 1.21e-17
* device instance cc_CKIN_XD1_dq r0 *1 0,0
Ccc_CKIN_XD1_dq CKIN XD1_dq 1.8151e-17
* device instance cc_CKIN_XD1_nm r0 *1 0,0
Ccc_CKIN_XD1_nm CKIN XD1_nm 1.21e-17
* device instance cc_CKIN_XD1_nt r0 *1 0,0
Ccc_CKIN_XD1_nt CKIN XD1_nt 1.21e-17
* device instance cc_CKIN_XD1_t1 r0 *1 0,0
Ccc_CKIN_XD1_t1 CKIN XD1_t1 1.21e-17
* device instance cc_CKIN_XD2_XDFFM_CKBB r0 *1 0,0
Ccc_CKIN_XD2_XDFFM_CKBB CKIN XD2_XDFFM_CKBB 1.8151e-17
* device instance cc_CKIN_XD2_XDFFM_CLKB r0 *1 0,0
Ccc_CKIN_XD2_XDFFM_CLKB CKIN XD2_XDFFM_CLKB 2.4201e-17
* device instance cc_CKIN_XD2_XDFFM_M r0 *1 0,0
Ccc_CKIN_XD2_XDFFM_M CKIN XD2_XDFFM_M 2.4201e-17
* device instance cc_CKIN_XD2_XDFFM_MB r0 *1 0,0
Ccc_CKIN_XD2_XDFFM_MB CKIN XD2_XDFFM_MB 1.21e-17
* device instance cc_CKIN_XD2_XDFFM_MFB r0 *1 0,0
Ccc_CKIN_XD2_XDFFM_MFB CKIN XD2_XDFFM_MFB 1.21e-17
* device instance cc_CKIN_XD2_XDFFM_S r0 *1 0,0
Ccc_CKIN_XD2_XDFFM_S CKIN XD2_XDFFM_S 1.8151e-17
* device instance cc_CKIN_XD2_XDFFM_SB r0 *1 0,0
Ccc_CKIN_XD2_XDFFM_SB CKIN XD2_XDFFM_SB 1.8151e-17
* device instance cc_CKIN_XD2_XDFFM_SFB r0 *1 0,0
Ccc_CKIN_XD2_XDFFM_SFB CKIN XD2_XDFFM_SFB 1.21e-17
* device instance cc_CKIN_XD2_XDFFQ_CKBB r0 *1 0,0
Ccc_CKIN_XD2_XDFFQ_CKBB CKIN XD2_XDFFQ_CKBB 1.8151e-17
* device instance cc_CKIN_XD2_XDFFQ_CLKB r0 *1 0,0
Ccc_CKIN_XD2_XDFFQ_CLKB CKIN XD2_XDFFQ_CLKB 2.4201e-17
* device instance cc_CKIN_XD2_XDFFQ_M r0 *1 0,0
Ccc_CKIN_XD2_XDFFQ_M CKIN XD2_XDFFQ_M 2.4201e-17
* device instance cc_CKIN_XD2_XDFFQ_MB r0 *1 0,0
Ccc_CKIN_XD2_XDFFQ_MB CKIN XD2_XDFFQ_MB 1.21e-17
* device instance cc_CKIN_XD2_XDFFQ_MFB r0 *1 0,0
Ccc_CKIN_XD2_XDFFQ_MFB CKIN XD2_XDFFQ_MFB 1.21e-17
* device instance cc_CKIN_XD2_XDFFQ_S r0 *1 0,0
Ccc_CKIN_XD2_XDFFQ_S CKIN XD2_XDFFQ_S 1.8151e-17
* device instance cc_CKIN_XD2_XDFFQ_SB r0 *1 0,0
Ccc_CKIN_XD2_XDFFQ_SB CKIN XD2_XDFFQ_SB 1.8151e-17
* device instance cc_CKIN_XD2_XDFFQ_SFB r0 *1 0,0
Ccc_CKIN_XD2_XDFFQ_SFB CKIN XD2_XDFFQ_SFB 1.21e-17
* device instance cc_CKIN_XD2_XN2_mid1 r0 *1 0,0
Ccc_CKIN_XD2_XN2_mid1 CKIN XD2_XN2_mid1 1.21e-17
* device instance cc_CKIN_XD2_XN3_mid1 r0 *1 0,0
Ccc_CKIN_XD2_XN3_mid1 CKIN XD2_XN3_mid1 1.21e-17
* device instance cc_CKIN_XD2_XN3_mid2 r0 *1 0,0
Ccc_CKIN_XD2_XN3_mid2 CKIN XD2_XN3_mid2 1.21e-17
* device instance cc_CKIN_XD2_dmodout r0 *1 0,0
Ccc_CKIN_XD2_dmodout CKIN XD2_dmodout 1.21e-17
* device instance cc_CKIN_XD2_dq r0 *1 0,0
Ccc_CKIN_XD2_dq CKIN XD2_dq 1.8151e-17
* device instance cc_CKIN_XD2_nm r0 *1 0,0
Ccc_CKIN_XD2_nm CKIN XD2_nm 1.21e-17
* device instance cc_CKIN_XD2_nt r0 *1 0,0
Ccc_CKIN_XD2_nt CKIN XD2_nt 1.21e-17
* device instance cc_CKIN_XD2_t1 r0 *1 0,0
Ccc_CKIN_XD2_t1 CKIN XD2_t1 1.21e-17
* device instance cc_CKIN_XD3_XDFFM_CKBB r0 *1 0,0
Ccc_CKIN_XD3_XDFFM_CKBB CKIN XD3_XDFFM_CKBB 1.8151e-17
* device instance cc_CKIN_XD3_XDFFM_CLKB r0 *1 0,0
Ccc_CKIN_XD3_XDFFM_CLKB CKIN XD3_XDFFM_CLKB 2.4201e-17
* device instance cc_CKIN_XD3_XDFFM_M r0 *1 0,0
Ccc_CKIN_XD3_XDFFM_M CKIN XD3_XDFFM_M 2.4201e-17
* device instance cc_CKIN_XD3_XDFFM_MB r0 *1 0,0
Ccc_CKIN_XD3_XDFFM_MB CKIN XD3_XDFFM_MB 1.21e-17
* device instance cc_CKIN_XD3_XDFFM_MFB r0 *1 0,0
Ccc_CKIN_XD3_XDFFM_MFB CKIN XD3_XDFFM_MFB 1.21e-17
* device instance cc_CKIN_XD3_XDFFM_S r0 *1 0,0
Ccc_CKIN_XD3_XDFFM_S CKIN XD3_XDFFM_S 1.8151e-17
* device instance cc_CKIN_XD3_XDFFM_SB r0 *1 0,0
Ccc_CKIN_XD3_XDFFM_SB CKIN XD3_XDFFM_SB 1.8151e-17
* device instance cc_CKIN_XD3_XDFFM_SFB r0 *1 0,0
Ccc_CKIN_XD3_XDFFM_SFB CKIN XD3_XDFFM_SFB 1.21e-17
* device instance cc_CKIN_XD3_XDFFQ_CKBB r0 *1 0,0
Ccc_CKIN_XD3_XDFFQ_CKBB CKIN XD3_XDFFQ_CKBB 1.8151e-17
* device instance cc_CKIN_XD3_XDFFQ_CLKB r0 *1 0,0
Ccc_CKIN_XD3_XDFFQ_CLKB CKIN XD3_XDFFQ_CLKB 2.4201e-17
* device instance cc_CKIN_XD3_XDFFQ_M r0 *1 0,0
Ccc_CKIN_XD3_XDFFQ_M CKIN XD3_XDFFQ_M 2.4201e-17
* device instance cc_CKIN_XD3_XDFFQ_MB r0 *1 0,0
Ccc_CKIN_XD3_XDFFQ_MB CKIN XD3_XDFFQ_MB 1.21e-17
* device instance cc_CKIN_XD3_XDFFQ_MFB r0 *1 0,0
Ccc_CKIN_XD3_XDFFQ_MFB CKIN XD3_XDFFQ_MFB 1.21e-17
* device instance cc_CKIN_XD3_XDFFQ_S r0 *1 0,0
Ccc_CKIN_XD3_XDFFQ_S CKIN XD3_XDFFQ_S 1.8151e-17
* device instance cc_CKIN_XD3_XDFFQ_SB r0 *1 0,0
Ccc_CKIN_XD3_XDFFQ_SB CKIN XD3_XDFFQ_SB 1.8151e-17
* device instance cc_CKIN_XD3_XDFFQ_SFB r0 *1 0,0
Ccc_CKIN_XD3_XDFFQ_SFB CKIN XD3_XDFFQ_SFB 1.21e-17
* device instance cc_CKIN_XD3_XN2_mid1 r0 *1 0,0
Ccc_CKIN_XD3_XN2_mid1 CKIN XD3_XN2_mid1 1.21e-17
* device instance cc_CKIN_XD3_XN3_mid1 r0 *1 0,0
Ccc_CKIN_XD3_XN3_mid1 CKIN XD3_XN3_mid1 1.21e-17
* device instance cc_CKIN_XD3_XN3_mid2 r0 *1 0,0
Ccc_CKIN_XD3_XN3_mid2 CKIN XD3_XN3_mid2 1.21e-17
* device instance cc_CKIN_XD3_dmodout r0 *1 0,0
Ccc_CKIN_XD3_dmodout CKIN XD3_dmodout 1.21e-17
* device instance cc_CKIN_XD3_dq r0 *1 0,0
Ccc_CKIN_XD3_dq CKIN XD3_dq 1.8151e-17
* device instance cc_CKIN_XD3_nm r0 *1 0,0
Ccc_CKIN_XD3_nm CKIN XD3_nm 1.21e-17
* device instance cc_CKIN_XD3_nt r0 *1 0,0
Ccc_CKIN_XD3_nt CKIN XD3_nt 1.21e-17
* device instance cc_CKIN_XD3_t1 r0 *1 0,0
Ccc_CKIN_XD3_t1 CKIN XD3_t1 1.21e-17
* device instance cc_CKIN_XD4_XDFFM_CKBB r0 *1 0,0
Ccc_CKIN_XD4_XDFFM_CKBB CKIN XD4_XDFFM_CKBB 1.8151e-17
* device instance cc_CKIN_XD4_XDFFM_CLKB r0 *1 0,0
Ccc_CKIN_XD4_XDFFM_CLKB CKIN XD4_XDFFM_CLKB 2.4201e-17
* device instance cc_CKIN_XD4_XDFFM_M r0 *1 0,0
Ccc_CKIN_XD4_XDFFM_M CKIN XD4_XDFFM_M 2.4201e-17
* device instance cc_CKIN_XD4_XDFFM_MB r0 *1 0,0
Ccc_CKIN_XD4_XDFFM_MB CKIN XD4_XDFFM_MB 1.21e-17
* device instance cc_CKIN_XD4_XDFFM_MFB r0 *1 0,0
Ccc_CKIN_XD4_XDFFM_MFB CKIN XD4_XDFFM_MFB 1.21e-17
* device instance cc_CKIN_XD4_XDFFM_S r0 *1 0,0
Ccc_CKIN_XD4_XDFFM_S CKIN XD4_XDFFM_S 1.8151e-17
* device instance cc_CKIN_XD4_XDFFM_SB r0 *1 0,0
Ccc_CKIN_XD4_XDFFM_SB CKIN XD4_XDFFM_SB 1.8151e-17
* device instance cc_CKIN_XD4_XDFFM_SFB r0 *1 0,0
Ccc_CKIN_XD4_XDFFM_SFB CKIN XD4_XDFFM_SFB 1.21e-17
* device instance cc_CKIN_XD4_XDFFQ_CKBB r0 *1 0,0
Ccc_CKIN_XD4_XDFFQ_CKBB CKIN XD4_XDFFQ_CKBB 1.8151e-17
* device instance cc_CKIN_XD4_XDFFQ_CLKB r0 *1 0,0
Ccc_CKIN_XD4_XDFFQ_CLKB CKIN XD4_XDFFQ_CLKB 2.4201e-17
* device instance cc_CKIN_XD4_XDFFQ_M r0 *1 0,0
Ccc_CKIN_XD4_XDFFQ_M CKIN XD4_XDFFQ_M 2.4201e-17
* device instance cc_CKIN_XD4_XDFFQ_MB r0 *1 0,0
Ccc_CKIN_XD4_XDFFQ_MB CKIN XD4_XDFFQ_MB 1.21e-17
* device instance cc_CKIN_XD4_XDFFQ_MFB r0 *1 0,0
Ccc_CKIN_XD4_XDFFQ_MFB CKIN XD4_XDFFQ_MFB 1.21e-17
* device instance cc_CKIN_XD4_XDFFQ_S r0 *1 0,0
Ccc_CKIN_XD4_XDFFQ_S CKIN XD4_XDFFQ_S 1.8151e-17
* device instance cc_CKIN_XD4_XDFFQ_SB r0 *1 0,0
Ccc_CKIN_XD4_XDFFQ_SB CKIN XD4_XDFFQ_SB 1.8151e-17
* device instance cc_CKIN_XD4_XDFFQ_SFB r0 *1 0,0
Ccc_CKIN_XD4_XDFFQ_SFB CKIN XD4_XDFFQ_SFB 1.21e-17
* device instance cc_CKIN_XD4_XN2_mid1 r0 *1 0,0
Ccc_CKIN_XD4_XN2_mid1 CKIN XD4_XN2_mid1 1.21e-17
* device instance cc_CKIN_XD4_XN3_mid1 r0 *1 0,0
Ccc_CKIN_XD4_XN3_mid1 CKIN XD4_XN3_mid1 1.21e-17
* device instance cc_CKIN_XD4_XN3_mid2 r0 *1 0,0
Ccc_CKIN_XD4_XN3_mid2 CKIN XD4_XN3_mid2 1.21e-17
* device instance cc_CKIN_XD4_dmodout r0 *1 0,0
Ccc_CKIN_XD4_dmodout CKIN XD4_dmodout 1.21e-17
* device instance cc_CKIN_XD4_dq r0 *1 0,0
Ccc_CKIN_XD4_dq CKIN XD4_dq 1.8151e-17
* device instance cc_CKIN_XD4_nm r0 *1 0,0
Ccc_CKIN_XD4_nm CKIN XD4_nm 1.21e-17
* device instance cc_CKIN_XD4_nt r0 *1 0,0
Ccc_CKIN_XD4_nt CKIN XD4_nt 1.21e-17
* device instance cc_CKIN_XD4_t1 r0 *1 0,0
Ccc_CKIN_XD4_t1 CKIN XD4_t1 1.21e-17
* device instance cc_CKIN_XD5_XDFFM_CKBB r0 *1 0,0
Ccc_CKIN_XD5_XDFFM_CKBB CKIN XD5_XDFFM_CKBB 1.8151e-17
* device instance cc_CKIN_XD5_XDFFM_CLKB r0 *1 0,0
Ccc_CKIN_XD5_XDFFM_CLKB CKIN XD5_XDFFM_CLKB 2.4201e-17
* device instance cc_CKIN_XD5_XDFFM_M r0 *1 0,0
Ccc_CKIN_XD5_XDFFM_M CKIN XD5_XDFFM_M 2.4201e-17
* device instance cc_CKIN_XD5_XDFFM_MB r0 *1 0,0
Ccc_CKIN_XD5_XDFFM_MB CKIN XD5_XDFFM_MB 1.21e-17
* device instance cc_CKIN_XD5_XDFFM_MFB r0 *1 0,0
Ccc_CKIN_XD5_XDFFM_MFB CKIN XD5_XDFFM_MFB 1.21e-17
* device instance cc_CKIN_XD5_XDFFM_S r0 *1 0,0
Ccc_CKIN_XD5_XDFFM_S CKIN XD5_XDFFM_S 1.8151e-17
* device instance cc_CKIN_XD5_XDFFM_SB r0 *1 0,0
Ccc_CKIN_XD5_XDFFM_SB CKIN XD5_XDFFM_SB 1.8151e-17
* device instance cc_CKIN_XD5_XDFFM_SFB r0 *1 0,0
Ccc_CKIN_XD5_XDFFM_SFB CKIN XD5_XDFFM_SFB 1.21e-17
* device instance cc_CKIN_XD5_XDFFQ_CKBB r0 *1 0,0
Ccc_CKIN_XD5_XDFFQ_CKBB CKIN XD5_XDFFQ_CKBB 1.8151e-17
* device instance cc_CKIN_XD5_XDFFQ_CLKB r0 *1 0,0
Ccc_CKIN_XD5_XDFFQ_CLKB CKIN XD5_XDFFQ_CLKB 2.4201e-17
* device instance cc_CKIN_XD5_XDFFQ_M r0 *1 0,0
Ccc_CKIN_XD5_XDFFQ_M CKIN XD5_XDFFQ_M 2.4201e-17
* device instance cc_CKIN_XD5_XDFFQ_MB r0 *1 0,0
Ccc_CKIN_XD5_XDFFQ_MB CKIN XD5_XDFFQ_MB 1.21e-17
* device instance cc_CKIN_XD5_XDFFQ_MFB r0 *1 0,0
Ccc_CKIN_XD5_XDFFQ_MFB CKIN XD5_XDFFQ_MFB 1.21e-17
* device instance cc_CKIN_XD5_XDFFQ_S r0 *1 0,0
Ccc_CKIN_XD5_XDFFQ_S CKIN XD5_XDFFQ_S 1.8151e-17
* device instance cc_CKIN_XD5_XDFFQ_SB r0 *1 0,0
Ccc_CKIN_XD5_XDFFQ_SB CKIN XD5_XDFFQ_SB 1.8151e-17
* device instance cc_CKIN_XD5_XDFFQ_SFB r0 *1 0,0
Ccc_CKIN_XD5_XDFFQ_SFB CKIN XD5_XDFFQ_SFB 1.21e-17
* device instance cc_CKIN_XD5_XN2_mid1 r0 *1 0,0
Ccc_CKIN_XD5_XN2_mid1 CKIN XD5_XN2_mid1 1.21e-17
* device instance cc_CKIN_XD5_XN3_mid1 r0 *1 0,0
Ccc_CKIN_XD5_XN3_mid1 CKIN XD5_XN3_mid1 1.21e-17
* device instance cc_CKIN_XD5_XN3_mid2 r0 *1 0,0
Ccc_CKIN_XD5_XN3_mid2 CKIN XD5_XN3_mid2 1.21e-17
* device instance cc_CKIN_XD5_dmodout r0 *1 0,0
Ccc_CKIN_XD5_dmodout CKIN XD5_dmodout 1.21e-17
* device instance cc_CKIN_XD5_dq r0 *1 0,0
Ccc_CKIN_XD5_dq CKIN XD5_dq 1.8151e-17
* device instance cc_CKIN_XD5_nm r0 *1 0,0
Ccc_CKIN_XD5_nm CKIN XD5_nm 1.21e-17
* device instance cc_CKIN_XD5_nt r0 *1 0,0
Ccc_CKIN_XD5_nt CKIN XD5_nt 1.21e-17
* device instance cc_CKIN_XD5_t1 r0 *1 0,0
Ccc_CKIN_XD5_t1 CKIN XD5_t1 1.21e-17
* device instance cc_CKIN_XFRT_CKBB r0 *1 0,0
Ccc_CKIN_XFRT_CKBB CKIN XFRT_CKBB 1.8151e-17
* device instance cc_CKIN_XFRT_CLKB r0 *1 0,0
Ccc_CKIN_XFRT_CLKB CKIN XFRT_CLKB 2.4201e-17
* device instance cc_CKIN_XFRT_M r0 *1 0,0
Ccc_CKIN_XFRT_M CKIN XFRT_M 2.4201e-17
* device instance cc_CKIN_XFRT_MB r0 *1 0,0
Ccc_CKIN_XFRT_MB CKIN XFRT_MB 1.21e-17
* device instance cc_CKIN_XFRT_MFB r0 *1 0,0
Ccc_CKIN_XFRT_MFB CKIN XFRT_MFB 1.21e-17
* device instance cc_CKIN_XFRT_S r0 *1 0,0
Ccc_CKIN_XFRT_S CKIN XFRT_S 1.8151e-17
* device instance cc_CKIN_XFRT_SB r0 *1 0,0
Ccc_CKIN_XFRT_SB CKIN XFRT_SB 1.8151e-17
* device instance cc_CKIN_XFRT_SFB r0 *1 0,0
Ccc_CKIN_XFRT_SFB CKIN XFRT_SFB 1.21e-17
* device instance cc_CKIN_ck1 r0 *1 0,0
Ccc_CKIN_ck1 CKIN ck1 4.2352e-17
* device instance cc_CKIN_ck2 r0 *1 0,0
Ccc_CKIN_ck2 CKIN ck2 3.0251e-17
* device instance cc_CKIN_ck3 r0 *1 0,0
Ccc_CKIN_ck3 CKIN ck3 3.0251e-17
* device instance cc_CKIN_ck4 r0 *1 0,0
Ccc_CKIN_ck4 CKIN ck4 3.0251e-17
* device instance cc_CKIN_ck5 r0 *1 0,0
Ccc_CKIN_ck5 CKIN ck5 3.0251e-17
* device instance cc_CKIN_mod0 r0 *1 0,0
Ccc_CKIN_mod0 CKIN mod0 3.0251e-17
* device instance cc_CKIN_mod1 r0 *1 0,0
Ccc_CKIN_mod1 CKIN mod1 2.4201e-17
* device instance cc_CKIN_mod2 r0 *1 0,0
Ccc_CKIN_mod2 CKIN mod2 2.4201e-17
* device instance cc_CKIN_mod3 r0 *1 0,0
Ccc_CKIN_mod3 CKIN mod3 2.4201e-17
* device instance cc_CKIN_mod4 r0 *1 0,0
Ccc_CKIN_mod4 CKIN mod4 2.4201e-17
* device instance cc_CKIN_net1 r0 *1 0,0
Ccc_CKIN_net1 CKIN net1 1.21e-17
* device instance cc_CKIN_VCO_DIVOUT r0 *1 0,0
Ccc_CKIN_VCO_DIVOUT CKIN_VCO DIVOUT 2.4201e-17
* device instance cc_CKIN_VCO_FB r0 *1 0,0
Ccc_CKIN_VCO_FB CKIN_VCO FB 6.05e-18
* device instance cc_CKIN_VCO_P0 r0 *1 0,0
Ccc_CKIN_VCO_P0 CKIN_VCO P0 6.05e-18
* device instance cc_CKIN_VCO_P1 r0 *1 0,0
Ccc_CKIN_VCO_P1 CKIN_VCO P1 6.05e-18
* device instance cc_CKIN_VCO_P2 r0 *1 0,0
Ccc_CKIN_VCO_P2 CKIN_VCO P2 6.05e-18
* device instance cc_CKIN_VCO_P3 r0 *1 0,0
Ccc_CKIN_VCO_P3 CKIN_VCO P3 6.05e-18
* device instance cc_CKIN_VCO_P4 r0 *1 0,0
Ccc_CKIN_VCO_P4 CKIN_VCO P4 6.05e-18
* device instance cc_CKIN_VCO_P5 r0 *1 0,0
Ccc_CKIN_VCO_P5 CKIN_VCO P5 6.05e-18
* device instance cc_CKIN_VCO_VDD_DIV r0 *1 0,0
Ccc_CKIN_VCO_VDD_DIV CKIN_VCO VDD_DIV 8.16784e-16
* device instance cc_CKIN_VCO_VSS r0 *1 0,0
Ccc_CKIN_VCO_VSS CKIN_VCO VSS 4.2352e-17
* device instance cc_CKIN_VCO_XD0_XDFFM_CKBB r0 *1 0,0
Ccc_CKIN_VCO_XD0_XDFFM_CKBB CKIN_VCO XD0_XDFFM_CKBB 1.8151e-17
* device instance cc_CKIN_VCO_XD0_XDFFM_CLKB r0 *1 0,0
Ccc_CKIN_VCO_XD0_XDFFM_CLKB CKIN_VCO XD0_XDFFM_CLKB 2.4201e-17
* device instance cc_CKIN_VCO_XD0_XDFFM_M r0 *1 0,0
Ccc_CKIN_VCO_XD0_XDFFM_M CKIN_VCO XD0_XDFFM_M 2.4201e-17
* device instance cc_CKIN_VCO_XD0_XDFFM_MB r0 *1 0,0
Ccc_CKIN_VCO_XD0_XDFFM_MB CKIN_VCO XD0_XDFFM_MB 1.21e-17
* device instance cc_CKIN_VCO_XD0_XDFFM_MFB r0 *1 0,0
Ccc_CKIN_VCO_XD0_XDFFM_MFB CKIN_VCO XD0_XDFFM_MFB 1.21e-17
* device instance cc_CKIN_VCO_XD0_XDFFM_S r0 *1 0,0
Ccc_CKIN_VCO_XD0_XDFFM_S CKIN_VCO XD0_XDFFM_S 1.8151e-17
* device instance cc_CKIN_VCO_XD0_XDFFM_SB r0 *1 0,0
Ccc_CKIN_VCO_XD0_XDFFM_SB CKIN_VCO XD0_XDFFM_SB 1.8151e-17
* device instance cc_CKIN_VCO_XD0_XDFFM_SFB r0 *1 0,0
Ccc_CKIN_VCO_XD0_XDFFM_SFB CKIN_VCO XD0_XDFFM_SFB 1.21e-17
* device instance cc_CKIN_VCO_XD0_XDFFQ_CKBB r0 *1 0,0
Ccc_CKIN_VCO_XD0_XDFFQ_CKBB CKIN_VCO XD0_XDFFQ_CKBB 1.8151e-17
* device instance cc_CKIN_VCO_XD0_XDFFQ_CLKB r0 *1 0,0
Ccc_CKIN_VCO_XD0_XDFFQ_CLKB CKIN_VCO XD0_XDFFQ_CLKB 2.4201e-17
* device instance cc_CKIN_VCO_XD0_XDFFQ_M r0 *1 0,0
Ccc_CKIN_VCO_XD0_XDFFQ_M CKIN_VCO XD0_XDFFQ_M 2.4201e-17
* device instance cc_CKIN_VCO_XD0_XDFFQ_MB r0 *1 0,0
Ccc_CKIN_VCO_XD0_XDFFQ_MB CKIN_VCO XD0_XDFFQ_MB 1.21e-17
* device instance cc_CKIN_VCO_XD0_XDFFQ_MFB r0 *1 0,0
Ccc_CKIN_VCO_XD0_XDFFQ_MFB CKIN_VCO XD0_XDFFQ_MFB 1.21e-17
* device instance cc_CKIN_VCO_XD0_XDFFQ_S r0 *1 0,0
Ccc_CKIN_VCO_XD0_XDFFQ_S CKIN_VCO XD0_XDFFQ_S 1.8151e-17
* device instance cc_CKIN_VCO_XD0_XDFFQ_SB r0 *1 0,0
Ccc_CKIN_VCO_XD0_XDFFQ_SB CKIN_VCO XD0_XDFFQ_SB 1.8151e-17
* device instance cc_CKIN_VCO_XD0_XDFFQ_SFB r0 *1 0,0
Ccc_CKIN_VCO_XD0_XDFFQ_SFB CKIN_VCO XD0_XDFFQ_SFB 1.21e-17
* device instance cc_CKIN_VCO_XD0_XNOR_midp r0 *1 0,0
Ccc_CKIN_VCO_XD0_XNOR_midp CKIN_VCO XD0_XNOR_midp 1.21e-17
* device instance cc_CKIN_VCO_XD0_dmodout r0 *1 0,0
Ccc_CKIN_VCO_XD0_dmodout CKIN_VCO XD0_dmodout 1.21e-17
* device instance cc_CKIN_VCO_XD0_dq r0 *1 0,0
Ccc_CKIN_VCO_XD0_dq CKIN_VCO XD0_dq 1.21e-17
* device instance cc_CKIN_VCO_XD0_nm r0 *1 0,0
Ccc_CKIN_VCO_XD0_nm CKIN_VCO XD0_nm 1.8151e-17
* device instance cc_CKIN_VCO_XD0_nt r0 *1 0,0
Ccc_CKIN_VCO_XD0_nt CKIN_VCO XD0_nt 2.4201e-17
* device instance cc_CKIN_VCO_XD0_t1 r0 *1 0,0
Ccc_CKIN_VCO_XD0_t1 CKIN_VCO XD0_t1 1.21e-17
* device instance cc_CKIN_VCO_XD1_XDFFM_CKBB r0 *1 0,0
Ccc_CKIN_VCO_XD1_XDFFM_CKBB CKIN_VCO XD1_XDFFM_CKBB 1.8151e-17
* device instance cc_CKIN_VCO_XD1_XDFFM_CLKB r0 *1 0,0
Ccc_CKIN_VCO_XD1_XDFFM_CLKB CKIN_VCO XD1_XDFFM_CLKB 2.4201e-17
* device instance cc_CKIN_VCO_XD1_XDFFM_M r0 *1 0,0
Ccc_CKIN_VCO_XD1_XDFFM_M CKIN_VCO XD1_XDFFM_M 2.4201e-17
* device instance cc_CKIN_VCO_XD1_XDFFM_MB r0 *1 0,0
Ccc_CKIN_VCO_XD1_XDFFM_MB CKIN_VCO XD1_XDFFM_MB 1.21e-17
* device instance cc_CKIN_VCO_XD1_XDFFM_MFB r0 *1 0,0
Ccc_CKIN_VCO_XD1_XDFFM_MFB CKIN_VCO XD1_XDFFM_MFB 1.21e-17
* device instance cc_CKIN_VCO_XD1_XDFFM_S r0 *1 0,0
Ccc_CKIN_VCO_XD1_XDFFM_S CKIN_VCO XD1_XDFFM_S 1.8151e-17
* device instance cc_CKIN_VCO_XD1_XDFFM_SB r0 *1 0,0
Ccc_CKIN_VCO_XD1_XDFFM_SB CKIN_VCO XD1_XDFFM_SB 1.8151e-17
* device instance cc_CKIN_VCO_XD1_XDFFM_SFB r0 *1 0,0
Ccc_CKIN_VCO_XD1_XDFFM_SFB CKIN_VCO XD1_XDFFM_SFB 1.21e-17
* device instance cc_CKIN_VCO_XD1_XDFFQ_CKBB r0 *1 0,0
Ccc_CKIN_VCO_XD1_XDFFQ_CKBB CKIN_VCO XD1_XDFFQ_CKBB 1.8151e-17
* device instance cc_CKIN_VCO_XD1_XDFFQ_CLKB r0 *1 0,0
Ccc_CKIN_VCO_XD1_XDFFQ_CLKB CKIN_VCO XD1_XDFFQ_CLKB 2.4201e-17
* device instance cc_CKIN_VCO_XD1_XDFFQ_M r0 *1 0,0
Ccc_CKIN_VCO_XD1_XDFFQ_M CKIN_VCO XD1_XDFFQ_M 2.4201e-17
* device instance cc_CKIN_VCO_XD1_XDFFQ_MB r0 *1 0,0
Ccc_CKIN_VCO_XD1_XDFFQ_MB CKIN_VCO XD1_XDFFQ_MB 1.21e-17
* device instance cc_CKIN_VCO_XD1_XDFFQ_MFB r0 *1 0,0
Ccc_CKIN_VCO_XD1_XDFFQ_MFB CKIN_VCO XD1_XDFFQ_MFB 1.21e-17
* device instance cc_CKIN_VCO_XD1_XDFFQ_S r0 *1 0,0
Ccc_CKIN_VCO_XD1_XDFFQ_S CKIN_VCO XD1_XDFFQ_S 1.8151e-17
* device instance cc_CKIN_VCO_XD1_XDFFQ_SB r0 *1 0,0
Ccc_CKIN_VCO_XD1_XDFFQ_SB CKIN_VCO XD1_XDFFQ_SB 1.8151e-17
* device instance cc_CKIN_VCO_XD1_XDFFQ_SFB r0 *1 0,0
Ccc_CKIN_VCO_XD1_XDFFQ_SFB CKIN_VCO XD1_XDFFQ_SFB 1.21e-17
* device instance cc_CKIN_VCO_XD1_XNOR_midp r0 *1 0,0
Ccc_CKIN_VCO_XD1_XNOR_midp CKIN_VCO XD1_XNOR_midp 1.21e-17
* device instance cc_CKIN_VCO_XD1_dmodout r0 *1 0,0
Ccc_CKIN_VCO_XD1_dmodout CKIN_VCO XD1_dmodout 1.21e-17
* device instance cc_CKIN_VCO_XD1_dq r0 *1 0,0
Ccc_CKIN_VCO_XD1_dq CKIN_VCO XD1_dq 1.21e-17
* device instance cc_CKIN_VCO_XD1_nm r0 *1 0,0
Ccc_CKIN_VCO_XD1_nm CKIN_VCO XD1_nm 1.8151e-17
* device instance cc_CKIN_VCO_XD1_nt r0 *1 0,0
Ccc_CKIN_VCO_XD1_nt CKIN_VCO XD1_nt 2.4201e-17
* device instance cc_CKIN_VCO_XD1_t1 r0 *1 0,0
Ccc_CKIN_VCO_XD1_t1 CKIN_VCO XD1_t1 1.21e-17
* device instance cc_CKIN_VCO_XD2_XDFFM_CKBB r0 *1 0,0
Ccc_CKIN_VCO_XD2_XDFFM_CKBB CKIN_VCO XD2_XDFFM_CKBB 1.8151e-17
* device instance cc_CKIN_VCO_XD2_XDFFM_CLKB r0 *1 0,0
Ccc_CKIN_VCO_XD2_XDFFM_CLKB CKIN_VCO XD2_XDFFM_CLKB 2.4201e-17
* device instance cc_CKIN_VCO_XD2_XDFFM_M r0 *1 0,0
Ccc_CKIN_VCO_XD2_XDFFM_M CKIN_VCO XD2_XDFFM_M 2.4201e-17
* device instance cc_CKIN_VCO_XD2_XDFFM_MB r0 *1 0,0
Ccc_CKIN_VCO_XD2_XDFFM_MB CKIN_VCO XD2_XDFFM_MB 1.21e-17
* device instance cc_CKIN_VCO_XD2_XDFFM_MFB r0 *1 0,0
Ccc_CKIN_VCO_XD2_XDFFM_MFB CKIN_VCO XD2_XDFFM_MFB 1.21e-17
* device instance cc_CKIN_VCO_XD2_XDFFM_S r0 *1 0,0
Ccc_CKIN_VCO_XD2_XDFFM_S CKIN_VCO XD2_XDFFM_S 1.8151e-17
* device instance cc_CKIN_VCO_XD2_XDFFM_SB r0 *1 0,0
Ccc_CKIN_VCO_XD2_XDFFM_SB CKIN_VCO XD2_XDFFM_SB 1.8151e-17
* device instance cc_CKIN_VCO_XD2_XDFFM_SFB r0 *1 0,0
Ccc_CKIN_VCO_XD2_XDFFM_SFB CKIN_VCO XD2_XDFFM_SFB 1.21e-17
* device instance cc_CKIN_VCO_XD2_XDFFQ_CKBB r0 *1 0,0
Ccc_CKIN_VCO_XD2_XDFFQ_CKBB CKIN_VCO XD2_XDFFQ_CKBB 1.8151e-17
* device instance cc_CKIN_VCO_XD2_XDFFQ_CLKB r0 *1 0,0
Ccc_CKIN_VCO_XD2_XDFFQ_CLKB CKIN_VCO XD2_XDFFQ_CLKB 2.4201e-17
* device instance cc_CKIN_VCO_XD2_XDFFQ_M r0 *1 0,0
Ccc_CKIN_VCO_XD2_XDFFQ_M CKIN_VCO XD2_XDFFQ_M 2.4201e-17
* device instance cc_CKIN_VCO_XD2_XDFFQ_MB r0 *1 0,0
Ccc_CKIN_VCO_XD2_XDFFQ_MB CKIN_VCO XD2_XDFFQ_MB 1.21e-17
* device instance cc_CKIN_VCO_XD2_XDFFQ_MFB r0 *1 0,0
Ccc_CKIN_VCO_XD2_XDFFQ_MFB CKIN_VCO XD2_XDFFQ_MFB 1.21e-17
* device instance cc_CKIN_VCO_XD2_XDFFQ_S r0 *1 0,0
Ccc_CKIN_VCO_XD2_XDFFQ_S CKIN_VCO XD2_XDFFQ_S 1.8151e-17
* device instance cc_CKIN_VCO_XD2_XDFFQ_SB r0 *1 0,0
Ccc_CKIN_VCO_XD2_XDFFQ_SB CKIN_VCO XD2_XDFFQ_SB 1.8151e-17
* device instance cc_CKIN_VCO_XD2_XDFFQ_SFB r0 *1 0,0
Ccc_CKIN_VCO_XD2_XDFFQ_SFB CKIN_VCO XD2_XDFFQ_SFB 1.21e-17
* device instance cc_CKIN_VCO_XD2_XNOR_midp r0 *1 0,0
Ccc_CKIN_VCO_XD2_XNOR_midp CKIN_VCO XD2_XNOR_midp 1.21e-17
* device instance cc_CKIN_VCO_XD2_dmodout r0 *1 0,0
Ccc_CKIN_VCO_XD2_dmodout CKIN_VCO XD2_dmodout 1.21e-17
* device instance cc_CKIN_VCO_XD2_dq r0 *1 0,0
Ccc_CKIN_VCO_XD2_dq CKIN_VCO XD2_dq 1.21e-17
* device instance cc_CKIN_VCO_XD2_nm r0 *1 0,0
Ccc_CKIN_VCO_XD2_nm CKIN_VCO XD2_nm 1.8151e-17
* device instance cc_CKIN_VCO_XD2_nt r0 *1 0,0
Ccc_CKIN_VCO_XD2_nt CKIN_VCO XD2_nt 2.4201e-17
* device instance cc_CKIN_VCO_XD2_t1 r0 *1 0,0
Ccc_CKIN_VCO_XD2_t1 CKIN_VCO XD2_t1 1.21e-17
* device instance cc_CKIN_VCO_XD3_XDFFM_CKBB r0 *1 0,0
Ccc_CKIN_VCO_XD3_XDFFM_CKBB CKIN_VCO XD3_XDFFM_CKBB 1.8151e-17
* device instance cc_CKIN_VCO_XD3_XDFFM_CLKB r0 *1 0,0
Ccc_CKIN_VCO_XD3_XDFFM_CLKB CKIN_VCO XD3_XDFFM_CLKB 2.4201e-17
* device instance cc_CKIN_VCO_XD3_XDFFM_M r0 *1 0,0
Ccc_CKIN_VCO_XD3_XDFFM_M CKIN_VCO XD3_XDFFM_M 2.4201e-17
* device instance cc_CKIN_VCO_XD3_XDFFM_MB r0 *1 0,0
Ccc_CKIN_VCO_XD3_XDFFM_MB CKIN_VCO XD3_XDFFM_MB 1.21e-17
* device instance cc_CKIN_VCO_XD3_XDFFM_MFB r0 *1 0,0
Ccc_CKIN_VCO_XD3_XDFFM_MFB CKIN_VCO XD3_XDFFM_MFB 1.21e-17
* device instance cc_CKIN_VCO_XD3_XDFFM_S r0 *1 0,0
Ccc_CKIN_VCO_XD3_XDFFM_S CKIN_VCO XD3_XDFFM_S 1.8151e-17
* device instance cc_CKIN_VCO_XD3_XDFFM_SB r0 *1 0,0
Ccc_CKIN_VCO_XD3_XDFFM_SB CKIN_VCO XD3_XDFFM_SB 1.8151e-17
* device instance cc_CKIN_VCO_XD3_XDFFM_SFB r0 *1 0,0
Ccc_CKIN_VCO_XD3_XDFFM_SFB CKIN_VCO XD3_XDFFM_SFB 1.21e-17
* device instance cc_CKIN_VCO_XD3_XDFFQ_CKBB r0 *1 0,0
Ccc_CKIN_VCO_XD3_XDFFQ_CKBB CKIN_VCO XD3_XDFFQ_CKBB 1.8151e-17
* device instance cc_CKIN_VCO_XD3_XDFFQ_CLKB r0 *1 0,0
Ccc_CKIN_VCO_XD3_XDFFQ_CLKB CKIN_VCO XD3_XDFFQ_CLKB 2.4201e-17
* device instance cc_CKIN_VCO_XD3_XDFFQ_M r0 *1 0,0
Ccc_CKIN_VCO_XD3_XDFFQ_M CKIN_VCO XD3_XDFFQ_M 2.4201e-17
* device instance cc_CKIN_VCO_XD3_XDFFQ_MB r0 *1 0,0
Ccc_CKIN_VCO_XD3_XDFFQ_MB CKIN_VCO XD3_XDFFQ_MB 1.21e-17
* device instance cc_CKIN_VCO_XD3_XDFFQ_MFB r0 *1 0,0
Ccc_CKIN_VCO_XD3_XDFFQ_MFB CKIN_VCO XD3_XDFFQ_MFB 1.21e-17
* device instance cc_CKIN_VCO_XD3_XDFFQ_S r0 *1 0,0
Ccc_CKIN_VCO_XD3_XDFFQ_S CKIN_VCO XD3_XDFFQ_S 1.8151e-17
* device instance cc_CKIN_VCO_XD3_XDFFQ_SB r0 *1 0,0
Ccc_CKIN_VCO_XD3_XDFFQ_SB CKIN_VCO XD3_XDFFQ_SB 1.8151e-17
* device instance cc_CKIN_VCO_XD3_XDFFQ_SFB r0 *1 0,0
Ccc_CKIN_VCO_XD3_XDFFQ_SFB CKIN_VCO XD3_XDFFQ_SFB 1.21e-17
* device instance cc_CKIN_VCO_XD3_XNOR_midp r0 *1 0,0
Ccc_CKIN_VCO_XD3_XNOR_midp CKIN_VCO XD3_XNOR_midp 1.21e-17
* device instance cc_CKIN_VCO_XD3_dmodout r0 *1 0,0
Ccc_CKIN_VCO_XD3_dmodout CKIN_VCO XD3_dmodout 1.21e-17
* device instance cc_CKIN_VCO_XD3_dq r0 *1 0,0
Ccc_CKIN_VCO_XD3_dq CKIN_VCO XD3_dq 1.21e-17
* device instance cc_CKIN_VCO_XD3_nm r0 *1 0,0
Ccc_CKIN_VCO_XD3_nm CKIN_VCO XD3_nm 1.8151e-17
* device instance cc_CKIN_VCO_XD3_nt r0 *1 0,0
Ccc_CKIN_VCO_XD3_nt CKIN_VCO XD3_nt 2.4201e-17
* device instance cc_CKIN_VCO_XD3_t1 r0 *1 0,0
Ccc_CKIN_VCO_XD3_t1 CKIN_VCO XD3_t1 1.21e-17
* device instance cc_CKIN_VCO_XD4_XDFFM_CKBB r0 *1 0,0
Ccc_CKIN_VCO_XD4_XDFFM_CKBB CKIN_VCO XD4_XDFFM_CKBB 1.8151e-17
* device instance cc_CKIN_VCO_XD4_XDFFM_CLKB r0 *1 0,0
Ccc_CKIN_VCO_XD4_XDFFM_CLKB CKIN_VCO XD4_XDFFM_CLKB 2.4201e-17
* device instance cc_CKIN_VCO_XD4_XDFFM_M r0 *1 0,0
Ccc_CKIN_VCO_XD4_XDFFM_M CKIN_VCO XD4_XDFFM_M 2.4201e-17
* device instance cc_CKIN_VCO_XD4_XDFFM_MB r0 *1 0,0
Ccc_CKIN_VCO_XD4_XDFFM_MB CKIN_VCO XD4_XDFFM_MB 1.21e-17
* device instance cc_CKIN_VCO_XD4_XDFFM_MFB r0 *1 0,0
Ccc_CKIN_VCO_XD4_XDFFM_MFB CKIN_VCO XD4_XDFFM_MFB 1.21e-17
* device instance cc_CKIN_VCO_XD4_XDFFM_S r0 *1 0,0
Ccc_CKIN_VCO_XD4_XDFFM_S CKIN_VCO XD4_XDFFM_S 1.8151e-17
* device instance cc_CKIN_VCO_XD4_XDFFM_SB r0 *1 0,0
Ccc_CKIN_VCO_XD4_XDFFM_SB CKIN_VCO XD4_XDFFM_SB 1.8151e-17
* device instance cc_CKIN_VCO_XD4_XDFFM_SFB r0 *1 0,0
Ccc_CKIN_VCO_XD4_XDFFM_SFB CKIN_VCO XD4_XDFFM_SFB 1.21e-17
* device instance cc_CKIN_VCO_XD4_XDFFQ_CKBB r0 *1 0,0
Ccc_CKIN_VCO_XD4_XDFFQ_CKBB CKIN_VCO XD4_XDFFQ_CKBB 1.8151e-17
* device instance cc_CKIN_VCO_XD4_XDFFQ_CLKB r0 *1 0,0
Ccc_CKIN_VCO_XD4_XDFFQ_CLKB CKIN_VCO XD4_XDFFQ_CLKB 2.4201e-17
* device instance cc_CKIN_VCO_XD4_XDFFQ_M r0 *1 0,0
Ccc_CKIN_VCO_XD4_XDFFQ_M CKIN_VCO XD4_XDFFQ_M 2.4201e-17
* device instance cc_CKIN_VCO_XD4_XDFFQ_MB r0 *1 0,0
Ccc_CKIN_VCO_XD4_XDFFQ_MB CKIN_VCO XD4_XDFFQ_MB 1.21e-17
* device instance cc_CKIN_VCO_XD4_XDFFQ_MFB r0 *1 0,0
Ccc_CKIN_VCO_XD4_XDFFQ_MFB CKIN_VCO XD4_XDFFQ_MFB 1.21e-17
* device instance cc_CKIN_VCO_XD4_XDFFQ_S r0 *1 0,0
Ccc_CKIN_VCO_XD4_XDFFQ_S CKIN_VCO XD4_XDFFQ_S 1.8151e-17
* device instance cc_CKIN_VCO_XD4_XDFFQ_SB r0 *1 0,0
Ccc_CKIN_VCO_XD4_XDFFQ_SB CKIN_VCO XD4_XDFFQ_SB 1.8151e-17
* device instance cc_CKIN_VCO_XD4_XDFFQ_SFB r0 *1 0,0
Ccc_CKIN_VCO_XD4_XDFFQ_SFB CKIN_VCO XD4_XDFFQ_SFB 1.21e-17
* device instance cc_CKIN_VCO_XD4_XNOR_midp r0 *1 0,0
Ccc_CKIN_VCO_XD4_XNOR_midp CKIN_VCO XD4_XNOR_midp 1.21e-17
* device instance cc_CKIN_VCO_XD4_dmodout r0 *1 0,0
Ccc_CKIN_VCO_XD4_dmodout CKIN_VCO XD4_dmodout 1.21e-17
* device instance cc_CKIN_VCO_XD4_dq r0 *1 0,0
Ccc_CKIN_VCO_XD4_dq CKIN_VCO XD4_dq 1.21e-17
* device instance cc_CKIN_VCO_XD4_nm r0 *1 0,0
Ccc_CKIN_VCO_XD4_nm CKIN_VCO XD4_nm 1.8151e-17
* device instance cc_CKIN_VCO_XD4_nt r0 *1 0,0
Ccc_CKIN_VCO_XD4_nt CKIN_VCO XD4_nt 2.4201e-17
* device instance cc_CKIN_VCO_XD4_t1 r0 *1 0,0
Ccc_CKIN_VCO_XD4_t1 CKIN_VCO XD4_t1 1.21e-17
* device instance cc_CKIN_VCO_XD5_XDFFM_CKBB r0 *1 0,0
Ccc_CKIN_VCO_XD5_XDFFM_CKBB CKIN_VCO XD5_XDFFM_CKBB 1.8151e-17
* device instance cc_CKIN_VCO_XD5_XDFFM_CLKB r0 *1 0,0
Ccc_CKIN_VCO_XD5_XDFFM_CLKB CKIN_VCO XD5_XDFFM_CLKB 2.4201e-17
* device instance cc_CKIN_VCO_XD5_XDFFM_M r0 *1 0,0
Ccc_CKIN_VCO_XD5_XDFFM_M CKIN_VCO XD5_XDFFM_M 2.4201e-17
* device instance cc_CKIN_VCO_XD5_XDFFM_MB r0 *1 0,0
Ccc_CKIN_VCO_XD5_XDFFM_MB CKIN_VCO XD5_XDFFM_MB 1.21e-17
* device instance cc_CKIN_VCO_XD5_XDFFM_MFB r0 *1 0,0
Ccc_CKIN_VCO_XD5_XDFFM_MFB CKIN_VCO XD5_XDFFM_MFB 1.21e-17
* device instance cc_CKIN_VCO_XD5_XDFFM_S r0 *1 0,0
Ccc_CKIN_VCO_XD5_XDFFM_S CKIN_VCO XD5_XDFFM_S 1.8151e-17
* device instance cc_CKIN_VCO_XD5_XDFFM_SB r0 *1 0,0
Ccc_CKIN_VCO_XD5_XDFFM_SB CKIN_VCO XD5_XDFFM_SB 1.8151e-17
* device instance cc_CKIN_VCO_XD5_XDFFM_SFB r0 *1 0,0
Ccc_CKIN_VCO_XD5_XDFFM_SFB CKIN_VCO XD5_XDFFM_SFB 1.21e-17
* device instance cc_CKIN_VCO_XD5_XDFFQ_CKBB r0 *1 0,0
Ccc_CKIN_VCO_XD5_XDFFQ_CKBB CKIN_VCO XD5_XDFFQ_CKBB 1.8151e-17
* device instance cc_CKIN_VCO_XD5_XDFFQ_CLKB r0 *1 0,0
Ccc_CKIN_VCO_XD5_XDFFQ_CLKB CKIN_VCO XD5_XDFFQ_CLKB 2.4201e-17
* device instance cc_CKIN_VCO_XD5_XDFFQ_M r0 *1 0,0
Ccc_CKIN_VCO_XD5_XDFFQ_M CKIN_VCO XD5_XDFFQ_M 2.4201e-17
* device instance cc_CKIN_VCO_XD5_XDFFQ_MB r0 *1 0,0
Ccc_CKIN_VCO_XD5_XDFFQ_MB CKIN_VCO XD5_XDFFQ_MB 1.21e-17
* device instance cc_CKIN_VCO_XD5_XDFFQ_MFB r0 *1 0,0
Ccc_CKIN_VCO_XD5_XDFFQ_MFB CKIN_VCO XD5_XDFFQ_MFB 1.21e-17
* device instance cc_CKIN_VCO_XD5_XDFFQ_S r0 *1 0,0
Ccc_CKIN_VCO_XD5_XDFFQ_S CKIN_VCO XD5_XDFFQ_S 1.8151e-17
* device instance cc_CKIN_VCO_XD5_XDFFQ_SB r0 *1 0,0
Ccc_CKIN_VCO_XD5_XDFFQ_SB CKIN_VCO XD5_XDFFQ_SB 1.8151e-17
* device instance cc_CKIN_VCO_XD5_XDFFQ_SFB r0 *1 0,0
Ccc_CKIN_VCO_XD5_XDFFQ_SFB CKIN_VCO XD5_XDFFQ_SFB 1.21e-17
* device instance cc_CKIN_VCO_XD5_XNOR_midp r0 *1 0,0
Ccc_CKIN_VCO_XD5_XNOR_midp CKIN_VCO XD5_XNOR_midp 1.21e-17
* device instance cc_CKIN_VCO_XD5_dmodout r0 *1 0,0
Ccc_CKIN_VCO_XD5_dmodout CKIN_VCO XD5_dmodout 1.21e-17
* device instance cc_CKIN_VCO_XD5_dq r0 *1 0,0
Ccc_CKIN_VCO_XD5_dq CKIN_VCO XD5_dq 1.21e-17
* device instance cc_CKIN_VCO_XD5_nm r0 *1 0,0
Ccc_CKIN_VCO_XD5_nm CKIN_VCO XD5_nm 1.8151e-17
* device instance cc_CKIN_VCO_XD5_nt r0 *1 0,0
Ccc_CKIN_VCO_XD5_nt CKIN_VCO XD5_nt 2.4201e-17
* device instance cc_CKIN_VCO_XD5_t1 r0 *1 0,0
Ccc_CKIN_VCO_XD5_t1 CKIN_VCO XD5_t1 1.21e-17
* device instance cc_CKIN_VCO_XFRT_CKBB r0 *1 0,0
Ccc_CKIN_VCO_XFRT_CKBB CKIN_VCO XFRT_CKBB 1.8151e-17
* device instance cc_CKIN_VCO_XFRT_CLKB r0 *1 0,0
Ccc_CKIN_VCO_XFRT_CLKB CKIN_VCO XFRT_CLKB 2.4201e-17
* device instance cc_CKIN_VCO_XFRT_M r0 *1 0,0
Ccc_CKIN_VCO_XFRT_M CKIN_VCO XFRT_M 2.4201e-17
* device instance cc_CKIN_VCO_XFRT_MB r0 *1 0,0
Ccc_CKIN_VCO_XFRT_MB CKIN_VCO XFRT_MB 1.21e-17
* device instance cc_CKIN_VCO_XFRT_MFB r0 *1 0,0
Ccc_CKIN_VCO_XFRT_MFB CKIN_VCO XFRT_MFB 1.21e-17
* device instance cc_CKIN_VCO_XFRT_S r0 *1 0,0
Ccc_CKIN_VCO_XFRT_S CKIN_VCO XFRT_S 1.8151e-17
* device instance cc_CKIN_VCO_XFRT_SB r0 *1 0,0
Ccc_CKIN_VCO_XFRT_SB CKIN_VCO XFRT_SB 1.8151e-17
* device instance cc_CKIN_VCO_XFRT_SFB r0 *1 0,0
Ccc_CKIN_VCO_XFRT_SFB CKIN_VCO XFRT_SFB 1.21e-17
* device instance cc_CKIN_VCO_ck1 r0 *1 0,0
Ccc_CKIN_VCO_ck1 CKIN_VCO ck1 3.0251e-17
* device instance cc_CKIN_VCO_ck2 r0 *1 0,0
Ccc_CKIN_VCO_ck2 CKIN_VCO ck2 3.0251e-17
* device instance cc_CKIN_VCO_ck3 r0 *1 0,0
Ccc_CKIN_VCO_ck3 CKIN_VCO ck3 3.0251e-17
* device instance cc_CKIN_VCO_ck4 r0 *1 0,0
Ccc_CKIN_VCO_ck4 CKIN_VCO ck4 3.0251e-17
* device instance cc_CKIN_VCO_ck5 r0 *1 0,0
Ccc_CKIN_VCO_ck5 CKIN_VCO ck5 3.0251e-17
* device instance cc_CKIN_VCO_mod0 r0 *1 0,0
Ccc_CKIN_VCO_mod0 CKIN_VCO mod0 2.4201e-17
* device instance cc_CKIN_VCO_mod1 r0 *1 0,0
Ccc_CKIN_VCO_mod1 CKIN_VCO mod1 2.4201e-17
* device instance cc_CKIN_VCO_mod2 r0 *1 0,0
Ccc_CKIN_VCO_mod2 CKIN_VCO mod2 2.4201e-17
* device instance cc_CKIN_VCO_mod3 r0 *1 0,0
Ccc_CKIN_VCO_mod3 CKIN_VCO mod3 2.4201e-17
* device instance cc_CKIN_VCO_mod4 r0 *1 0,0
Ccc_CKIN_VCO_mod4 CKIN_VCO mod4 2.4201e-17
* device instance cc_CKIN_VCO_net1 r0 *1 0,0
Ccc_CKIN_VCO_net1 CKIN_VCO net1 1.21e-17
* device instance cc_DIVOUT_FB r0 *1 0,0
Ccc_DIVOUT_FB DIVOUT FB 6.05e-18
* device instance cc_DIVOUT_P0 r0 *1 0,0
Ccc_DIVOUT_P0 DIVOUT P0 6.05e-18
* device instance cc_DIVOUT_P1 r0 *1 0,0
Ccc_DIVOUT_P1 DIVOUT P1 6.05e-18
* device instance cc_DIVOUT_P2 r0 *1 0,0
Ccc_DIVOUT_P2 DIVOUT P2 6.05e-18
* device instance cc_DIVOUT_P3 r0 *1 0,0
Ccc_DIVOUT_P3 DIVOUT P3 6.05e-18
* device instance cc_DIVOUT_P4 r0 *1 0,0
Ccc_DIVOUT_P4 DIVOUT P4 6.05e-18
* device instance cc_DIVOUT_P5 r0 *1 0,0
Ccc_DIVOUT_P5 DIVOUT P5 6.05e-18
* device instance cc_DIVOUT_VDD_DIV r0 *1 0,0
Ccc_DIVOUT_VDD_DIV DIVOUT VDD_DIV 8.40178e-16
* device instance cc_DIVOUT_VSS r0 *1 0,0
Ccc_DIVOUT_VSS DIVOUT VSS 1.565e-16
* device instance cc_DIVOUT_XD0_XDFFM_CKBB r0 *1 0,0
Ccc_DIVOUT_XD0_XDFFM_CKBB DIVOUT XD0_XDFFM_CKBB 1.8151e-17
* device instance cc_DIVOUT_XD0_XDFFM_CLKB r0 *1 0,0
Ccc_DIVOUT_XD0_XDFFM_CLKB DIVOUT XD0_XDFFM_CLKB 2.4201e-17
* device instance cc_DIVOUT_XD0_XDFFM_M r0 *1 0,0
Ccc_DIVOUT_XD0_XDFFM_M DIVOUT XD0_XDFFM_M 2.4201e-17
* device instance cc_DIVOUT_XD0_XDFFM_MB r0 *1 0,0
Ccc_DIVOUT_XD0_XDFFM_MB DIVOUT XD0_XDFFM_MB 1.21e-17
* device instance cc_DIVOUT_XD0_XDFFM_MFB r0 *1 0,0
Ccc_DIVOUT_XD0_XDFFM_MFB DIVOUT XD0_XDFFM_MFB 1.21e-17
* device instance cc_DIVOUT_XD0_XDFFM_S r0 *1 0,0
Ccc_DIVOUT_XD0_XDFFM_S DIVOUT XD0_XDFFM_S 1.8151e-17
* device instance cc_DIVOUT_XD0_XDFFM_SB r0 *1 0,0
Ccc_DIVOUT_XD0_XDFFM_SB DIVOUT XD0_XDFFM_SB 1.8151e-17
* device instance cc_DIVOUT_XD0_XDFFM_SFB r0 *1 0,0
Ccc_DIVOUT_XD0_XDFFM_SFB DIVOUT XD0_XDFFM_SFB 1.21e-17
* device instance cc_DIVOUT_XD0_XDFFQ_CKBB r0 *1 0,0
Ccc_DIVOUT_XD0_XDFFQ_CKBB DIVOUT XD0_XDFFQ_CKBB 1.8151e-17
* device instance cc_DIVOUT_XD0_XDFFQ_CLKB r0 *1 0,0
Ccc_DIVOUT_XD0_XDFFQ_CLKB DIVOUT XD0_XDFFQ_CLKB 2.4201e-17
* device instance cc_DIVOUT_XD0_XDFFQ_M r0 *1 0,0
Ccc_DIVOUT_XD0_XDFFQ_M DIVOUT XD0_XDFFQ_M 2.4201e-17
* device instance cc_DIVOUT_XD0_XDFFQ_MB r0 *1 0,0
Ccc_DIVOUT_XD0_XDFFQ_MB DIVOUT XD0_XDFFQ_MB 1.21e-17
* device instance cc_DIVOUT_XD0_XDFFQ_MFB r0 *1 0,0
Ccc_DIVOUT_XD0_XDFFQ_MFB DIVOUT XD0_XDFFQ_MFB 1.21e-17
* device instance cc_DIVOUT_XD0_XDFFQ_S r0 *1 0,0
Ccc_DIVOUT_XD0_XDFFQ_S DIVOUT XD0_XDFFQ_S 1.8151e-17
* device instance cc_DIVOUT_XD0_XDFFQ_SB r0 *1 0,0
Ccc_DIVOUT_XD0_XDFFQ_SB DIVOUT XD0_XDFFQ_SB 1.8151e-17
* device instance cc_DIVOUT_XD0_XDFFQ_SFB r0 *1 0,0
Ccc_DIVOUT_XD0_XDFFQ_SFB DIVOUT XD0_XDFFQ_SFB 1.21e-17
* device instance cc_DIVOUT_XD0_XNOR_midp r0 *1 0,0
Ccc_DIVOUT_XD0_XNOR_midp DIVOUT XD0_XNOR_midp 1.21e-17
* device instance cc_DIVOUT_XD0_dmodout r0 *1 0,0
Ccc_DIVOUT_XD0_dmodout DIVOUT XD0_dmodout 1.21e-17
* device instance cc_DIVOUT_XD0_dq r0 *1 0,0
Ccc_DIVOUT_XD0_dq DIVOUT XD0_dq 1.21e-17
* device instance cc_DIVOUT_XD0_nm r0 *1 0,0
Ccc_DIVOUT_XD0_nm DIVOUT XD0_nm 1.8151e-17
* device instance cc_DIVOUT_XD0_nt r0 *1 0,0
Ccc_DIVOUT_XD0_nt DIVOUT XD0_nt 2.4201e-17
* device instance cc_DIVOUT_XD0_t1 r0 *1 0,0
Ccc_DIVOUT_XD0_t1 DIVOUT XD0_t1 1.21e-17
* device instance cc_DIVOUT_XD1_XDFFM_CKBB r0 *1 0,0
Ccc_DIVOUT_XD1_XDFFM_CKBB DIVOUT XD1_XDFFM_CKBB 1.8151e-17
* device instance cc_DIVOUT_XD1_XDFFM_CLKB r0 *1 0,0
Ccc_DIVOUT_XD1_XDFFM_CLKB DIVOUT XD1_XDFFM_CLKB 2.4201e-17
* device instance cc_DIVOUT_XD1_XDFFM_M r0 *1 0,0
Ccc_DIVOUT_XD1_XDFFM_M DIVOUT XD1_XDFFM_M 2.4201e-17
* device instance cc_DIVOUT_XD1_XDFFM_MB r0 *1 0,0
Ccc_DIVOUT_XD1_XDFFM_MB DIVOUT XD1_XDFFM_MB 1.21e-17
* device instance cc_DIVOUT_XD1_XDFFM_MFB r0 *1 0,0
Ccc_DIVOUT_XD1_XDFFM_MFB DIVOUT XD1_XDFFM_MFB 1.21e-17
* device instance cc_DIVOUT_XD1_XDFFM_S r0 *1 0,0
Ccc_DIVOUT_XD1_XDFFM_S DIVOUT XD1_XDFFM_S 1.8151e-17
* device instance cc_DIVOUT_XD1_XDFFM_SB r0 *1 0,0
Ccc_DIVOUT_XD1_XDFFM_SB DIVOUT XD1_XDFFM_SB 1.8151e-17
* device instance cc_DIVOUT_XD1_XDFFM_SFB r0 *1 0,0
Ccc_DIVOUT_XD1_XDFFM_SFB DIVOUT XD1_XDFFM_SFB 1.21e-17
* device instance cc_DIVOUT_XD1_XDFFQ_CKBB r0 *1 0,0
Ccc_DIVOUT_XD1_XDFFQ_CKBB DIVOUT XD1_XDFFQ_CKBB 1.8151e-17
* device instance cc_DIVOUT_XD1_XDFFQ_CLKB r0 *1 0,0
Ccc_DIVOUT_XD1_XDFFQ_CLKB DIVOUT XD1_XDFFQ_CLKB 2.4201e-17
* device instance cc_DIVOUT_XD1_XDFFQ_M r0 *1 0,0
Ccc_DIVOUT_XD1_XDFFQ_M DIVOUT XD1_XDFFQ_M 2.4201e-17
* device instance cc_DIVOUT_XD1_XDFFQ_MB r0 *1 0,0
Ccc_DIVOUT_XD1_XDFFQ_MB DIVOUT XD1_XDFFQ_MB 1.21e-17
* device instance cc_DIVOUT_XD1_XDFFQ_MFB r0 *1 0,0
Ccc_DIVOUT_XD1_XDFFQ_MFB DIVOUT XD1_XDFFQ_MFB 1.21e-17
* device instance cc_DIVOUT_XD1_XDFFQ_S r0 *1 0,0
Ccc_DIVOUT_XD1_XDFFQ_S DIVOUT XD1_XDFFQ_S 1.8151e-17
* device instance cc_DIVOUT_XD1_XDFFQ_SB r0 *1 0,0
Ccc_DIVOUT_XD1_XDFFQ_SB DIVOUT XD1_XDFFQ_SB 1.8151e-17
* device instance cc_DIVOUT_XD1_XDFFQ_SFB r0 *1 0,0
Ccc_DIVOUT_XD1_XDFFQ_SFB DIVOUT XD1_XDFFQ_SFB 1.21e-17
* device instance cc_DIVOUT_XD1_XNOR_midp r0 *1 0,0
Ccc_DIVOUT_XD1_XNOR_midp DIVOUT XD1_XNOR_midp 1.21e-17
* device instance cc_DIVOUT_XD1_dmodout r0 *1 0,0
Ccc_DIVOUT_XD1_dmodout DIVOUT XD1_dmodout 1.21e-17
* device instance cc_DIVOUT_XD1_dq r0 *1 0,0
Ccc_DIVOUT_XD1_dq DIVOUT XD1_dq 1.21e-17
* device instance cc_DIVOUT_XD1_nm r0 *1 0,0
Ccc_DIVOUT_XD1_nm DIVOUT XD1_nm 1.8151e-17
* device instance cc_DIVOUT_XD1_nt r0 *1 0,0
Ccc_DIVOUT_XD1_nt DIVOUT XD1_nt 2.4201e-17
* device instance cc_DIVOUT_XD1_t1 r0 *1 0,0
Ccc_DIVOUT_XD1_t1 DIVOUT XD1_t1 1.21e-17
* device instance cc_DIVOUT_XD2_XDFFM_CKBB r0 *1 0,0
Ccc_DIVOUT_XD2_XDFFM_CKBB DIVOUT XD2_XDFFM_CKBB 1.8151e-17
* device instance cc_DIVOUT_XD2_XDFFM_CLKB r0 *1 0,0
Ccc_DIVOUT_XD2_XDFFM_CLKB DIVOUT XD2_XDFFM_CLKB 2.4201e-17
* device instance cc_DIVOUT_XD2_XDFFM_M r0 *1 0,0
Ccc_DIVOUT_XD2_XDFFM_M DIVOUT XD2_XDFFM_M 2.4201e-17
* device instance cc_DIVOUT_XD2_XDFFM_MB r0 *1 0,0
Ccc_DIVOUT_XD2_XDFFM_MB DIVOUT XD2_XDFFM_MB 1.21e-17
* device instance cc_DIVOUT_XD2_XDFFM_MFB r0 *1 0,0
Ccc_DIVOUT_XD2_XDFFM_MFB DIVOUT XD2_XDFFM_MFB 1.21e-17
* device instance cc_DIVOUT_XD2_XDFFM_S r0 *1 0,0
Ccc_DIVOUT_XD2_XDFFM_S DIVOUT XD2_XDFFM_S 1.8151e-17
* device instance cc_DIVOUT_XD2_XDFFM_SB r0 *1 0,0
Ccc_DIVOUT_XD2_XDFFM_SB DIVOUT XD2_XDFFM_SB 1.8151e-17
* device instance cc_DIVOUT_XD2_XDFFM_SFB r0 *1 0,0
Ccc_DIVOUT_XD2_XDFFM_SFB DIVOUT XD2_XDFFM_SFB 1.21e-17
* device instance cc_DIVOUT_XD2_XDFFQ_CKBB r0 *1 0,0
Ccc_DIVOUT_XD2_XDFFQ_CKBB DIVOUT XD2_XDFFQ_CKBB 1.8151e-17
* device instance cc_DIVOUT_XD2_XDFFQ_CLKB r0 *1 0,0
Ccc_DIVOUT_XD2_XDFFQ_CLKB DIVOUT XD2_XDFFQ_CLKB 2.4201e-17
* device instance cc_DIVOUT_XD2_XDFFQ_M r0 *1 0,0
Ccc_DIVOUT_XD2_XDFFQ_M DIVOUT XD2_XDFFQ_M 2.4201e-17
* device instance cc_DIVOUT_XD2_XDFFQ_MB r0 *1 0,0
Ccc_DIVOUT_XD2_XDFFQ_MB DIVOUT XD2_XDFFQ_MB 1.21e-17
* device instance cc_DIVOUT_XD2_XDFFQ_MFB r0 *1 0,0
Ccc_DIVOUT_XD2_XDFFQ_MFB DIVOUT XD2_XDFFQ_MFB 1.21e-17
* device instance cc_DIVOUT_XD2_XDFFQ_S r0 *1 0,0
Ccc_DIVOUT_XD2_XDFFQ_S DIVOUT XD2_XDFFQ_S 1.8151e-17
* device instance cc_DIVOUT_XD2_XDFFQ_SB r0 *1 0,0
Ccc_DIVOUT_XD2_XDFFQ_SB DIVOUT XD2_XDFFQ_SB 1.8151e-17
* device instance cc_DIVOUT_XD2_XDFFQ_SFB r0 *1 0,0
Ccc_DIVOUT_XD2_XDFFQ_SFB DIVOUT XD2_XDFFQ_SFB 1.21e-17
* device instance cc_DIVOUT_XD2_XNOR_midp r0 *1 0,0
Ccc_DIVOUT_XD2_XNOR_midp DIVOUT XD2_XNOR_midp 1.21e-17
* device instance cc_DIVOUT_XD2_dmodout r0 *1 0,0
Ccc_DIVOUT_XD2_dmodout DIVOUT XD2_dmodout 1.21e-17
* device instance cc_DIVOUT_XD2_dq r0 *1 0,0
Ccc_DIVOUT_XD2_dq DIVOUT XD2_dq 1.21e-17
* device instance cc_DIVOUT_XD2_nm r0 *1 0,0
Ccc_DIVOUT_XD2_nm DIVOUT XD2_nm 1.8151e-17
* device instance cc_DIVOUT_XD2_nt r0 *1 0,0
Ccc_DIVOUT_XD2_nt DIVOUT XD2_nt 2.4201e-17
* device instance cc_DIVOUT_XD2_t1 r0 *1 0,0
Ccc_DIVOUT_XD2_t1 DIVOUT XD2_t1 1.21e-17
* device instance cc_DIVOUT_XD3_XDFFM_CKBB r0 *1 0,0
Ccc_DIVOUT_XD3_XDFFM_CKBB DIVOUT XD3_XDFFM_CKBB 1.8151e-17
* device instance cc_DIVOUT_XD3_XDFFM_CLKB r0 *1 0,0
Ccc_DIVOUT_XD3_XDFFM_CLKB DIVOUT XD3_XDFFM_CLKB 2.4201e-17
* device instance cc_DIVOUT_XD3_XDFFM_M r0 *1 0,0
Ccc_DIVOUT_XD3_XDFFM_M DIVOUT XD3_XDFFM_M 2.4201e-17
* device instance cc_DIVOUT_XD3_XDFFM_MB r0 *1 0,0
Ccc_DIVOUT_XD3_XDFFM_MB DIVOUT XD3_XDFFM_MB 1.21e-17
* device instance cc_DIVOUT_XD3_XDFFM_MFB r0 *1 0,0
Ccc_DIVOUT_XD3_XDFFM_MFB DIVOUT XD3_XDFFM_MFB 1.21e-17
* device instance cc_DIVOUT_XD3_XDFFM_S r0 *1 0,0
Ccc_DIVOUT_XD3_XDFFM_S DIVOUT XD3_XDFFM_S 1.8151e-17
* device instance cc_DIVOUT_XD3_XDFFM_SB r0 *1 0,0
Ccc_DIVOUT_XD3_XDFFM_SB DIVOUT XD3_XDFFM_SB 1.8151e-17
* device instance cc_DIVOUT_XD3_XDFFM_SFB r0 *1 0,0
Ccc_DIVOUT_XD3_XDFFM_SFB DIVOUT XD3_XDFFM_SFB 1.21e-17
* device instance cc_DIVOUT_XD3_XDFFQ_CKBB r0 *1 0,0
Ccc_DIVOUT_XD3_XDFFQ_CKBB DIVOUT XD3_XDFFQ_CKBB 1.8151e-17
* device instance cc_DIVOUT_XD3_XDFFQ_CLKB r0 *1 0,0
Ccc_DIVOUT_XD3_XDFFQ_CLKB DIVOUT XD3_XDFFQ_CLKB 2.4201e-17
* device instance cc_DIVOUT_XD3_XDFFQ_M r0 *1 0,0
Ccc_DIVOUT_XD3_XDFFQ_M DIVOUT XD3_XDFFQ_M 2.4201e-17
* device instance cc_DIVOUT_XD3_XDFFQ_MB r0 *1 0,0
Ccc_DIVOUT_XD3_XDFFQ_MB DIVOUT XD3_XDFFQ_MB 1.21e-17
* device instance cc_DIVOUT_XD3_XDFFQ_MFB r0 *1 0,0
Ccc_DIVOUT_XD3_XDFFQ_MFB DIVOUT XD3_XDFFQ_MFB 1.21e-17
* device instance cc_DIVOUT_XD3_XDFFQ_S r0 *1 0,0
Ccc_DIVOUT_XD3_XDFFQ_S DIVOUT XD3_XDFFQ_S 1.8151e-17
* device instance cc_DIVOUT_XD3_XDFFQ_SB r0 *1 0,0
Ccc_DIVOUT_XD3_XDFFQ_SB DIVOUT XD3_XDFFQ_SB 1.8151e-17
* device instance cc_DIVOUT_XD3_XDFFQ_SFB r0 *1 0,0
Ccc_DIVOUT_XD3_XDFFQ_SFB DIVOUT XD3_XDFFQ_SFB 1.21e-17
* device instance cc_DIVOUT_XD3_XNOR_midp r0 *1 0,0
Ccc_DIVOUT_XD3_XNOR_midp DIVOUT XD3_XNOR_midp 1.21e-17
* device instance cc_DIVOUT_XD3_dmodout r0 *1 0,0
Ccc_DIVOUT_XD3_dmodout DIVOUT XD3_dmodout 1.21e-17
* device instance cc_DIVOUT_XD3_dq r0 *1 0,0
Ccc_DIVOUT_XD3_dq DIVOUT XD3_dq 1.21e-17
* device instance cc_DIVOUT_XD3_nm r0 *1 0,0
Ccc_DIVOUT_XD3_nm DIVOUT XD3_nm 1.8151e-17
* device instance cc_DIVOUT_XD3_nt r0 *1 0,0
Ccc_DIVOUT_XD3_nt DIVOUT XD3_nt 2.4201e-17
* device instance cc_DIVOUT_XD3_t1 r0 *1 0,0
Ccc_DIVOUT_XD3_t1 DIVOUT XD3_t1 1.21e-17
* device instance cc_DIVOUT_XD4_XDFFM_CKBB r0 *1 0,0
Ccc_DIVOUT_XD4_XDFFM_CKBB DIVOUT XD4_XDFFM_CKBB 1.8151e-17
* device instance cc_DIVOUT_XD4_XDFFM_CLKB r0 *1 0,0
Ccc_DIVOUT_XD4_XDFFM_CLKB DIVOUT XD4_XDFFM_CLKB 2.4201e-17
* device instance cc_DIVOUT_XD4_XDFFM_M r0 *1 0,0
Ccc_DIVOUT_XD4_XDFFM_M DIVOUT XD4_XDFFM_M 2.4201e-17
* device instance cc_DIVOUT_XD4_XDFFM_MB r0 *1 0,0
Ccc_DIVOUT_XD4_XDFFM_MB DIVOUT XD4_XDFFM_MB 1.21e-17
* device instance cc_DIVOUT_XD4_XDFFM_MFB r0 *1 0,0
Ccc_DIVOUT_XD4_XDFFM_MFB DIVOUT XD4_XDFFM_MFB 1.21e-17
* device instance cc_DIVOUT_XD4_XDFFM_S r0 *1 0,0
Ccc_DIVOUT_XD4_XDFFM_S DIVOUT XD4_XDFFM_S 1.8151e-17
* device instance cc_DIVOUT_XD4_XDFFM_SB r0 *1 0,0
Ccc_DIVOUT_XD4_XDFFM_SB DIVOUT XD4_XDFFM_SB 1.8151e-17
* device instance cc_DIVOUT_XD4_XDFFM_SFB r0 *1 0,0
Ccc_DIVOUT_XD4_XDFFM_SFB DIVOUT XD4_XDFFM_SFB 1.21e-17
* device instance cc_DIVOUT_XD4_XDFFQ_CKBB r0 *1 0,0
Ccc_DIVOUT_XD4_XDFFQ_CKBB DIVOUT XD4_XDFFQ_CKBB 1.8151e-17
* device instance cc_DIVOUT_XD4_XDFFQ_CLKB r0 *1 0,0
Ccc_DIVOUT_XD4_XDFFQ_CLKB DIVOUT XD4_XDFFQ_CLKB 2.4201e-17
* device instance cc_DIVOUT_XD4_XDFFQ_M r0 *1 0,0
Ccc_DIVOUT_XD4_XDFFQ_M DIVOUT XD4_XDFFQ_M 2.4201e-17
* device instance cc_DIVOUT_XD4_XDFFQ_MB r0 *1 0,0
Ccc_DIVOUT_XD4_XDFFQ_MB DIVOUT XD4_XDFFQ_MB 1.21e-17
* device instance cc_DIVOUT_XD4_XDFFQ_MFB r0 *1 0,0
Ccc_DIVOUT_XD4_XDFFQ_MFB DIVOUT XD4_XDFFQ_MFB 1.21e-17
* device instance cc_DIVOUT_XD4_XDFFQ_S r0 *1 0,0
Ccc_DIVOUT_XD4_XDFFQ_S DIVOUT XD4_XDFFQ_S 1.8151e-17
* device instance cc_DIVOUT_XD4_XDFFQ_SB r0 *1 0,0
Ccc_DIVOUT_XD4_XDFFQ_SB DIVOUT XD4_XDFFQ_SB 1.8151e-17
* device instance cc_DIVOUT_XD4_XDFFQ_SFB r0 *1 0,0
Ccc_DIVOUT_XD4_XDFFQ_SFB DIVOUT XD4_XDFFQ_SFB 1.21e-17
* device instance cc_DIVOUT_XD4_XNOR_midp r0 *1 0,0
Ccc_DIVOUT_XD4_XNOR_midp DIVOUT XD4_XNOR_midp 1.21e-17
* device instance cc_DIVOUT_XD4_dmodout r0 *1 0,0
Ccc_DIVOUT_XD4_dmodout DIVOUT XD4_dmodout 1.21e-17
* device instance cc_DIVOUT_XD4_dq r0 *1 0,0
Ccc_DIVOUT_XD4_dq DIVOUT XD4_dq 1.21e-17
* device instance cc_DIVOUT_XD4_nm r0 *1 0,0
Ccc_DIVOUT_XD4_nm DIVOUT XD4_nm 1.8151e-17
* device instance cc_DIVOUT_XD4_nt r0 *1 0,0
Ccc_DIVOUT_XD4_nt DIVOUT XD4_nt 2.4201e-17
* device instance cc_DIVOUT_XD4_t1 r0 *1 0,0
Ccc_DIVOUT_XD4_t1 DIVOUT XD4_t1 1.21e-17
* device instance cc_DIVOUT_XD5_XDFFM_CKBB r0 *1 0,0
Ccc_DIVOUT_XD5_XDFFM_CKBB DIVOUT XD5_XDFFM_CKBB 3.6302e-17
* device instance cc_DIVOUT_XD5_XDFFM_CLKB r0 *1 0,0
Ccc_DIVOUT_XD5_XDFFM_CLKB DIVOUT XD5_XDFFM_CLKB 4.8402e-17
* device instance cc_DIVOUT_XD5_XDFFM_M r0 *1 0,0
Ccc_DIVOUT_XD5_XDFFM_M DIVOUT XD5_XDFFM_M 4.8402e-17
* device instance cc_DIVOUT_XD5_XDFFM_MB r0 *1 0,0
Ccc_DIVOUT_XD5_XDFFM_MB DIVOUT XD5_XDFFM_MB 2.4201e-17
* device instance cc_DIVOUT_XD5_XDFFM_MFB r0 *1 0,0
Ccc_DIVOUT_XD5_XDFFM_MFB DIVOUT XD5_XDFFM_MFB 2.4201e-17
* device instance cc_DIVOUT_XD5_XDFFM_S r0 *1 0,0
Ccc_DIVOUT_XD5_XDFFM_S DIVOUT XD5_XDFFM_S 3.6302e-17
* device instance cc_DIVOUT_XD5_XDFFM_SB r0 *1 0,0
Ccc_DIVOUT_XD5_XDFFM_SB DIVOUT XD5_XDFFM_SB 3.6302e-17
* device instance cc_DIVOUT_XD5_XDFFM_SFB r0 *1 0,0
Ccc_DIVOUT_XD5_XDFFM_SFB DIVOUT XD5_XDFFM_SFB 2.4201e-17
* device instance cc_DIVOUT_XD5_XDFFQ_CKBB r0 *1 0,0
Ccc_DIVOUT_XD5_XDFFQ_CKBB DIVOUT XD5_XDFFQ_CKBB 3.6302e-17
* device instance cc_DIVOUT_XD5_XDFFQ_CLKB r0 *1 0,0
Ccc_DIVOUT_XD5_XDFFQ_CLKB DIVOUT XD5_XDFFQ_CLKB 4.8402e-17
* device instance cc_DIVOUT_XD5_XDFFQ_M r0 *1 0,0
Ccc_DIVOUT_XD5_XDFFQ_M DIVOUT XD5_XDFFQ_M 4.8402e-17
* device instance cc_DIVOUT_XD5_XDFFQ_MB r0 *1 0,0
Ccc_DIVOUT_XD5_XDFFQ_MB DIVOUT XD5_XDFFQ_MB 2.4201e-17
* device instance cc_DIVOUT_XD5_XDFFQ_MFB r0 *1 0,0
Ccc_DIVOUT_XD5_XDFFQ_MFB DIVOUT XD5_XDFFQ_MFB 2.4201e-17
* device instance cc_DIVOUT_XD5_XDFFQ_S r0 *1 0,0
Ccc_DIVOUT_XD5_XDFFQ_S DIVOUT XD5_XDFFQ_S 3.6302e-17
* device instance cc_DIVOUT_XD5_XDFFQ_SB r0 *1 0,0
Ccc_DIVOUT_XD5_XDFFQ_SB DIVOUT XD5_XDFFQ_SB 3.6302e-17
* device instance cc_DIVOUT_XD5_XDFFQ_SFB r0 *1 0,0
Ccc_DIVOUT_XD5_XDFFQ_SFB DIVOUT XD5_XDFFQ_SFB 2.4201e-17
* device instance cc_DIVOUT_XD5_XN2_mid1 r0 *1 0,0
Ccc_DIVOUT_XD5_XN2_mid1 DIVOUT XD5_XN2_mid1 1.21e-17
* device instance cc_DIVOUT_XD5_XNOR_midp r0 *1 0,0
Ccc_DIVOUT_XD5_XNOR_midp DIVOUT XD5_XNOR_midp 1.21e-17
* device instance cc_DIVOUT_XD5_dmodout r0 *1 0,0
Ccc_DIVOUT_XD5_dmodout DIVOUT XD5_dmodout 2.4201e-17
* device instance cc_DIVOUT_XD5_dq r0 *1 0,0
Ccc_DIVOUT_XD5_dq DIVOUT XD5_dq 3.0251e-17
* device instance cc_DIVOUT_XD5_nm r0 *1 0,0
Ccc_DIVOUT_XD5_nm DIVOUT XD5_nm 3.0251e-17
* device instance cc_DIVOUT_XD5_nt r0 *1 0,0
Ccc_DIVOUT_XD5_nt DIVOUT XD5_nt 2.4201e-17
* device instance cc_DIVOUT_XD5_t1 r0 *1 0,0
Ccc_DIVOUT_XD5_t1 DIVOUT XD5_t1 1.8151e-17
* device instance cc_DIVOUT_XFRT_CKBB r0 *1 0,0
Ccc_DIVOUT_XFRT_CKBB DIVOUT XFRT_CKBB 3.0251e-17
* device instance cc_DIVOUT_XFRT_CLKB r0 *1 0,0
Ccc_DIVOUT_XFRT_CLKB DIVOUT XFRT_CLKB 3.6302e-17
* device instance cc_DIVOUT_XFRT_M r0 *1 0,0
Ccc_DIVOUT_XFRT_M DIVOUT XFRT_M 3.4688e-17
* device instance cc_DIVOUT_XFRT_MB r0 *1 0,0
Ccc_DIVOUT_XFRT_MB DIVOUT XFRT_MB 1.21e-17
* device instance cc_DIVOUT_XFRT_MFB r0 *1 0,0
Ccc_DIVOUT_XFRT_MFB DIVOUT XFRT_MFB 1.21e-17
* device instance cc_DIVOUT_XFRT_S r0 *1 0,0
Ccc_DIVOUT_XFRT_S DIVOUT XFRT_S 1.8151e-17
* device instance cc_DIVOUT_XFRT_SB r0 *1 0,0
Ccc_DIVOUT_XFRT_SB DIVOUT XFRT_SB 1.8151e-17
* device instance cc_DIVOUT_XFRT_SFB r0 *1 0,0
Ccc_DIVOUT_XFRT_SFB DIVOUT XFRT_SFB 1.21e-17
* device instance cc_DIVOUT_ck1 r0 *1 0,0
Ccc_DIVOUT_ck1 DIVOUT ck1 3.0251e-17
* device instance cc_DIVOUT_ck2 r0 *1 0,0
Ccc_DIVOUT_ck2 DIVOUT ck2 3.0251e-17
* device instance cc_DIVOUT_ck3 r0 *1 0,0
Ccc_DIVOUT_ck3 DIVOUT ck3 3.0251e-17
* device instance cc_DIVOUT_ck4 r0 *1 0,0
Ccc_DIVOUT_ck4 DIVOUT ck4 3.0251e-17
* device instance cc_DIVOUT_ck5 r0 *1 0,0
Ccc_DIVOUT_ck5 DIVOUT ck5 4.2352e-17
* device instance cc_DIVOUT_mod0 r0 *1 0,0
Ccc_DIVOUT_mod0 DIVOUT mod0 2.4201e-17
* device instance cc_DIVOUT_mod1 r0 *1 0,0
Ccc_DIVOUT_mod1 DIVOUT mod1 2.4201e-17
* device instance cc_DIVOUT_mod2 r0 *1 0,0
Ccc_DIVOUT_mod2 DIVOUT mod2 2.4201e-17
* device instance cc_DIVOUT_mod3 r0 *1 0,0
Ccc_DIVOUT_mod3 DIVOUT mod3 2.4201e-17
* device instance cc_DIVOUT_mod4 r0 *1 0,0
Ccc_DIVOUT_mod4 DIVOUT mod4 3.0251e-17
* device instance cc_DIVOUT_net1 r0 *1 0,0
Ccc_DIVOUT_net1 DIVOUT net1 1.21e-17
* device instance cc_FB_P0 r0 *1 0,0
Ccc_FB_P0 FB P0 6.05e-18
* device instance cc_FB_P1 r0 *1 0,0
Ccc_FB_P1 FB P1 6.05e-18
* device instance cc_FB_P2 r0 *1 0,0
Ccc_FB_P2 FB P2 6.05e-18
* device instance cc_FB_P3 r0 *1 0,0
Ccc_FB_P3 FB P3 6.05e-18
* device instance cc_FB_P4 r0 *1 0,0
Ccc_FB_P4 FB P4 6.05e-18
* device instance cc_FB_P5 r0 *1 0,0
Ccc_FB_P5 FB P5 6.05e-18
* device instance cc_FB_VDD_DIV r0 *1 0,0
Ccc_FB_VDD_DIV FB VDD_DIV 8.64379e-16
* device instance cc_FB_VSS r0 *1 0,0
Ccc_FB_VSS FB VSS 5.244e-18
* device instance cc_FB_XD0_XDFFM_CKBB r0 *1 0,0
Ccc_FB_XD0_XDFFM_CKBB FB XD0_XDFFM_CKBB 1.8151e-17
* device instance cc_FB_XD0_XDFFM_CLKB r0 *1 0,0
Ccc_FB_XD0_XDFFM_CLKB FB XD0_XDFFM_CLKB 2.4201e-17
* device instance cc_FB_XD0_XDFFM_M r0 *1 0,0
Ccc_FB_XD0_XDFFM_M FB XD0_XDFFM_M 2.4201e-17
* device instance cc_FB_XD0_XDFFM_MB r0 *1 0,0
Ccc_FB_XD0_XDFFM_MB FB XD0_XDFFM_MB 1.21e-17
* device instance cc_FB_XD0_XDFFM_MFB r0 *1 0,0
Ccc_FB_XD0_XDFFM_MFB FB XD0_XDFFM_MFB 1.21e-17
* device instance cc_FB_XD0_XDFFM_S r0 *1 0,0
Ccc_FB_XD0_XDFFM_S FB XD0_XDFFM_S 1.8151e-17
* device instance cc_FB_XD0_XDFFM_SB r0 *1 0,0
Ccc_FB_XD0_XDFFM_SB FB XD0_XDFFM_SB 1.8151e-17
* device instance cc_FB_XD0_XDFFM_SFB r0 *1 0,0
Ccc_FB_XD0_XDFFM_SFB FB XD0_XDFFM_SFB 1.21e-17
* device instance cc_FB_XD0_XDFFQ_CKBB r0 *1 0,0
Ccc_FB_XD0_XDFFQ_CKBB FB XD0_XDFFQ_CKBB 1.8151e-17
* device instance cc_FB_XD0_XDFFQ_CLKB r0 *1 0,0
Ccc_FB_XD0_XDFFQ_CLKB FB XD0_XDFFQ_CLKB 2.4201e-17
* device instance cc_FB_XD0_XDFFQ_M r0 *1 0,0
Ccc_FB_XD0_XDFFQ_M FB XD0_XDFFQ_M 2.4201e-17
* device instance cc_FB_XD0_XDFFQ_MB r0 *1 0,0
Ccc_FB_XD0_XDFFQ_MB FB XD0_XDFFQ_MB 1.21e-17
* device instance cc_FB_XD0_XDFFQ_MFB r0 *1 0,0
Ccc_FB_XD0_XDFFQ_MFB FB XD0_XDFFQ_MFB 1.21e-17
* device instance cc_FB_XD0_XDFFQ_S r0 *1 0,0
Ccc_FB_XD0_XDFFQ_S FB XD0_XDFFQ_S 1.8151e-17
* device instance cc_FB_XD0_XDFFQ_SB r0 *1 0,0
Ccc_FB_XD0_XDFFQ_SB FB XD0_XDFFQ_SB 1.8151e-17
* device instance cc_FB_XD0_XDFFQ_SFB r0 *1 0,0
Ccc_FB_XD0_XDFFQ_SFB FB XD0_XDFFQ_SFB 1.21e-17
* device instance cc_FB_XD0_XNOR_midp r0 *1 0,0
Ccc_FB_XD0_XNOR_midp FB XD0_XNOR_midp 1.21e-17
* device instance cc_FB_XD0_dmodout r0 *1 0,0
Ccc_FB_XD0_dmodout FB XD0_dmodout 1.21e-17
* device instance cc_FB_XD0_dq r0 *1 0,0
Ccc_FB_XD0_dq FB XD0_dq 1.21e-17
* device instance cc_FB_XD0_nm r0 *1 0,0
Ccc_FB_XD0_nm FB XD0_nm 1.8151e-17
* device instance cc_FB_XD0_nt r0 *1 0,0
Ccc_FB_XD0_nt FB XD0_nt 2.4201e-17
* device instance cc_FB_XD0_t1 r0 *1 0,0
Ccc_FB_XD0_t1 FB XD0_t1 1.21e-17
* device instance cc_FB_XD1_XDFFM_CKBB r0 *1 0,0
Ccc_FB_XD1_XDFFM_CKBB FB XD1_XDFFM_CKBB 1.8151e-17
* device instance cc_FB_XD1_XDFFM_CLKB r0 *1 0,0
Ccc_FB_XD1_XDFFM_CLKB FB XD1_XDFFM_CLKB 2.4201e-17
* device instance cc_FB_XD1_XDFFM_M r0 *1 0,0
Ccc_FB_XD1_XDFFM_M FB XD1_XDFFM_M 2.4201e-17
* device instance cc_FB_XD1_XDFFM_MB r0 *1 0,0
Ccc_FB_XD1_XDFFM_MB FB XD1_XDFFM_MB 1.21e-17
* device instance cc_FB_XD1_XDFFM_MFB r0 *1 0,0
Ccc_FB_XD1_XDFFM_MFB FB XD1_XDFFM_MFB 1.21e-17
* device instance cc_FB_XD1_XDFFM_S r0 *1 0,0
Ccc_FB_XD1_XDFFM_S FB XD1_XDFFM_S 1.8151e-17
* device instance cc_FB_XD1_XDFFM_SB r0 *1 0,0
Ccc_FB_XD1_XDFFM_SB FB XD1_XDFFM_SB 1.8151e-17
* device instance cc_FB_XD1_XDFFM_SFB r0 *1 0,0
Ccc_FB_XD1_XDFFM_SFB FB XD1_XDFFM_SFB 1.21e-17
* device instance cc_FB_XD1_XDFFQ_CKBB r0 *1 0,0
Ccc_FB_XD1_XDFFQ_CKBB FB XD1_XDFFQ_CKBB 1.8151e-17
* device instance cc_FB_XD1_XDFFQ_CLKB r0 *1 0,0
Ccc_FB_XD1_XDFFQ_CLKB FB XD1_XDFFQ_CLKB 2.4201e-17
* device instance cc_FB_XD1_XDFFQ_M r0 *1 0,0
Ccc_FB_XD1_XDFFQ_M FB XD1_XDFFQ_M 2.4201e-17
* device instance cc_FB_XD1_XDFFQ_MB r0 *1 0,0
Ccc_FB_XD1_XDFFQ_MB FB XD1_XDFFQ_MB 1.21e-17
* device instance cc_FB_XD1_XDFFQ_MFB r0 *1 0,0
Ccc_FB_XD1_XDFFQ_MFB FB XD1_XDFFQ_MFB 1.21e-17
* device instance cc_FB_XD1_XDFFQ_S r0 *1 0,0
Ccc_FB_XD1_XDFFQ_S FB XD1_XDFFQ_S 1.8151e-17
* device instance cc_FB_XD1_XDFFQ_SB r0 *1 0,0
Ccc_FB_XD1_XDFFQ_SB FB XD1_XDFFQ_SB 1.8151e-17
* device instance cc_FB_XD1_XDFFQ_SFB r0 *1 0,0
Ccc_FB_XD1_XDFFQ_SFB FB XD1_XDFFQ_SFB 1.21e-17
* device instance cc_FB_XD1_XNOR_midp r0 *1 0,0
Ccc_FB_XD1_XNOR_midp FB XD1_XNOR_midp 1.21e-17
* device instance cc_FB_XD1_dmodout r0 *1 0,0
Ccc_FB_XD1_dmodout FB XD1_dmodout 1.21e-17
* device instance cc_FB_XD1_dq r0 *1 0,0
Ccc_FB_XD1_dq FB XD1_dq 1.21e-17
* device instance cc_FB_XD1_nm r0 *1 0,0
Ccc_FB_XD1_nm FB XD1_nm 1.8151e-17
* device instance cc_FB_XD1_nt r0 *1 0,0
Ccc_FB_XD1_nt FB XD1_nt 2.4201e-17
* device instance cc_FB_XD1_t1 r0 *1 0,0
Ccc_FB_XD1_t1 FB XD1_t1 1.21e-17
* device instance cc_FB_XD2_XDFFM_CKBB r0 *1 0,0
Ccc_FB_XD2_XDFFM_CKBB FB XD2_XDFFM_CKBB 1.8151e-17
* device instance cc_FB_XD2_XDFFM_CLKB r0 *1 0,0
Ccc_FB_XD2_XDFFM_CLKB FB XD2_XDFFM_CLKB 2.4201e-17
* device instance cc_FB_XD2_XDFFM_M r0 *1 0,0
Ccc_FB_XD2_XDFFM_M FB XD2_XDFFM_M 2.4201e-17
* device instance cc_FB_XD2_XDFFM_MB r0 *1 0,0
Ccc_FB_XD2_XDFFM_MB FB XD2_XDFFM_MB 1.21e-17
* device instance cc_FB_XD2_XDFFM_MFB r0 *1 0,0
Ccc_FB_XD2_XDFFM_MFB FB XD2_XDFFM_MFB 1.21e-17
* device instance cc_FB_XD2_XDFFM_S r0 *1 0,0
Ccc_FB_XD2_XDFFM_S FB XD2_XDFFM_S 1.8151e-17
* device instance cc_FB_XD2_XDFFM_SB r0 *1 0,0
Ccc_FB_XD2_XDFFM_SB FB XD2_XDFFM_SB 1.8151e-17
* device instance cc_FB_XD2_XDFFM_SFB r0 *1 0,0
Ccc_FB_XD2_XDFFM_SFB FB XD2_XDFFM_SFB 1.21e-17
* device instance cc_FB_XD2_XDFFQ_CKBB r0 *1 0,0
Ccc_FB_XD2_XDFFQ_CKBB FB XD2_XDFFQ_CKBB 1.8151e-17
* device instance cc_FB_XD2_XDFFQ_CLKB r0 *1 0,0
Ccc_FB_XD2_XDFFQ_CLKB FB XD2_XDFFQ_CLKB 2.4201e-17
* device instance cc_FB_XD2_XDFFQ_M r0 *1 0,0
Ccc_FB_XD2_XDFFQ_M FB XD2_XDFFQ_M 2.4201e-17
* device instance cc_FB_XD2_XDFFQ_MB r0 *1 0,0
Ccc_FB_XD2_XDFFQ_MB FB XD2_XDFFQ_MB 1.21e-17
* device instance cc_FB_XD2_XDFFQ_MFB r0 *1 0,0
Ccc_FB_XD2_XDFFQ_MFB FB XD2_XDFFQ_MFB 1.21e-17
* device instance cc_FB_XD2_XDFFQ_S r0 *1 0,0
Ccc_FB_XD2_XDFFQ_S FB XD2_XDFFQ_S 1.8151e-17
* device instance cc_FB_XD2_XDFFQ_SB r0 *1 0,0
Ccc_FB_XD2_XDFFQ_SB FB XD2_XDFFQ_SB 1.8151e-17
* device instance cc_FB_XD2_XDFFQ_SFB r0 *1 0,0
Ccc_FB_XD2_XDFFQ_SFB FB XD2_XDFFQ_SFB 1.21e-17
* device instance cc_FB_XD2_XNOR_midp r0 *1 0,0
Ccc_FB_XD2_XNOR_midp FB XD2_XNOR_midp 1.21e-17
* device instance cc_FB_XD2_dmodout r0 *1 0,0
Ccc_FB_XD2_dmodout FB XD2_dmodout 1.21e-17
* device instance cc_FB_XD2_dq r0 *1 0,0
Ccc_FB_XD2_dq FB XD2_dq 1.21e-17
* device instance cc_FB_XD2_nm r0 *1 0,0
Ccc_FB_XD2_nm FB XD2_nm 1.8151e-17
* device instance cc_FB_XD2_nt r0 *1 0,0
Ccc_FB_XD2_nt FB XD2_nt 2.4201e-17
* device instance cc_FB_XD2_t1 r0 *1 0,0
Ccc_FB_XD2_t1 FB XD2_t1 1.21e-17
* device instance cc_FB_XD3_XDFFM_CKBB r0 *1 0,0
Ccc_FB_XD3_XDFFM_CKBB FB XD3_XDFFM_CKBB 1.8151e-17
* device instance cc_FB_XD3_XDFFM_CLKB r0 *1 0,0
Ccc_FB_XD3_XDFFM_CLKB FB XD3_XDFFM_CLKB 2.4201e-17
* device instance cc_FB_XD3_XDFFM_M r0 *1 0,0
Ccc_FB_XD3_XDFFM_M FB XD3_XDFFM_M 2.4201e-17
* device instance cc_FB_XD3_XDFFM_MB r0 *1 0,0
Ccc_FB_XD3_XDFFM_MB FB XD3_XDFFM_MB 1.21e-17
* device instance cc_FB_XD3_XDFFM_MFB r0 *1 0,0
Ccc_FB_XD3_XDFFM_MFB FB XD3_XDFFM_MFB 1.21e-17
* device instance cc_FB_XD3_XDFFM_S r0 *1 0,0
Ccc_FB_XD3_XDFFM_S FB XD3_XDFFM_S 1.8151e-17
* device instance cc_FB_XD3_XDFFM_SB r0 *1 0,0
Ccc_FB_XD3_XDFFM_SB FB XD3_XDFFM_SB 1.8151e-17
* device instance cc_FB_XD3_XDFFM_SFB r0 *1 0,0
Ccc_FB_XD3_XDFFM_SFB FB XD3_XDFFM_SFB 1.21e-17
* device instance cc_FB_XD3_XDFFQ_CKBB r0 *1 0,0
Ccc_FB_XD3_XDFFQ_CKBB FB XD3_XDFFQ_CKBB 1.8151e-17
* device instance cc_FB_XD3_XDFFQ_CLKB r0 *1 0,0
Ccc_FB_XD3_XDFFQ_CLKB FB XD3_XDFFQ_CLKB 2.4201e-17
* device instance cc_FB_XD3_XDFFQ_M r0 *1 0,0
Ccc_FB_XD3_XDFFQ_M FB XD3_XDFFQ_M 2.4201e-17
* device instance cc_FB_XD3_XDFFQ_MB r0 *1 0,0
Ccc_FB_XD3_XDFFQ_MB FB XD3_XDFFQ_MB 1.21e-17
* device instance cc_FB_XD3_XDFFQ_MFB r0 *1 0,0
Ccc_FB_XD3_XDFFQ_MFB FB XD3_XDFFQ_MFB 1.21e-17
* device instance cc_FB_XD3_XDFFQ_S r0 *1 0,0
Ccc_FB_XD3_XDFFQ_S FB XD3_XDFFQ_S 1.8151e-17
* device instance cc_FB_XD3_XDFFQ_SB r0 *1 0,0
Ccc_FB_XD3_XDFFQ_SB FB XD3_XDFFQ_SB 1.8151e-17
* device instance cc_FB_XD3_XDFFQ_SFB r0 *1 0,0
Ccc_FB_XD3_XDFFQ_SFB FB XD3_XDFFQ_SFB 1.21e-17
* device instance cc_FB_XD3_XNOR_midp r0 *1 0,0
Ccc_FB_XD3_XNOR_midp FB XD3_XNOR_midp 1.21e-17
* device instance cc_FB_XD3_dmodout r0 *1 0,0
Ccc_FB_XD3_dmodout FB XD3_dmodout 1.21e-17
* device instance cc_FB_XD3_dq r0 *1 0,0
Ccc_FB_XD3_dq FB XD3_dq 1.21e-17
* device instance cc_FB_XD3_nm r0 *1 0,0
Ccc_FB_XD3_nm FB XD3_nm 1.8151e-17
* device instance cc_FB_XD3_nt r0 *1 0,0
Ccc_FB_XD3_nt FB XD3_nt 2.4201e-17
* device instance cc_FB_XD3_t1 r0 *1 0,0
Ccc_FB_XD3_t1 FB XD3_t1 1.21e-17
* device instance cc_FB_XD4_XDFFM_CKBB r0 *1 0,0
Ccc_FB_XD4_XDFFM_CKBB FB XD4_XDFFM_CKBB 1.8151e-17
* device instance cc_FB_XD4_XDFFM_CLKB r0 *1 0,0
Ccc_FB_XD4_XDFFM_CLKB FB XD4_XDFFM_CLKB 2.4201e-17
* device instance cc_FB_XD4_XDFFM_M r0 *1 0,0
Ccc_FB_XD4_XDFFM_M FB XD4_XDFFM_M 2.4201e-17
* device instance cc_FB_XD4_XDFFM_MB r0 *1 0,0
Ccc_FB_XD4_XDFFM_MB FB XD4_XDFFM_MB 1.21e-17
* device instance cc_FB_XD4_XDFFM_MFB r0 *1 0,0
Ccc_FB_XD4_XDFFM_MFB FB XD4_XDFFM_MFB 1.21e-17
* device instance cc_FB_XD4_XDFFM_S r0 *1 0,0
Ccc_FB_XD4_XDFFM_S FB XD4_XDFFM_S 1.8151e-17
* device instance cc_FB_XD4_XDFFM_SB r0 *1 0,0
Ccc_FB_XD4_XDFFM_SB FB XD4_XDFFM_SB 1.8151e-17
* device instance cc_FB_XD4_XDFFM_SFB r0 *1 0,0
Ccc_FB_XD4_XDFFM_SFB FB XD4_XDFFM_SFB 1.21e-17
* device instance cc_FB_XD4_XDFFQ_CKBB r0 *1 0,0
Ccc_FB_XD4_XDFFQ_CKBB FB XD4_XDFFQ_CKBB 1.8151e-17
* device instance cc_FB_XD4_XDFFQ_CLKB r0 *1 0,0
Ccc_FB_XD4_XDFFQ_CLKB FB XD4_XDFFQ_CLKB 2.4201e-17
* device instance cc_FB_XD4_XDFFQ_M r0 *1 0,0
Ccc_FB_XD4_XDFFQ_M FB XD4_XDFFQ_M 2.4201e-17
* device instance cc_FB_XD4_XDFFQ_MB r0 *1 0,0
Ccc_FB_XD4_XDFFQ_MB FB XD4_XDFFQ_MB 1.21e-17
* device instance cc_FB_XD4_XDFFQ_MFB r0 *1 0,0
Ccc_FB_XD4_XDFFQ_MFB FB XD4_XDFFQ_MFB 1.21e-17
* device instance cc_FB_XD4_XDFFQ_S r0 *1 0,0
Ccc_FB_XD4_XDFFQ_S FB XD4_XDFFQ_S 1.8151e-17
* device instance cc_FB_XD4_XDFFQ_SB r0 *1 0,0
Ccc_FB_XD4_XDFFQ_SB FB XD4_XDFFQ_SB 1.8151e-17
* device instance cc_FB_XD4_XDFFQ_SFB r0 *1 0,0
Ccc_FB_XD4_XDFFQ_SFB FB XD4_XDFFQ_SFB 1.21e-17
* device instance cc_FB_XD4_XNOR_midp r0 *1 0,0
Ccc_FB_XD4_XNOR_midp FB XD4_XNOR_midp 1.21e-17
* device instance cc_FB_XD4_dmodout r0 *1 0,0
Ccc_FB_XD4_dmodout FB XD4_dmodout 1.21e-17
* device instance cc_FB_XD4_dq r0 *1 0,0
Ccc_FB_XD4_dq FB XD4_dq 1.21e-17
* device instance cc_FB_XD4_nm r0 *1 0,0
Ccc_FB_XD4_nm FB XD4_nm 1.8151e-17
* device instance cc_FB_XD4_nt r0 *1 0,0
Ccc_FB_XD4_nt FB XD4_nt 2.4201e-17
* device instance cc_FB_XD4_t1 r0 *1 0,0
Ccc_FB_XD4_t1 FB XD4_t1 1.21e-17
* device instance cc_FB_XD5_XDFFM_CKBB r0 *1 0,0
Ccc_FB_XD5_XDFFM_CKBB FB XD5_XDFFM_CKBB 1.8151e-17
* device instance cc_FB_XD5_XDFFM_CLKB r0 *1 0,0
Ccc_FB_XD5_XDFFM_CLKB FB XD5_XDFFM_CLKB 2.4201e-17
* device instance cc_FB_XD5_XDFFM_M r0 *1 0,0
Ccc_FB_XD5_XDFFM_M FB XD5_XDFFM_M 2.4201e-17
* device instance cc_FB_XD5_XDFFM_MB r0 *1 0,0
Ccc_FB_XD5_XDFFM_MB FB XD5_XDFFM_MB 1.21e-17
* device instance cc_FB_XD5_XDFFM_MFB r0 *1 0,0
Ccc_FB_XD5_XDFFM_MFB FB XD5_XDFFM_MFB 1.21e-17
* device instance cc_FB_XD5_XDFFM_S r0 *1 0,0
Ccc_FB_XD5_XDFFM_S FB XD5_XDFFM_S 1.8151e-17
* device instance cc_FB_XD5_XDFFM_SB r0 *1 0,0
Ccc_FB_XD5_XDFFM_SB FB XD5_XDFFM_SB 1.8151e-17
* device instance cc_FB_XD5_XDFFM_SFB r0 *1 0,0
Ccc_FB_XD5_XDFFM_SFB FB XD5_XDFFM_SFB 1.21e-17
* device instance cc_FB_XD5_XDFFQ_CKBB r0 *1 0,0
Ccc_FB_XD5_XDFFQ_CKBB FB XD5_XDFFQ_CKBB 1.8151e-17
* device instance cc_FB_XD5_XDFFQ_CLKB r0 *1 0,0
Ccc_FB_XD5_XDFFQ_CLKB FB XD5_XDFFQ_CLKB 2.4201e-17
* device instance cc_FB_XD5_XDFFQ_M r0 *1 0,0
Ccc_FB_XD5_XDFFQ_M FB XD5_XDFFQ_M 2.4201e-17
* device instance cc_FB_XD5_XDFFQ_MB r0 *1 0,0
Ccc_FB_XD5_XDFFQ_MB FB XD5_XDFFQ_MB 1.21e-17
* device instance cc_FB_XD5_XDFFQ_MFB r0 *1 0,0
Ccc_FB_XD5_XDFFQ_MFB FB XD5_XDFFQ_MFB 1.21e-17
* device instance cc_FB_XD5_XDFFQ_S r0 *1 0,0
Ccc_FB_XD5_XDFFQ_S FB XD5_XDFFQ_S 1.8151e-17
* device instance cc_FB_XD5_XDFFQ_SB r0 *1 0,0
Ccc_FB_XD5_XDFFQ_SB FB XD5_XDFFQ_SB 1.8151e-17
* device instance cc_FB_XD5_XDFFQ_SFB r0 *1 0,0
Ccc_FB_XD5_XDFFQ_SFB FB XD5_XDFFQ_SFB 1.21e-17
* device instance cc_FB_XD5_XNOR_midp r0 *1 0,0
Ccc_FB_XD5_XNOR_midp FB XD5_XNOR_midp 1.21e-17
* device instance cc_FB_XD5_dmodout r0 *1 0,0
Ccc_FB_XD5_dmodout FB XD5_dmodout 1.21e-17
* device instance cc_FB_XD5_dq r0 *1 0,0
Ccc_FB_XD5_dq FB XD5_dq 1.21e-17
* device instance cc_FB_XD5_nm r0 *1 0,0
Ccc_FB_XD5_nm FB XD5_nm 1.8151e-17
* device instance cc_FB_XD5_nt r0 *1 0,0
Ccc_FB_XD5_nt FB XD5_nt 2.4201e-17
* device instance cc_FB_XD5_t1 r0 *1 0,0
Ccc_FB_XD5_t1 FB XD5_t1 1.21e-17
* device instance cc_FB_XFRT_CKBB r0 *1 0,0
Ccc_FB_XFRT_CKBB FB XFRT_CKBB 1.8151e-17
* device instance cc_FB_XFRT_CLKB r0 *1 0,0
Ccc_FB_XFRT_CLKB FB XFRT_CLKB 2.4201e-17
* device instance cc_FB_XFRT_M r0 *1 0,0
Ccc_FB_XFRT_M FB XFRT_M 2.4201e-17
* device instance cc_FB_XFRT_MB r0 *1 0,0
Ccc_FB_XFRT_MB FB XFRT_MB 1.21e-17
* device instance cc_FB_XFRT_MFB r0 *1 0,0
Ccc_FB_XFRT_MFB FB XFRT_MFB 1.21e-17
* device instance cc_FB_XFRT_S r0 *1 0,0
Ccc_FB_XFRT_S FB XFRT_S 1.8151e-17
* device instance cc_FB_XFRT_SB r0 *1 0,0
Ccc_FB_XFRT_SB FB XFRT_SB 1.8151e-17
* device instance cc_FB_XFRT_SFB r0 *1 0,0
Ccc_FB_XFRT_SFB FB XFRT_SFB 1.21e-17
* device instance cc_FB_ck1 r0 *1 0,0
Ccc_FB_ck1 FB ck1 3.0251e-17
* device instance cc_FB_ck2 r0 *1 0,0
Ccc_FB_ck2 FB ck2 3.0251e-17
* device instance cc_FB_ck3 r0 *1 0,0
Ccc_FB_ck3 FB ck3 3.0251e-17
* device instance cc_FB_ck4 r0 *1 0,0
Ccc_FB_ck4 FB ck4 3.0251e-17
* device instance cc_FB_ck5 r0 *1 0,0
Ccc_FB_ck5 FB ck5 3.0251e-17
* device instance cc_FB_mod0 r0 *1 0,0
Ccc_FB_mod0 FB mod0 2.4201e-17
* device instance cc_FB_mod1 r0 *1 0,0
Ccc_FB_mod1 FB mod1 2.4201e-17
* device instance cc_FB_mod2 r0 *1 0,0
Ccc_FB_mod2 FB mod2 2.4201e-17
* device instance cc_FB_mod3 r0 *1 0,0
Ccc_FB_mod3 FB mod3 2.4201e-17
* device instance cc_FB_mod4 r0 *1 0,0
Ccc_FB_mod4 FB mod4 2.4201e-17
* device instance cc_FB_net1 r0 *1 0,0
Ccc_FB_net1 FB net1 1.21e-17
* device instance cc_P0_P1 r0 *1 0,0
Ccc_P0_P1 P0 P1 6.05e-18
* device instance cc_P0_P2 r0 *1 0,0
Ccc_P0_P2 P0 P2 6.05e-18
* device instance cc_P0_P3 r0 *1 0,0
Ccc_P0_P3 P0 P3 6.05e-18
* device instance cc_P0_P4 r0 *1 0,0
Ccc_P0_P4 P0 P4 6.05e-18
* device instance cc_P0_P5 r0 *1 0,0
Ccc_P0_P5 P0 P5 6.05e-18
* device instance cc_P0_VDD_DIV r0 *1 0,0
Ccc_P0_VDD_DIV P0 VDD_DIV 2.4201e-17
* device instance cc_P0_VSS r0 *1 0,0
Ccc_P0_VSS P0 VSS 7.68382e-16
* device instance cc_P0_XD0_XDFFM_CKBB r0 *1 0,0
Ccc_P0_XD0_XDFFM_CKBB P0 XD0_XDFFM_CKBB 1.8151e-17
* device instance cc_P0_XD0_XDFFM_CLKB r0 *1 0,0
Ccc_P0_XD0_XDFFM_CLKB P0 XD0_XDFFM_CLKB 2.4201e-17
* device instance cc_P0_XD0_XDFFM_M r0 *1 0,0
Ccc_P0_XD0_XDFFM_M P0 XD0_XDFFM_M 2.4201e-17
* device instance cc_P0_XD0_XDFFM_MB r0 *1 0,0
Ccc_P0_XD0_XDFFM_MB P0 XD0_XDFFM_MB 1.21e-17
* device instance cc_P0_XD0_XDFFM_MFB r0 *1 0,0
Ccc_P0_XD0_XDFFM_MFB P0 XD0_XDFFM_MFB 1.21e-17
* device instance cc_P0_XD0_XDFFM_S r0 *1 0,0
Ccc_P0_XD0_XDFFM_S P0 XD0_XDFFM_S 1.8151e-17
* device instance cc_P0_XD0_XDFFM_SB r0 *1 0,0
Ccc_P0_XD0_XDFFM_SB P0 XD0_XDFFM_SB 1.8151e-17
* device instance cc_P0_XD0_XDFFM_SFB r0 *1 0,0
Ccc_P0_XD0_XDFFM_SFB P0 XD0_XDFFM_SFB 1.21e-17
* device instance cc_P0_XD0_XDFFQ_CKBB r0 *1 0,0
Ccc_P0_XD0_XDFFQ_CKBB P0 XD0_XDFFQ_CKBB 1.8151e-17
* device instance cc_P0_XD0_XDFFQ_CLKB r0 *1 0,0
Ccc_P0_XD0_XDFFQ_CLKB P0 XD0_XDFFQ_CLKB 2.4201e-17
* device instance cc_P0_XD0_XDFFQ_M r0 *1 0,0
Ccc_P0_XD0_XDFFQ_M P0 XD0_XDFFQ_M 2.4201e-17
* device instance cc_P0_XD0_XDFFQ_MB r0 *1 0,0
Ccc_P0_XD0_XDFFQ_MB P0 XD0_XDFFQ_MB 1.21e-17
* device instance cc_P0_XD0_XDFFQ_MFB r0 *1 0,0
Ccc_P0_XD0_XDFFQ_MFB P0 XD0_XDFFQ_MFB 1.21e-17
* device instance cc_P0_XD0_XDFFQ_S r0 *1 0,0
Ccc_P0_XD0_XDFFQ_S P0 XD0_XDFFQ_S 1.8151e-17
* device instance cc_P0_XD0_XDFFQ_SB r0 *1 0,0
Ccc_P0_XD0_XDFFQ_SB P0 XD0_XDFFQ_SB 1.8151e-17
* device instance cc_P0_XD0_XDFFQ_SFB r0 *1 0,0
Ccc_P0_XD0_XDFFQ_SFB P0 XD0_XDFFQ_SFB 1.21e-17
* device instance cc_P0_XD0_XN2_mid1 r0 *1 0,0
Ccc_P0_XD0_XN2_mid1 P0 XD0_XN2_mid1 1.21e-17
* device instance cc_P0_XD0_XN3_mid1 r0 *1 0,0
Ccc_P0_XD0_XN3_mid1 P0 XD0_XN3_mid1 6.05e-18
* device instance cc_P0_XD0_XN3_mid2 r0 *1 0,0
Ccc_P0_XD0_XN3_mid2 P0 XD0_XN3_mid2 1.21e-17
* device instance cc_P0_XD0_dmodout r0 *1 0,0
Ccc_P0_XD0_dmodout P0 XD0_dmodout 1.21e-17
* device instance cc_P0_XD0_dq r0 *1 0,0
Ccc_P0_XD0_dq P0 XD0_dq 1.8151e-17
* device instance cc_P0_XD0_nm r0 *1 0,0
Ccc_P0_XD0_nm P0 XD0_nm 1.21e-17
* device instance cc_P0_XD0_nt r0 *1 0,0
Ccc_P0_XD0_nt P0 XD0_nt 1.21e-17
* device instance cc_P0_XD0_t1 r0 *1 0,0
Ccc_P0_XD0_t1 P0 XD0_t1 1.21e-17
* device instance cc_P0_XD1_XDFFM_CKBB r0 *1 0,0
Ccc_P0_XD1_XDFFM_CKBB P0 XD1_XDFFM_CKBB 1.8151e-17
* device instance cc_P0_XD1_XDFFM_CLKB r0 *1 0,0
Ccc_P0_XD1_XDFFM_CLKB P0 XD1_XDFFM_CLKB 2.4201e-17
* device instance cc_P0_XD1_XDFFM_M r0 *1 0,0
Ccc_P0_XD1_XDFFM_M P0 XD1_XDFFM_M 2.4201e-17
* device instance cc_P0_XD1_XDFFM_MB r0 *1 0,0
Ccc_P0_XD1_XDFFM_MB P0 XD1_XDFFM_MB 1.21e-17
* device instance cc_P0_XD1_XDFFM_MFB r0 *1 0,0
Ccc_P0_XD1_XDFFM_MFB P0 XD1_XDFFM_MFB 1.21e-17
* device instance cc_P0_XD1_XDFFM_S r0 *1 0,0
Ccc_P0_XD1_XDFFM_S P0 XD1_XDFFM_S 1.8151e-17
* device instance cc_P0_XD1_XDFFM_SB r0 *1 0,0
Ccc_P0_XD1_XDFFM_SB P0 XD1_XDFFM_SB 1.8151e-17
* device instance cc_P0_XD1_XDFFM_SFB r0 *1 0,0
Ccc_P0_XD1_XDFFM_SFB P0 XD1_XDFFM_SFB 1.21e-17
* device instance cc_P0_XD1_XDFFQ_CKBB r0 *1 0,0
Ccc_P0_XD1_XDFFQ_CKBB P0 XD1_XDFFQ_CKBB 1.8151e-17
* device instance cc_P0_XD1_XDFFQ_CLKB r0 *1 0,0
Ccc_P0_XD1_XDFFQ_CLKB P0 XD1_XDFFQ_CLKB 2.4201e-17
* device instance cc_P0_XD1_XDFFQ_M r0 *1 0,0
Ccc_P0_XD1_XDFFQ_M P0 XD1_XDFFQ_M 2.4201e-17
* device instance cc_P0_XD1_XDFFQ_MB r0 *1 0,0
Ccc_P0_XD1_XDFFQ_MB P0 XD1_XDFFQ_MB 1.21e-17
* device instance cc_P0_XD1_XDFFQ_MFB r0 *1 0,0
Ccc_P0_XD1_XDFFQ_MFB P0 XD1_XDFFQ_MFB 1.21e-17
* device instance cc_P0_XD1_XDFFQ_S r0 *1 0,0
Ccc_P0_XD1_XDFFQ_S P0 XD1_XDFFQ_S 1.8151e-17
* device instance cc_P0_XD1_XDFFQ_SB r0 *1 0,0
Ccc_P0_XD1_XDFFQ_SB P0 XD1_XDFFQ_SB 1.8151e-17
* device instance cc_P0_XD1_XDFFQ_SFB r0 *1 0,0
Ccc_P0_XD1_XDFFQ_SFB P0 XD1_XDFFQ_SFB 1.21e-17
* device instance cc_P0_XD1_XN2_mid1 r0 *1 0,0
Ccc_P0_XD1_XN2_mid1 P0 XD1_XN2_mid1 1.21e-17
* device instance cc_P0_XD1_XN3_mid1 r0 *1 0,0
Ccc_P0_XD1_XN3_mid1 P0 XD1_XN3_mid1 1.21e-17
* device instance cc_P0_XD1_XN3_mid2 r0 *1 0,0
Ccc_P0_XD1_XN3_mid2 P0 XD1_XN3_mid2 1.21e-17
* device instance cc_P0_XD1_dmodout r0 *1 0,0
Ccc_P0_XD1_dmodout P0 XD1_dmodout 1.21e-17
* device instance cc_P0_XD1_dq r0 *1 0,0
Ccc_P0_XD1_dq P0 XD1_dq 1.8151e-17
* device instance cc_P0_XD1_nm r0 *1 0,0
Ccc_P0_XD1_nm P0 XD1_nm 1.21e-17
* device instance cc_P0_XD1_nt r0 *1 0,0
Ccc_P0_XD1_nt P0 XD1_nt 1.21e-17
* device instance cc_P0_XD1_t1 r0 *1 0,0
Ccc_P0_XD1_t1 P0 XD1_t1 1.21e-17
* device instance cc_P0_XD2_XDFFM_CKBB r0 *1 0,0
Ccc_P0_XD2_XDFFM_CKBB P0 XD2_XDFFM_CKBB 1.8151e-17
* device instance cc_P0_XD2_XDFFM_CLKB r0 *1 0,0
Ccc_P0_XD2_XDFFM_CLKB P0 XD2_XDFFM_CLKB 2.4201e-17
* device instance cc_P0_XD2_XDFFM_M r0 *1 0,0
Ccc_P0_XD2_XDFFM_M P0 XD2_XDFFM_M 2.4201e-17
* device instance cc_P0_XD2_XDFFM_MB r0 *1 0,0
Ccc_P0_XD2_XDFFM_MB P0 XD2_XDFFM_MB 1.21e-17
* device instance cc_P0_XD2_XDFFM_MFB r0 *1 0,0
Ccc_P0_XD2_XDFFM_MFB P0 XD2_XDFFM_MFB 1.21e-17
* device instance cc_P0_XD2_XDFFM_S r0 *1 0,0
Ccc_P0_XD2_XDFFM_S P0 XD2_XDFFM_S 1.8151e-17
* device instance cc_P0_XD2_XDFFM_SB r0 *1 0,0
Ccc_P0_XD2_XDFFM_SB P0 XD2_XDFFM_SB 1.8151e-17
* device instance cc_P0_XD2_XDFFM_SFB r0 *1 0,0
Ccc_P0_XD2_XDFFM_SFB P0 XD2_XDFFM_SFB 1.21e-17
* device instance cc_P0_XD2_XDFFQ_CKBB r0 *1 0,0
Ccc_P0_XD2_XDFFQ_CKBB P0 XD2_XDFFQ_CKBB 1.8151e-17
* device instance cc_P0_XD2_XDFFQ_CLKB r0 *1 0,0
Ccc_P0_XD2_XDFFQ_CLKB P0 XD2_XDFFQ_CLKB 2.4201e-17
* device instance cc_P0_XD2_XDFFQ_M r0 *1 0,0
Ccc_P0_XD2_XDFFQ_M P0 XD2_XDFFQ_M 2.4201e-17
* device instance cc_P0_XD2_XDFFQ_MB r0 *1 0,0
Ccc_P0_XD2_XDFFQ_MB P0 XD2_XDFFQ_MB 1.21e-17
* device instance cc_P0_XD2_XDFFQ_MFB r0 *1 0,0
Ccc_P0_XD2_XDFFQ_MFB P0 XD2_XDFFQ_MFB 1.21e-17
* device instance cc_P0_XD2_XDFFQ_S r0 *1 0,0
Ccc_P0_XD2_XDFFQ_S P0 XD2_XDFFQ_S 1.8151e-17
* device instance cc_P0_XD2_XDFFQ_SB r0 *1 0,0
Ccc_P0_XD2_XDFFQ_SB P0 XD2_XDFFQ_SB 1.8151e-17
* device instance cc_P0_XD2_XDFFQ_SFB r0 *1 0,0
Ccc_P0_XD2_XDFFQ_SFB P0 XD2_XDFFQ_SFB 1.21e-17
* device instance cc_P0_XD2_XN2_mid1 r0 *1 0,0
Ccc_P0_XD2_XN2_mid1 P0 XD2_XN2_mid1 1.21e-17
* device instance cc_P0_XD2_XN3_mid1 r0 *1 0,0
Ccc_P0_XD2_XN3_mid1 P0 XD2_XN3_mid1 1.21e-17
* device instance cc_P0_XD2_XN3_mid2 r0 *1 0,0
Ccc_P0_XD2_XN3_mid2 P0 XD2_XN3_mid2 1.21e-17
* device instance cc_P0_XD2_dmodout r0 *1 0,0
Ccc_P0_XD2_dmodout P0 XD2_dmodout 1.21e-17
* device instance cc_P0_XD2_dq r0 *1 0,0
Ccc_P0_XD2_dq P0 XD2_dq 1.8151e-17
* device instance cc_P0_XD2_nm r0 *1 0,0
Ccc_P0_XD2_nm P0 XD2_nm 1.21e-17
* device instance cc_P0_XD2_nt r0 *1 0,0
Ccc_P0_XD2_nt P0 XD2_nt 1.21e-17
* device instance cc_P0_XD2_t1 r0 *1 0,0
Ccc_P0_XD2_t1 P0 XD2_t1 1.21e-17
* device instance cc_P0_XD3_XDFFM_CKBB r0 *1 0,0
Ccc_P0_XD3_XDFFM_CKBB P0 XD3_XDFFM_CKBB 1.8151e-17
* device instance cc_P0_XD3_XDFFM_CLKB r0 *1 0,0
Ccc_P0_XD3_XDFFM_CLKB P0 XD3_XDFFM_CLKB 2.4201e-17
* device instance cc_P0_XD3_XDFFM_M r0 *1 0,0
Ccc_P0_XD3_XDFFM_M P0 XD3_XDFFM_M 2.4201e-17
* device instance cc_P0_XD3_XDFFM_MB r0 *1 0,0
Ccc_P0_XD3_XDFFM_MB P0 XD3_XDFFM_MB 1.21e-17
* device instance cc_P0_XD3_XDFFM_MFB r0 *1 0,0
Ccc_P0_XD3_XDFFM_MFB P0 XD3_XDFFM_MFB 1.21e-17
* device instance cc_P0_XD3_XDFFM_S r0 *1 0,0
Ccc_P0_XD3_XDFFM_S P0 XD3_XDFFM_S 1.8151e-17
* device instance cc_P0_XD3_XDFFM_SB r0 *1 0,0
Ccc_P0_XD3_XDFFM_SB P0 XD3_XDFFM_SB 1.8151e-17
* device instance cc_P0_XD3_XDFFM_SFB r0 *1 0,0
Ccc_P0_XD3_XDFFM_SFB P0 XD3_XDFFM_SFB 1.21e-17
* device instance cc_P0_XD3_XDFFQ_CKBB r0 *1 0,0
Ccc_P0_XD3_XDFFQ_CKBB P0 XD3_XDFFQ_CKBB 1.8151e-17
* device instance cc_P0_XD3_XDFFQ_CLKB r0 *1 0,0
Ccc_P0_XD3_XDFFQ_CLKB P0 XD3_XDFFQ_CLKB 2.4201e-17
* device instance cc_P0_XD3_XDFFQ_M r0 *1 0,0
Ccc_P0_XD3_XDFFQ_M P0 XD3_XDFFQ_M 2.4201e-17
* device instance cc_P0_XD3_XDFFQ_MB r0 *1 0,0
Ccc_P0_XD3_XDFFQ_MB P0 XD3_XDFFQ_MB 1.21e-17
* device instance cc_P0_XD3_XDFFQ_MFB r0 *1 0,0
Ccc_P0_XD3_XDFFQ_MFB P0 XD3_XDFFQ_MFB 1.21e-17
* device instance cc_P0_XD3_XDFFQ_S r0 *1 0,0
Ccc_P0_XD3_XDFFQ_S P0 XD3_XDFFQ_S 1.8151e-17
* device instance cc_P0_XD3_XDFFQ_SB r0 *1 0,0
Ccc_P0_XD3_XDFFQ_SB P0 XD3_XDFFQ_SB 1.8151e-17
* device instance cc_P0_XD3_XDFFQ_SFB r0 *1 0,0
Ccc_P0_XD3_XDFFQ_SFB P0 XD3_XDFFQ_SFB 1.21e-17
* device instance cc_P0_XD3_XN2_mid1 r0 *1 0,0
Ccc_P0_XD3_XN2_mid1 P0 XD3_XN2_mid1 1.21e-17
* device instance cc_P0_XD3_XN3_mid1 r0 *1 0,0
Ccc_P0_XD3_XN3_mid1 P0 XD3_XN3_mid1 1.21e-17
* device instance cc_P0_XD3_XN3_mid2 r0 *1 0,0
Ccc_P0_XD3_XN3_mid2 P0 XD3_XN3_mid2 1.21e-17
* device instance cc_P0_XD3_dmodout r0 *1 0,0
Ccc_P0_XD3_dmodout P0 XD3_dmodout 1.21e-17
* device instance cc_P0_XD3_dq r0 *1 0,0
Ccc_P0_XD3_dq P0 XD3_dq 1.8151e-17
* device instance cc_P0_XD3_nm r0 *1 0,0
Ccc_P0_XD3_nm P0 XD3_nm 1.21e-17
* device instance cc_P0_XD3_nt r0 *1 0,0
Ccc_P0_XD3_nt P0 XD3_nt 1.21e-17
* device instance cc_P0_XD3_t1 r0 *1 0,0
Ccc_P0_XD3_t1 P0 XD3_t1 1.21e-17
* device instance cc_P0_XD4_XDFFM_CKBB r0 *1 0,0
Ccc_P0_XD4_XDFFM_CKBB P0 XD4_XDFFM_CKBB 1.8151e-17
* device instance cc_P0_XD4_XDFFM_CLKB r0 *1 0,0
Ccc_P0_XD4_XDFFM_CLKB P0 XD4_XDFFM_CLKB 2.4201e-17
* device instance cc_P0_XD4_XDFFM_M r0 *1 0,0
Ccc_P0_XD4_XDFFM_M P0 XD4_XDFFM_M 2.4201e-17
* device instance cc_P0_XD4_XDFFM_MB r0 *1 0,0
Ccc_P0_XD4_XDFFM_MB P0 XD4_XDFFM_MB 1.21e-17
* device instance cc_P0_XD4_XDFFM_MFB r0 *1 0,0
Ccc_P0_XD4_XDFFM_MFB P0 XD4_XDFFM_MFB 1.21e-17
* device instance cc_P0_XD4_XDFFM_S r0 *1 0,0
Ccc_P0_XD4_XDFFM_S P0 XD4_XDFFM_S 1.8151e-17
* device instance cc_P0_XD4_XDFFM_SB r0 *1 0,0
Ccc_P0_XD4_XDFFM_SB P0 XD4_XDFFM_SB 1.8151e-17
* device instance cc_P0_XD4_XDFFM_SFB r0 *1 0,0
Ccc_P0_XD4_XDFFM_SFB P0 XD4_XDFFM_SFB 1.21e-17
* device instance cc_P0_XD4_XDFFQ_CKBB r0 *1 0,0
Ccc_P0_XD4_XDFFQ_CKBB P0 XD4_XDFFQ_CKBB 1.8151e-17
* device instance cc_P0_XD4_XDFFQ_CLKB r0 *1 0,0
Ccc_P0_XD4_XDFFQ_CLKB P0 XD4_XDFFQ_CLKB 2.4201e-17
* device instance cc_P0_XD4_XDFFQ_M r0 *1 0,0
Ccc_P0_XD4_XDFFQ_M P0 XD4_XDFFQ_M 2.4201e-17
* device instance cc_P0_XD4_XDFFQ_MB r0 *1 0,0
Ccc_P0_XD4_XDFFQ_MB P0 XD4_XDFFQ_MB 1.21e-17
* device instance cc_P0_XD4_XDFFQ_MFB r0 *1 0,0
Ccc_P0_XD4_XDFFQ_MFB P0 XD4_XDFFQ_MFB 1.21e-17
* device instance cc_P0_XD4_XDFFQ_S r0 *1 0,0
Ccc_P0_XD4_XDFFQ_S P0 XD4_XDFFQ_S 1.8151e-17
* device instance cc_P0_XD4_XDFFQ_SB r0 *1 0,0
Ccc_P0_XD4_XDFFQ_SB P0 XD4_XDFFQ_SB 1.8151e-17
* device instance cc_P0_XD4_XDFFQ_SFB r0 *1 0,0
Ccc_P0_XD4_XDFFQ_SFB P0 XD4_XDFFQ_SFB 1.21e-17
* device instance cc_P0_XD4_XN2_mid1 r0 *1 0,0
Ccc_P0_XD4_XN2_mid1 P0 XD4_XN2_mid1 1.21e-17
* device instance cc_P0_XD4_XN3_mid1 r0 *1 0,0
Ccc_P0_XD4_XN3_mid1 P0 XD4_XN3_mid1 1.21e-17
* device instance cc_P0_XD4_XN3_mid2 r0 *1 0,0
Ccc_P0_XD4_XN3_mid2 P0 XD4_XN3_mid2 1.21e-17
* device instance cc_P0_XD4_dmodout r0 *1 0,0
Ccc_P0_XD4_dmodout P0 XD4_dmodout 1.21e-17
* device instance cc_P0_XD4_dq r0 *1 0,0
Ccc_P0_XD4_dq P0 XD4_dq 1.8151e-17
* device instance cc_P0_XD4_nm r0 *1 0,0
Ccc_P0_XD4_nm P0 XD4_nm 1.21e-17
* device instance cc_P0_XD4_nt r0 *1 0,0
Ccc_P0_XD4_nt P0 XD4_nt 1.21e-17
* device instance cc_P0_XD4_t1 r0 *1 0,0
Ccc_P0_XD4_t1 P0 XD4_t1 1.21e-17
* device instance cc_P0_XD5_XDFFM_CKBB r0 *1 0,0
Ccc_P0_XD5_XDFFM_CKBB P0 XD5_XDFFM_CKBB 1.8151e-17
* device instance cc_P0_XD5_XDFFM_CLKB r0 *1 0,0
Ccc_P0_XD5_XDFFM_CLKB P0 XD5_XDFFM_CLKB 2.4201e-17
* device instance cc_P0_XD5_XDFFM_M r0 *1 0,0
Ccc_P0_XD5_XDFFM_M P0 XD5_XDFFM_M 2.4201e-17
* device instance cc_P0_XD5_XDFFM_MB r0 *1 0,0
Ccc_P0_XD5_XDFFM_MB P0 XD5_XDFFM_MB 1.21e-17
* device instance cc_P0_XD5_XDFFM_MFB r0 *1 0,0
Ccc_P0_XD5_XDFFM_MFB P0 XD5_XDFFM_MFB 1.21e-17
* device instance cc_P0_XD5_XDFFM_S r0 *1 0,0
Ccc_P0_XD5_XDFFM_S P0 XD5_XDFFM_S 1.8151e-17
* device instance cc_P0_XD5_XDFFM_SB r0 *1 0,0
Ccc_P0_XD5_XDFFM_SB P0 XD5_XDFFM_SB 1.8151e-17
* device instance cc_P0_XD5_XDFFM_SFB r0 *1 0,0
Ccc_P0_XD5_XDFFM_SFB P0 XD5_XDFFM_SFB 1.21e-17
* device instance cc_P0_XD5_XDFFQ_CKBB r0 *1 0,0
Ccc_P0_XD5_XDFFQ_CKBB P0 XD5_XDFFQ_CKBB 1.8151e-17
* device instance cc_P0_XD5_XDFFQ_CLKB r0 *1 0,0
Ccc_P0_XD5_XDFFQ_CLKB P0 XD5_XDFFQ_CLKB 2.4201e-17
* device instance cc_P0_XD5_XDFFQ_M r0 *1 0,0
Ccc_P0_XD5_XDFFQ_M P0 XD5_XDFFQ_M 2.4201e-17
* device instance cc_P0_XD5_XDFFQ_MB r0 *1 0,0
Ccc_P0_XD5_XDFFQ_MB P0 XD5_XDFFQ_MB 1.21e-17
* device instance cc_P0_XD5_XDFFQ_MFB r0 *1 0,0
Ccc_P0_XD5_XDFFQ_MFB P0 XD5_XDFFQ_MFB 1.21e-17
* device instance cc_P0_XD5_XDFFQ_S r0 *1 0,0
Ccc_P0_XD5_XDFFQ_S P0 XD5_XDFFQ_S 1.8151e-17
* device instance cc_P0_XD5_XDFFQ_SB r0 *1 0,0
Ccc_P0_XD5_XDFFQ_SB P0 XD5_XDFFQ_SB 1.8151e-17
* device instance cc_P0_XD5_XDFFQ_SFB r0 *1 0,0
Ccc_P0_XD5_XDFFQ_SFB P0 XD5_XDFFQ_SFB 1.21e-17
* device instance cc_P0_XD5_XN2_mid1 r0 *1 0,0
Ccc_P0_XD5_XN2_mid1 P0 XD5_XN2_mid1 1.21e-17
* device instance cc_P0_XD5_XN3_mid1 r0 *1 0,0
Ccc_P0_XD5_XN3_mid1 P0 XD5_XN3_mid1 1.21e-17
* device instance cc_P0_XD5_XN3_mid2 r0 *1 0,0
Ccc_P0_XD5_XN3_mid2 P0 XD5_XN3_mid2 1.21e-17
* device instance cc_P0_XD5_dmodout r0 *1 0,0
Ccc_P0_XD5_dmodout P0 XD5_dmodout 1.21e-17
* device instance cc_P0_XD5_dq r0 *1 0,0
Ccc_P0_XD5_dq P0 XD5_dq 1.8151e-17
* device instance cc_P0_XD5_nm r0 *1 0,0
Ccc_P0_XD5_nm P0 XD5_nm 1.21e-17
* device instance cc_P0_XD5_nt r0 *1 0,0
Ccc_P0_XD5_nt P0 XD5_nt 1.21e-17
* device instance cc_P0_XD5_t1 r0 *1 0,0
Ccc_P0_XD5_t1 P0 XD5_t1 1.21e-17
* device instance cc_P0_XFRT_CKBB r0 *1 0,0
Ccc_P0_XFRT_CKBB P0 XFRT_CKBB 1.8151e-17
* device instance cc_P0_XFRT_CLKB r0 *1 0,0
Ccc_P0_XFRT_CLKB P0 XFRT_CLKB 2.4201e-17
* device instance cc_P0_XFRT_M r0 *1 0,0
Ccc_P0_XFRT_M P0 XFRT_M 2.4201e-17
* device instance cc_P0_XFRT_MB r0 *1 0,0
Ccc_P0_XFRT_MB P0 XFRT_MB 1.21e-17
* device instance cc_P0_XFRT_MFB r0 *1 0,0
Ccc_P0_XFRT_MFB P0 XFRT_MFB 1.21e-17
* device instance cc_P0_XFRT_S r0 *1 0,0
Ccc_P0_XFRT_S P0 XFRT_S 1.8151e-17
* device instance cc_P0_XFRT_SB r0 *1 0,0
Ccc_P0_XFRT_SB P0 XFRT_SB 1.8151e-17
* device instance cc_P0_XFRT_SFB r0 *1 0,0
Ccc_P0_XFRT_SFB P0 XFRT_SFB 1.21e-17
* device instance cc_P0_ck1 r0 *1 0,0
Ccc_P0_ck1 P0 ck1 3.0251e-17
* device instance cc_P0_ck2 r0 *1 0,0
Ccc_P0_ck2 P0 ck2 3.0251e-17
* device instance cc_P0_ck3 r0 *1 0,0
Ccc_P0_ck3 P0 ck3 3.0251e-17
* device instance cc_P0_ck4 r0 *1 0,0
Ccc_P0_ck4 P0 ck4 3.0251e-17
* device instance cc_P0_ck5 r0 *1 0,0
Ccc_P0_ck5 P0 ck5 3.0251e-17
* device instance cc_P0_mod0 r0 *1 0,0
Ccc_P0_mod0 P0 mod0 2.4201e-17
* device instance cc_P0_mod1 r0 *1 0,0
Ccc_P0_mod1 P0 mod1 2.4201e-17
* device instance cc_P0_mod2 r0 *1 0,0
Ccc_P0_mod2 P0 mod2 2.4201e-17
* device instance cc_P0_mod3 r0 *1 0,0
Ccc_P0_mod3 P0 mod3 2.4201e-17
* device instance cc_P0_mod4 r0 *1 0,0
Ccc_P0_mod4 P0 mod4 2.4201e-17
* device instance cc_P0_net1 r0 *1 0,0
Ccc_P0_net1 P0 net1 1.21e-17
* device instance cc_P1_P2 r0 *1 0,0
Ccc_P1_P2 P1 P2 6.05e-18
* device instance cc_P1_P3 r0 *1 0,0
Ccc_P1_P3 P1 P3 6.05e-18
* device instance cc_P1_P4 r0 *1 0,0
Ccc_P1_P4 P1 P4 6.05e-18
* device instance cc_P1_P5 r0 *1 0,0
Ccc_P1_P5 P1 P5 6.05e-18
* device instance cc_P1_VDD_DIV r0 *1 0,0
Ccc_P1_VDD_DIV P1 VDD_DIV 1.57306e-16
* device instance cc_P1_VSS r0 *1 0,0
Ccc_P1_VSS P1 VSS 6.47377e-16
* device instance cc_P1_XD0_XDFFM_CKBB r0 *1 0,0
Ccc_P1_XD0_XDFFM_CKBB P1 XD0_XDFFM_CKBB 1.8151e-17
* device instance cc_P1_XD0_XDFFM_CLKB r0 *1 0,0
Ccc_P1_XD0_XDFFM_CLKB P1 XD0_XDFFM_CLKB 2.4201e-17
* device instance cc_P1_XD0_XDFFM_M r0 *1 0,0
Ccc_P1_XD0_XDFFM_M P1 XD0_XDFFM_M 2.4201e-17
* device instance cc_P1_XD0_XDFFM_MB r0 *1 0,0
Ccc_P1_XD0_XDFFM_MB P1 XD0_XDFFM_MB 1.21e-17
* device instance cc_P1_XD0_XDFFM_MFB r0 *1 0,0
Ccc_P1_XD0_XDFFM_MFB P1 XD0_XDFFM_MFB 1.21e-17
* device instance cc_P1_XD0_XDFFM_S r0 *1 0,0
Ccc_P1_XD0_XDFFM_S P1 XD0_XDFFM_S 1.8151e-17
* device instance cc_P1_XD0_XDFFM_SB r0 *1 0,0
Ccc_P1_XD0_XDFFM_SB P1 XD0_XDFFM_SB 1.8151e-17
* device instance cc_P1_XD0_XDFFM_SFB r0 *1 0,0
Ccc_P1_XD0_XDFFM_SFB P1 XD0_XDFFM_SFB 1.21e-17
* device instance cc_P1_XD0_XDFFQ_CKBB r0 *1 0,0
Ccc_P1_XD0_XDFFQ_CKBB P1 XD0_XDFFQ_CKBB 1.8151e-17
* device instance cc_P1_XD0_XDFFQ_CLKB r0 *1 0,0
Ccc_P1_XD0_XDFFQ_CLKB P1 XD0_XDFFQ_CLKB 2.4201e-17
* device instance cc_P1_XD0_XDFFQ_M r0 *1 0,0
Ccc_P1_XD0_XDFFQ_M P1 XD0_XDFFQ_M 2.4201e-17
* device instance cc_P1_XD0_XDFFQ_MB r0 *1 0,0
Ccc_P1_XD0_XDFFQ_MB P1 XD0_XDFFQ_MB 1.21e-17
* device instance cc_P1_XD0_XDFFQ_MFB r0 *1 0,0
Ccc_P1_XD0_XDFFQ_MFB P1 XD0_XDFFQ_MFB 1.21e-17
* device instance cc_P1_XD0_XDFFQ_S r0 *1 0,0
Ccc_P1_XD0_XDFFQ_S P1 XD0_XDFFQ_S 1.8151e-17
* device instance cc_P1_XD0_XDFFQ_SB r0 *1 0,0
Ccc_P1_XD0_XDFFQ_SB P1 XD0_XDFFQ_SB 1.8151e-17
* device instance cc_P1_XD0_XDFFQ_SFB r0 *1 0,0
Ccc_P1_XD0_XDFFQ_SFB P1 XD0_XDFFQ_SFB 1.21e-17
* device instance cc_P1_XD0_XNOR_midp r0 *1 0,0
Ccc_P1_XD0_XNOR_midp P1 XD0_XNOR_midp 1.21e-17
* device instance cc_P1_XD0_dmodout r0 *1 0,0
Ccc_P1_XD0_dmodout P1 XD0_dmodout 1.21e-17
* device instance cc_P1_XD0_dq r0 *1 0,0
Ccc_P1_XD0_dq P1 XD0_dq 1.21e-17
* device instance cc_P1_XD0_nm r0 *1 0,0
Ccc_P1_XD0_nm P1 XD0_nm 1.8151e-17
* device instance cc_P1_XD0_nt r0 *1 0,0
Ccc_P1_XD0_nt P1 XD0_nt 2.4201e-17
* device instance cc_P1_XD0_t1 r0 *1 0,0
Ccc_P1_XD0_t1 P1 XD0_t1 1.21e-17
* device instance cc_P1_XD1_XDFFM_CKBB r0 *1 0,0
Ccc_P1_XD1_XDFFM_CKBB P1 XD1_XDFFM_CKBB 1.8151e-17
* device instance cc_P1_XD1_XDFFM_CLKB r0 *1 0,0
Ccc_P1_XD1_XDFFM_CLKB P1 XD1_XDFFM_CLKB 2.4201e-17
* device instance cc_P1_XD1_XDFFM_M r0 *1 0,0
Ccc_P1_XD1_XDFFM_M P1 XD1_XDFFM_M 2.4201e-17
* device instance cc_P1_XD1_XDFFM_MB r0 *1 0,0
Ccc_P1_XD1_XDFFM_MB P1 XD1_XDFFM_MB 1.21e-17
* device instance cc_P1_XD1_XDFFM_MFB r0 *1 0,0
Ccc_P1_XD1_XDFFM_MFB P1 XD1_XDFFM_MFB 1.21e-17
* device instance cc_P1_XD1_XDFFM_S r0 *1 0,0
Ccc_P1_XD1_XDFFM_S P1 XD1_XDFFM_S 1.8151e-17
* device instance cc_P1_XD1_XDFFM_SB r0 *1 0,0
Ccc_P1_XD1_XDFFM_SB P1 XD1_XDFFM_SB 1.8151e-17
* device instance cc_P1_XD1_XDFFM_SFB r0 *1 0,0
Ccc_P1_XD1_XDFFM_SFB P1 XD1_XDFFM_SFB 1.21e-17
* device instance cc_P1_XD1_XDFFQ_CKBB r0 *1 0,0
Ccc_P1_XD1_XDFFQ_CKBB P1 XD1_XDFFQ_CKBB 1.8151e-17
* device instance cc_P1_XD1_XDFFQ_CLKB r0 *1 0,0
Ccc_P1_XD1_XDFFQ_CLKB P1 XD1_XDFFQ_CLKB 2.4201e-17
* device instance cc_P1_XD1_XDFFQ_M r0 *1 0,0
Ccc_P1_XD1_XDFFQ_M P1 XD1_XDFFQ_M 2.4201e-17
* device instance cc_P1_XD1_XDFFQ_MB r0 *1 0,0
Ccc_P1_XD1_XDFFQ_MB P1 XD1_XDFFQ_MB 1.21e-17
* device instance cc_P1_XD1_XDFFQ_MFB r0 *1 0,0
Ccc_P1_XD1_XDFFQ_MFB P1 XD1_XDFFQ_MFB 1.21e-17
* device instance cc_P1_XD1_XDFFQ_S r0 *1 0,0
Ccc_P1_XD1_XDFFQ_S P1 XD1_XDFFQ_S 1.8151e-17
* device instance cc_P1_XD1_XDFFQ_SB r0 *1 0,0
Ccc_P1_XD1_XDFFQ_SB P1 XD1_XDFFQ_SB 1.8151e-17
* device instance cc_P1_XD1_XDFFQ_SFB r0 *1 0,0
Ccc_P1_XD1_XDFFQ_SFB P1 XD1_XDFFQ_SFB 1.21e-17
* device instance cc_P1_XD1_XN2_mid1 r0 *1 0,0
Ccc_P1_XD1_XN2_mid1 P1 XD1_XN2_mid1 1.21e-17
* device instance cc_P1_XD1_XN3_mid1 r0 *1 0,0
Ccc_P1_XD1_XN3_mid1 P1 XD1_XN3_mid1 6.05e-18
* device instance cc_P1_XD1_XN3_mid2 r0 *1 0,0
Ccc_P1_XD1_XN3_mid2 P1 XD1_XN3_mid2 1.21e-17
* device instance cc_P1_XD1_dmodout r0 *1 0,0
Ccc_P1_XD1_dmodout P1 XD1_dmodout 1.21e-17
* device instance cc_P1_XD1_dq r0 *1 0,0
Ccc_P1_XD1_dq P1 XD1_dq 1.8151e-17
* device instance cc_P1_XD1_nm r0 *1 0,0
Ccc_P1_XD1_nm P1 XD1_nm 1.21e-17
* device instance cc_P1_XD1_nt r0 *1 0,0
Ccc_P1_XD1_nt P1 XD1_nt 1.21e-17
* device instance cc_P1_XD1_t1 r0 *1 0,0
Ccc_P1_XD1_t1 P1 XD1_t1 1.21e-17
* device instance cc_P1_XD2_XDFFM_CKBB r0 *1 0,0
Ccc_P1_XD2_XDFFM_CKBB P1 XD2_XDFFM_CKBB 1.8151e-17
* device instance cc_P1_XD2_XDFFM_CLKB r0 *1 0,0
Ccc_P1_XD2_XDFFM_CLKB P1 XD2_XDFFM_CLKB 2.4201e-17
* device instance cc_P1_XD2_XDFFM_M r0 *1 0,0
Ccc_P1_XD2_XDFFM_M P1 XD2_XDFFM_M 2.4201e-17
* device instance cc_P1_XD2_XDFFM_MB r0 *1 0,0
Ccc_P1_XD2_XDFFM_MB P1 XD2_XDFFM_MB 1.21e-17
* device instance cc_P1_XD2_XDFFM_MFB r0 *1 0,0
Ccc_P1_XD2_XDFFM_MFB P1 XD2_XDFFM_MFB 1.21e-17
* device instance cc_P1_XD2_XDFFM_S r0 *1 0,0
Ccc_P1_XD2_XDFFM_S P1 XD2_XDFFM_S 1.8151e-17
* device instance cc_P1_XD2_XDFFM_SB r0 *1 0,0
Ccc_P1_XD2_XDFFM_SB P1 XD2_XDFFM_SB 1.8151e-17
* device instance cc_P1_XD2_XDFFM_SFB r0 *1 0,0
Ccc_P1_XD2_XDFFM_SFB P1 XD2_XDFFM_SFB 1.21e-17
* device instance cc_P1_XD2_XDFFQ_CKBB r0 *1 0,0
Ccc_P1_XD2_XDFFQ_CKBB P1 XD2_XDFFQ_CKBB 1.8151e-17
* device instance cc_P1_XD2_XDFFQ_CLKB r0 *1 0,0
Ccc_P1_XD2_XDFFQ_CLKB P1 XD2_XDFFQ_CLKB 2.4201e-17
* device instance cc_P1_XD2_XDFFQ_M r0 *1 0,0
Ccc_P1_XD2_XDFFQ_M P1 XD2_XDFFQ_M 2.4201e-17
* device instance cc_P1_XD2_XDFFQ_MB r0 *1 0,0
Ccc_P1_XD2_XDFFQ_MB P1 XD2_XDFFQ_MB 1.21e-17
* device instance cc_P1_XD2_XDFFQ_MFB r0 *1 0,0
Ccc_P1_XD2_XDFFQ_MFB P1 XD2_XDFFQ_MFB 1.21e-17
* device instance cc_P1_XD2_XDFFQ_S r0 *1 0,0
Ccc_P1_XD2_XDFFQ_S P1 XD2_XDFFQ_S 1.8151e-17
* device instance cc_P1_XD2_XDFFQ_SB r0 *1 0,0
Ccc_P1_XD2_XDFFQ_SB P1 XD2_XDFFQ_SB 1.8151e-17
* device instance cc_P1_XD2_XDFFQ_SFB r0 *1 0,0
Ccc_P1_XD2_XDFFQ_SFB P1 XD2_XDFFQ_SFB 1.21e-17
* device instance cc_P1_XD2_XN2_mid1 r0 *1 0,0
Ccc_P1_XD2_XN2_mid1 P1 XD2_XN2_mid1 1.21e-17
* device instance cc_P1_XD2_XN3_mid1 r0 *1 0,0
Ccc_P1_XD2_XN3_mid1 P1 XD2_XN3_mid1 1.21e-17
* device instance cc_P1_XD2_XN3_mid2 r0 *1 0,0
Ccc_P1_XD2_XN3_mid2 P1 XD2_XN3_mid2 1.21e-17
* device instance cc_P1_XD2_dmodout r0 *1 0,0
Ccc_P1_XD2_dmodout P1 XD2_dmodout 1.21e-17
* device instance cc_P1_XD2_dq r0 *1 0,0
Ccc_P1_XD2_dq P1 XD2_dq 1.8151e-17
* device instance cc_P1_XD2_nm r0 *1 0,0
Ccc_P1_XD2_nm P1 XD2_nm 1.21e-17
* device instance cc_P1_XD2_nt r0 *1 0,0
Ccc_P1_XD2_nt P1 XD2_nt 1.21e-17
* device instance cc_P1_XD2_t1 r0 *1 0,0
Ccc_P1_XD2_t1 P1 XD2_t1 1.21e-17
* device instance cc_P1_XD3_XDFFM_CKBB r0 *1 0,0
Ccc_P1_XD3_XDFFM_CKBB P1 XD3_XDFFM_CKBB 1.8151e-17
* device instance cc_P1_XD3_XDFFM_CLKB r0 *1 0,0
Ccc_P1_XD3_XDFFM_CLKB P1 XD3_XDFFM_CLKB 2.4201e-17
* device instance cc_P1_XD3_XDFFM_M r0 *1 0,0
Ccc_P1_XD3_XDFFM_M P1 XD3_XDFFM_M 2.4201e-17
* device instance cc_P1_XD3_XDFFM_MB r0 *1 0,0
Ccc_P1_XD3_XDFFM_MB P1 XD3_XDFFM_MB 1.21e-17
* device instance cc_P1_XD3_XDFFM_MFB r0 *1 0,0
Ccc_P1_XD3_XDFFM_MFB P1 XD3_XDFFM_MFB 1.21e-17
* device instance cc_P1_XD3_XDFFM_S r0 *1 0,0
Ccc_P1_XD3_XDFFM_S P1 XD3_XDFFM_S 1.8151e-17
* device instance cc_P1_XD3_XDFFM_SB r0 *1 0,0
Ccc_P1_XD3_XDFFM_SB P1 XD3_XDFFM_SB 1.8151e-17
* device instance cc_P1_XD3_XDFFM_SFB r0 *1 0,0
Ccc_P1_XD3_XDFFM_SFB P1 XD3_XDFFM_SFB 1.21e-17
* device instance cc_P1_XD3_XDFFQ_CKBB r0 *1 0,0
Ccc_P1_XD3_XDFFQ_CKBB P1 XD3_XDFFQ_CKBB 1.8151e-17
* device instance cc_P1_XD3_XDFFQ_CLKB r0 *1 0,0
Ccc_P1_XD3_XDFFQ_CLKB P1 XD3_XDFFQ_CLKB 2.4201e-17
* device instance cc_P1_XD3_XDFFQ_M r0 *1 0,0
Ccc_P1_XD3_XDFFQ_M P1 XD3_XDFFQ_M 2.4201e-17
* device instance cc_P1_XD3_XDFFQ_MB r0 *1 0,0
Ccc_P1_XD3_XDFFQ_MB P1 XD3_XDFFQ_MB 1.21e-17
* device instance cc_P1_XD3_XDFFQ_MFB r0 *1 0,0
Ccc_P1_XD3_XDFFQ_MFB P1 XD3_XDFFQ_MFB 1.21e-17
* device instance cc_P1_XD3_XDFFQ_S r0 *1 0,0
Ccc_P1_XD3_XDFFQ_S P1 XD3_XDFFQ_S 1.8151e-17
* device instance cc_P1_XD3_XDFFQ_SB r0 *1 0,0
Ccc_P1_XD3_XDFFQ_SB P1 XD3_XDFFQ_SB 1.8151e-17
* device instance cc_P1_XD3_XDFFQ_SFB r0 *1 0,0
Ccc_P1_XD3_XDFFQ_SFB P1 XD3_XDFFQ_SFB 1.21e-17
* device instance cc_P1_XD3_XN2_mid1 r0 *1 0,0
Ccc_P1_XD3_XN2_mid1 P1 XD3_XN2_mid1 1.21e-17
* device instance cc_P1_XD3_XN3_mid1 r0 *1 0,0
Ccc_P1_XD3_XN3_mid1 P1 XD3_XN3_mid1 1.21e-17
* device instance cc_P1_XD3_XN3_mid2 r0 *1 0,0
Ccc_P1_XD3_XN3_mid2 P1 XD3_XN3_mid2 1.21e-17
* device instance cc_P1_XD3_dmodout r0 *1 0,0
Ccc_P1_XD3_dmodout P1 XD3_dmodout 1.21e-17
* device instance cc_P1_XD3_dq r0 *1 0,0
Ccc_P1_XD3_dq P1 XD3_dq 1.8151e-17
* device instance cc_P1_XD3_nm r0 *1 0,0
Ccc_P1_XD3_nm P1 XD3_nm 1.21e-17
* device instance cc_P1_XD3_nt r0 *1 0,0
Ccc_P1_XD3_nt P1 XD3_nt 1.21e-17
* device instance cc_P1_XD3_t1 r0 *1 0,0
Ccc_P1_XD3_t1 P1 XD3_t1 1.21e-17
* device instance cc_P1_XD4_XDFFM_CKBB r0 *1 0,0
Ccc_P1_XD4_XDFFM_CKBB P1 XD4_XDFFM_CKBB 1.8151e-17
* device instance cc_P1_XD4_XDFFM_CLKB r0 *1 0,0
Ccc_P1_XD4_XDFFM_CLKB P1 XD4_XDFFM_CLKB 2.4201e-17
* device instance cc_P1_XD4_XDFFM_M r0 *1 0,0
Ccc_P1_XD4_XDFFM_M P1 XD4_XDFFM_M 2.4201e-17
* device instance cc_P1_XD4_XDFFM_MB r0 *1 0,0
Ccc_P1_XD4_XDFFM_MB P1 XD4_XDFFM_MB 1.21e-17
* device instance cc_P1_XD4_XDFFM_MFB r0 *1 0,0
Ccc_P1_XD4_XDFFM_MFB P1 XD4_XDFFM_MFB 1.21e-17
* device instance cc_P1_XD4_XDFFM_S r0 *1 0,0
Ccc_P1_XD4_XDFFM_S P1 XD4_XDFFM_S 1.8151e-17
* device instance cc_P1_XD4_XDFFM_SB r0 *1 0,0
Ccc_P1_XD4_XDFFM_SB P1 XD4_XDFFM_SB 1.8151e-17
* device instance cc_P1_XD4_XDFFM_SFB r0 *1 0,0
Ccc_P1_XD4_XDFFM_SFB P1 XD4_XDFFM_SFB 1.21e-17
* device instance cc_P1_XD4_XDFFQ_CKBB r0 *1 0,0
Ccc_P1_XD4_XDFFQ_CKBB P1 XD4_XDFFQ_CKBB 1.8151e-17
* device instance cc_P1_XD4_XDFFQ_CLKB r0 *1 0,0
Ccc_P1_XD4_XDFFQ_CLKB P1 XD4_XDFFQ_CLKB 2.4201e-17
* device instance cc_P1_XD4_XDFFQ_M r0 *1 0,0
Ccc_P1_XD4_XDFFQ_M P1 XD4_XDFFQ_M 2.4201e-17
* device instance cc_P1_XD4_XDFFQ_MB r0 *1 0,0
Ccc_P1_XD4_XDFFQ_MB P1 XD4_XDFFQ_MB 1.21e-17
* device instance cc_P1_XD4_XDFFQ_MFB r0 *1 0,0
Ccc_P1_XD4_XDFFQ_MFB P1 XD4_XDFFQ_MFB 1.21e-17
* device instance cc_P1_XD4_XDFFQ_S r0 *1 0,0
Ccc_P1_XD4_XDFFQ_S P1 XD4_XDFFQ_S 1.8151e-17
* device instance cc_P1_XD4_XDFFQ_SB r0 *1 0,0
Ccc_P1_XD4_XDFFQ_SB P1 XD4_XDFFQ_SB 1.8151e-17
* device instance cc_P1_XD4_XDFFQ_SFB r0 *1 0,0
Ccc_P1_XD4_XDFFQ_SFB P1 XD4_XDFFQ_SFB 1.21e-17
* device instance cc_P1_XD4_XN2_mid1 r0 *1 0,0
Ccc_P1_XD4_XN2_mid1 P1 XD4_XN2_mid1 1.21e-17
* device instance cc_P1_XD4_XN3_mid1 r0 *1 0,0
Ccc_P1_XD4_XN3_mid1 P1 XD4_XN3_mid1 1.21e-17
* device instance cc_P1_XD4_XN3_mid2 r0 *1 0,0
Ccc_P1_XD4_XN3_mid2 P1 XD4_XN3_mid2 1.21e-17
* device instance cc_P1_XD4_dmodout r0 *1 0,0
Ccc_P1_XD4_dmodout P1 XD4_dmodout 1.21e-17
* device instance cc_P1_XD4_dq r0 *1 0,0
Ccc_P1_XD4_dq P1 XD4_dq 1.8151e-17
* device instance cc_P1_XD4_nm r0 *1 0,0
Ccc_P1_XD4_nm P1 XD4_nm 1.21e-17
* device instance cc_P1_XD4_nt r0 *1 0,0
Ccc_P1_XD4_nt P1 XD4_nt 1.21e-17
* device instance cc_P1_XD4_t1 r0 *1 0,0
Ccc_P1_XD4_t1 P1 XD4_t1 1.21e-17
* device instance cc_P1_XD5_XDFFM_CKBB r0 *1 0,0
Ccc_P1_XD5_XDFFM_CKBB P1 XD5_XDFFM_CKBB 1.8151e-17
* device instance cc_P1_XD5_XDFFM_CLKB r0 *1 0,0
Ccc_P1_XD5_XDFFM_CLKB P1 XD5_XDFFM_CLKB 2.4201e-17
* device instance cc_P1_XD5_XDFFM_M r0 *1 0,0
Ccc_P1_XD5_XDFFM_M P1 XD5_XDFFM_M 2.4201e-17
* device instance cc_P1_XD5_XDFFM_MB r0 *1 0,0
Ccc_P1_XD5_XDFFM_MB P1 XD5_XDFFM_MB 1.21e-17
* device instance cc_P1_XD5_XDFFM_MFB r0 *1 0,0
Ccc_P1_XD5_XDFFM_MFB P1 XD5_XDFFM_MFB 1.21e-17
* device instance cc_P1_XD5_XDFFM_S r0 *1 0,0
Ccc_P1_XD5_XDFFM_S P1 XD5_XDFFM_S 1.8151e-17
* device instance cc_P1_XD5_XDFFM_SB r0 *1 0,0
Ccc_P1_XD5_XDFFM_SB P1 XD5_XDFFM_SB 1.8151e-17
* device instance cc_P1_XD5_XDFFM_SFB r0 *1 0,0
Ccc_P1_XD5_XDFFM_SFB P1 XD5_XDFFM_SFB 1.21e-17
* device instance cc_P1_XD5_XDFFQ_CKBB r0 *1 0,0
Ccc_P1_XD5_XDFFQ_CKBB P1 XD5_XDFFQ_CKBB 1.8151e-17
* device instance cc_P1_XD5_XDFFQ_CLKB r0 *1 0,0
Ccc_P1_XD5_XDFFQ_CLKB P1 XD5_XDFFQ_CLKB 2.4201e-17
* device instance cc_P1_XD5_XDFFQ_M r0 *1 0,0
Ccc_P1_XD5_XDFFQ_M P1 XD5_XDFFQ_M 2.4201e-17
* device instance cc_P1_XD5_XDFFQ_MB r0 *1 0,0
Ccc_P1_XD5_XDFFQ_MB P1 XD5_XDFFQ_MB 1.21e-17
* device instance cc_P1_XD5_XDFFQ_MFB r0 *1 0,0
Ccc_P1_XD5_XDFFQ_MFB P1 XD5_XDFFQ_MFB 1.21e-17
* device instance cc_P1_XD5_XDFFQ_S r0 *1 0,0
Ccc_P1_XD5_XDFFQ_S P1 XD5_XDFFQ_S 1.8151e-17
* device instance cc_P1_XD5_XDFFQ_SB r0 *1 0,0
Ccc_P1_XD5_XDFFQ_SB P1 XD5_XDFFQ_SB 1.8151e-17
* device instance cc_P1_XD5_XDFFQ_SFB r0 *1 0,0
Ccc_P1_XD5_XDFFQ_SFB P1 XD5_XDFFQ_SFB 1.21e-17
* device instance cc_P1_XD5_XN2_mid1 r0 *1 0,0
Ccc_P1_XD5_XN2_mid1 P1 XD5_XN2_mid1 1.21e-17
* device instance cc_P1_XD5_XN3_mid1 r0 *1 0,0
Ccc_P1_XD5_XN3_mid1 P1 XD5_XN3_mid1 1.21e-17
* device instance cc_P1_XD5_XN3_mid2 r0 *1 0,0
Ccc_P1_XD5_XN3_mid2 P1 XD5_XN3_mid2 1.21e-17
* device instance cc_P1_XD5_dmodout r0 *1 0,0
Ccc_P1_XD5_dmodout P1 XD5_dmodout 1.21e-17
* device instance cc_P1_XD5_dq r0 *1 0,0
Ccc_P1_XD5_dq P1 XD5_dq 1.8151e-17
* device instance cc_P1_XD5_nm r0 *1 0,0
Ccc_P1_XD5_nm P1 XD5_nm 1.21e-17
* device instance cc_P1_XD5_nt r0 *1 0,0
Ccc_P1_XD5_nt P1 XD5_nt 1.21e-17
* device instance cc_P1_XD5_t1 r0 *1 0,0
Ccc_P1_XD5_t1 P1 XD5_t1 1.21e-17
* device instance cc_P1_XFRT_CKBB r0 *1 0,0
Ccc_P1_XFRT_CKBB P1 XFRT_CKBB 1.8151e-17
* device instance cc_P1_XFRT_CLKB r0 *1 0,0
Ccc_P1_XFRT_CLKB P1 XFRT_CLKB 2.4201e-17
* device instance cc_P1_XFRT_M r0 *1 0,0
Ccc_P1_XFRT_M P1 XFRT_M 2.4201e-17
* device instance cc_P1_XFRT_MB r0 *1 0,0
Ccc_P1_XFRT_MB P1 XFRT_MB 1.21e-17
* device instance cc_P1_XFRT_MFB r0 *1 0,0
Ccc_P1_XFRT_MFB P1 XFRT_MFB 1.21e-17
* device instance cc_P1_XFRT_S r0 *1 0,0
Ccc_P1_XFRT_S P1 XFRT_S 1.8151e-17
* device instance cc_P1_XFRT_SB r0 *1 0,0
Ccc_P1_XFRT_SB P1 XFRT_SB 1.8151e-17
* device instance cc_P1_XFRT_SFB r0 *1 0,0
Ccc_P1_XFRT_SFB P1 XFRT_SFB 1.21e-17
* device instance cc_P1_ck1 r0 *1 0,0
Ccc_P1_ck1 P1 ck1 3.0251e-17
* device instance cc_P1_ck2 r0 *1 0,0
Ccc_P1_ck2 P1 ck2 3.0251e-17
* device instance cc_P1_ck3 r0 *1 0,0
Ccc_P1_ck3 P1 ck3 3.0251e-17
* device instance cc_P1_ck4 r0 *1 0,0
Ccc_P1_ck4 P1 ck4 3.0251e-17
* device instance cc_P1_ck5 r0 *1 0,0
Ccc_P1_ck5 P1 ck5 3.0251e-17
* device instance cc_P1_mod0 r0 *1 0,0
Ccc_P1_mod0 P1 mod0 2.4201e-17
* device instance cc_P1_mod1 r0 *1 0,0
Ccc_P1_mod1 P1 mod1 2.4201e-17
* device instance cc_P1_mod2 r0 *1 0,0
Ccc_P1_mod2 P1 mod2 2.4201e-17
* device instance cc_P1_mod3 r0 *1 0,0
Ccc_P1_mod3 P1 mod3 2.4201e-17
* device instance cc_P1_mod4 r0 *1 0,0
Ccc_P1_mod4 P1 mod4 2.4201e-17
* device instance cc_P1_net1 r0 *1 0,0
Ccc_P1_net1 P1 net1 1.21e-17
* device instance cc_P2_P3 r0 *1 0,0
Ccc_P2_P3 P2 P3 6.05e-18
* device instance cc_P2_P4 r0 *1 0,0
Ccc_P2_P4 P2 P4 6.05e-18
* device instance cc_P2_P5 r0 *1 0,0
Ccc_P2_P5 P2 P5 6.05e-18
* device instance cc_P2_VDD_DIV r0 *1 0,0
Ccc_P2_VDD_DIV P2 VDD_DIV 2.90412e-16
* device instance cc_P2_VSS r0 *1 0,0
Ccc_P2_VSS P2 VSS 5.26372e-16
* device instance cc_P2_XD0_XDFFM_CKBB r0 *1 0,0
Ccc_P2_XD0_XDFFM_CKBB P2 XD0_XDFFM_CKBB 1.8151e-17
* device instance cc_P2_XD0_XDFFM_CLKB r0 *1 0,0
Ccc_P2_XD0_XDFFM_CLKB P2 XD0_XDFFM_CLKB 2.4201e-17
* device instance cc_P2_XD0_XDFFM_M r0 *1 0,0
Ccc_P2_XD0_XDFFM_M P2 XD0_XDFFM_M 2.4201e-17
* device instance cc_P2_XD0_XDFFM_MB r0 *1 0,0
Ccc_P2_XD0_XDFFM_MB P2 XD0_XDFFM_MB 1.21e-17
* device instance cc_P2_XD0_XDFFM_MFB r0 *1 0,0
Ccc_P2_XD0_XDFFM_MFB P2 XD0_XDFFM_MFB 1.21e-17
* device instance cc_P2_XD0_XDFFM_S r0 *1 0,0
Ccc_P2_XD0_XDFFM_S P2 XD0_XDFFM_S 1.8151e-17
* device instance cc_P2_XD0_XDFFM_SB r0 *1 0,0
Ccc_P2_XD0_XDFFM_SB P2 XD0_XDFFM_SB 1.8151e-17
* device instance cc_P2_XD0_XDFFM_SFB r0 *1 0,0
Ccc_P2_XD0_XDFFM_SFB P2 XD0_XDFFM_SFB 1.21e-17
* device instance cc_P2_XD0_XDFFQ_CKBB r0 *1 0,0
Ccc_P2_XD0_XDFFQ_CKBB P2 XD0_XDFFQ_CKBB 1.8151e-17
* device instance cc_P2_XD0_XDFFQ_CLKB r0 *1 0,0
Ccc_P2_XD0_XDFFQ_CLKB P2 XD0_XDFFQ_CLKB 2.4201e-17
* device instance cc_P2_XD0_XDFFQ_M r0 *1 0,0
Ccc_P2_XD0_XDFFQ_M P2 XD0_XDFFQ_M 2.4201e-17
* device instance cc_P2_XD0_XDFFQ_MB r0 *1 0,0
Ccc_P2_XD0_XDFFQ_MB P2 XD0_XDFFQ_MB 1.21e-17
* device instance cc_P2_XD0_XDFFQ_MFB r0 *1 0,0
Ccc_P2_XD0_XDFFQ_MFB P2 XD0_XDFFQ_MFB 1.21e-17
* device instance cc_P2_XD0_XDFFQ_S r0 *1 0,0
Ccc_P2_XD0_XDFFQ_S P2 XD0_XDFFQ_S 1.8151e-17
* device instance cc_P2_XD0_XDFFQ_SB r0 *1 0,0
Ccc_P2_XD0_XDFFQ_SB P2 XD0_XDFFQ_SB 1.8151e-17
* device instance cc_P2_XD0_XDFFQ_SFB r0 *1 0,0
Ccc_P2_XD0_XDFFQ_SFB P2 XD0_XDFFQ_SFB 1.21e-17
* device instance cc_P2_XD0_XNOR_midp r0 *1 0,0
Ccc_P2_XD0_XNOR_midp P2 XD0_XNOR_midp 1.21e-17
* device instance cc_P2_XD0_dmodout r0 *1 0,0
Ccc_P2_XD0_dmodout P2 XD0_dmodout 1.21e-17
* device instance cc_P2_XD0_dq r0 *1 0,0
Ccc_P2_XD0_dq P2 XD0_dq 1.21e-17
* device instance cc_P2_XD0_nm r0 *1 0,0
Ccc_P2_XD0_nm P2 XD0_nm 1.8151e-17
* device instance cc_P2_XD0_nt r0 *1 0,0
Ccc_P2_XD0_nt P2 XD0_nt 2.4201e-17
* device instance cc_P2_XD0_t1 r0 *1 0,0
Ccc_P2_XD0_t1 P2 XD0_t1 1.21e-17
* device instance cc_P2_XD1_XDFFM_CKBB r0 *1 0,0
Ccc_P2_XD1_XDFFM_CKBB P2 XD1_XDFFM_CKBB 1.8151e-17
* device instance cc_P2_XD1_XDFFM_CLKB r0 *1 0,0
Ccc_P2_XD1_XDFFM_CLKB P2 XD1_XDFFM_CLKB 2.4201e-17
* device instance cc_P2_XD1_XDFFM_M r0 *1 0,0
Ccc_P2_XD1_XDFFM_M P2 XD1_XDFFM_M 2.4201e-17
* device instance cc_P2_XD1_XDFFM_MB r0 *1 0,0
Ccc_P2_XD1_XDFFM_MB P2 XD1_XDFFM_MB 1.21e-17
* device instance cc_P2_XD1_XDFFM_MFB r0 *1 0,0
Ccc_P2_XD1_XDFFM_MFB P2 XD1_XDFFM_MFB 1.21e-17
* device instance cc_P2_XD1_XDFFM_S r0 *1 0,0
Ccc_P2_XD1_XDFFM_S P2 XD1_XDFFM_S 1.8151e-17
* device instance cc_P2_XD1_XDFFM_SB r0 *1 0,0
Ccc_P2_XD1_XDFFM_SB P2 XD1_XDFFM_SB 1.8151e-17
* device instance cc_P2_XD1_XDFFM_SFB r0 *1 0,0
Ccc_P2_XD1_XDFFM_SFB P2 XD1_XDFFM_SFB 1.21e-17
* device instance cc_P2_XD1_XDFFQ_CKBB r0 *1 0,0
Ccc_P2_XD1_XDFFQ_CKBB P2 XD1_XDFFQ_CKBB 1.8151e-17
* device instance cc_P2_XD1_XDFFQ_CLKB r0 *1 0,0
Ccc_P2_XD1_XDFFQ_CLKB P2 XD1_XDFFQ_CLKB 2.4201e-17
* device instance cc_P2_XD1_XDFFQ_M r0 *1 0,0
Ccc_P2_XD1_XDFFQ_M P2 XD1_XDFFQ_M 2.4201e-17
* device instance cc_P2_XD1_XDFFQ_MB r0 *1 0,0
Ccc_P2_XD1_XDFFQ_MB P2 XD1_XDFFQ_MB 1.21e-17
* device instance cc_P2_XD1_XDFFQ_MFB r0 *1 0,0
Ccc_P2_XD1_XDFFQ_MFB P2 XD1_XDFFQ_MFB 1.21e-17
* device instance cc_P2_XD1_XDFFQ_S r0 *1 0,0
Ccc_P2_XD1_XDFFQ_S P2 XD1_XDFFQ_S 1.8151e-17
* device instance cc_P2_XD1_XDFFQ_SB r0 *1 0,0
Ccc_P2_XD1_XDFFQ_SB P2 XD1_XDFFQ_SB 1.8151e-17
* device instance cc_P2_XD1_XDFFQ_SFB r0 *1 0,0
Ccc_P2_XD1_XDFFQ_SFB P2 XD1_XDFFQ_SFB 1.21e-17
* device instance cc_P2_XD1_XNOR_midp r0 *1 0,0
Ccc_P2_XD1_XNOR_midp P2 XD1_XNOR_midp 1.21e-17
* device instance cc_P2_XD1_dmodout r0 *1 0,0
Ccc_P2_XD1_dmodout P2 XD1_dmodout 1.21e-17
* device instance cc_P2_XD1_dq r0 *1 0,0
Ccc_P2_XD1_dq P2 XD1_dq 1.21e-17
* device instance cc_P2_XD1_nm r0 *1 0,0
Ccc_P2_XD1_nm P2 XD1_nm 1.8151e-17
* device instance cc_P2_XD1_nt r0 *1 0,0
Ccc_P2_XD1_nt P2 XD1_nt 2.4201e-17
* device instance cc_P2_XD1_t1 r0 *1 0,0
Ccc_P2_XD1_t1 P2 XD1_t1 1.21e-17
* device instance cc_P2_XD2_XDFFM_CKBB r0 *1 0,0
Ccc_P2_XD2_XDFFM_CKBB P2 XD2_XDFFM_CKBB 1.8151e-17
* device instance cc_P2_XD2_XDFFM_CLKB r0 *1 0,0
Ccc_P2_XD2_XDFFM_CLKB P2 XD2_XDFFM_CLKB 2.4201e-17
* device instance cc_P2_XD2_XDFFM_M r0 *1 0,0
Ccc_P2_XD2_XDFFM_M P2 XD2_XDFFM_M 2.4201e-17
* device instance cc_P2_XD2_XDFFM_MB r0 *1 0,0
Ccc_P2_XD2_XDFFM_MB P2 XD2_XDFFM_MB 1.21e-17
* device instance cc_P2_XD2_XDFFM_MFB r0 *1 0,0
Ccc_P2_XD2_XDFFM_MFB P2 XD2_XDFFM_MFB 1.21e-17
* device instance cc_P2_XD2_XDFFM_S r0 *1 0,0
Ccc_P2_XD2_XDFFM_S P2 XD2_XDFFM_S 1.8151e-17
* device instance cc_P2_XD2_XDFFM_SB r0 *1 0,0
Ccc_P2_XD2_XDFFM_SB P2 XD2_XDFFM_SB 1.8151e-17
* device instance cc_P2_XD2_XDFFM_SFB r0 *1 0,0
Ccc_P2_XD2_XDFFM_SFB P2 XD2_XDFFM_SFB 1.21e-17
* device instance cc_P2_XD2_XDFFQ_CKBB r0 *1 0,0
Ccc_P2_XD2_XDFFQ_CKBB P2 XD2_XDFFQ_CKBB 1.8151e-17
* device instance cc_P2_XD2_XDFFQ_CLKB r0 *1 0,0
Ccc_P2_XD2_XDFFQ_CLKB P2 XD2_XDFFQ_CLKB 2.4201e-17
* device instance cc_P2_XD2_XDFFQ_M r0 *1 0,0
Ccc_P2_XD2_XDFFQ_M P2 XD2_XDFFQ_M 2.4201e-17
* device instance cc_P2_XD2_XDFFQ_MB r0 *1 0,0
Ccc_P2_XD2_XDFFQ_MB P2 XD2_XDFFQ_MB 1.21e-17
* device instance cc_P2_XD2_XDFFQ_MFB r0 *1 0,0
Ccc_P2_XD2_XDFFQ_MFB P2 XD2_XDFFQ_MFB 1.21e-17
* device instance cc_P2_XD2_XDFFQ_S r0 *1 0,0
Ccc_P2_XD2_XDFFQ_S P2 XD2_XDFFQ_S 1.8151e-17
* device instance cc_P2_XD2_XDFFQ_SB r0 *1 0,0
Ccc_P2_XD2_XDFFQ_SB P2 XD2_XDFFQ_SB 1.8151e-17
* device instance cc_P2_XD2_XDFFQ_SFB r0 *1 0,0
Ccc_P2_XD2_XDFFQ_SFB P2 XD2_XDFFQ_SFB 1.21e-17
* device instance cc_P2_XD2_XN2_mid1 r0 *1 0,0
Ccc_P2_XD2_XN2_mid1 P2 XD2_XN2_mid1 1.21e-17
* device instance cc_P2_XD2_XN3_mid1 r0 *1 0,0
Ccc_P2_XD2_XN3_mid1 P2 XD2_XN3_mid1 6.05e-18
* device instance cc_P2_XD2_XN3_mid2 r0 *1 0,0
Ccc_P2_XD2_XN3_mid2 P2 XD2_XN3_mid2 1.21e-17
* device instance cc_P2_XD2_dmodout r0 *1 0,0
Ccc_P2_XD2_dmodout P2 XD2_dmodout 1.21e-17
* device instance cc_P2_XD2_dq r0 *1 0,0
Ccc_P2_XD2_dq P2 XD2_dq 1.8151e-17
* device instance cc_P2_XD2_nm r0 *1 0,0
Ccc_P2_XD2_nm P2 XD2_nm 1.21e-17
* device instance cc_P2_XD2_nt r0 *1 0,0
Ccc_P2_XD2_nt P2 XD2_nt 1.21e-17
* device instance cc_P2_XD2_t1 r0 *1 0,0
Ccc_P2_XD2_t1 P2 XD2_t1 1.21e-17
* device instance cc_P2_XD3_XDFFM_CKBB r0 *1 0,0
Ccc_P2_XD3_XDFFM_CKBB P2 XD3_XDFFM_CKBB 1.8151e-17
* device instance cc_P2_XD3_XDFFM_CLKB r0 *1 0,0
Ccc_P2_XD3_XDFFM_CLKB P2 XD3_XDFFM_CLKB 2.4201e-17
* device instance cc_P2_XD3_XDFFM_M r0 *1 0,0
Ccc_P2_XD3_XDFFM_M P2 XD3_XDFFM_M 2.4201e-17
* device instance cc_P2_XD3_XDFFM_MB r0 *1 0,0
Ccc_P2_XD3_XDFFM_MB P2 XD3_XDFFM_MB 1.21e-17
* device instance cc_P2_XD3_XDFFM_MFB r0 *1 0,0
Ccc_P2_XD3_XDFFM_MFB P2 XD3_XDFFM_MFB 1.21e-17
* device instance cc_P2_XD3_XDFFM_S r0 *1 0,0
Ccc_P2_XD3_XDFFM_S P2 XD3_XDFFM_S 1.8151e-17
* device instance cc_P2_XD3_XDFFM_SB r0 *1 0,0
Ccc_P2_XD3_XDFFM_SB P2 XD3_XDFFM_SB 1.8151e-17
* device instance cc_P2_XD3_XDFFM_SFB r0 *1 0,0
Ccc_P2_XD3_XDFFM_SFB P2 XD3_XDFFM_SFB 1.21e-17
* device instance cc_P2_XD3_XDFFQ_CKBB r0 *1 0,0
Ccc_P2_XD3_XDFFQ_CKBB P2 XD3_XDFFQ_CKBB 1.8151e-17
* device instance cc_P2_XD3_XDFFQ_CLKB r0 *1 0,0
Ccc_P2_XD3_XDFFQ_CLKB P2 XD3_XDFFQ_CLKB 2.4201e-17
* device instance cc_P2_XD3_XDFFQ_M r0 *1 0,0
Ccc_P2_XD3_XDFFQ_M P2 XD3_XDFFQ_M 2.4201e-17
* device instance cc_P2_XD3_XDFFQ_MB r0 *1 0,0
Ccc_P2_XD3_XDFFQ_MB P2 XD3_XDFFQ_MB 1.21e-17
* device instance cc_P2_XD3_XDFFQ_MFB r0 *1 0,0
Ccc_P2_XD3_XDFFQ_MFB P2 XD3_XDFFQ_MFB 1.21e-17
* device instance cc_P2_XD3_XDFFQ_S r0 *1 0,0
Ccc_P2_XD3_XDFFQ_S P2 XD3_XDFFQ_S 1.8151e-17
* device instance cc_P2_XD3_XDFFQ_SB r0 *1 0,0
Ccc_P2_XD3_XDFFQ_SB P2 XD3_XDFFQ_SB 1.8151e-17
* device instance cc_P2_XD3_XDFFQ_SFB r0 *1 0,0
Ccc_P2_XD3_XDFFQ_SFB P2 XD3_XDFFQ_SFB 1.21e-17
* device instance cc_P2_XD3_XN2_mid1 r0 *1 0,0
Ccc_P2_XD3_XN2_mid1 P2 XD3_XN2_mid1 1.21e-17
* device instance cc_P2_XD3_XN3_mid1 r0 *1 0,0
Ccc_P2_XD3_XN3_mid1 P2 XD3_XN3_mid1 1.21e-17
* device instance cc_P2_XD3_XN3_mid2 r0 *1 0,0
Ccc_P2_XD3_XN3_mid2 P2 XD3_XN3_mid2 1.21e-17
* device instance cc_P2_XD3_dmodout r0 *1 0,0
Ccc_P2_XD3_dmodout P2 XD3_dmodout 1.21e-17
* device instance cc_P2_XD3_dq r0 *1 0,0
Ccc_P2_XD3_dq P2 XD3_dq 1.8151e-17
* device instance cc_P2_XD3_nm r0 *1 0,0
Ccc_P2_XD3_nm P2 XD3_nm 1.21e-17
* device instance cc_P2_XD3_nt r0 *1 0,0
Ccc_P2_XD3_nt P2 XD3_nt 1.21e-17
* device instance cc_P2_XD3_t1 r0 *1 0,0
Ccc_P2_XD3_t1 P2 XD3_t1 1.21e-17
* device instance cc_P2_XD4_XDFFM_CKBB r0 *1 0,0
Ccc_P2_XD4_XDFFM_CKBB P2 XD4_XDFFM_CKBB 1.8151e-17
* device instance cc_P2_XD4_XDFFM_CLKB r0 *1 0,0
Ccc_P2_XD4_XDFFM_CLKB P2 XD4_XDFFM_CLKB 2.4201e-17
* device instance cc_P2_XD4_XDFFM_M r0 *1 0,0
Ccc_P2_XD4_XDFFM_M P2 XD4_XDFFM_M 2.4201e-17
* device instance cc_P2_XD4_XDFFM_MB r0 *1 0,0
Ccc_P2_XD4_XDFFM_MB P2 XD4_XDFFM_MB 1.21e-17
* device instance cc_P2_XD4_XDFFM_MFB r0 *1 0,0
Ccc_P2_XD4_XDFFM_MFB P2 XD4_XDFFM_MFB 1.21e-17
* device instance cc_P2_XD4_XDFFM_S r0 *1 0,0
Ccc_P2_XD4_XDFFM_S P2 XD4_XDFFM_S 1.8151e-17
* device instance cc_P2_XD4_XDFFM_SB r0 *1 0,0
Ccc_P2_XD4_XDFFM_SB P2 XD4_XDFFM_SB 1.8151e-17
* device instance cc_P2_XD4_XDFFM_SFB r0 *1 0,0
Ccc_P2_XD4_XDFFM_SFB P2 XD4_XDFFM_SFB 1.21e-17
* device instance cc_P2_XD4_XDFFQ_CKBB r0 *1 0,0
Ccc_P2_XD4_XDFFQ_CKBB P2 XD4_XDFFQ_CKBB 1.8151e-17
* device instance cc_P2_XD4_XDFFQ_CLKB r0 *1 0,0
Ccc_P2_XD4_XDFFQ_CLKB P2 XD4_XDFFQ_CLKB 2.4201e-17
* device instance cc_P2_XD4_XDFFQ_M r0 *1 0,0
Ccc_P2_XD4_XDFFQ_M P2 XD4_XDFFQ_M 2.4201e-17
* device instance cc_P2_XD4_XDFFQ_MB r0 *1 0,0
Ccc_P2_XD4_XDFFQ_MB P2 XD4_XDFFQ_MB 1.21e-17
* device instance cc_P2_XD4_XDFFQ_MFB r0 *1 0,0
Ccc_P2_XD4_XDFFQ_MFB P2 XD4_XDFFQ_MFB 1.21e-17
* device instance cc_P2_XD4_XDFFQ_S r0 *1 0,0
Ccc_P2_XD4_XDFFQ_S P2 XD4_XDFFQ_S 1.8151e-17
* device instance cc_P2_XD4_XDFFQ_SB r0 *1 0,0
Ccc_P2_XD4_XDFFQ_SB P2 XD4_XDFFQ_SB 1.8151e-17
* device instance cc_P2_XD4_XDFFQ_SFB r0 *1 0,0
Ccc_P2_XD4_XDFFQ_SFB P2 XD4_XDFFQ_SFB 1.21e-17
* device instance cc_P2_XD4_XN2_mid1 r0 *1 0,0
Ccc_P2_XD4_XN2_mid1 P2 XD4_XN2_mid1 1.21e-17
* device instance cc_P2_XD4_XN3_mid1 r0 *1 0,0
Ccc_P2_XD4_XN3_mid1 P2 XD4_XN3_mid1 1.21e-17
* device instance cc_P2_XD4_XN3_mid2 r0 *1 0,0
Ccc_P2_XD4_XN3_mid2 P2 XD4_XN3_mid2 1.21e-17
* device instance cc_P2_XD4_dmodout r0 *1 0,0
Ccc_P2_XD4_dmodout P2 XD4_dmodout 1.21e-17
* device instance cc_P2_XD4_dq r0 *1 0,0
Ccc_P2_XD4_dq P2 XD4_dq 1.8151e-17
* device instance cc_P2_XD4_nm r0 *1 0,0
Ccc_P2_XD4_nm P2 XD4_nm 1.21e-17
* device instance cc_P2_XD4_nt r0 *1 0,0
Ccc_P2_XD4_nt P2 XD4_nt 1.21e-17
* device instance cc_P2_XD4_t1 r0 *1 0,0
Ccc_P2_XD4_t1 P2 XD4_t1 1.21e-17
* device instance cc_P2_XD5_XDFFM_CKBB r0 *1 0,0
Ccc_P2_XD5_XDFFM_CKBB P2 XD5_XDFFM_CKBB 1.8151e-17
* device instance cc_P2_XD5_XDFFM_CLKB r0 *1 0,0
Ccc_P2_XD5_XDFFM_CLKB P2 XD5_XDFFM_CLKB 2.4201e-17
* device instance cc_P2_XD5_XDFFM_M r0 *1 0,0
Ccc_P2_XD5_XDFFM_M P2 XD5_XDFFM_M 2.4201e-17
* device instance cc_P2_XD5_XDFFM_MB r0 *1 0,0
Ccc_P2_XD5_XDFFM_MB P2 XD5_XDFFM_MB 1.21e-17
* device instance cc_P2_XD5_XDFFM_MFB r0 *1 0,0
Ccc_P2_XD5_XDFFM_MFB P2 XD5_XDFFM_MFB 1.21e-17
* device instance cc_P2_XD5_XDFFM_S r0 *1 0,0
Ccc_P2_XD5_XDFFM_S P2 XD5_XDFFM_S 1.8151e-17
* device instance cc_P2_XD5_XDFFM_SB r0 *1 0,0
Ccc_P2_XD5_XDFFM_SB P2 XD5_XDFFM_SB 1.8151e-17
* device instance cc_P2_XD5_XDFFM_SFB r0 *1 0,0
Ccc_P2_XD5_XDFFM_SFB P2 XD5_XDFFM_SFB 1.21e-17
* device instance cc_P2_XD5_XDFFQ_CKBB r0 *1 0,0
Ccc_P2_XD5_XDFFQ_CKBB P2 XD5_XDFFQ_CKBB 1.8151e-17
* device instance cc_P2_XD5_XDFFQ_CLKB r0 *1 0,0
Ccc_P2_XD5_XDFFQ_CLKB P2 XD5_XDFFQ_CLKB 2.4201e-17
* device instance cc_P2_XD5_XDFFQ_M r0 *1 0,0
Ccc_P2_XD5_XDFFQ_M P2 XD5_XDFFQ_M 2.4201e-17
* device instance cc_P2_XD5_XDFFQ_MB r0 *1 0,0
Ccc_P2_XD5_XDFFQ_MB P2 XD5_XDFFQ_MB 1.21e-17
* device instance cc_P2_XD5_XDFFQ_MFB r0 *1 0,0
Ccc_P2_XD5_XDFFQ_MFB P2 XD5_XDFFQ_MFB 1.21e-17
* device instance cc_P2_XD5_XDFFQ_S r0 *1 0,0
Ccc_P2_XD5_XDFFQ_S P2 XD5_XDFFQ_S 1.8151e-17
* device instance cc_P2_XD5_XDFFQ_SB r0 *1 0,0
Ccc_P2_XD5_XDFFQ_SB P2 XD5_XDFFQ_SB 1.8151e-17
* device instance cc_P2_XD5_XDFFQ_SFB r0 *1 0,0
Ccc_P2_XD5_XDFFQ_SFB P2 XD5_XDFFQ_SFB 1.21e-17
* device instance cc_P2_XD5_XN2_mid1 r0 *1 0,0
Ccc_P2_XD5_XN2_mid1 P2 XD5_XN2_mid1 1.21e-17
* device instance cc_P2_XD5_XN3_mid1 r0 *1 0,0
Ccc_P2_XD5_XN3_mid1 P2 XD5_XN3_mid1 1.21e-17
* device instance cc_P2_XD5_XN3_mid2 r0 *1 0,0
Ccc_P2_XD5_XN3_mid2 P2 XD5_XN3_mid2 1.21e-17
* device instance cc_P2_XD5_dmodout r0 *1 0,0
Ccc_P2_XD5_dmodout P2 XD5_dmodout 1.21e-17
* device instance cc_P2_XD5_dq r0 *1 0,0
Ccc_P2_XD5_dq P2 XD5_dq 1.8151e-17
* device instance cc_P2_XD5_nm r0 *1 0,0
Ccc_P2_XD5_nm P2 XD5_nm 1.21e-17
* device instance cc_P2_XD5_nt r0 *1 0,0
Ccc_P2_XD5_nt P2 XD5_nt 1.21e-17
* device instance cc_P2_XD5_t1 r0 *1 0,0
Ccc_P2_XD5_t1 P2 XD5_t1 1.21e-17
* device instance cc_P2_XFRT_CKBB r0 *1 0,0
Ccc_P2_XFRT_CKBB P2 XFRT_CKBB 1.8151e-17
* device instance cc_P2_XFRT_CLKB r0 *1 0,0
Ccc_P2_XFRT_CLKB P2 XFRT_CLKB 2.4201e-17
* device instance cc_P2_XFRT_M r0 *1 0,0
Ccc_P2_XFRT_M P2 XFRT_M 2.4201e-17
* device instance cc_P2_XFRT_MB r0 *1 0,0
Ccc_P2_XFRT_MB P2 XFRT_MB 1.21e-17
* device instance cc_P2_XFRT_MFB r0 *1 0,0
Ccc_P2_XFRT_MFB P2 XFRT_MFB 1.21e-17
* device instance cc_P2_XFRT_S r0 *1 0,0
Ccc_P2_XFRT_S P2 XFRT_S 1.8151e-17
* device instance cc_P2_XFRT_SB r0 *1 0,0
Ccc_P2_XFRT_SB P2 XFRT_SB 1.8151e-17
* device instance cc_P2_XFRT_SFB r0 *1 0,0
Ccc_P2_XFRT_SFB P2 XFRT_SFB 1.21e-17
* device instance cc_P2_ck1 r0 *1 0,0
Ccc_P2_ck1 P2 ck1 3.0251e-17
* device instance cc_P2_ck2 r0 *1 0,0
Ccc_P2_ck2 P2 ck2 3.0251e-17
* device instance cc_P2_ck3 r0 *1 0,0
Ccc_P2_ck3 P2 ck3 3.0251e-17
* device instance cc_P2_ck4 r0 *1 0,0
Ccc_P2_ck4 P2 ck4 3.0251e-17
* device instance cc_P2_ck5 r0 *1 0,0
Ccc_P2_ck5 P2 ck5 3.0251e-17
* device instance cc_P2_mod0 r0 *1 0,0
Ccc_P2_mod0 P2 mod0 2.4201e-17
* device instance cc_P2_mod1 r0 *1 0,0
Ccc_P2_mod1 P2 mod1 2.4201e-17
* device instance cc_P2_mod2 r0 *1 0,0
Ccc_P2_mod2 P2 mod2 2.4201e-17
* device instance cc_P2_mod3 r0 *1 0,0
Ccc_P2_mod3 P2 mod3 2.4201e-17
* device instance cc_P2_mod4 r0 *1 0,0
Ccc_P2_mod4 P2 mod4 2.4201e-17
* device instance cc_P2_net1 r0 *1 0,0
Ccc_P2_net1 P2 net1 1.21e-17
* device instance cc_P3_P4 r0 *1 0,0
Ccc_P3_P4 P3 P4 6.05e-18
* device instance cc_P3_P5 r0 *1 0,0
Ccc_P3_P5 P3 P5 6.05e-18
* device instance cc_P3_VDD_DIV r0 *1 0,0
Ccc_P3_VDD_DIV P3 VDD_DIV 4.23517e-16
* device instance cc_P3_VSS r0 *1 0,0
Ccc_P3_VSS P3 VSS 4.05367e-16
* device instance cc_P3_XD0_XDFFM_CKBB r0 *1 0,0
Ccc_P3_XD0_XDFFM_CKBB P3 XD0_XDFFM_CKBB 1.8151e-17
* device instance cc_P3_XD0_XDFFM_CLKB r0 *1 0,0
Ccc_P3_XD0_XDFFM_CLKB P3 XD0_XDFFM_CLKB 2.4201e-17
* device instance cc_P3_XD0_XDFFM_M r0 *1 0,0
Ccc_P3_XD0_XDFFM_M P3 XD0_XDFFM_M 2.4201e-17
* device instance cc_P3_XD0_XDFFM_MB r0 *1 0,0
Ccc_P3_XD0_XDFFM_MB P3 XD0_XDFFM_MB 1.21e-17
* device instance cc_P3_XD0_XDFFM_MFB r0 *1 0,0
Ccc_P3_XD0_XDFFM_MFB P3 XD0_XDFFM_MFB 1.21e-17
* device instance cc_P3_XD0_XDFFM_S r0 *1 0,0
Ccc_P3_XD0_XDFFM_S P3 XD0_XDFFM_S 1.8151e-17
* device instance cc_P3_XD0_XDFFM_SB r0 *1 0,0
Ccc_P3_XD0_XDFFM_SB P3 XD0_XDFFM_SB 1.8151e-17
* device instance cc_P3_XD0_XDFFM_SFB r0 *1 0,0
Ccc_P3_XD0_XDFFM_SFB P3 XD0_XDFFM_SFB 1.21e-17
* device instance cc_P3_XD0_XDFFQ_CKBB r0 *1 0,0
Ccc_P3_XD0_XDFFQ_CKBB P3 XD0_XDFFQ_CKBB 1.8151e-17
* device instance cc_P3_XD0_XDFFQ_CLKB r0 *1 0,0
Ccc_P3_XD0_XDFFQ_CLKB P3 XD0_XDFFQ_CLKB 2.4201e-17
* device instance cc_P3_XD0_XDFFQ_M r0 *1 0,0
Ccc_P3_XD0_XDFFQ_M P3 XD0_XDFFQ_M 2.4201e-17
* device instance cc_P3_XD0_XDFFQ_MB r0 *1 0,0
Ccc_P3_XD0_XDFFQ_MB P3 XD0_XDFFQ_MB 1.21e-17
* device instance cc_P3_XD0_XDFFQ_MFB r0 *1 0,0
Ccc_P3_XD0_XDFFQ_MFB P3 XD0_XDFFQ_MFB 1.21e-17
* device instance cc_P3_XD0_XDFFQ_S r0 *1 0,0
Ccc_P3_XD0_XDFFQ_S P3 XD0_XDFFQ_S 1.8151e-17
* device instance cc_P3_XD0_XDFFQ_SB r0 *1 0,0
Ccc_P3_XD0_XDFFQ_SB P3 XD0_XDFFQ_SB 1.8151e-17
* device instance cc_P3_XD0_XDFFQ_SFB r0 *1 0,0
Ccc_P3_XD0_XDFFQ_SFB P3 XD0_XDFFQ_SFB 1.21e-17
* device instance cc_P3_XD0_XNOR_midp r0 *1 0,0
Ccc_P3_XD0_XNOR_midp P3 XD0_XNOR_midp 1.21e-17
* device instance cc_P3_XD0_dmodout r0 *1 0,0
Ccc_P3_XD0_dmodout P3 XD0_dmodout 1.21e-17
* device instance cc_P3_XD0_dq r0 *1 0,0
Ccc_P3_XD0_dq P3 XD0_dq 1.21e-17
* device instance cc_P3_XD0_nm r0 *1 0,0
Ccc_P3_XD0_nm P3 XD0_nm 1.8151e-17
* device instance cc_P3_XD0_nt r0 *1 0,0
Ccc_P3_XD0_nt P3 XD0_nt 2.4201e-17
* device instance cc_P3_XD0_t1 r0 *1 0,0
Ccc_P3_XD0_t1 P3 XD0_t1 1.21e-17
* device instance cc_P3_XD1_XDFFM_CKBB r0 *1 0,0
Ccc_P3_XD1_XDFFM_CKBB P3 XD1_XDFFM_CKBB 1.8151e-17
* device instance cc_P3_XD1_XDFFM_CLKB r0 *1 0,0
Ccc_P3_XD1_XDFFM_CLKB P3 XD1_XDFFM_CLKB 2.4201e-17
* device instance cc_P3_XD1_XDFFM_M r0 *1 0,0
Ccc_P3_XD1_XDFFM_M P3 XD1_XDFFM_M 2.4201e-17
* device instance cc_P3_XD1_XDFFM_MB r0 *1 0,0
Ccc_P3_XD1_XDFFM_MB P3 XD1_XDFFM_MB 1.21e-17
* device instance cc_P3_XD1_XDFFM_MFB r0 *1 0,0
Ccc_P3_XD1_XDFFM_MFB P3 XD1_XDFFM_MFB 1.21e-17
* device instance cc_P3_XD1_XDFFM_S r0 *1 0,0
Ccc_P3_XD1_XDFFM_S P3 XD1_XDFFM_S 1.8151e-17
* device instance cc_P3_XD1_XDFFM_SB r0 *1 0,0
Ccc_P3_XD1_XDFFM_SB P3 XD1_XDFFM_SB 1.8151e-17
* device instance cc_P3_XD1_XDFFM_SFB r0 *1 0,0
Ccc_P3_XD1_XDFFM_SFB P3 XD1_XDFFM_SFB 1.21e-17
* device instance cc_P3_XD1_XDFFQ_CKBB r0 *1 0,0
Ccc_P3_XD1_XDFFQ_CKBB P3 XD1_XDFFQ_CKBB 1.8151e-17
* device instance cc_P3_XD1_XDFFQ_CLKB r0 *1 0,0
Ccc_P3_XD1_XDFFQ_CLKB P3 XD1_XDFFQ_CLKB 2.4201e-17
* device instance cc_P3_XD1_XDFFQ_M r0 *1 0,0
Ccc_P3_XD1_XDFFQ_M P3 XD1_XDFFQ_M 2.4201e-17
* device instance cc_P3_XD1_XDFFQ_MB r0 *1 0,0
Ccc_P3_XD1_XDFFQ_MB P3 XD1_XDFFQ_MB 1.21e-17
* device instance cc_P3_XD1_XDFFQ_MFB r0 *1 0,0
Ccc_P3_XD1_XDFFQ_MFB P3 XD1_XDFFQ_MFB 1.21e-17
* device instance cc_P3_XD1_XDFFQ_S r0 *1 0,0
Ccc_P3_XD1_XDFFQ_S P3 XD1_XDFFQ_S 1.8151e-17
* device instance cc_P3_XD1_XDFFQ_SB r0 *1 0,0
Ccc_P3_XD1_XDFFQ_SB P3 XD1_XDFFQ_SB 1.8151e-17
* device instance cc_P3_XD1_XDFFQ_SFB r0 *1 0,0
Ccc_P3_XD1_XDFFQ_SFB P3 XD1_XDFFQ_SFB 1.21e-17
* device instance cc_P3_XD1_XNOR_midp r0 *1 0,0
Ccc_P3_XD1_XNOR_midp P3 XD1_XNOR_midp 1.21e-17
* device instance cc_P3_XD1_dmodout r0 *1 0,0
Ccc_P3_XD1_dmodout P3 XD1_dmodout 1.21e-17
* device instance cc_P3_XD1_dq r0 *1 0,0
Ccc_P3_XD1_dq P3 XD1_dq 1.21e-17
* device instance cc_P3_XD1_nm r0 *1 0,0
Ccc_P3_XD1_nm P3 XD1_nm 1.8151e-17
* device instance cc_P3_XD1_nt r0 *1 0,0
Ccc_P3_XD1_nt P3 XD1_nt 2.4201e-17
* device instance cc_P3_XD1_t1 r0 *1 0,0
Ccc_P3_XD1_t1 P3 XD1_t1 1.21e-17
* device instance cc_P3_XD2_XDFFM_CKBB r0 *1 0,0
Ccc_P3_XD2_XDFFM_CKBB P3 XD2_XDFFM_CKBB 1.8151e-17
* device instance cc_P3_XD2_XDFFM_CLKB r0 *1 0,0
Ccc_P3_XD2_XDFFM_CLKB P3 XD2_XDFFM_CLKB 2.4201e-17
* device instance cc_P3_XD2_XDFFM_M r0 *1 0,0
Ccc_P3_XD2_XDFFM_M P3 XD2_XDFFM_M 2.4201e-17
* device instance cc_P3_XD2_XDFFM_MB r0 *1 0,0
Ccc_P3_XD2_XDFFM_MB P3 XD2_XDFFM_MB 1.21e-17
* device instance cc_P3_XD2_XDFFM_MFB r0 *1 0,0
Ccc_P3_XD2_XDFFM_MFB P3 XD2_XDFFM_MFB 1.21e-17
* device instance cc_P3_XD2_XDFFM_S r0 *1 0,0
Ccc_P3_XD2_XDFFM_S P3 XD2_XDFFM_S 1.8151e-17
* device instance cc_P3_XD2_XDFFM_SB r0 *1 0,0
Ccc_P3_XD2_XDFFM_SB P3 XD2_XDFFM_SB 1.8151e-17
* device instance cc_P3_XD2_XDFFM_SFB r0 *1 0,0
Ccc_P3_XD2_XDFFM_SFB P3 XD2_XDFFM_SFB 1.21e-17
* device instance cc_P3_XD2_XDFFQ_CKBB r0 *1 0,0
Ccc_P3_XD2_XDFFQ_CKBB P3 XD2_XDFFQ_CKBB 1.8151e-17
* device instance cc_P3_XD2_XDFFQ_CLKB r0 *1 0,0
Ccc_P3_XD2_XDFFQ_CLKB P3 XD2_XDFFQ_CLKB 2.4201e-17
* device instance cc_P3_XD2_XDFFQ_M r0 *1 0,0
Ccc_P3_XD2_XDFFQ_M P3 XD2_XDFFQ_M 2.4201e-17
* device instance cc_P3_XD2_XDFFQ_MB r0 *1 0,0
Ccc_P3_XD2_XDFFQ_MB P3 XD2_XDFFQ_MB 1.21e-17
* device instance cc_P3_XD2_XDFFQ_MFB r0 *1 0,0
Ccc_P3_XD2_XDFFQ_MFB P3 XD2_XDFFQ_MFB 1.21e-17
* device instance cc_P3_XD2_XDFFQ_S r0 *1 0,0
Ccc_P3_XD2_XDFFQ_S P3 XD2_XDFFQ_S 1.8151e-17
* device instance cc_P3_XD2_XDFFQ_SB r0 *1 0,0
Ccc_P3_XD2_XDFFQ_SB P3 XD2_XDFFQ_SB 1.8151e-17
* device instance cc_P3_XD2_XDFFQ_SFB r0 *1 0,0
Ccc_P3_XD2_XDFFQ_SFB P3 XD2_XDFFQ_SFB 1.21e-17
* device instance cc_P3_XD2_XNOR_midp r0 *1 0,0
Ccc_P3_XD2_XNOR_midp P3 XD2_XNOR_midp 1.21e-17
* device instance cc_P3_XD2_dmodout r0 *1 0,0
Ccc_P3_XD2_dmodout P3 XD2_dmodout 1.21e-17
* device instance cc_P3_XD2_dq r0 *1 0,0
Ccc_P3_XD2_dq P3 XD2_dq 1.21e-17
* device instance cc_P3_XD2_nm r0 *1 0,0
Ccc_P3_XD2_nm P3 XD2_nm 1.8151e-17
* device instance cc_P3_XD2_nt r0 *1 0,0
Ccc_P3_XD2_nt P3 XD2_nt 2.4201e-17
* device instance cc_P3_XD2_t1 r0 *1 0,0
Ccc_P3_XD2_t1 P3 XD2_t1 1.21e-17
* device instance cc_P3_XD3_XDFFM_CKBB r0 *1 0,0
Ccc_P3_XD3_XDFFM_CKBB P3 XD3_XDFFM_CKBB 1.8151e-17
* device instance cc_P3_XD3_XDFFM_CLKB r0 *1 0,0
Ccc_P3_XD3_XDFFM_CLKB P3 XD3_XDFFM_CLKB 2.4201e-17
* device instance cc_P3_XD3_XDFFM_M r0 *1 0,0
Ccc_P3_XD3_XDFFM_M P3 XD3_XDFFM_M 2.4201e-17
* device instance cc_P3_XD3_XDFFM_MB r0 *1 0,0
Ccc_P3_XD3_XDFFM_MB P3 XD3_XDFFM_MB 1.21e-17
* device instance cc_P3_XD3_XDFFM_MFB r0 *1 0,0
Ccc_P3_XD3_XDFFM_MFB P3 XD3_XDFFM_MFB 1.21e-17
* device instance cc_P3_XD3_XDFFM_S r0 *1 0,0
Ccc_P3_XD3_XDFFM_S P3 XD3_XDFFM_S 1.8151e-17
* device instance cc_P3_XD3_XDFFM_SB r0 *1 0,0
Ccc_P3_XD3_XDFFM_SB P3 XD3_XDFFM_SB 1.8151e-17
* device instance cc_P3_XD3_XDFFM_SFB r0 *1 0,0
Ccc_P3_XD3_XDFFM_SFB P3 XD3_XDFFM_SFB 1.21e-17
* device instance cc_P3_XD3_XDFFQ_CKBB r0 *1 0,0
Ccc_P3_XD3_XDFFQ_CKBB P3 XD3_XDFFQ_CKBB 1.8151e-17
* device instance cc_P3_XD3_XDFFQ_CLKB r0 *1 0,0
Ccc_P3_XD3_XDFFQ_CLKB P3 XD3_XDFFQ_CLKB 2.4201e-17
* device instance cc_P3_XD3_XDFFQ_M r0 *1 0,0
Ccc_P3_XD3_XDFFQ_M P3 XD3_XDFFQ_M 2.4201e-17
* device instance cc_P3_XD3_XDFFQ_MB r0 *1 0,0
Ccc_P3_XD3_XDFFQ_MB P3 XD3_XDFFQ_MB 1.21e-17
* device instance cc_P3_XD3_XDFFQ_MFB r0 *1 0,0
Ccc_P3_XD3_XDFFQ_MFB P3 XD3_XDFFQ_MFB 1.21e-17
* device instance cc_P3_XD3_XDFFQ_S r0 *1 0,0
Ccc_P3_XD3_XDFFQ_S P3 XD3_XDFFQ_S 1.8151e-17
* device instance cc_P3_XD3_XDFFQ_SB r0 *1 0,0
Ccc_P3_XD3_XDFFQ_SB P3 XD3_XDFFQ_SB 1.8151e-17
* device instance cc_P3_XD3_XDFFQ_SFB r0 *1 0,0
Ccc_P3_XD3_XDFFQ_SFB P3 XD3_XDFFQ_SFB 1.21e-17
* device instance cc_P3_XD3_XN2_mid1 r0 *1 0,0
Ccc_P3_XD3_XN2_mid1 P3 XD3_XN2_mid1 1.21e-17
* device instance cc_P3_XD3_XN3_mid1 r0 *1 0,0
Ccc_P3_XD3_XN3_mid1 P3 XD3_XN3_mid1 6.05e-18
* device instance cc_P3_XD3_XN3_mid2 r0 *1 0,0
Ccc_P3_XD3_XN3_mid2 P3 XD3_XN3_mid2 1.21e-17
* device instance cc_P3_XD3_dmodout r0 *1 0,0
Ccc_P3_XD3_dmodout P3 XD3_dmodout 1.21e-17
* device instance cc_P3_XD3_dq r0 *1 0,0
Ccc_P3_XD3_dq P3 XD3_dq 1.8151e-17
* device instance cc_P3_XD3_nm r0 *1 0,0
Ccc_P3_XD3_nm P3 XD3_nm 1.21e-17
* device instance cc_P3_XD3_nt r0 *1 0,0
Ccc_P3_XD3_nt P3 XD3_nt 1.21e-17
* device instance cc_P3_XD3_t1 r0 *1 0,0
Ccc_P3_XD3_t1 P3 XD3_t1 1.21e-17
* device instance cc_P3_XD4_XDFFM_CKBB r0 *1 0,0
Ccc_P3_XD4_XDFFM_CKBB P3 XD4_XDFFM_CKBB 1.8151e-17
* device instance cc_P3_XD4_XDFFM_CLKB r0 *1 0,0
Ccc_P3_XD4_XDFFM_CLKB P3 XD4_XDFFM_CLKB 2.4201e-17
* device instance cc_P3_XD4_XDFFM_M r0 *1 0,0
Ccc_P3_XD4_XDFFM_M P3 XD4_XDFFM_M 2.4201e-17
* device instance cc_P3_XD4_XDFFM_MB r0 *1 0,0
Ccc_P3_XD4_XDFFM_MB P3 XD4_XDFFM_MB 1.21e-17
* device instance cc_P3_XD4_XDFFM_MFB r0 *1 0,0
Ccc_P3_XD4_XDFFM_MFB P3 XD4_XDFFM_MFB 1.21e-17
* device instance cc_P3_XD4_XDFFM_S r0 *1 0,0
Ccc_P3_XD4_XDFFM_S P3 XD4_XDFFM_S 1.8151e-17
* device instance cc_P3_XD4_XDFFM_SB r0 *1 0,0
Ccc_P3_XD4_XDFFM_SB P3 XD4_XDFFM_SB 1.8151e-17
* device instance cc_P3_XD4_XDFFM_SFB r0 *1 0,0
Ccc_P3_XD4_XDFFM_SFB P3 XD4_XDFFM_SFB 1.21e-17
* device instance cc_P3_XD4_XDFFQ_CKBB r0 *1 0,0
Ccc_P3_XD4_XDFFQ_CKBB P3 XD4_XDFFQ_CKBB 1.8151e-17
* device instance cc_P3_XD4_XDFFQ_CLKB r0 *1 0,0
Ccc_P3_XD4_XDFFQ_CLKB P3 XD4_XDFFQ_CLKB 2.4201e-17
* device instance cc_P3_XD4_XDFFQ_M r0 *1 0,0
Ccc_P3_XD4_XDFFQ_M P3 XD4_XDFFQ_M 2.4201e-17
* device instance cc_P3_XD4_XDFFQ_MB r0 *1 0,0
Ccc_P3_XD4_XDFFQ_MB P3 XD4_XDFFQ_MB 1.21e-17
* device instance cc_P3_XD4_XDFFQ_MFB r0 *1 0,0
Ccc_P3_XD4_XDFFQ_MFB P3 XD4_XDFFQ_MFB 1.21e-17
* device instance cc_P3_XD4_XDFFQ_S r0 *1 0,0
Ccc_P3_XD4_XDFFQ_S P3 XD4_XDFFQ_S 1.8151e-17
* device instance cc_P3_XD4_XDFFQ_SB r0 *1 0,0
Ccc_P3_XD4_XDFFQ_SB P3 XD4_XDFFQ_SB 1.8151e-17
* device instance cc_P3_XD4_XDFFQ_SFB r0 *1 0,0
Ccc_P3_XD4_XDFFQ_SFB P3 XD4_XDFFQ_SFB 1.21e-17
* device instance cc_P3_XD4_XN2_mid1 r0 *1 0,0
Ccc_P3_XD4_XN2_mid1 P3 XD4_XN2_mid1 1.21e-17
* device instance cc_P3_XD4_XN3_mid1 r0 *1 0,0
Ccc_P3_XD4_XN3_mid1 P3 XD4_XN3_mid1 1.21e-17
* device instance cc_P3_XD4_XN3_mid2 r0 *1 0,0
Ccc_P3_XD4_XN3_mid2 P3 XD4_XN3_mid2 1.21e-17
* device instance cc_P3_XD4_dmodout r0 *1 0,0
Ccc_P3_XD4_dmodout P3 XD4_dmodout 1.21e-17
* device instance cc_P3_XD4_dq r0 *1 0,0
Ccc_P3_XD4_dq P3 XD4_dq 1.8151e-17
* device instance cc_P3_XD4_nm r0 *1 0,0
Ccc_P3_XD4_nm P3 XD4_nm 1.21e-17
* device instance cc_P3_XD4_nt r0 *1 0,0
Ccc_P3_XD4_nt P3 XD4_nt 1.21e-17
* device instance cc_P3_XD4_t1 r0 *1 0,0
Ccc_P3_XD4_t1 P3 XD4_t1 1.21e-17
* device instance cc_P3_XD5_XDFFM_CKBB r0 *1 0,0
Ccc_P3_XD5_XDFFM_CKBB P3 XD5_XDFFM_CKBB 1.8151e-17
* device instance cc_P3_XD5_XDFFM_CLKB r0 *1 0,0
Ccc_P3_XD5_XDFFM_CLKB P3 XD5_XDFFM_CLKB 2.4201e-17
* device instance cc_P3_XD5_XDFFM_M r0 *1 0,0
Ccc_P3_XD5_XDFFM_M P3 XD5_XDFFM_M 2.4201e-17
* device instance cc_P3_XD5_XDFFM_MB r0 *1 0,0
Ccc_P3_XD5_XDFFM_MB P3 XD5_XDFFM_MB 1.21e-17
* device instance cc_P3_XD5_XDFFM_MFB r0 *1 0,0
Ccc_P3_XD5_XDFFM_MFB P3 XD5_XDFFM_MFB 1.21e-17
* device instance cc_P3_XD5_XDFFM_S r0 *1 0,0
Ccc_P3_XD5_XDFFM_S P3 XD5_XDFFM_S 1.8151e-17
* device instance cc_P3_XD5_XDFFM_SB r0 *1 0,0
Ccc_P3_XD5_XDFFM_SB P3 XD5_XDFFM_SB 1.8151e-17
* device instance cc_P3_XD5_XDFFM_SFB r0 *1 0,0
Ccc_P3_XD5_XDFFM_SFB P3 XD5_XDFFM_SFB 1.21e-17
* device instance cc_P3_XD5_XDFFQ_CKBB r0 *1 0,0
Ccc_P3_XD5_XDFFQ_CKBB P3 XD5_XDFFQ_CKBB 1.8151e-17
* device instance cc_P3_XD5_XDFFQ_CLKB r0 *1 0,0
Ccc_P3_XD5_XDFFQ_CLKB P3 XD5_XDFFQ_CLKB 2.4201e-17
* device instance cc_P3_XD5_XDFFQ_M r0 *1 0,0
Ccc_P3_XD5_XDFFQ_M P3 XD5_XDFFQ_M 2.4201e-17
* device instance cc_P3_XD5_XDFFQ_MB r0 *1 0,0
Ccc_P3_XD5_XDFFQ_MB P3 XD5_XDFFQ_MB 1.21e-17
* device instance cc_P3_XD5_XDFFQ_MFB r0 *1 0,0
Ccc_P3_XD5_XDFFQ_MFB P3 XD5_XDFFQ_MFB 1.21e-17
* device instance cc_P3_XD5_XDFFQ_S r0 *1 0,0
Ccc_P3_XD5_XDFFQ_S P3 XD5_XDFFQ_S 1.8151e-17
* device instance cc_P3_XD5_XDFFQ_SB r0 *1 0,0
Ccc_P3_XD5_XDFFQ_SB P3 XD5_XDFFQ_SB 1.8151e-17
* device instance cc_P3_XD5_XDFFQ_SFB r0 *1 0,0
Ccc_P3_XD5_XDFFQ_SFB P3 XD5_XDFFQ_SFB 1.21e-17
* device instance cc_P3_XD5_XN2_mid1 r0 *1 0,0
Ccc_P3_XD5_XN2_mid1 P3 XD5_XN2_mid1 1.21e-17
* device instance cc_P3_XD5_XN3_mid1 r0 *1 0,0
Ccc_P3_XD5_XN3_mid1 P3 XD5_XN3_mid1 1.21e-17
* device instance cc_P3_XD5_XN3_mid2 r0 *1 0,0
Ccc_P3_XD5_XN3_mid2 P3 XD5_XN3_mid2 1.21e-17
* device instance cc_P3_XD5_dmodout r0 *1 0,0
Ccc_P3_XD5_dmodout P3 XD5_dmodout 1.21e-17
* device instance cc_P3_XD5_dq r0 *1 0,0
Ccc_P3_XD5_dq P3 XD5_dq 1.8151e-17
* device instance cc_P3_XD5_nm r0 *1 0,0
Ccc_P3_XD5_nm P3 XD5_nm 1.21e-17
* device instance cc_P3_XD5_nt r0 *1 0,0
Ccc_P3_XD5_nt P3 XD5_nt 1.21e-17
* device instance cc_P3_XD5_t1 r0 *1 0,0
Ccc_P3_XD5_t1 P3 XD5_t1 1.21e-17
* device instance cc_P3_XFRT_CKBB r0 *1 0,0
Ccc_P3_XFRT_CKBB P3 XFRT_CKBB 1.8151e-17
* device instance cc_P3_XFRT_CLKB r0 *1 0,0
Ccc_P3_XFRT_CLKB P3 XFRT_CLKB 2.4201e-17
* device instance cc_P3_XFRT_M r0 *1 0,0
Ccc_P3_XFRT_M P3 XFRT_M 2.4201e-17
* device instance cc_P3_XFRT_MB r0 *1 0,0
Ccc_P3_XFRT_MB P3 XFRT_MB 1.21e-17
* device instance cc_P3_XFRT_MFB r0 *1 0,0
Ccc_P3_XFRT_MFB P3 XFRT_MFB 1.21e-17
* device instance cc_P3_XFRT_S r0 *1 0,0
Ccc_P3_XFRT_S P3 XFRT_S 1.8151e-17
* device instance cc_P3_XFRT_SB r0 *1 0,0
Ccc_P3_XFRT_SB P3 XFRT_SB 1.8151e-17
* device instance cc_P3_XFRT_SFB r0 *1 0,0
Ccc_P3_XFRT_SFB P3 XFRT_SFB 1.21e-17
* device instance cc_P3_ck1 r0 *1 0,0
Ccc_P3_ck1 P3 ck1 3.0251e-17
* device instance cc_P3_ck2 r0 *1 0,0
Ccc_P3_ck2 P3 ck2 3.0251e-17
* device instance cc_P3_ck3 r0 *1 0,0
Ccc_P3_ck3 P3 ck3 3.0251e-17
* device instance cc_P3_ck4 r0 *1 0,0
Ccc_P3_ck4 P3 ck4 3.0251e-17
* device instance cc_P3_ck5 r0 *1 0,0
Ccc_P3_ck5 P3 ck5 3.0251e-17
* device instance cc_P3_mod0 r0 *1 0,0
Ccc_P3_mod0 P3 mod0 2.4201e-17
* device instance cc_P3_mod1 r0 *1 0,0
Ccc_P3_mod1 P3 mod1 2.4201e-17
* device instance cc_P3_mod2 r0 *1 0,0
Ccc_P3_mod2 P3 mod2 2.4201e-17
* device instance cc_P3_mod3 r0 *1 0,0
Ccc_P3_mod3 P3 mod3 2.4201e-17
* device instance cc_P3_mod4 r0 *1 0,0
Ccc_P3_mod4 P3 mod4 2.4201e-17
* device instance cc_P3_net1 r0 *1 0,0
Ccc_P3_net1 P3 net1 1.21e-17
* device instance cc_P4_P5 r0 *1 0,0
Ccc_P4_P5 P4 P5 6.05e-18
* device instance cc_P4_VDD_DIV r0 *1 0,0
Ccc_P4_VDD_DIV P4 VDD_DIV 5.56623e-16
* device instance cc_P4_VSS r0 *1 0,0
Ccc_P4_VSS P4 VSS 2.84362e-16
* device instance cc_P4_XD0_XDFFM_CKBB r0 *1 0,0
Ccc_P4_XD0_XDFFM_CKBB P4 XD0_XDFFM_CKBB 1.8151e-17
* device instance cc_P4_XD0_XDFFM_CLKB r0 *1 0,0
Ccc_P4_XD0_XDFFM_CLKB P4 XD0_XDFFM_CLKB 2.4201e-17
* device instance cc_P4_XD0_XDFFM_M r0 *1 0,0
Ccc_P4_XD0_XDFFM_M P4 XD0_XDFFM_M 2.4201e-17
* device instance cc_P4_XD0_XDFFM_MB r0 *1 0,0
Ccc_P4_XD0_XDFFM_MB P4 XD0_XDFFM_MB 1.21e-17
* device instance cc_P4_XD0_XDFFM_MFB r0 *1 0,0
Ccc_P4_XD0_XDFFM_MFB P4 XD0_XDFFM_MFB 1.21e-17
* device instance cc_P4_XD0_XDFFM_S r0 *1 0,0
Ccc_P4_XD0_XDFFM_S P4 XD0_XDFFM_S 1.8151e-17
* device instance cc_P4_XD0_XDFFM_SB r0 *1 0,0
Ccc_P4_XD0_XDFFM_SB P4 XD0_XDFFM_SB 1.8151e-17
* device instance cc_P4_XD0_XDFFM_SFB r0 *1 0,0
Ccc_P4_XD0_XDFFM_SFB P4 XD0_XDFFM_SFB 1.21e-17
* device instance cc_P4_XD0_XDFFQ_CKBB r0 *1 0,0
Ccc_P4_XD0_XDFFQ_CKBB P4 XD0_XDFFQ_CKBB 1.8151e-17
* device instance cc_P4_XD0_XDFFQ_CLKB r0 *1 0,0
Ccc_P4_XD0_XDFFQ_CLKB P4 XD0_XDFFQ_CLKB 2.4201e-17
* device instance cc_P4_XD0_XDFFQ_M r0 *1 0,0
Ccc_P4_XD0_XDFFQ_M P4 XD0_XDFFQ_M 2.4201e-17
* device instance cc_P4_XD0_XDFFQ_MB r0 *1 0,0
Ccc_P4_XD0_XDFFQ_MB P4 XD0_XDFFQ_MB 1.21e-17
* device instance cc_P4_XD0_XDFFQ_MFB r0 *1 0,0
Ccc_P4_XD0_XDFFQ_MFB P4 XD0_XDFFQ_MFB 1.21e-17
* device instance cc_P4_XD0_XDFFQ_S r0 *1 0,0
Ccc_P4_XD0_XDFFQ_S P4 XD0_XDFFQ_S 1.8151e-17
* device instance cc_P4_XD0_XDFFQ_SB r0 *1 0,0
Ccc_P4_XD0_XDFFQ_SB P4 XD0_XDFFQ_SB 1.8151e-17
* device instance cc_P4_XD0_XDFFQ_SFB r0 *1 0,0
Ccc_P4_XD0_XDFFQ_SFB P4 XD0_XDFFQ_SFB 1.21e-17
* device instance cc_P4_XD0_XNOR_midp r0 *1 0,0
Ccc_P4_XD0_XNOR_midp P4 XD0_XNOR_midp 1.21e-17
* device instance cc_P4_XD0_dmodout r0 *1 0,0
Ccc_P4_XD0_dmodout P4 XD0_dmodout 1.21e-17
* device instance cc_P4_XD0_dq r0 *1 0,0
Ccc_P4_XD0_dq P4 XD0_dq 1.21e-17
* device instance cc_P4_XD0_nm r0 *1 0,0
Ccc_P4_XD0_nm P4 XD0_nm 1.8151e-17
* device instance cc_P4_XD0_nt r0 *1 0,0
Ccc_P4_XD0_nt P4 XD0_nt 2.4201e-17
* device instance cc_P4_XD0_t1 r0 *1 0,0
Ccc_P4_XD0_t1 P4 XD0_t1 1.21e-17
* device instance cc_P4_XD1_XDFFM_CKBB r0 *1 0,0
Ccc_P4_XD1_XDFFM_CKBB P4 XD1_XDFFM_CKBB 1.8151e-17
* device instance cc_P4_XD1_XDFFM_CLKB r0 *1 0,0
Ccc_P4_XD1_XDFFM_CLKB P4 XD1_XDFFM_CLKB 2.4201e-17
* device instance cc_P4_XD1_XDFFM_M r0 *1 0,0
Ccc_P4_XD1_XDFFM_M P4 XD1_XDFFM_M 2.4201e-17
* device instance cc_P4_XD1_XDFFM_MB r0 *1 0,0
Ccc_P4_XD1_XDFFM_MB P4 XD1_XDFFM_MB 1.21e-17
* device instance cc_P4_XD1_XDFFM_MFB r0 *1 0,0
Ccc_P4_XD1_XDFFM_MFB P4 XD1_XDFFM_MFB 1.21e-17
* device instance cc_P4_XD1_XDFFM_S r0 *1 0,0
Ccc_P4_XD1_XDFFM_S P4 XD1_XDFFM_S 1.8151e-17
* device instance cc_P4_XD1_XDFFM_SB r0 *1 0,0
Ccc_P4_XD1_XDFFM_SB P4 XD1_XDFFM_SB 1.8151e-17
* device instance cc_P4_XD1_XDFFM_SFB r0 *1 0,0
Ccc_P4_XD1_XDFFM_SFB P4 XD1_XDFFM_SFB 1.21e-17
* device instance cc_P4_XD1_XDFFQ_CKBB r0 *1 0,0
Ccc_P4_XD1_XDFFQ_CKBB P4 XD1_XDFFQ_CKBB 1.8151e-17
* device instance cc_P4_XD1_XDFFQ_CLKB r0 *1 0,0
Ccc_P4_XD1_XDFFQ_CLKB P4 XD1_XDFFQ_CLKB 2.4201e-17
* device instance cc_P4_XD1_XDFFQ_M r0 *1 0,0
Ccc_P4_XD1_XDFFQ_M P4 XD1_XDFFQ_M 2.4201e-17
* device instance cc_P4_XD1_XDFFQ_MB r0 *1 0,0
Ccc_P4_XD1_XDFFQ_MB P4 XD1_XDFFQ_MB 1.21e-17
* device instance cc_P4_XD1_XDFFQ_MFB r0 *1 0,0
Ccc_P4_XD1_XDFFQ_MFB P4 XD1_XDFFQ_MFB 1.21e-17
* device instance cc_P4_XD1_XDFFQ_S r0 *1 0,0
Ccc_P4_XD1_XDFFQ_S P4 XD1_XDFFQ_S 1.8151e-17
* device instance cc_P4_XD1_XDFFQ_SB r0 *1 0,0
Ccc_P4_XD1_XDFFQ_SB P4 XD1_XDFFQ_SB 1.8151e-17
* device instance cc_P4_XD1_XDFFQ_SFB r0 *1 0,0
Ccc_P4_XD1_XDFFQ_SFB P4 XD1_XDFFQ_SFB 1.21e-17
* device instance cc_P4_XD1_XNOR_midp r0 *1 0,0
Ccc_P4_XD1_XNOR_midp P4 XD1_XNOR_midp 1.21e-17
* device instance cc_P4_XD1_dmodout r0 *1 0,0
Ccc_P4_XD1_dmodout P4 XD1_dmodout 1.21e-17
* device instance cc_P4_XD1_dq r0 *1 0,0
Ccc_P4_XD1_dq P4 XD1_dq 1.21e-17
* device instance cc_P4_XD1_nm r0 *1 0,0
Ccc_P4_XD1_nm P4 XD1_nm 1.8151e-17
* device instance cc_P4_XD1_nt r0 *1 0,0
Ccc_P4_XD1_nt P4 XD1_nt 2.4201e-17
* device instance cc_P4_XD1_t1 r0 *1 0,0
Ccc_P4_XD1_t1 P4 XD1_t1 1.21e-17
* device instance cc_P4_XD2_XDFFM_CKBB r0 *1 0,0
Ccc_P4_XD2_XDFFM_CKBB P4 XD2_XDFFM_CKBB 1.8151e-17
* device instance cc_P4_XD2_XDFFM_CLKB r0 *1 0,0
Ccc_P4_XD2_XDFFM_CLKB P4 XD2_XDFFM_CLKB 2.4201e-17
* device instance cc_P4_XD2_XDFFM_M r0 *1 0,0
Ccc_P4_XD2_XDFFM_M P4 XD2_XDFFM_M 2.4201e-17
* device instance cc_P4_XD2_XDFFM_MB r0 *1 0,0
Ccc_P4_XD2_XDFFM_MB P4 XD2_XDFFM_MB 1.21e-17
* device instance cc_P4_XD2_XDFFM_MFB r0 *1 0,0
Ccc_P4_XD2_XDFFM_MFB P4 XD2_XDFFM_MFB 1.21e-17
* device instance cc_P4_XD2_XDFFM_S r0 *1 0,0
Ccc_P4_XD2_XDFFM_S P4 XD2_XDFFM_S 1.8151e-17
* device instance cc_P4_XD2_XDFFM_SB r0 *1 0,0
Ccc_P4_XD2_XDFFM_SB P4 XD2_XDFFM_SB 1.8151e-17
* device instance cc_P4_XD2_XDFFM_SFB r0 *1 0,0
Ccc_P4_XD2_XDFFM_SFB P4 XD2_XDFFM_SFB 1.21e-17
* device instance cc_P4_XD2_XDFFQ_CKBB r0 *1 0,0
Ccc_P4_XD2_XDFFQ_CKBB P4 XD2_XDFFQ_CKBB 1.8151e-17
* device instance cc_P4_XD2_XDFFQ_CLKB r0 *1 0,0
Ccc_P4_XD2_XDFFQ_CLKB P4 XD2_XDFFQ_CLKB 2.4201e-17
* device instance cc_P4_XD2_XDFFQ_M r0 *1 0,0
Ccc_P4_XD2_XDFFQ_M P4 XD2_XDFFQ_M 2.4201e-17
* device instance cc_P4_XD2_XDFFQ_MB r0 *1 0,0
Ccc_P4_XD2_XDFFQ_MB P4 XD2_XDFFQ_MB 1.21e-17
* device instance cc_P4_XD2_XDFFQ_MFB r0 *1 0,0
Ccc_P4_XD2_XDFFQ_MFB P4 XD2_XDFFQ_MFB 1.21e-17
* device instance cc_P4_XD2_XDFFQ_S r0 *1 0,0
Ccc_P4_XD2_XDFFQ_S P4 XD2_XDFFQ_S 1.8151e-17
* device instance cc_P4_XD2_XDFFQ_SB r0 *1 0,0
Ccc_P4_XD2_XDFFQ_SB P4 XD2_XDFFQ_SB 1.8151e-17
* device instance cc_P4_XD2_XDFFQ_SFB r0 *1 0,0
Ccc_P4_XD2_XDFFQ_SFB P4 XD2_XDFFQ_SFB 1.21e-17
* device instance cc_P4_XD2_XNOR_midp r0 *1 0,0
Ccc_P4_XD2_XNOR_midp P4 XD2_XNOR_midp 1.21e-17
* device instance cc_P4_XD2_dmodout r0 *1 0,0
Ccc_P4_XD2_dmodout P4 XD2_dmodout 1.21e-17
* device instance cc_P4_XD2_dq r0 *1 0,0
Ccc_P4_XD2_dq P4 XD2_dq 1.21e-17
* device instance cc_P4_XD2_nm r0 *1 0,0
Ccc_P4_XD2_nm P4 XD2_nm 1.8151e-17
* device instance cc_P4_XD2_nt r0 *1 0,0
Ccc_P4_XD2_nt P4 XD2_nt 2.4201e-17
* device instance cc_P4_XD2_t1 r0 *1 0,0
Ccc_P4_XD2_t1 P4 XD2_t1 1.21e-17
* device instance cc_P4_XD3_XDFFM_CKBB r0 *1 0,0
Ccc_P4_XD3_XDFFM_CKBB P4 XD3_XDFFM_CKBB 1.8151e-17
* device instance cc_P4_XD3_XDFFM_CLKB r0 *1 0,0
Ccc_P4_XD3_XDFFM_CLKB P4 XD3_XDFFM_CLKB 2.4201e-17
* device instance cc_P4_XD3_XDFFM_M r0 *1 0,0
Ccc_P4_XD3_XDFFM_M P4 XD3_XDFFM_M 2.4201e-17
* device instance cc_P4_XD3_XDFFM_MB r0 *1 0,0
Ccc_P4_XD3_XDFFM_MB P4 XD3_XDFFM_MB 1.21e-17
* device instance cc_P4_XD3_XDFFM_MFB r0 *1 0,0
Ccc_P4_XD3_XDFFM_MFB P4 XD3_XDFFM_MFB 1.21e-17
* device instance cc_P4_XD3_XDFFM_S r0 *1 0,0
Ccc_P4_XD3_XDFFM_S P4 XD3_XDFFM_S 1.8151e-17
* device instance cc_P4_XD3_XDFFM_SB r0 *1 0,0
Ccc_P4_XD3_XDFFM_SB P4 XD3_XDFFM_SB 1.8151e-17
* device instance cc_P4_XD3_XDFFM_SFB r0 *1 0,0
Ccc_P4_XD3_XDFFM_SFB P4 XD3_XDFFM_SFB 1.21e-17
* device instance cc_P4_XD3_XDFFQ_CKBB r0 *1 0,0
Ccc_P4_XD3_XDFFQ_CKBB P4 XD3_XDFFQ_CKBB 1.8151e-17
* device instance cc_P4_XD3_XDFFQ_CLKB r0 *1 0,0
Ccc_P4_XD3_XDFFQ_CLKB P4 XD3_XDFFQ_CLKB 2.4201e-17
* device instance cc_P4_XD3_XDFFQ_M r0 *1 0,0
Ccc_P4_XD3_XDFFQ_M P4 XD3_XDFFQ_M 2.4201e-17
* device instance cc_P4_XD3_XDFFQ_MB r0 *1 0,0
Ccc_P4_XD3_XDFFQ_MB P4 XD3_XDFFQ_MB 1.21e-17
* device instance cc_P4_XD3_XDFFQ_MFB r0 *1 0,0
Ccc_P4_XD3_XDFFQ_MFB P4 XD3_XDFFQ_MFB 1.21e-17
* device instance cc_P4_XD3_XDFFQ_S r0 *1 0,0
Ccc_P4_XD3_XDFFQ_S P4 XD3_XDFFQ_S 1.8151e-17
* device instance cc_P4_XD3_XDFFQ_SB r0 *1 0,0
Ccc_P4_XD3_XDFFQ_SB P4 XD3_XDFFQ_SB 1.8151e-17
* device instance cc_P4_XD3_XDFFQ_SFB r0 *1 0,0
Ccc_P4_XD3_XDFFQ_SFB P4 XD3_XDFFQ_SFB 1.21e-17
* device instance cc_P4_XD3_XNOR_midp r0 *1 0,0
Ccc_P4_XD3_XNOR_midp P4 XD3_XNOR_midp 1.21e-17
* device instance cc_P4_XD3_dmodout r0 *1 0,0
Ccc_P4_XD3_dmodout P4 XD3_dmodout 1.21e-17
* device instance cc_P4_XD3_dq r0 *1 0,0
Ccc_P4_XD3_dq P4 XD3_dq 1.21e-17
* device instance cc_P4_XD3_nm r0 *1 0,0
Ccc_P4_XD3_nm P4 XD3_nm 1.8151e-17
* device instance cc_P4_XD3_nt r0 *1 0,0
Ccc_P4_XD3_nt P4 XD3_nt 2.4201e-17
* device instance cc_P4_XD3_t1 r0 *1 0,0
Ccc_P4_XD3_t1 P4 XD3_t1 1.21e-17
* device instance cc_P4_XD4_XDFFM_CKBB r0 *1 0,0
Ccc_P4_XD4_XDFFM_CKBB P4 XD4_XDFFM_CKBB 1.8151e-17
* device instance cc_P4_XD4_XDFFM_CLKB r0 *1 0,0
Ccc_P4_XD4_XDFFM_CLKB P4 XD4_XDFFM_CLKB 2.4201e-17
* device instance cc_P4_XD4_XDFFM_M r0 *1 0,0
Ccc_P4_XD4_XDFFM_M P4 XD4_XDFFM_M 2.4201e-17
* device instance cc_P4_XD4_XDFFM_MB r0 *1 0,0
Ccc_P4_XD4_XDFFM_MB P4 XD4_XDFFM_MB 1.21e-17
* device instance cc_P4_XD4_XDFFM_MFB r0 *1 0,0
Ccc_P4_XD4_XDFFM_MFB P4 XD4_XDFFM_MFB 1.21e-17
* device instance cc_P4_XD4_XDFFM_S r0 *1 0,0
Ccc_P4_XD4_XDFFM_S P4 XD4_XDFFM_S 1.8151e-17
* device instance cc_P4_XD4_XDFFM_SB r0 *1 0,0
Ccc_P4_XD4_XDFFM_SB P4 XD4_XDFFM_SB 1.8151e-17
* device instance cc_P4_XD4_XDFFM_SFB r0 *1 0,0
Ccc_P4_XD4_XDFFM_SFB P4 XD4_XDFFM_SFB 1.21e-17
* device instance cc_P4_XD4_XDFFQ_CKBB r0 *1 0,0
Ccc_P4_XD4_XDFFQ_CKBB P4 XD4_XDFFQ_CKBB 1.8151e-17
* device instance cc_P4_XD4_XDFFQ_CLKB r0 *1 0,0
Ccc_P4_XD4_XDFFQ_CLKB P4 XD4_XDFFQ_CLKB 2.4201e-17
* device instance cc_P4_XD4_XDFFQ_M r0 *1 0,0
Ccc_P4_XD4_XDFFQ_M P4 XD4_XDFFQ_M 2.4201e-17
* device instance cc_P4_XD4_XDFFQ_MB r0 *1 0,0
Ccc_P4_XD4_XDFFQ_MB P4 XD4_XDFFQ_MB 1.21e-17
* device instance cc_P4_XD4_XDFFQ_MFB r0 *1 0,0
Ccc_P4_XD4_XDFFQ_MFB P4 XD4_XDFFQ_MFB 1.21e-17
* device instance cc_P4_XD4_XDFFQ_S r0 *1 0,0
Ccc_P4_XD4_XDFFQ_S P4 XD4_XDFFQ_S 1.8151e-17
* device instance cc_P4_XD4_XDFFQ_SB r0 *1 0,0
Ccc_P4_XD4_XDFFQ_SB P4 XD4_XDFFQ_SB 1.8151e-17
* device instance cc_P4_XD4_XDFFQ_SFB r0 *1 0,0
Ccc_P4_XD4_XDFFQ_SFB P4 XD4_XDFFQ_SFB 1.21e-17
* device instance cc_P4_XD4_XN2_mid1 r0 *1 0,0
Ccc_P4_XD4_XN2_mid1 P4 XD4_XN2_mid1 1.21e-17
* device instance cc_P4_XD4_XN3_mid1 r0 *1 0,0
Ccc_P4_XD4_XN3_mid1 P4 XD4_XN3_mid1 6.05e-18
* device instance cc_P4_XD4_XN3_mid2 r0 *1 0,0
Ccc_P4_XD4_XN3_mid2 P4 XD4_XN3_mid2 1.21e-17
* device instance cc_P4_XD4_dmodout r0 *1 0,0
Ccc_P4_XD4_dmodout P4 XD4_dmodout 1.21e-17
* device instance cc_P4_XD4_dq r0 *1 0,0
Ccc_P4_XD4_dq P4 XD4_dq 1.8151e-17
* device instance cc_P4_XD4_nm r0 *1 0,0
Ccc_P4_XD4_nm P4 XD4_nm 1.21e-17
* device instance cc_P4_XD4_nt r0 *1 0,0
Ccc_P4_XD4_nt P4 XD4_nt 1.21e-17
* device instance cc_P4_XD4_t1 r0 *1 0,0
Ccc_P4_XD4_t1 P4 XD4_t1 1.21e-17
* device instance cc_P4_XD5_XDFFM_CKBB r0 *1 0,0
Ccc_P4_XD5_XDFFM_CKBB P4 XD5_XDFFM_CKBB 1.8151e-17
* device instance cc_P4_XD5_XDFFM_CLKB r0 *1 0,0
Ccc_P4_XD5_XDFFM_CLKB P4 XD5_XDFFM_CLKB 2.4201e-17
* device instance cc_P4_XD5_XDFFM_M r0 *1 0,0
Ccc_P4_XD5_XDFFM_M P4 XD5_XDFFM_M 2.4201e-17
* device instance cc_P4_XD5_XDFFM_MB r0 *1 0,0
Ccc_P4_XD5_XDFFM_MB P4 XD5_XDFFM_MB 1.21e-17
* device instance cc_P4_XD5_XDFFM_MFB r0 *1 0,0
Ccc_P4_XD5_XDFFM_MFB P4 XD5_XDFFM_MFB 1.21e-17
* device instance cc_P4_XD5_XDFFM_S r0 *1 0,0
Ccc_P4_XD5_XDFFM_S P4 XD5_XDFFM_S 1.8151e-17
* device instance cc_P4_XD5_XDFFM_SB r0 *1 0,0
Ccc_P4_XD5_XDFFM_SB P4 XD5_XDFFM_SB 1.8151e-17
* device instance cc_P4_XD5_XDFFM_SFB r0 *1 0,0
Ccc_P4_XD5_XDFFM_SFB P4 XD5_XDFFM_SFB 1.21e-17
* device instance cc_P4_XD5_XDFFQ_CKBB r0 *1 0,0
Ccc_P4_XD5_XDFFQ_CKBB P4 XD5_XDFFQ_CKBB 1.8151e-17
* device instance cc_P4_XD5_XDFFQ_CLKB r0 *1 0,0
Ccc_P4_XD5_XDFFQ_CLKB P4 XD5_XDFFQ_CLKB 2.4201e-17
* device instance cc_P4_XD5_XDFFQ_M r0 *1 0,0
Ccc_P4_XD5_XDFFQ_M P4 XD5_XDFFQ_M 2.4201e-17
* device instance cc_P4_XD5_XDFFQ_MB r0 *1 0,0
Ccc_P4_XD5_XDFFQ_MB P4 XD5_XDFFQ_MB 1.21e-17
* device instance cc_P4_XD5_XDFFQ_MFB r0 *1 0,0
Ccc_P4_XD5_XDFFQ_MFB P4 XD5_XDFFQ_MFB 1.21e-17
* device instance cc_P4_XD5_XDFFQ_S r0 *1 0,0
Ccc_P4_XD5_XDFFQ_S P4 XD5_XDFFQ_S 1.8151e-17
* device instance cc_P4_XD5_XDFFQ_SB r0 *1 0,0
Ccc_P4_XD5_XDFFQ_SB P4 XD5_XDFFQ_SB 1.8151e-17
* device instance cc_P4_XD5_XDFFQ_SFB r0 *1 0,0
Ccc_P4_XD5_XDFFQ_SFB P4 XD5_XDFFQ_SFB 1.21e-17
* device instance cc_P4_XD5_XN2_mid1 r0 *1 0,0
Ccc_P4_XD5_XN2_mid1 P4 XD5_XN2_mid1 1.21e-17
* device instance cc_P4_XD5_XN3_mid1 r0 *1 0,0
Ccc_P4_XD5_XN3_mid1 P4 XD5_XN3_mid1 1.21e-17
* device instance cc_P4_XD5_XN3_mid2 r0 *1 0,0
Ccc_P4_XD5_XN3_mid2 P4 XD5_XN3_mid2 1.21e-17
* device instance cc_P4_XD5_dmodout r0 *1 0,0
Ccc_P4_XD5_dmodout P4 XD5_dmodout 1.21e-17
* device instance cc_P4_XD5_dq r0 *1 0,0
Ccc_P4_XD5_dq P4 XD5_dq 1.8151e-17
* device instance cc_P4_XD5_nm r0 *1 0,0
Ccc_P4_XD5_nm P4 XD5_nm 1.21e-17
* device instance cc_P4_XD5_nt r0 *1 0,0
Ccc_P4_XD5_nt P4 XD5_nt 1.21e-17
* device instance cc_P4_XD5_t1 r0 *1 0,0
Ccc_P4_XD5_t1 P4 XD5_t1 1.21e-17
* device instance cc_P4_XFRT_CKBB r0 *1 0,0
Ccc_P4_XFRT_CKBB P4 XFRT_CKBB 1.8151e-17
* device instance cc_P4_XFRT_CLKB r0 *1 0,0
Ccc_P4_XFRT_CLKB P4 XFRT_CLKB 2.4201e-17
* device instance cc_P4_XFRT_M r0 *1 0,0
Ccc_P4_XFRT_M P4 XFRT_M 2.4201e-17
* device instance cc_P4_XFRT_MB r0 *1 0,0
Ccc_P4_XFRT_MB P4 XFRT_MB 1.21e-17
* device instance cc_P4_XFRT_MFB r0 *1 0,0
Ccc_P4_XFRT_MFB P4 XFRT_MFB 1.21e-17
* device instance cc_P4_XFRT_S r0 *1 0,0
Ccc_P4_XFRT_S P4 XFRT_S 1.8151e-17
* device instance cc_P4_XFRT_SB r0 *1 0,0
Ccc_P4_XFRT_SB P4 XFRT_SB 1.8151e-17
* device instance cc_P4_XFRT_SFB r0 *1 0,0
Ccc_P4_XFRT_SFB P4 XFRT_SFB 1.21e-17
* device instance cc_P4_ck1 r0 *1 0,0
Ccc_P4_ck1 P4 ck1 3.0251e-17
* device instance cc_P4_ck2 r0 *1 0,0
Ccc_P4_ck2 P4 ck2 3.0251e-17
* device instance cc_P4_ck3 r0 *1 0,0
Ccc_P4_ck3 P4 ck3 3.0251e-17
* device instance cc_P4_ck4 r0 *1 0,0
Ccc_P4_ck4 P4 ck4 3.0251e-17
* device instance cc_P4_ck5 r0 *1 0,0
Ccc_P4_ck5 P4 ck5 3.0251e-17
* device instance cc_P4_mod0 r0 *1 0,0
Ccc_P4_mod0 P4 mod0 2.4201e-17
* device instance cc_P4_mod1 r0 *1 0,0
Ccc_P4_mod1 P4 mod1 2.4201e-17
* device instance cc_P4_mod2 r0 *1 0,0
Ccc_P4_mod2 P4 mod2 2.4201e-17
* device instance cc_P4_mod3 r0 *1 0,0
Ccc_P4_mod3 P4 mod3 2.4201e-17
* device instance cc_P4_mod4 r0 *1 0,0
Ccc_P4_mod4 P4 mod4 2.4201e-17
* device instance cc_P4_net1 r0 *1 0,0
Ccc_P4_net1 P4 net1 1.21e-17
* device instance cc_P5_VDD_DIV r0 *1 0,0
Ccc_P5_VDD_DIV P5 VDD_DIV 6.89728e-16
* device instance cc_P5_VSS r0 *1 0,0
Ccc_P5_VSS P5 VSS 1.63357e-16
* device instance cc_P5_XD0_XDFFM_CKBB r0 *1 0,0
Ccc_P5_XD0_XDFFM_CKBB P5 XD0_XDFFM_CKBB 1.8151e-17
* device instance cc_P5_XD0_XDFFM_CLKB r0 *1 0,0
Ccc_P5_XD0_XDFFM_CLKB P5 XD0_XDFFM_CLKB 2.4201e-17
* device instance cc_P5_XD0_XDFFM_M r0 *1 0,0
Ccc_P5_XD0_XDFFM_M P5 XD0_XDFFM_M 2.4201e-17
* device instance cc_P5_XD0_XDFFM_MB r0 *1 0,0
Ccc_P5_XD0_XDFFM_MB P5 XD0_XDFFM_MB 1.21e-17
* device instance cc_P5_XD0_XDFFM_MFB r0 *1 0,0
Ccc_P5_XD0_XDFFM_MFB P5 XD0_XDFFM_MFB 1.21e-17
* device instance cc_P5_XD0_XDFFM_S r0 *1 0,0
Ccc_P5_XD0_XDFFM_S P5 XD0_XDFFM_S 1.8151e-17
* device instance cc_P5_XD0_XDFFM_SB r0 *1 0,0
Ccc_P5_XD0_XDFFM_SB P5 XD0_XDFFM_SB 1.8151e-17
* device instance cc_P5_XD0_XDFFM_SFB r0 *1 0,0
Ccc_P5_XD0_XDFFM_SFB P5 XD0_XDFFM_SFB 1.21e-17
* device instance cc_P5_XD0_XDFFQ_CKBB r0 *1 0,0
Ccc_P5_XD0_XDFFQ_CKBB P5 XD0_XDFFQ_CKBB 1.8151e-17
* device instance cc_P5_XD0_XDFFQ_CLKB r0 *1 0,0
Ccc_P5_XD0_XDFFQ_CLKB P5 XD0_XDFFQ_CLKB 2.4201e-17
* device instance cc_P5_XD0_XDFFQ_M r0 *1 0,0
Ccc_P5_XD0_XDFFQ_M P5 XD0_XDFFQ_M 2.4201e-17
* device instance cc_P5_XD0_XDFFQ_MB r0 *1 0,0
Ccc_P5_XD0_XDFFQ_MB P5 XD0_XDFFQ_MB 1.21e-17
* device instance cc_P5_XD0_XDFFQ_MFB r0 *1 0,0
Ccc_P5_XD0_XDFFQ_MFB P5 XD0_XDFFQ_MFB 1.21e-17
* device instance cc_P5_XD0_XDFFQ_S r0 *1 0,0
Ccc_P5_XD0_XDFFQ_S P5 XD0_XDFFQ_S 1.8151e-17
* device instance cc_P5_XD0_XDFFQ_SB r0 *1 0,0
Ccc_P5_XD0_XDFFQ_SB P5 XD0_XDFFQ_SB 1.8151e-17
* device instance cc_P5_XD0_XDFFQ_SFB r0 *1 0,0
Ccc_P5_XD0_XDFFQ_SFB P5 XD0_XDFFQ_SFB 1.21e-17
* device instance cc_P5_XD0_XNOR_midp r0 *1 0,0
Ccc_P5_XD0_XNOR_midp P5 XD0_XNOR_midp 1.21e-17
* device instance cc_P5_XD0_dmodout r0 *1 0,0
Ccc_P5_XD0_dmodout P5 XD0_dmodout 1.21e-17
* device instance cc_P5_XD0_dq r0 *1 0,0
Ccc_P5_XD0_dq P5 XD0_dq 1.21e-17
* device instance cc_P5_XD0_nm r0 *1 0,0
Ccc_P5_XD0_nm P5 XD0_nm 1.8151e-17
* device instance cc_P5_XD0_nt r0 *1 0,0
Ccc_P5_XD0_nt P5 XD0_nt 2.4201e-17
* device instance cc_P5_XD0_t1 r0 *1 0,0
Ccc_P5_XD0_t1 P5 XD0_t1 1.21e-17
* device instance cc_P5_XD1_XDFFM_CKBB r0 *1 0,0
Ccc_P5_XD1_XDFFM_CKBB P5 XD1_XDFFM_CKBB 1.8151e-17
* device instance cc_P5_XD1_XDFFM_CLKB r0 *1 0,0
Ccc_P5_XD1_XDFFM_CLKB P5 XD1_XDFFM_CLKB 2.4201e-17
* device instance cc_P5_XD1_XDFFM_M r0 *1 0,0
Ccc_P5_XD1_XDFFM_M P5 XD1_XDFFM_M 2.4201e-17
* device instance cc_P5_XD1_XDFFM_MB r0 *1 0,0
Ccc_P5_XD1_XDFFM_MB P5 XD1_XDFFM_MB 1.21e-17
* device instance cc_P5_XD1_XDFFM_MFB r0 *1 0,0
Ccc_P5_XD1_XDFFM_MFB P5 XD1_XDFFM_MFB 1.21e-17
* device instance cc_P5_XD1_XDFFM_S r0 *1 0,0
Ccc_P5_XD1_XDFFM_S P5 XD1_XDFFM_S 1.8151e-17
* device instance cc_P5_XD1_XDFFM_SB r0 *1 0,0
Ccc_P5_XD1_XDFFM_SB P5 XD1_XDFFM_SB 1.8151e-17
* device instance cc_P5_XD1_XDFFM_SFB r0 *1 0,0
Ccc_P5_XD1_XDFFM_SFB P5 XD1_XDFFM_SFB 1.21e-17
* device instance cc_P5_XD1_XDFFQ_CKBB r0 *1 0,0
Ccc_P5_XD1_XDFFQ_CKBB P5 XD1_XDFFQ_CKBB 1.8151e-17
* device instance cc_P5_XD1_XDFFQ_CLKB r0 *1 0,0
Ccc_P5_XD1_XDFFQ_CLKB P5 XD1_XDFFQ_CLKB 2.4201e-17
* device instance cc_P5_XD1_XDFFQ_M r0 *1 0,0
Ccc_P5_XD1_XDFFQ_M P5 XD1_XDFFQ_M 2.4201e-17
* device instance cc_P5_XD1_XDFFQ_MB r0 *1 0,0
Ccc_P5_XD1_XDFFQ_MB P5 XD1_XDFFQ_MB 1.21e-17
* device instance cc_P5_XD1_XDFFQ_MFB r0 *1 0,0
Ccc_P5_XD1_XDFFQ_MFB P5 XD1_XDFFQ_MFB 1.21e-17
* device instance cc_P5_XD1_XDFFQ_S r0 *1 0,0
Ccc_P5_XD1_XDFFQ_S P5 XD1_XDFFQ_S 1.8151e-17
* device instance cc_P5_XD1_XDFFQ_SB r0 *1 0,0
Ccc_P5_XD1_XDFFQ_SB P5 XD1_XDFFQ_SB 1.8151e-17
* device instance cc_P5_XD1_XDFFQ_SFB r0 *1 0,0
Ccc_P5_XD1_XDFFQ_SFB P5 XD1_XDFFQ_SFB 1.21e-17
* device instance cc_P5_XD1_XNOR_midp r0 *1 0,0
Ccc_P5_XD1_XNOR_midp P5 XD1_XNOR_midp 1.21e-17
* device instance cc_P5_XD1_dmodout r0 *1 0,0
Ccc_P5_XD1_dmodout P5 XD1_dmodout 1.21e-17
* device instance cc_P5_XD1_dq r0 *1 0,0
Ccc_P5_XD1_dq P5 XD1_dq 1.21e-17
* device instance cc_P5_XD1_nm r0 *1 0,0
Ccc_P5_XD1_nm P5 XD1_nm 1.8151e-17
* device instance cc_P5_XD1_nt r0 *1 0,0
Ccc_P5_XD1_nt P5 XD1_nt 2.4201e-17
* device instance cc_P5_XD1_t1 r0 *1 0,0
Ccc_P5_XD1_t1 P5 XD1_t1 1.21e-17
* device instance cc_P5_XD2_XDFFM_CKBB r0 *1 0,0
Ccc_P5_XD2_XDFFM_CKBB P5 XD2_XDFFM_CKBB 1.8151e-17
* device instance cc_P5_XD2_XDFFM_CLKB r0 *1 0,0
Ccc_P5_XD2_XDFFM_CLKB P5 XD2_XDFFM_CLKB 2.4201e-17
* device instance cc_P5_XD2_XDFFM_M r0 *1 0,0
Ccc_P5_XD2_XDFFM_M P5 XD2_XDFFM_M 2.4201e-17
* device instance cc_P5_XD2_XDFFM_MB r0 *1 0,0
Ccc_P5_XD2_XDFFM_MB P5 XD2_XDFFM_MB 1.21e-17
* device instance cc_P5_XD2_XDFFM_MFB r0 *1 0,0
Ccc_P5_XD2_XDFFM_MFB P5 XD2_XDFFM_MFB 1.21e-17
* device instance cc_P5_XD2_XDFFM_S r0 *1 0,0
Ccc_P5_XD2_XDFFM_S P5 XD2_XDFFM_S 1.8151e-17
* device instance cc_P5_XD2_XDFFM_SB r0 *1 0,0
Ccc_P5_XD2_XDFFM_SB P5 XD2_XDFFM_SB 1.8151e-17
* device instance cc_P5_XD2_XDFFM_SFB r0 *1 0,0
Ccc_P5_XD2_XDFFM_SFB P5 XD2_XDFFM_SFB 1.21e-17
* device instance cc_P5_XD2_XDFFQ_CKBB r0 *1 0,0
Ccc_P5_XD2_XDFFQ_CKBB P5 XD2_XDFFQ_CKBB 1.8151e-17
* device instance cc_P5_XD2_XDFFQ_CLKB r0 *1 0,0
Ccc_P5_XD2_XDFFQ_CLKB P5 XD2_XDFFQ_CLKB 2.4201e-17
* device instance cc_P5_XD2_XDFFQ_M r0 *1 0,0
Ccc_P5_XD2_XDFFQ_M P5 XD2_XDFFQ_M 2.4201e-17
* device instance cc_P5_XD2_XDFFQ_MB r0 *1 0,0
Ccc_P5_XD2_XDFFQ_MB P5 XD2_XDFFQ_MB 1.21e-17
* device instance cc_P5_XD2_XDFFQ_MFB r0 *1 0,0
Ccc_P5_XD2_XDFFQ_MFB P5 XD2_XDFFQ_MFB 1.21e-17
* device instance cc_P5_XD2_XDFFQ_S r0 *1 0,0
Ccc_P5_XD2_XDFFQ_S P5 XD2_XDFFQ_S 1.8151e-17
* device instance cc_P5_XD2_XDFFQ_SB r0 *1 0,0
Ccc_P5_XD2_XDFFQ_SB P5 XD2_XDFFQ_SB 1.8151e-17
* device instance cc_P5_XD2_XDFFQ_SFB r0 *1 0,0
Ccc_P5_XD2_XDFFQ_SFB P5 XD2_XDFFQ_SFB 1.21e-17
* device instance cc_P5_XD2_XNOR_midp r0 *1 0,0
Ccc_P5_XD2_XNOR_midp P5 XD2_XNOR_midp 1.21e-17
* device instance cc_P5_XD2_dmodout r0 *1 0,0
Ccc_P5_XD2_dmodout P5 XD2_dmodout 1.21e-17
* device instance cc_P5_XD2_dq r0 *1 0,0
Ccc_P5_XD2_dq P5 XD2_dq 1.21e-17
* device instance cc_P5_XD2_nm r0 *1 0,0
Ccc_P5_XD2_nm P5 XD2_nm 1.8151e-17
* device instance cc_P5_XD2_nt r0 *1 0,0
Ccc_P5_XD2_nt P5 XD2_nt 2.4201e-17
* device instance cc_P5_XD2_t1 r0 *1 0,0
Ccc_P5_XD2_t1 P5 XD2_t1 1.21e-17
* device instance cc_P5_XD3_XDFFM_CKBB r0 *1 0,0
Ccc_P5_XD3_XDFFM_CKBB P5 XD3_XDFFM_CKBB 1.8151e-17
* device instance cc_P5_XD3_XDFFM_CLKB r0 *1 0,0
Ccc_P5_XD3_XDFFM_CLKB P5 XD3_XDFFM_CLKB 2.4201e-17
* device instance cc_P5_XD3_XDFFM_M r0 *1 0,0
Ccc_P5_XD3_XDFFM_M P5 XD3_XDFFM_M 2.4201e-17
* device instance cc_P5_XD3_XDFFM_MB r0 *1 0,0
Ccc_P5_XD3_XDFFM_MB P5 XD3_XDFFM_MB 1.21e-17
* device instance cc_P5_XD3_XDFFM_MFB r0 *1 0,0
Ccc_P5_XD3_XDFFM_MFB P5 XD3_XDFFM_MFB 1.21e-17
* device instance cc_P5_XD3_XDFFM_S r0 *1 0,0
Ccc_P5_XD3_XDFFM_S P5 XD3_XDFFM_S 1.8151e-17
* device instance cc_P5_XD3_XDFFM_SB r0 *1 0,0
Ccc_P5_XD3_XDFFM_SB P5 XD3_XDFFM_SB 1.8151e-17
* device instance cc_P5_XD3_XDFFM_SFB r0 *1 0,0
Ccc_P5_XD3_XDFFM_SFB P5 XD3_XDFFM_SFB 1.21e-17
* device instance cc_P5_XD3_XDFFQ_CKBB r0 *1 0,0
Ccc_P5_XD3_XDFFQ_CKBB P5 XD3_XDFFQ_CKBB 1.8151e-17
* device instance cc_P5_XD3_XDFFQ_CLKB r0 *1 0,0
Ccc_P5_XD3_XDFFQ_CLKB P5 XD3_XDFFQ_CLKB 2.4201e-17
* device instance cc_P5_XD3_XDFFQ_M r0 *1 0,0
Ccc_P5_XD3_XDFFQ_M P5 XD3_XDFFQ_M 2.4201e-17
* device instance cc_P5_XD3_XDFFQ_MB r0 *1 0,0
Ccc_P5_XD3_XDFFQ_MB P5 XD3_XDFFQ_MB 1.21e-17
* device instance cc_P5_XD3_XDFFQ_MFB r0 *1 0,0
Ccc_P5_XD3_XDFFQ_MFB P5 XD3_XDFFQ_MFB 1.21e-17
* device instance cc_P5_XD3_XDFFQ_S r0 *1 0,0
Ccc_P5_XD3_XDFFQ_S P5 XD3_XDFFQ_S 1.8151e-17
* device instance cc_P5_XD3_XDFFQ_SB r0 *1 0,0
Ccc_P5_XD3_XDFFQ_SB P5 XD3_XDFFQ_SB 1.8151e-17
* device instance cc_P5_XD3_XDFFQ_SFB r0 *1 0,0
Ccc_P5_XD3_XDFFQ_SFB P5 XD3_XDFFQ_SFB 1.21e-17
* device instance cc_P5_XD3_XNOR_midp r0 *1 0,0
Ccc_P5_XD3_XNOR_midp P5 XD3_XNOR_midp 1.21e-17
* device instance cc_P5_XD3_dmodout r0 *1 0,0
Ccc_P5_XD3_dmodout P5 XD3_dmodout 1.21e-17
* device instance cc_P5_XD3_dq r0 *1 0,0
Ccc_P5_XD3_dq P5 XD3_dq 1.21e-17
* device instance cc_P5_XD3_nm r0 *1 0,0
Ccc_P5_XD3_nm P5 XD3_nm 1.8151e-17
* device instance cc_P5_XD3_nt r0 *1 0,0
Ccc_P5_XD3_nt P5 XD3_nt 2.4201e-17
* device instance cc_P5_XD3_t1 r0 *1 0,0
Ccc_P5_XD3_t1 P5 XD3_t1 1.21e-17
* device instance cc_P5_XD4_XDFFM_CKBB r0 *1 0,0
Ccc_P5_XD4_XDFFM_CKBB P5 XD4_XDFFM_CKBB 1.8151e-17
* device instance cc_P5_XD4_XDFFM_CLKB r0 *1 0,0
Ccc_P5_XD4_XDFFM_CLKB P5 XD4_XDFFM_CLKB 2.4201e-17
* device instance cc_P5_XD4_XDFFM_M r0 *1 0,0
Ccc_P5_XD4_XDFFM_M P5 XD4_XDFFM_M 2.4201e-17
* device instance cc_P5_XD4_XDFFM_MB r0 *1 0,0
Ccc_P5_XD4_XDFFM_MB P5 XD4_XDFFM_MB 1.21e-17
* device instance cc_P5_XD4_XDFFM_MFB r0 *1 0,0
Ccc_P5_XD4_XDFFM_MFB P5 XD4_XDFFM_MFB 1.21e-17
* device instance cc_P5_XD4_XDFFM_S r0 *1 0,0
Ccc_P5_XD4_XDFFM_S P5 XD4_XDFFM_S 1.8151e-17
* device instance cc_P5_XD4_XDFFM_SB r0 *1 0,0
Ccc_P5_XD4_XDFFM_SB P5 XD4_XDFFM_SB 1.8151e-17
* device instance cc_P5_XD4_XDFFM_SFB r0 *1 0,0
Ccc_P5_XD4_XDFFM_SFB P5 XD4_XDFFM_SFB 1.21e-17
* device instance cc_P5_XD4_XDFFQ_CKBB r0 *1 0,0
Ccc_P5_XD4_XDFFQ_CKBB P5 XD4_XDFFQ_CKBB 1.8151e-17
* device instance cc_P5_XD4_XDFFQ_CLKB r0 *1 0,0
Ccc_P5_XD4_XDFFQ_CLKB P5 XD4_XDFFQ_CLKB 2.4201e-17
* device instance cc_P5_XD4_XDFFQ_M r0 *1 0,0
Ccc_P5_XD4_XDFFQ_M P5 XD4_XDFFQ_M 2.4201e-17
* device instance cc_P5_XD4_XDFFQ_MB r0 *1 0,0
Ccc_P5_XD4_XDFFQ_MB P5 XD4_XDFFQ_MB 1.21e-17
* device instance cc_P5_XD4_XDFFQ_MFB r0 *1 0,0
Ccc_P5_XD4_XDFFQ_MFB P5 XD4_XDFFQ_MFB 1.21e-17
* device instance cc_P5_XD4_XDFFQ_S r0 *1 0,0
Ccc_P5_XD4_XDFFQ_S P5 XD4_XDFFQ_S 1.8151e-17
* device instance cc_P5_XD4_XDFFQ_SB r0 *1 0,0
Ccc_P5_XD4_XDFFQ_SB P5 XD4_XDFFQ_SB 1.8151e-17
* device instance cc_P5_XD4_XDFFQ_SFB r0 *1 0,0
Ccc_P5_XD4_XDFFQ_SFB P5 XD4_XDFFQ_SFB 1.21e-17
* device instance cc_P5_XD4_XNOR_midp r0 *1 0,0
Ccc_P5_XD4_XNOR_midp P5 XD4_XNOR_midp 1.21e-17
* device instance cc_P5_XD4_dmodout r0 *1 0,0
Ccc_P5_XD4_dmodout P5 XD4_dmodout 1.21e-17
* device instance cc_P5_XD4_dq r0 *1 0,0
Ccc_P5_XD4_dq P5 XD4_dq 1.21e-17
* device instance cc_P5_XD4_nm r0 *1 0,0
Ccc_P5_XD4_nm P5 XD4_nm 1.8151e-17
* device instance cc_P5_XD4_nt r0 *1 0,0
Ccc_P5_XD4_nt P5 XD4_nt 2.4201e-17
* device instance cc_P5_XD4_t1 r0 *1 0,0
Ccc_P5_XD4_t1 P5 XD4_t1 1.21e-17
* device instance cc_P5_XD5_XDFFM_CKBB r0 *1 0,0
Ccc_P5_XD5_XDFFM_CKBB P5 XD5_XDFFM_CKBB 1.8151e-17
* device instance cc_P5_XD5_XDFFM_CLKB r0 *1 0,0
Ccc_P5_XD5_XDFFM_CLKB P5 XD5_XDFFM_CLKB 2.4201e-17
* device instance cc_P5_XD5_XDFFM_M r0 *1 0,0
Ccc_P5_XD5_XDFFM_M P5 XD5_XDFFM_M 2.4201e-17
* device instance cc_P5_XD5_XDFFM_MB r0 *1 0,0
Ccc_P5_XD5_XDFFM_MB P5 XD5_XDFFM_MB 1.21e-17
* device instance cc_P5_XD5_XDFFM_MFB r0 *1 0,0
Ccc_P5_XD5_XDFFM_MFB P5 XD5_XDFFM_MFB 1.21e-17
* device instance cc_P5_XD5_XDFFM_S r0 *1 0,0
Ccc_P5_XD5_XDFFM_S P5 XD5_XDFFM_S 1.8151e-17
* device instance cc_P5_XD5_XDFFM_SB r0 *1 0,0
Ccc_P5_XD5_XDFFM_SB P5 XD5_XDFFM_SB 1.8151e-17
* device instance cc_P5_XD5_XDFFM_SFB r0 *1 0,0
Ccc_P5_XD5_XDFFM_SFB P5 XD5_XDFFM_SFB 1.21e-17
* device instance cc_P5_XD5_XDFFQ_CKBB r0 *1 0,0
Ccc_P5_XD5_XDFFQ_CKBB P5 XD5_XDFFQ_CKBB 1.8151e-17
* device instance cc_P5_XD5_XDFFQ_CLKB r0 *1 0,0
Ccc_P5_XD5_XDFFQ_CLKB P5 XD5_XDFFQ_CLKB 2.4201e-17
* device instance cc_P5_XD5_XDFFQ_M r0 *1 0,0
Ccc_P5_XD5_XDFFQ_M P5 XD5_XDFFQ_M 2.4201e-17
* device instance cc_P5_XD5_XDFFQ_MB r0 *1 0,0
Ccc_P5_XD5_XDFFQ_MB P5 XD5_XDFFQ_MB 1.21e-17
* device instance cc_P5_XD5_XDFFQ_MFB r0 *1 0,0
Ccc_P5_XD5_XDFFQ_MFB P5 XD5_XDFFQ_MFB 1.21e-17
* device instance cc_P5_XD5_XDFFQ_S r0 *1 0,0
Ccc_P5_XD5_XDFFQ_S P5 XD5_XDFFQ_S 1.8151e-17
* device instance cc_P5_XD5_XDFFQ_SB r0 *1 0,0
Ccc_P5_XD5_XDFFQ_SB P5 XD5_XDFFQ_SB 1.8151e-17
* device instance cc_P5_XD5_XDFFQ_SFB r0 *1 0,0
Ccc_P5_XD5_XDFFQ_SFB P5 XD5_XDFFQ_SFB 1.21e-17
* device instance cc_P5_XD5_XN2_mid1 r0 *1 0,0
Ccc_P5_XD5_XN2_mid1 P5 XD5_XN2_mid1 1.21e-17
* device instance cc_P5_XD5_XN3_mid1 r0 *1 0,0
Ccc_P5_XD5_XN3_mid1 P5 XD5_XN3_mid1 6.05e-18
* device instance cc_P5_XD5_XN3_mid2 r0 *1 0,0
Ccc_P5_XD5_XN3_mid2 P5 XD5_XN3_mid2 1.21e-17
* device instance cc_P5_XD5_dmodout r0 *1 0,0
Ccc_P5_XD5_dmodout P5 XD5_dmodout 1.21e-17
* device instance cc_P5_XD5_dq r0 *1 0,0
Ccc_P5_XD5_dq P5 XD5_dq 1.8151e-17
* device instance cc_P5_XD5_nm r0 *1 0,0
Ccc_P5_XD5_nm P5 XD5_nm 1.21e-17
* device instance cc_P5_XD5_nt r0 *1 0,0
Ccc_P5_XD5_nt P5 XD5_nt 1.21e-17
* device instance cc_P5_XD5_t1 r0 *1 0,0
Ccc_P5_XD5_t1 P5 XD5_t1 1.21e-17
* device instance cc_P5_XFRT_CKBB r0 *1 0,0
Ccc_P5_XFRT_CKBB P5 XFRT_CKBB 1.8151e-17
* device instance cc_P5_XFRT_CLKB r0 *1 0,0
Ccc_P5_XFRT_CLKB P5 XFRT_CLKB 2.4201e-17
* device instance cc_P5_XFRT_M r0 *1 0,0
Ccc_P5_XFRT_M P5 XFRT_M 2.4201e-17
* device instance cc_P5_XFRT_MB r0 *1 0,0
Ccc_P5_XFRT_MB P5 XFRT_MB 1.21e-17
* device instance cc_P5_XFRT_MFB r0 *1 0,0
Ccc_P5_XFRT_MFB P5 XFRT_MFB 1.21e-17
* device instance cc_P5_XFRT_S r0 *1 0,0
Ccc_P5_XFRT_S P5 XFRT_S 1.8151e-17
* device instance cc_P5_XFRT_SB r0 *1 0,0
Ccc_P5_XFRT_SB P5 XFRT_SB 1.8151e-17
* device instance cc_P5_XFRT_SFB r0 *1 0,0
Ccc_P5_XFRT_SFB P5 XFRT_SFB 1.21e-17
* device instance cc_P5_ck1 r0 *1 0,0
Ccc_P5_ck1 P5 ck1 3.0251e-17
* device instance cc_P5_ck2 r0 *1 0,0
Ccc_P5_ck2 P5 ck2 3.0251e-17
* device instance cc_P5_ck3 r0 *1 0,0
Ccc_P5_ck3 P5 ck3 3.0251e-17
* device instance cc_P5_ck4 r0 *1 0,0
Ccc_P5_ck4 P5 ck4 3.0251e-17
* device instance cc_P5_ck5 r0 *1 0,0
Ccc_P5_ck5 P5 ck5 3.0251e-17
* device instance cc_P5_mod0 r0 *1 0,0
Ccc_P5_mod0 P5 mod0 2.4201e-17
* device instance cc_P5_mod1 r0 *1 0,0
Ccc_P5_mod1 P5 mod1 2.4201e-17
* device instance cc_P5_mod2 r0 *1 0,0
Ccc_P5_mod2 P5 mod2 2.4201e-17
* device instance cc_P5_mod3 r0 *1 0,0
Ccc_P5_mod3 P5 mod3 2.4201e-17
* device instance cc_P5_mod4 r0 *1 0,0
Ccc_P5_mod4 P5 mod4 2.4201e-17
* device instance cc_P5_net1 r0 *1 0,0
Ccc_P5_net1 P5 net1 1.21e-17
* device instance cc_VDD_DIV_VSS r0 *1 0,0
Ccc_VDD_DIV_VSS VDD_DIV VSS 1.63357e-16
* device instance cc_VDD_DIV_XD0_XDFFM_CKBB r0 *1 0,0
Ccc_VDD_DIV_XD0_XDFFM_CKBB VDD_DIV XD0_XDFFM_CKBB 2.3394e-17
* device instance cc_VDD_DIV_XD0_XDFFM_CLKB r0 *1 0,0
Ccc_VDD_DIV_XD0_XDFFM_CLKB VDD_DIV XD0_XDFFM_CLKB 2.9445e-17
* device instance cc_VDD_DIV_XD0_XDFFM_M r0 *1 0,0
Ccc_VDD_DIV_XD0_XDFFM_M VDD_DIV XD0_XDFFM_M 2.4201e-17
* device instance cc_VDD_DIV_XD0_XDFFM_MB r0 *1 0,0
Ccc_VDD_DIV_XD0_XDFFM_MB VDD_DIV XD0_XDFFM_MB 1.7344e-17
* device instance cc_VDD_DIV_XD0_XDFFM_MFB r0 *1 0,0
Ccc_VDD_DIV_XD0_XDFFM_MFB VDD_DIV XD0_XDFFM_MFB 1.7344e-17
* device instance cc_VDD_DIV_XD0_XDFFM_S r0 *1 0,0
Ccc_VDD_DIV_XD0_XDFFM_S VDD_DIV XD0_XDFFM_S 1.8151e-17
* device instance cc_VDD_DIV_XD0_XDFFM_SB r0 *1 0,0
Ccc_VDD_DIV_XD0_XDFFM_SB VDD_DIV XD0_XDFFM_SB 2.3394e-17
* device instance cc_VDD_DIV_XD0_XDFFM_SFB r0 *1 0,0
Ccc_VDD_DIV_XD0_XDFFM_SFB VDD_DIV XD0_XDFFM_SFB 1.7344e-17
* device instance cc_VDD_DIV_XD0_XDFFQ_CKBB r0 *1 0,0
Ccc_VDD_DIV_XD0_XDFFQ_CKBB VDD_DIV XD0_XDFFQ_CKBB 2.3394e-17
* device instance cc_VDD_DIV_XD0_XDFFQ_CLKB r0 *1 0,0
Ccc_VDD_DIV_XD0_XDFFQ_CLKB VDD_DIV XD0_XDFFQ_CLKB 2.9445e-17
* device instance cc_VDD_DIV_XD0_XDFFQ_M r0 *1 0,0
Ccc_VDD_DIV_XD0_XDFFQ_M VDD_DIV XD0_XDFFQ_M 2.4201e-17
* device instance cc_VDD_DIV_XD0_XDFFQ_MB r0 *1 0,0
Ccc_VDD_DIV_XD0_XDFFQ_MB VDD_DIV XD0_XDFFQ_MB 1.7344e-17
* device instance cc_VDD_DIV_XD0_XDFFQ_MFB r0 *1 0,0
Ccc_VDD_DIV_XD0_XDFFQ_MFB VDD_DIV XD0_XDFFQ_MFB 1.7344e-17
* device instance cc_VDD_DIV_XD0_XDFFQ_S r0 *1 0,0
Ccc_VDD_DIV_XD0_XDFFQ_S VDD_DIV XD0_XDFFQ_S 1.8151e-17
* device instance cc_VDD_DIV_XD0_XDFFQ_SB r0 *1 0,0
Ccc_VDD_DIV_XD0_XDFFQ_SB VDD_DIV XD0_XDFFQ_SB 2.3394e-17
* device instance cc_VDD_DIV_XD0_XDFFQ_SFB r0 *1 0,0
Ccc_VDD_DIV_XD0_XDFFQ_SFB VDD_DIV XD0_XDFFQ_SFB 1.7344e-17
* device instance cc_VDD_DIV_XD0_XNOR_midp r0 *1 0,0
Ccc_VDD_DIV_XD0_XNOR_midp VDD_DIV XD0_XNOR_midp 1.7344e-17
* device instance cc_VDD_DIV_XD0_dmodout r0 *1 0,0
Ccc_VDD_DIV_XD0_dmodout VDD_DIV XD0_dmodout 1.7344e-17
* device instance cc_VDD_DIV_XD0_dq r0 *1 0,0
Ccc_VDD_DIV_XD0_dq VDD_DIV XD0_dq 1.21e-17
* device instance cc_VDD_DIV_XD0_nm r0 *1 0,0
Ccc_VDD_DIV_XD0_nm VDD_DIV XD0_nm 2.8638e-17
* device instance cc_VDD_DIV_XD0_nt r0 *1 0,0
Ccc_VDD_DIV_XD0_nt VDD_DIV XD0_nt 3.9932e-17
* device instance cc_VDD_DIV_XD0_t1 r0 *1 0,0
Ccc_VDD_DIV_XD0_t1 VDD_DIV XD0_t1 1.7344e-17
* device instance cc_VDD_DIV_XD1_XDFFM_CKBB r0 *1 0,0
Ccc_VDD_DIV_XD1_XDFFM_CKBB VDD_DIV XD1_XDFFM_CKBB 2.3394e-17
* device instance cc_VDD_DIV_XD1_XDFFM_CLKB r0 *1 0,0
Ccc_VDD_DIV_XD1_XDFFM_CLKB VDD_DIV XD1_XDFFM_CLKB 2.9445e-17
* device instance cc_VDD_DIV_XD1_XDFFM_M r0 *1 0,0
Ccc_VDD_DIV_XD1_XDFFM_M VDD_DIV XD1_XDFFM_M 2.4201e-17
* device instance cc_VDD_DIV_XD1_XDFFM_MB r0 *1 0,0
Ccc_VDD_DIV_XD1_XDFFM_MB VDD_DIV XD1_XDFFM_MB 1.7344e-17
* device instance cc_VDD_DIV_XD1_XDFFM_MFB r0 *1 0,0
Ccc_VDD_DIV_XD1_XDFFM_MFB VDD_DIV XD1_XDFFM_MFB 1.7344e-17
* device instance cc_VDD_DIV_XD1_XDFFM_S r0 *1 0,0
Ccc_VDD_DIV_XD1_XDFFM_S VDD_DIV XD1_XDFFM_S 1.8151e-17
* device instance cc_VDD_DIV_XD1_XDFFM_SB r0 *1 0,0
Ccc_VDD_DIV_XD1_XDFFM_SB VDD_DIV XD1_XDFFM_SB 2.3394e-17
* device instance cc_VDD_DIV_XD1_XDFFM_SFB r0 *1 0,0
Ccc_VDD_DIV_XD1_XDFFM_SFB VDD_DIV XD1_XDFFM_SFB 1.7344e-17
* device instance cc_VDD_DIV_XD1_XDFFQ_CKBB r0 *1 0,0
Ccc_VDD_DIV_XD1_XDFFQ_CKBB VDD_DIV XD1_XDFFQ_CKBB 2.3394e-17
* device instance cc_VDD_DIV_XD1_XDFFQ_CLKB r0 *1 0,0
Ccc_VDD_DIV_XD1_XDFFQ_CLKB VDD_DIV XD1_XDFFQ_CLKB 2.9445e-17
* device instance cc_VDD_DIV_XD1_XDFFQ_M r0 *1 0,0
Ccc_VDD_DIV_XD1_XDFFQ_M VDD_DIV XD1_XDFFQ_M 2.4201e-17
* device instance cc_VDD_DIV_XD1_XDFFQ_MB r0 *1 0,0
Ccc_VDD_DIV_XD1_XDFFQ_MB VDD_DIV XD1_XDFFQ_MB 1.7344e-17
* device instance cc_VDD_DIV_XD1_XDFFQ_MFB r0 *1 0,0
Ccc_VDD_DIV_XD1_XDFFQ_MFB VDD_DIV XD1_XDFFQ_MFB 1.7344e-17
* device instance cc_VDD_DIV_XD1_XDFFQ_S r0 *1 0,0
Ccc_VDD_DIV_XD1_XDFFQ_S VDD_DIV XD1_XDFFQ_S 1.8151e-17
* device instance cc_VDD_DIV_XD1_XDFFQ_SB r0 *1 0,0
Ccc_VDD_DIV_XD1_XDFFQ_SB VDD_DIV XD1_XDFFQ_SB 2.3394e-17
* device instance cc_VDD_DIV_XD1_XDFFQ_SFB r0 *1 0,0
Ccc_VDD_DIV_XD1_XDFFQ_SFB VDD_DIV XD1_XDFFQ_SFB 1.7344e-17
* device instance cc_VDD_DIV_XD1_XNOR_midp r0 *1 0,0
Ccc_VDD_DIV_XD1_XNOR_midp VDD_DIV XD1_XNOR_midp 1.7344e-17
* device instance cc_VDD_DIV_XD1_dmodout r0 *1 0,0
Ccc_VDD_DIV_XD1_dmodout VDD_DIV XD1_dmodout 1.7344e-17
* device instance cc_VDD_DIV_XD1_dq r0 *1 0,0
Ccc_VDD_DIV_XD1_dq VDD_DIV XD1_dq 1.21e-17
* device instance cc_VDD_DIV_XD1_nm r0 *1 0,0
Ccc_VDD_DIV_XD1_nm VDD_DIV XD1_nm 2.8638e-17
* device instance cc_VDD_DIV_XD1_nt r0 *1 0,0
Ccc_VDD_DIV_XD1_nt VDD_DIV XD1_nt 3.9932e-17
* device instance cc_VDD_DIV_XD1_t1 r0 *1 0,0
Ccc_VDD_DIV_XD1_t1 VDD_DIV XD1_t1 1.7344e-17
* device instance cc_VDD_DIV_XD2_XDFFM_CKBB r0 *1 0,0
Ccc_VDD_DIV_XD2_XDFFM_CKBB VDD_DIV XD2_XDFFM_CKBB 2.3394e-17
* device instance cc_VDD_DIV_XD2_XDFFM_CLKB r0 *1 0,0
Ccc_VDD_DIV_XD2_XDFFM_CLKB VDD_DIV XD2_XDFFM_CLKB 2.9445e-17
* device instance cc_VDD_DIV_XD2_XDFFM_M r0 *1 0,0
Ccc_VDD_DIV_XD2_XDFFM_M VDD_DIV XD2_XDFFM_M 2.4201e-17
* device instance cc_VDD_DIV_XD2_XDFFM_MB r0 *1 0,0
Ccc_VDD_DIV_XD2_XDFFM_MB VDD_DIV XD2_XDFFM_MB 1.7344e-17
* device instance cc_VDD_DIV_XD2_XDFFM_MFB r0 *1 0,0
Ccc_VDD_DIV_XD2_XDFFM_MFB VDD_DIV XD2_XDFFM_MFB 1.7344e-17
* device instance cc_VDD_DIV_XD2_XDFFM_S r0 *1 0,0
Ccc_VDD_DIV_XD2_XDFFM_S VDD_DIV XD2_XDFFM_S 1.8151e-17
* device instance cc_VDD_DIV_XD2_XDFFM_SB r0 *1 0,0
Ccc_VDD_DIV_XD2_XDFFM_SB VDD_DIV XD2_XDFFM_SB 2.3394e-17
* device instance cc_VDD_DIV_XD2_XDFFM_SFB r0 *1 0,0
Ccc_VDD_DIV_XD2_XDFFM_SFB VDD_DIV XD2_XDFFM_SFB 1.7344e-17
* device instance cc_VDD_DIV_XD2_XDFFQ_CKBB r0 *1 0,0
Ccc_VDD_DIV_XD2_XDFFQ_CKBB VDD_DIV XD2_XDFFQ_CKBB 2.3394e-17
* device instance cc_VDD_DIV_XD2_XDFFQ_CLKB r0 *1 0,0
Ccc_VDD_DIV_XD2_XDFFQ_CLKB VDD_DIV XD2_XDFFQ_CLKB 2.9445e-17
* device instance cc_VDD_DIV_XD2_XDFFQ_M r0 *1 0,0
Ccc_VDD_DIV_XD2_XDFFQ_M VDD_DIV XD2_XDFFQ_M 2.4201e-17
* device instance cc_VDD_DIV_XD2_XDFFQ_MB r0 *1 0,0
Ccc_VDD_DIV_XD2_XDFFQ_MB VDD_DIV XD2_XDFFQ_MB 1.7344e-17
* device instance cc_VDD_DIV_XD2_XDFFQ_MFB r0 *1 0,0
Ccc_VDD_DIV_XD2_XDFFQ_MFB VDD_DIV XD2_XDFFQ_MFB 1.7344e-17
* device instance cc_VDD_DIV_XD2_XDFFQ_S r0 *1 0,0
Ccc_VDD_DIV_XD2_XDFFQ_S VDD_DIV XD2_XDFFQ_S 1.8151e-17
* device instance cc_VDD_DIV_XD2_XDFFQ_SB r0 *1 0,0
Ccc_VDD_DIV_XD2_XDFFQ_SB VDD_DIV XD2_XDFFQ_SB 2.3394e-17
* device instance cc_VDD_DIV_XD2_XDFFQ_SFB r0 *1 0,0
Ccc_VDD_DIV_XD2_XDFFQ_SFB VDD_DIV XD2_XDFFQ_SFB 1.7344e-17
* device instance cc_VDD_DIV_XD2_XNOR_midp r0 *1 0,0
Ccc_VDD_DIV_XD2_XNOR_midp VDD_DIV XD2_XNOR_midp 1.7344e-17
* device instance cc_VDD_DIV_XD2_dmodout r0 *1 0,0
Ccc_VDD_DIV_XD2_dmodout VDD_DIV XD2_dmodout 1.7344e-17
* device instance cc_VDD_DIV_XD2_dq r0 *1 0,0
Ccc_VDD_DIV_XD2_dq VDD_DIV XD2_dq 1.21e-17
* device instance cc_VDD_DIV_XD2_nm r0 *1 0,0
Ccc_VDD_DIV_XD2_nm VDD_DIV XD2_nm 2.8638e-17
* device instance cc_VDD_DIV_XD2_nt r0 *1 0,0
Ccc_VDD_DIV_XD2_nt VDD_DIV XD2_nt 3.9932e-17
* device instance cc_VDD_DIV_XD2_t1 r0 *1 0,0
Ccc_VDD_DIV_XD2_t1 VDD_DIV XD2_t1 1.7344e-17
* device instance cc_VDD_DIV_XD3_XDFFM_CKBB r0 *1 0,0
Ccc_VDD_DIV_XD3_XDFFM_CKBB VDD_DIV XD3_XDFFM_CKBB 2.3394e-17
* device instance cc_VDD_DIV_XD3_XDFFM_CLKB r0 *1 0,0
Ccc_VDD_DIV_XD3_XDFFM_CLKB VDD_DIV XD3_XDFFM_CLKB 2.9445e-17
* device instance cc_VDD_DIV_XD3_XDFFM_M r0 *1 0,0
Ccc_VDD_DIV_XD3_XDFFM_M VDD_DIV XD3_XDFFM_M 2.4201e-17
* device instance cc_VDD_DIV_XD3_XDFFM_MB r0 *1 0,0
Ccc_VDD_DIV_XD3_XDFFM_MB VDD_DIV XD3_XDFFM_MB 1.7344e-17
* device instance cc_VDD_DIV_XD3_XDFFM_MFB r0 *1 0,0
Ccc_VDD_DIV_XD3_XDFFM_MFB VDD_DIV XD3_XDFFM_MFB 1.7344e-17
* device instance cc_VDD_DIV_XD3_XDFFM_S r0 *1 0,0
Ccc_VDD_DIV_XD3_XDFFM_S VDD_DIV XD3_XDFFM_S 1.8151e-17
* device instance cc_VDD_DIV_XD3_XDFFM_SB r0 *1 0,0
Ccc_VDD_DIV_XD3_XDFFM_SB VDD_DIV XD3_XDFFM_SB 2.3394e-17
* device instance cc_VDD_DIV_XD3_XDFFM_SFB r0 *1 0,0
Ccc_VDD_DIV_XD3_XDFFM_SFB VDD_DIV XD3_XDFFM_SFB 1.7344e-17
* device instance cc_VDD_DIV_XD3_XDFFQ_CKBB r0 *1 0,0
Ccc_VDD_DIV_XD3_XDFFQ_CKBB VDD_DIV XD3_XDFFQ_CKBB 2.3394e-17
* device instance cc_VDD_DIV_XD3_XDFFQ_CLKB r0 *1 0,0
Ccc_VDD_DIV_XD3_XDFFQ_CLKB VDD_DIV XD3_XDFFQ_CLKB 2.9445e-17
* device instance cc_VDD_DIV_XD3_XDFFQ_M r0 *1 0,0
Ccc_VDD_DIV_XD3_XDFFQ_M VDD_DIV XD3_XDFFQ_M 2.4201e-17
* device instance cc_VDD_DIV_XD3_XDFFQ_MB r0 *1 0,0
Ccc_VDD_DIV_XD3_XDFFQ_MB VDD_DIV XD3_XDFFQ_MB 1.7344e-17
* device instance cc_VDD_DIV_XD3_XDFFQ_MFB r0 *1 0,0
Ccc_VDD_DIV_XD3_XDFFQ_MFB VDD_DIV XD3_XDFFQ_MFB 1.7344e-17
* device instance cc_VDD_DIV_XD3_XDFFQ_S r0 *1 0,0
Ccc_VDD_DIV_XD3_XDFFQ_S VDD_DIV XD3_XDFFQ_S 1.8151e-17
* device instance cc_VDD_DIV_XD3_XDFFQ_SB r0 *1 0,0
Ccc_VDD_DIV_XD3_XDFFQ_SB VDD_DIV XD3_XDFFQ_SB 2.3394e-17
* device instance cc_VDD_DIV_XD3_XDFFQ_SFB r0 *1 0,0
Ccc_VDD_DIV_XD3_XDFFQ_SFB VDD_DIV XD3_XDFFQ_SFB 1.7344e-17
* device instance cc_VDD_DIV_XD3_XNOR_midp r0 *1 0,0
Ccc_VDD_DIV_XD3_XNOR_midp VDD_DIV XD3_XNOR_midp 1.7344e-17
* device instance cc_VDD_DIV_XD3_dmodout r0 *1 0,0
Ccc_VDD_DIV_XD3_dmodout VDD_DIV XD3_dmodout 1.7344e-17
* device instance cc_VDD_DIV_XD3_dq r0 *1 0,0
Ccc_VDD_DIV_XD3_dq VDD_DIV XD3_dq 1.21e-17
* device instance cc_VDD_DIV_XD3_nm r0 *1 0,0
Ccc_VDD_DIV_XD3_nm VDD_DIV XD3_nm 2.8638e-17
* device instance cc_VDD_DIV_XD3_nt r0 *1 0,0
Ccc_VDD_DIV_XD3_nt VDD_DIV XD3_nt 3.9932e-17
* device instance cc_VDD_DIV_XD3_t1 r0 *1 0,0
Ccc_VDD_DIV_XD3_t1 VDD_DIV XD3_t1 1.7344e-17
* device instance cc_VDD_DIV_XD4_XDFFM_CKBB r0 *1 0,0
Ccc_VDD_DIV_XD4_XDFFM_CKBB VDD_DIV XD4_XDFFM_CKBB 2.3394e-17
* device instance cc_VDD_DIV_XD4_XDFFM_CLKB r0 *1 0,0
Ccc_VDD_DIV_XD4_XDFFM_CLKB VDD_DIV XD4_XDFFM_CLKB 2.9445e-17
* device instance cc_VDD_DIV_XD4_XDFFM_M r0 *1 0,0
Ccc_VDD_DIV_XD4_XDFFM_M VDD_DIV XD4_XDFFM_M 2.4201e-17
* device instance cc_VDD_DIV_XD4_XDFFM_MB r0 *1 0,0
Ccc_VDD_DIV_XD4_XDFFM_MB VDD_DIV XD4_XDFFM_MB 1.7344e-17
* device instance cc_VDD_DIV_XD4_XDFFM_MFB r0 *1 0,0
Ccc_VDD_DIV_XD4_XDFFM_MFB VDD_DIV XD4_XDFFM_MFB 1.7344e-17
* device instance cc_VDD_DIV_XD4_XDFFM_S r0 *1 0,0
Ccc_VDD_DIV_XD4_XDFFM_S VDD_DIV XD4_XDFFM_S 1.8151e-17
* device instance cc_VDD_DIV_XD4_XDFFM_SB r0 *1 0,0
Ccc_VDD_DIV_XD4_XDFFM_SB VDD_DIV XD4_XDFFM_SB 2.3394e-17
* device instance cc_VDD_DIV_XD4_XDFFM_SFB r0 *1 0,0
Ccc_VDD_DIV_XD4_XDFFM_SFB VDD_DIV XD4_XDFFM_SFB 1.7344e-17
* device instance cc_VDD_DIV_XD4_XDFFQ_CKBB r0 *1 0,0
Ccc_VDD_DIV_XD4_XDFFQ_CKBB VDD_DIV XD4_XDFFQ_CKBB 2.3394e-17
* device instance cc_VDD_DIV_XD4_XDFFQ_CLKB r0 *1 0,0
Ccc_VDD_DIV_XD4_XDFFQ_CLKB VDD_DIV XD4_XDFFQ_CLKB 2.9445e-17
* device instance cc_VDD_DIV_XD4_XDFFQ_M r0 *1 0,0
Ccc_VDD_DIV_XD4_XDFFQ_M VDD_DIV XD4_XDFFQ_M 2.4201e-17
* device instance cc_VDD_DIV_XD4_XDFFQ_MB r0 *1 0,0
Ccc_VDD_DIV_XD4_XDFFQ_MB VDD_DIV XD4_XDFFQ_MB 1.7344e-17
* device instance cc_VDD_DIV_XD4_XDFFQ_MFB r0 *1 0,0
Ccc_VDD_DIV_XD4_XDFFQ_MFB VDD_DIV XD4_XDFFQ_MFB 1.7344e-17
* device instance cc_VDD_DIV_XD4_XDFFQ_S r0 *1 0,0
Ccc_VDD_DIV_XD4_XDFFQ_S VDD_DIV XD4_XDFFQ_S 1.8151e-17
* device instance cc_VDD_DIV_XD4_XDFFQ_SB r0 *1 0,0
Ccc_VDD_DIV_XD4_XDFFQ_SB VDD_DIV XD4_XDFFQ_SB 2.3394e-17
* device instance cc_VDD_DIV_XD4_XDFFQ_SFB r0 *1 0,0
Ccc_VDD_DIV_XD4_XDFFQ_SFB VDD_DIV XD4_XDFFQ_SFB 1.7344e-17
* device instance cc_VDD_DIV_XD4_XNOR_midp r0 *1 0,0
Ccc_VDD_DIV_XD4_XNOR_midp VDD_DIV XD4_XNOR_midp 1.7344e-17
* device instance cc_VDD_DIV_XD4_dmodout r0 *1 0,0
Ccc_VDD_DIV_XD4_dmodout VDD_DIV XD4_dmodout 1.7344e-17
* device instance cc_VDD_DIV_XD4_dq r0 *1 0,0
Ccc_VDD_DIV_XD4_dq VDD_DIV XD4_dq 1.21e-17
* device instance cc_VDD_DIV_XD4_nm r0 *1 0,0
Ccc_VDD_DIV_XD4_nm VDD_DIV XD4_nm 2.8638e-17
* device instance cc_VDD_DIV_XD4_nt r0 *1 0,0
Ccc_VDD_DIV_XD4_nt VDD_DIV XD4_nt 3.9932e-17
* device instance cc_VDD_DIV_XD4_t1 r0 *1 0,0
Ccc_VDD_DIV_XD4_t1 VDD_DIV XD4_t1 1.7344e-17
* device instance cc_VDD_DIV_XD5_XDFFM_CKBB r0 *1 0,0
Ccc_VDD_DIV_XD5_XDFFM_CKBB VDD_DIV XD5_XDFFM_CKBB 4.1545e-17
* device instance cc_VDD_DIV_XD5_XDFFM_CLKB r0 *1 0,0
Ccc_VDD_DIV_XD5_XDFFM_CLKB VDD_DIV XD5_XDFFM_CLKB 5.3646e-17
* device instance cc_VDD_DIV_XD5_XDFFM_M r0 *1 0,0
Ccc_VDD_DIV_XD5_XDFFM_M VDD_DIV XD5_XDFFM_M 4.8402e-17
* device instance cc_VDD_DIV_XD5_XDFFM_MB r0 *1 0,0
Ccc_VDD_DIV_XD5_XDFFM_MB VDD_DIV XD5_XDFFM_MB 2.9445e-17
* device instance cc_VDD_DIV_XD5_XDFFM_MFB r0 *1 0,0
Ccc_VDD_DIV_XD5_XDFFM_MFB VDD_DIV XD5_XDFFM_MFB 2.9445e-17
* device instance cc_VDD_DIV_XD5_XDFFM_S r0 *1 0,0
Ccc_VDD_DIV_XD5_XDFFM_S VDD_DIV XD5_XDFFM_S 3.6302e-17
* device instance cc_VDD_DIV_XD5_XDFFM_SB r0 *1 0,0
Ccc_VDD_DIV_XD5_XDFFM_SB VDD_DIV XD5_XDFFM_SB 4.1545e-17
* device instance cc_VDD_DIV_XD5_XDFFM_SFB r0 *1 0,0
Ccc_VDD_DIV_XD5_XDFFM_SFB VDD_DIV XD5_XDFFM_SFB 2.9445e-17
* device instance cc_VDD_DIV_XD5_XDFFQ_CKBB r0 *1 0,0
Ccc_VDD_DIV_XD5_XDFFQ_CKBB VDD_DIV XD5_XDFFQ_CKBB 4.1545e-17
* device instance cc_VDD_DIV_XD5_XDFFQ_CLKB r0 *1 0,0
Ccc_VDD_DIV_XD5_XDFFQ_CLKB VDD_DIV XD5_XDFFQ_CLKB 5.3646e-17
* device instance cc_VDD_DIV_XD5_XDFFQ_M r0 *1 0,0
Ccc_VDD_DIV_XD5_XDFFQ_M VDD_DIV XD5_XDFFQ_M 4.8402e-17
* device instance cc_VDD_DIV_XD5_XDFFQ_MB r0 *1 0,0
Ccc_VDD_DIV_XD5_XDFFQ_MB VDD_DIV XD5_XDFFQ_MB 2.9445e-17
* device instance cc_VDD_DIV_XD5_XDFFQ_MFB r0 *1 0,0
Ccc_VDD_DIV_XD5_XDFFQ_MFB VDD_DIV XD5_XDFFQ_MFB 2.9445e-17
* device instance cc_VDD_DIV_XD5_XDFFQ_S r0 *1 0,0
Ccc_VDD_DIV_XD5_XDFFQ_S VDD_DIV XD5_XDFFQ_S 3.6302e-17
* device instance cc_VDD_DIV_XD5_XDFFQ_SB r0 *1 0,0
Ccc_VDD_DIV_XD5_XDFFQ_SB VDD_DIV XD5_XDFFQ_SB 4.1545e-17
* device instance cc_VDD_DIV_XD5_XDFFQ_SFB r0 *1 0,0
Ccc_VDD_DIV_XD5_XDFFQ_SFB VDD_DIV XD5_XDFFQ_SFB 2.9445e-17
* device instance cc_VDD_DIV_XD5_XN2_mid1 r0 *1 0,0
Ccc_VDD_DIV_XD5_XN2_mid1 VDD_DIV XD5_XN2_mid1 1.21e-17
* device instance cc_VDD_DIV_XD5_XN3_mid1 r0 *1 0,0
Ccc_VDD_DIV_XD5_XN3_mid1 VDD_DIV XD5_XN3_mid1 1.21e-17
* device instance cc_VDD_DIV_XD5_XN3_mid2 r0 *1 0,0
Ccc_VDD_DIV_XD5_XN3_mid2 VDD_DIV XD5_XN3_mid2 1.21e-17
* device instance cc_VDD_DIV_XD5_XNOR_midp r0 *1 0,0
Ccc_VDD_DIV_XD5_XNOR_midp VDD_DIV XD5_XNOR_midp 1.7344e-17
* device instance cc_VDD_DIV_XD5_dmodout r0 *1 0,0
Ccc_VDD_DIV_XD5_dmodout VDD_DIV XD5_dmodout 2.9445e-17
* device instance cc_VDD_DIV_XD5_dq r0 *1 0,0
Ccc_VDD_DIV_XD5_dq VDD_DIV XD5_dq 3.0251e-17
* device instance cc_VDD_DIV_XD5_nm r0 *1 0,0
Ccc_VDD_DIV_XD5_nm VDD_DIV XD5_nm 4.0738e-17
* device instance cc_VDD_DIV_XD5_nt r0 *1 0,0
Ccc_VDD_DIV_XD5_nt VDD_DIV XD5_nt 5.2032e-17
* device instance cc_VDD_DIV_XD5_t1 r0 *1 0,0
Ccc_VDD_DIV_XD5_t1 VDD_DIV XD5_t1 2.9445e-17
* device instance cc_VDD_DIV_XFRT_CKBB r0 *1 0,0
Ccc_VDD_DIV_XFRT_CKBB VDD_DIV XFRT_CKBB 4.1545e-17
* device instance cc_VDD_DIV_XFRT_CLKB r0 *1 0,0
Ccc_VDD_DIV_XFRT_CLKB VDD_DIV XFRT_CLKB 5.3646e-17
* device instance cc_VDD_DIV_XFRT_M r0 *1 0,0
Ccc_VDD_DIV_XFRT_M VDD_DIV XFRT_M 4.8402e-17
* device instance cc_VDD_DIV_XFRT_MB r0 *1 0,0
Ccc_VDD_DIV_XFRT_MB VDD_DIV XFRT_MB 2.9445e-17
* device instance cc_VDD_DIV_XFRT_MFB r0 *1 0,0
Ccc_VDD_DIV_XFRT_MFB VDD_DIV XFRT_MFB 2.9445e-17
* device instance cc_VDD_DIV_XFRT_S r0 *1 0,0
Ccc_VDD_DIV_XFRT_S VDD_DIV XFRT_S 3.6302e-17
* device instance cc_VDD_DIV_XFRT_SB r0 *1 0,0
Ccc_VDD_DIV_XFRT_SB VDD_DIV XFRT_SB 4.1545e-17
* device instance cc_VDD_DIV_XFRT_SFB r0 *1 0,0
Ccc_VDD_DIV_XFRT_SFB VDD_DIV XFRT_SFB 2.9445e-17
* device instance cc_VDD_DIV_ck1 r0 *1 0,0
Ccc_VDD_DIV_ck1 VDD_DIV ck1 3.5495e-17
* device instance cc_VDD_DIV_ck2 r0 *1 0,0
Ccc_VDD_DIV_ck2 VDD_DIV ck2 3.5495e-17
* device instance cc_VDD_DIV_ck3 r0 *1 0,0
Ccc_VDD_DIV_ck3 VDD_DIV ck3 3.5495e-17
* device instance cc_VDD_DIV_ck4 r0 *1 0,0
Ccc_VDD_DIV_ck4 VDD_DIV ck4 3.5495e-17
* device instance cc_VDD_DIV_ck5 r0 *1 0,0
Ccc_VDD_DIV_ck5 VDD_DIV ck5 4.7595e-17
* device instance cc_VDD_DIV_mod0 r0 *1 0,0
Ccc_VDD_DIV_mod0 VDD_DIV mod0 2.9445e-17
* device instance cc_VDD_DIV_mod1 r0 *1 0,0
Ccc_VDD_DIV_mod1 VDD_DIV mod1 2.9445e-17
* device instance cc_VDD_DIV_mod2 r0 *1 0,0
Ccc_VDD_DIV_mod2 VDD_DIV mod2 2.9445e-17
* device instance cc_VDD_DIV_mod3 r0 *1 0,0
Ccc_VDD_DIV_mod3 VDD_DIV mod3 2.9445e-17
* device instance cc_VDD_DIV_mod4 r0 *1 0,0
Ccc_VDD_DIV_mod4 VDD_DIV mod4 4.1545e-17
* device instance cc_VDD_DIV_net1 r0 *1 0,0
Ccc_VDD_DIV_net1 VDD_DIV net1 1.7344e-17
* device instance cc_VSS_XD0_XDFFM_CKBB r0 *1 0,0
Ccc_VSS_XD0_XDFFM_CKBB VSS XD0_XDFFM_CKBB 2.3394e-17
* device instance cc_VSS_XD0_XDFFM_CLKB r0 *1 0,0
Ccc_VSS_XD0_XDFFM_CLKB VSS XD0_XDFFM_CLKB 2.9445e-17
* device instance cc_VSS_XD0_XDFFM_M r0 *1 0,0
Ccc_VSS_XD0_XDFFM_M VSS XD0_XDFFM_M 2.4201e-17
* device instance cc_VSS_XD0_XDFFM_MB r0 *1 0,0
Ccc_VSS_XD0_XDFFM_MB VSS XD0_XDFFM_MB 1.7344e-17
* device instance cc_VSS_XD0_XDFFM_MFB r0 *1 0,0
Ccc_VSS_XD0_XDFFM_MFB VSS XD0_XDFFM_MFB 1.7344e-17
* device instance cc_VSS_XD0_XDFFM_S r0 *1 0,0
Ccc_VSS_XD0_XDFFM_S VSS XD0_XDFFM_S 1.8151e-17
* device instance cc_VSS_XD0_XDFFM_SB r0 *1 0,0
Ccc_VSS_XD0_XDFFM_SB VSS XD0_XDFFM_SB 2.3394e-17
* device instance cc_VSS_XD0_XDFFM_SFB r0 *1 0,0
Ccc_VSS_XD0_XDFFM_SFB VSS XD0_XDFFM_SFB 1.7344e-17
* device instance cc_VSS_XD0_XDFFQ_CKBB r0 *1 0,0
Ccc_VSS_XD0_XDFFQ_CKBB VSS XD0_XDFFQ_CKBB 2.3394e-17
* device instance cc_VSS_XD0_XDFFQ_CLKB r0 *1 0,0
Ccc_VSS_XD0_XDFFQ_CLKB VSS XD0_XDFFQ_CLKB 2.9445e-17
* device instance cc_VSS_XD0_XDFFQ_M r0 *1 0,0
Ccc_VSS_XD0_XDFFQ_M VSS XD0_XDFFQ_M 2.4201e-17
* device instance cc_VSS_XD0_XDFFQ_MB r0 *1 0,0
Ccc_VSS_XD0_XDFFQ_MB VSS XD0_XDFFQ_MB 1.7344e-17
* device instance cc_VSS_XD0_XDFFQ_MFB r0 *1 0,0
Ccc_VSS_XD0_XDFFQ_MFB VSS XD0_XDFFQ_MFB 1.7344e-17
* device instance cc_VSS_XD0_XDFFQ_S r0 *1 0,0
Ccc_VSS_XD0_XDFFQ_S VSS XD0_XDFFQ_S 1.8151e-17
* device instance cc_VSS_XD0_XDFFQ_SB r0 *1 0,0
Ccc_VSS_XD0_XDFFQ_SB VSS XD0_XDFFQ_SB 2.3394e-17
* device instance cc_VSS_XD0_XDFFQ_SFB r0 *1 0,0
Ccc_VSS_XD0_XDFFQ_SFB VSS XD0_XDFFQ_SFB 1.7344e-17
* device instance cc_VSS_XD0_XN2_mid1 r0 *1 0,0
Ccc_VSS_XD0_XN2_mid1 VSS XD0_XN2_mid1 1.7344e-17
* device instance cc_VSS_XD0_XN3_mid1 r0 *1 0,0
Ccc_VSS_XD0_XN3_mid1 VSS XD0_XN3_mid1 1.21e-17
* device instance cc_VSS_XD0_XN3_mid2 r0 *1 0,0
Ccc_VSS_XD0_XN3_mid2 VSS XD0_XN3_mid2 1.7344e-17
* device instance cc_VSS_XD0_dmodout r0 *1 0,0
Ccc_VSS_XD0_dmodout VSS XD0_dmodout 1.7344e-17
* device instance cc_VSS_XD0_dq r0 *1 0,0
Ccc_VSS_XD0_dq VSS XD0_dq 2.8638e-17
* device instance cc_VSS_XD0_nm r0 *1 0,0
Ccc_VSS_XD0_nm VSS XD0_nm 1.21e-17
* device instance cc_VSS_XD0_nt r0 *1 0,0
Ccc_VSS_XD0_nt VSS XD0_nt 1.21e-17
* device instance cc_VSS_XD0_t1 r0 *1 0,0
Ccc_VSS_XD0_t1 VSS XD0_t1 1.7344e-17
* device instance cc_VSS_XD1_XDFFM_CKBB r0 *1 0,0
Ccc_VSS_XD1_XDFFM_CKBB VSS XD1_XDFFM_CKBB 2.3394e-17
* device instance cc_VSS_XD1_XDFFM_CLKB r0 *1 0,0
Ccc_VSS_XD1_XDFFM_CLKB VSS XD1_XDFFM_CLKB 2.9445e-17
* device instance cc_VSS_XD1_XDFFM_M r0 *1 0,0
Ccc_VSS_XD1_XDFFM_M VSS XD1_XDFFM_M 2.4201e-17
* device instance cc_VSS_XD1_XDFFM_MB r0 *1 0,0
Ccc_VSS_XD1_XDFFM_MB VSS XD1_XDFFM_MB 1.7344e-17
* device instance cc_VSS_XD1_XDFFM_MFB r0 *1 0,0
Ccc_VSS_XD1_XDFFM_MFB VSS XD1_XDFFM_MFB 1.7344e-17
* device instance cc_VSS_XD1_XDFFM_S r0 *1 0,0
Ccc_VSS_XD1_XDFFM_S VSS XD1_XDFFM_S 1.8151e-17
* device instance cc_VSS_XD1_XDFFM_SB r0 *1 0,0
Ccc_VSS_XD1_XDFFM_SB VSS XD1_XDFFM_SB 2.3394e-17
* device instance cc_VSS_XD1_XDFFM_SFB r0 *1 0,0
Ccc_VSS_XD1_XDFFM_SFB VSS XD1_XDFFM_SFB 1.7344e-17
* device instance cc_VSS_XD1_XDFFQ_CKBB r0 *1 0,0
Ccc_VSS_XD1_XDFFQ_CKBB VSS XD1_XDFFQ_CKBB 2.3394e-17
* device instance cc_VSS_XD1_XDFFQ_CLKB r0 *1 0,0
Ccc_VSS_XD1_XDFFQ_CLKB VSS XD1_XDFFQ_CLKB 2.9445e-17
* device instance cc_VSS_XD1_XDFFQ_M r0 *1 0,0
Ccc_VSS_XD1_XDFFQ_M VSS XD1_XDFFQ_M 2.4201e-17
* device instance cc_VSS_XD1_XDFFQ_MB r0 *1 0,0
Ccc_VSS_XD1_XDFFQ_MB VSS XD1_XDFFQ_MB 1.7344e-17
* device instance cc_VSS_XD1_XDFFQ_MFB r0 *1 0,0
Ccc_VSS_XD1_XDFFQ_MFB VSS XD1_XDFFQ_MFB 1.7344e-17
* device instance cc_VSS_XD1_XDFFQ_S r0 *1 0,0
Ccc_VSS_XD1_XDFFQ_S VSS XD1_XDFFQ_S 1.8151e-17
* device instance cc_VSS_XD1_XDFFQ_SB r0 *1 0,0
Ccc_VSS_XD1_XDFFQ_SB VSS XD1_XDFFQ_SB 2.3394e-17
* device instance cc_VSS_XD1_XDFFQ_SFB r0 *1 0,0
Ccc_VSS_XD1_XDFFQ_SFB VSS XD1_XDFFQ_SFB 1.7344e-17
* device instance cc_VSS_XD1_XN2_mid1 r0 *1 0,0
Ccc_VSS_XD1_XN2_mid1 VSS XD1_XN2_mid1 1.7344e-17
* device instance cc_VSS_XD1_XN3_mid1 r0 *1 0,0
Ccc_VSS_XD1_XN3_mid1 VSS XD1_XN3_mid1 1.21e-17
* device instance cc_VSS_XD1_XN3_mid2 r0 *1 0,0
Ccc_VSS_XD1_XN3_mid2 VSS XD1_XN3_mid2 1.7344e-17
* device instance cc_VSS_XD1_dmodout r0 *1 0,0
Ccc_VSS_XD1_dmodout VSS XD1_dmodout 1.7344e-17
* device instance cc_VSS_XD1_dq r0 *1 0,0
Ccc_VSS_XD1_dq VSS XD1_dq 2.8638e-17
* device instance cc_VSS_XD1_nm r0 *1 0,0
Ccc_VSS_XD1_nm VSS XD1_nm 1.21e-17
* device instance cc_VSS_XD1_nt r0 *1 0,0
Ccc_VSS_XD1_nt VSS XD1_nt 1.21e-17
* device instance cc_VSS_XD1_t1 r0 *1 0,0
Ccc_VSS_XD1_t1 VSS XD1_t1 1.7344e-17
* device instance cc_VSS_XD2_XDFFM_CKBB r0 *1 0,0
Ccc_VSS_XD2_XDFFM_CKBB VSS XD2_XDFFM_CKBB 2.3394e-17
* device instance cc_VSS_XD2_XDFFM_CLKB r0 *1 0,0
Ccc_VSS_XD2_XDFFM_CLKB VSS XD2_XDFFM_CLKB 2.9445e-17
* device instance cc_VSS_XD2_XDFFM_M r0 *1 0,0
Ccc_VSS_XD2_XDFFM_M VSS XD2_XDFFM_M 2.4201e-17
* device instance cc_VSS_XD2_XDFFM_MB r0 *1 0,0
Ccc_VSS_XD2_XDFFM_MB VSS XD2_XDFFM_MB 1.7344e-17
* device instance cc_VSS_XD2_XDFFM_MFB r0 *1 0,0
Ccc_VSS_XD2_XDFFM_MFB VSS XD2_XDFFM_MFB 1.7344e-17
* device instance cc_VSS_XD2_XDFFM_S r0 *1 0,0
Ccc_VSS_XD2_XDFFM_S VSS XD2_XDFFM_S 1.8151e-17
* device instance cc_VSS_XD2_XDFFM_SB r0 *1 0,0
Ccc_VSS_XD2_XDFFM_SB VSS XD2_XDFFM_SB 2.3394e-17
* device instance cc_VSS_XD2_XDFFM_SFB r0 *1 0,0
Ccc_VSS_XD2_XDFFM_SFB VSS XD2_XDFFM_SFB 1.7344e-17
* device instance cc_VSS_XD2_XDFFQ_CKBB r0 *1 0,0
Ccc_VSS_XD2_XDFFQ_CKBB VSS XD2_XDFFQ_CKBB 2.3394e-17
* device instance cc_VSS_XD2_XDFFQ_CLKB r0 *1 0,0
Ccc_VSS_XD2_XDFFQ_CLKB VSS XD2_XDFFQ_CLKB 2.9445e-17
* device instance cc_VSS_XD2_XDFFQ_M r0 *1 0,0
Ccc_VSS_XD2_XDFFQ_M VSS XD2_XDFFQ_M 2.4201e-17
* device instance cc_VSS_XD2_XDFFQ_MB r0 *1 0,0
Ccc_VSS_XD2_XDFFQ_MB VSS XD2_XDFFQ_MB 1.7344e-17
* device instance cc_VSS_XD2_XDFFQ_MFB r0 *1 0,0
Ccc_VSS_XD2_XDFFQ_MFB VSS XD2_XDFFQ_MFB 1.7344e-17
* device instance cc_VSS_XD2_XDFFQ_S r0 *1 0,0
Ccc_VSS_XD2_XDFFQ_S VSS XD2_XDFFQ_S 1.8151e-17
* device instance cc_VSS_XD2_XDFFQ_SB r0 *1 0,0
Ccc_VSS_XD2_XDFFQ_SB VSS XD2_XDFFQ_SB 2.3394e-17
* device instance cc_VSS_XD2_XDFFQ_SFB r0 *1 0,0
Ccc_VSS_XD2_XDFFQ_SFB VSS XD2_XDFFQ_SFB 1.7344e-17
* device instance cc_VSS_XD2_XN2_mid1 r0 *1 0,0
Ccc_VSS_XD2_XN2_mid1 VSS XD2_XN2_mid1 1.7344e-17
* device instance cc_VSS_XD2_XN3_mid1 r0 *1 0,0
Ccc_VSS_XD2_XN3_mid1 VSS XD2_XN3_mid1 1.21e-17
* device instance cc_VSS_XD2_XN3_mid2 r0 *1 0,0
Ccc_VSS_XD2_XN3_mid2 VSS XD2_XN3_mid2 1.7344e-17
* device instance cc_VSS_XD2_dmodout r0 *1 0,0
Ccc_VSS_XD2_dmodout VSS XD2_dmodout 1.7344e-17
* device instance cc_VSS_XD2_dq r0 *1 0,0
Ccc_VSS_XD2_dq VSS XD2_dq 2.8638e-17
* device instance cc_VSS_XD2_nm r0 *1 0,0
Ccc_VSS_XD2_nm VSS XD2_nm 1.21e-17
* device instance cc_VSS_XD2_nt r0 *1 0,0
Ccc_VSS_XD2_nt VSS XD2_nt 1.21e-17
* device instance cc_VSS_XD2_t1 r0 *1 0,0
Ccc_VSS_XD2_t1 VSS XD2_t1 1.7344e-17
* device instance cc_VSS_XD3_XDFFM_CKBB r0 *1 0,0
Ccc_VSS_XD3_XDFFM_CKBB VSS XD3_XDFFM_CKBB 2.3394e-17
* device instance cc_VSS_XD3_XDFFM_CLKB r0 *1 0,0
Ccc_VSS_XD3_XDFFM_CLKB VSS XD3_XDFFM_CLKB 2.9445e-17
* device instance cc_VSS_XD3_XDFFM_M r0 *1 0,0
Ccc_VSS_XD3_XDFFM_M VSS XD3_XDFFM_M 2.4201e-17
* device instance cc_VSS_XD3_XDFFM_MB r0 *1 0,0
Ccc_VSS_XD3_XDFFM_MB VSS XD3_XDFFM_MB 1.7344e-17
* device instance cc_VSS_XD3_XDFFM_MFB r0 *1 0,0
Ccc_VSS_XD3_XDFFM_MFB VSS XD3_XDFFM_MFB 1.7344e-17
* device instance cc_VSS_XD3_XDFFM_S r0 *1 0,0
Ccc_VSS_XD3_XDFFM_S VSS XD3_XDFFM_S 1.8151e-17
* device instance cc_VSS_XD3_XDFFM_SB r0 *1 0,0
Ccc_VSS_XD3_XDFFM_SB VSS XD3_XDFFM_SB 2.3394e-17
* device instance cc_VSS_XD3_XDFFM_SFB r0 *1 0,0
Ccc_VSS_XD3_XDFFM_SFB VSS XD3_XDFFM_SFB 1.7344e-17
* device instance cc_VSS_XD3_XDFFQ_CKBB r0 *1 0,0
Ccc_VSS_XD3_XDFFQ_CKBB VSS XD3_XDFFQ_CKBB 2.3394e-17
* device instance cc_VSS_XD3_XDFFQ_CLKB r0 *1 0,0
Ccc_VSS_XD3_XDFFQ_CLKB VSS XD3_XDFFQ_CLKB 2.9445e-17
* device instance cc_VSS_XD3_XDFFQ_M r0 *1 0,0
Ccc_VSS_XD3_XDFFQ_M VSS XD3_XDFFQ_M 2.4201e-17
* device instance cc_VSS_XD3_XDFFQ_MB r0 *1 0,0
Ccc_VSS_XD3_XDFFQ_MB VSS XD3_XDFFQ_MB 1.7344e-17
* device instance cc_VSS_XD3_XDFFQ_MFB r0 *1 0,0
Ccc_VSS_XD3_XDFFQ_MFB VSS XD3_XDFFQ_MFB 1.7344e-17
* device instance cc_VSS_XD3_XDFFQ_S r0 *1 0,0
Ccc_VSS_XD3_XDFFQ_S VSS XD3_XDFFQ_S 1.8151e-17
* device instance cc_VSS_XD3_XDFFQ_SB r0 *1 0,0
Ccc_VSS_XD3_XDFFQ_SB VSS XD3_XDFFQ_SB 2.3394e-17
* device instance cc_VSS_XD3_XDFFQ_SFB r0 *1 0,0
Ccc_VSS_XD3_XDFFQ_SFB VSS XD3_XDFFQ_SFB 1.7344e-17
* device instance cc_VSS_XD3_XN2_mid1 r0 *1 0,0
Ccc_VSS_XD3_XN2_mid1 VSS XD3_XN2_mid1 1.7344e-17
* device instance cc_VSS_XD3_XN3_mid1 r0 *1 0,0
Ccc_VSS_XD3_XN3_mid1 VSS XD3_XN3_mid1 1.21e-17
* device instance cc_VSS_XD3_XN3_mid2 r0 *1 0,0
Ccc_VSS_XD3_XN3_mid2 VSS XD3_XN3_mid2 1.7344e-17
* device instance cc_VSS_XD3_dmodout r0 *1 0,0
Ccc_VSS_XD3_dmodout VSS XD3_dmodout 1.7344e-17
* device instance cc_VSS_XD3_dq r0 *1 0,0
Ccc_VSS_XD3_dq VSS XD3_dq 2.8638e-17
* device instance cc_VSS_XD3_nm r0 *1 0,0
Ccc_VSS_XD3_nm VSS XD3_nm 1.21e-17
* device instance cc_VSS_XD3_nt r0 *1 0,0
Ccc_VSS_XD3_nt VSS XD3_nt 1.21e-17
* device instance cc_VSS_XD3_t1 r0 *1 0,0
Ccc_VSS_XD3_t1 VSS XD3_t1 1.7344e-17
* device instance cc_VSS_XD4_XDFFM_CKBB r0 *1 0,0
Ccc_VSS_XD4_XDFFM_CKBB VSS XD4_XDFFM_CKBB 2.3394e-17
* device instance cc_VSS_XD4_XDFFM_CLKB r0 *1 0,0
Ccc_VSS_XD4_XDFFM_CLKB VSS XD4_XDFFM_CLKB 2.9445e-17
* device instance cc_VSS_XD4_XDFFM_M r0 *1 0,0
Ccc_VSS_XD4_XDFFM_M VSS XD4_XDFFM_M 2.4201e-17
* device instance cc_VSS_XD4_XDFFM_MB r0 *1 0,0
Ccc_VSS_XD4_XDFFM_MB VSS XD4_XDFFM_MB 1.7344e-17
* device instance cc_VSS_XD4_XDFFM_MFB r0 *1 0,0
Ccc_VSS_XD4_XDFFM_MFB VSS XD4_XDFFM_MFB 1.7344e-17
* device instance cc_VSS_XD4_XDFFM_S r0 *1 0,0
Ccc_VSS_XD4_XDFFM_S VSS XD4_XDFFM_S 1.8151e-17
* device instance cc_VSS_XD4_XDFFM_SB r0 *1 0,0
Ccc_VSS_XD4_XDFFM_SB VSS XD4_XDFFM_SB 2.3394e-17
* device instance cc_VSS_XD4_XDFFM_SFB r0 *1 0,0
Ccc_VSS_XD4_XDFFM_SFB VSS XD4_XDFFM_SFB 1.7344e-17
* device instance cc_VSS_XD4_XDFFQ_CKBB r0 *1 0,0
Ccc_VSS_XD4_XDFFQ_CKBB VSS XD4_XDFFQ_CKBB 2.3394e-17
* device instance cc_VSS_XD4_XDFFQ_CLKB r0 *1 0,0
Ccc_VSS_XD4_XDFFQ_CLKB VSS XD4_XDFFQ_CLKB 2.9445e-17
* device instance cc_VSS_XD4_XDFFQ_M r0 *1 0,0
Ccc_VSS_XD4_XDFFQ_M VSS XD4_XDFFQ_M 2.4201e-17
* device instance cc_VSS_XD4_XDFFQ_MB r0 *1 0,0
Ccc_VSS_XD4_XDFFQ_MB VSS XD4_XDFFQ_MB 1.7344e-17
* device instance cc_VSS_XD4_XDFFQ_MFB r0 *1 0,0
Ccc_VSS_XD4_XDFFQ_MFB VSS XD4_XDFFQ_MFB 1.7344e-17
* device instance cc_VSS_XD4_XDFFQ_S r0 *1 0,0
Ccc_VSS_XD4_XDFFQ_S VSS XD4_XDFFQ_S 1.8151e-17
* device instance cc_VSS_XD4_XDFFQ_SB r0 *1 0,0
Ccc_VSS_XD4_XDFFQ_SB VSS XD4_XDFFQ_SB 2.3394e-17
* device instance cc_VSS_XD4_XDFFQ_SFB r0 *1 0,0
Ccc_VSS_XD4_XDFFQ_SFB VSS XD4_XDFFQ_SFB 1.7344e-17
* device instance cc_VSS_XD4_XN2_mid1 r0 *1 0,0
Ccc_VSS_XD4_XN2_mid1 VSS XD4_XN2_mid1 1.7344e-17
* device instance cc_VSS_XD4_XN3_mid1 r0 *1 0,0
Ccc_VSS_XD4_XN3_mid1 VSS XD4_XN3_mid1 1.21e-17
* device instance cc_VSS_XD4_XN3_mid2 r0 *1 0,0
Ccc_VSS_XD4_XN3_mid2 VSS XD4_XN3_mid2 1.7344e-17
* device instance cc_VSS_XD4_dmodout r0 *1 0,0
Ccc_VSS_XD4_dmodout VSS XD4_dmodout 1.7344e-17
* device instance cc_VSS_XD4_dq r0 *1 0,0
Ccc_VSS_XD4_dq VSS XD4_dq 2.8638e-17
* device instance cc_VSS_XD4_nm r0 *1 0,0
Ccc_VSS_XD4_nm VSS XD4_nm 1.21e-17
* device instance cc_VSS_XD4_nt r0 *1 0,0
Ccc_VSS_XD4_nt VSS XD4_nt 1.21e-17
* device instance cc_VSS_XD4_t1 r0 *1 0,0
Ccc_VSS_XD4_t1 VSS XD4_t1 1.7344e-17
* device instance cc_VSS_XD5_XDFFM_CKBB r0 *1 0,0
Ccc_VSS_XD5_XDFFM_CKBB VSS XD5_XDFFM_CKBB 2.3394e-17
* device instance cc_VSS_XD5_XDFFM_CLKB r0 *1 0,0
Ccc_VSS_XD5_XDFFM_CLKB VSS XD5_XDFFM_CLKB 2.9445e-17
* device instance cc_VSS_XD5_XDFFM_M r0 *1 0,0
Ccc_VSS_XD5_XDFFM_M VSS XD5_XDFFM_M 2.4201e-17
* device instance cc_VSS_XD5_XDFFM_MB r0 *1 0,0
Ccc_VSS_XD5_XDFFM_MB VSS XD5_XDFFM_MB 1.7344e-17
* device instance cc_VSS_XD5_XDFFM_MFB r0 *1 0,0
Ccc_VSS_XD5_XDFFM_MFB VSS XD5_XDFFM_MFB 1.7344e-17
* device instance cc_VSS_XD5_XDFFM_S r0 *1 0,0
Ccc_VSS_XD5_XDFFM_S VSS XD5_XDFFM_S 1.8151e-17
* device instance cc_VSS_XD5_XDFFM_SB r0 *1 0,0
Ccc_VSS_XD5_XDFFM_SB VSS XD5_XDFFM_SB 2.3394e-17
* device instance cc_VSS_XD5_XDFFM_SFB r0 *1 0,0
Ccc_VSS_XD5_XDFFM_SFB VSS XD5_XDFFM_SFB 1.7344e-17
* device instance cc_VSS_XD5_XDFFQ_CKBB r0 *1 0,0
Ccc_VSS_XD5_XDFFQ_CKBB VSS XD5_XDFFQ_CKBB 2.3394e-17
* device instance cc_VSS_XD5_XDFFQ_CLKB r0 *1 0,0
Ccc_VSS_XD5_XDFFQ_CLKB VSS XD5_XDFFQ_CLKB 2.9445e-17
* device instance cc_VSS_XD5_XDFFQ_M r0 *1 0,0
Ccc_VSS_XD5_XDFFQ_M VSS XD5_XDFFQ_M 2.4201e-17
* device instance cc_VSS_XD5_XDFFQ_MB r0 *1 0,0
Ccc_VSS_XD5_XDFFQ_MB VSS XD5_XDFFQ_MB 1.7344e-17
* device instance cc_VSS_XD5_XDFFQ_MFB r0 *1 0,0
Ccc_VSS_XD5_XDFFQ_MFB VSS XD5_XDFFQ_MFB 1.7344e-17
* device instance cc_VSS_XD5_XDFFQ_S r0 *1 0,0
Ccc_VSS_XD5_XDFFQ_S VSS XD5_XDFFQ_S 1.8151e-17
* device instance cc_VSS_XD5_XDFFQ_SB r0 *1 0,0
Ccc_VSS_XD5_XDFFQ_SB VSS XD5_XDFFQ_SB 2.3394e-17
* device instance cc_VSS_XD5_XDFFQ_SFB r0 *1 0,0
Ccc_VSS_XD5_XDFFQ_SFB VSS XD5_XDFFQ_SFB 1.7344e-17
* device instance cc_VSS_XD5_XN2_mid1 r0 *1 0,0
Ccc_VSS_XD5_XN2_mid1 VSS XD5_XN2_mid1 1.7344e-17
* device instance cc_VSS_XD5_XN3_mid1 r0 *1 0,0
Ccc_VSS_XD5_XN3_mid1 VSS XD5_XN3_mid1 1.21e-17
* device instance cc_VSS_XD5_XN3_mid2 r0 *1 0,0
Ccc_VSS_XD5_XN3_mid2 VSS XD5_XN3_mid2 1.7344e-17
* device instance cc_VSS_XD5_dmodout r0 *1 0,0
Ccc_VSS_XD5_dmodout VSS XD5_dmodout 1.7344e-17
* device instance cc_VSS_XD5_dq r0 *1 0,0
Ccc_VSS_XD5_dq VSS XD5_dq 2.8638e-17
* device instance cc_VSS_XD5_nm r0 *1 0,0
Ccc_VSS_XD5_nm VSS XD5_nm 1.21e-17
* device instance cc_VSS_XD5_nt r0 *1 0,0
Ccc_VSS_XD5_nt VSS XD5_nt 1.21e-17
* device instance cc_VSS_XD5_t1 r0 *1 0,0
Ccc_VSS_XD5_t1 VSS XD5_t1 1.7344e-17
* device instance cc_VSS_XFRT_CKBB r0 *1 0,0
Ccc_VSS_XFRT_CKBB VSS XFRT_CKBB 2.3394e-17
* device instance cc_VSS_XFRT_CLKB r0 *1 0,0
Ccc_VSS_XFRT_CLKB VSS XFRT_CLKB 2.9445e-17
* device instance cc_VSS_XFRT_M r0 *1 0,0
Ccc_VSS_XFRT_M VSS XFRT_M 2.4201e-17
* device instance cc_VSS_XFRT_MB r0 *1 0,0
Ccc_VSS_XFRT_MB VSS XFRT_MB 1.7344e-17
* device instance cc_VSS_XFRT_MFB r0 *1 0,0
Ccc_VSS_XFRT_MFB VSS XFRT_MFB 1.7344e-17
* device instance cc_VSS_XFRT_S r0 *1 0,0
Ccc_VSS_XFRT_S VSS XFRT_S 1.8151e-17
* device instance cc_VSS_XFRT_SB r0 *1 0,0
Ccc_VSS_XFRT_SB VSS XFRT_SB 2.3394e-17
* device instance cc_VSS_XFRT_SFB r0 *1 0,0
Ccc_VSS_XFRT_SFB VSS XFRT_SFB 1.7344e-17
* device instance cc_VSS_ck1 r0 *1 0,0
Ccc_VSS_ck1 VSS ck1 3.5495e-17
* device instance cc_VSS_ck2 r0 *1 0,0
Ccc_VSS_ck2 VSS ck2 3.5495e-17
* device instance cc_VSS_ck3 r0 *1 0,0
Ccc_VSS_ck3 VSS ck3 3.5495e-17
* device instance cc_VSS_ck4 r0 *1 0,0
Ccc_VSS_ck4 VSS ck4 3.5495e-17
* device instance cc_VSS_ck5 r0 *1 0,0
Ccc_VSS_ck5 VSS ck5 3.5495e-17
* device instance cc_VSS_mod0 r0 *1 0,0
Ccc_VSS_mod0 VSS mod0 2.9445e-17
* device instance cc_VSS_mod1 r0 *1 0,0
Ccc_VSS_mod1 VSS mod1 2.9445e-17
* device instance cc_VSS_mod2 r0 *1 0,0
Ccc_VSS_mod2 VSS mod2 2.9445e-17
* device instance cc_VSS_mod3 r0 *1 0,0
Ccc_VSS_mod3 VSS mod3 2.9445e-17
* device instance cc_VSS_mod4 r0 *1 0,0
Ccc_VSS_mod4 VSS mod4 2.9445e-17
* device instance cc_VSS_net1 r0 *1 0,0
Ccc_VSS_net1 VSS net1 1.7344e-17
* device instance cc_XD0_XDFFM_CKBB_XD0_XDFFM_CLKB r0 *1 0,0
Ccc_XD0_XDFFM_CKBB_XD0_XDFFM_CLKB XD0_XDFFM_CKBB XD0_XDFFM_CLKB 3.6302e-17
* device instance cc_XD0_XDFFM_CKBB_XD0_XDFFM_M r0 *1 0,0
Ccc_XD0_XDFFM_CKBB_XD0_XDFFM_M XD0_XDFFM_CKBB XD0_XDFFM_M 4.8402e-17
* device instance cc_XD0_XDFFM_CKBB_XD0_XDFFM_MB r0 *1 0,0
Ccc_XD0_XDFFM_CKBB_XD0_XDFFM_MB XD0_XDFFM_CKBB XD0_XDFFM_MB 2.4201e-17
* device instance cc_XD0_XDFFM_CKBB_XD0_XDFFM_MFB r0 *1 0,0
Ccc_XD0_XDFFM_CKBB_XD0_XDFFM_MFB XD0_XDFFM_CKBB XD0_XDFFM_MFB 2.4201e-17
* device instance cc_XD0_XDFFM_CKBB_XD0_XDFFM_S r0 *1 0,0
Ccc_XD0_XDFFM_CKBB_XD0_XDFFM_S XD0_XDFFM_CKBB XD0_XDFFM_S 3.0251e-17
* device instance cc_XD0_XDFFM_CKBB_XD0_XDFFM_SB r0 *1 0,0
Ccc_XD0_XDFFM_CKBB_XD0_XDFFM_SB XD0_XDFFM_CKBB XD0_XDFFM_SB 3.0251e-17
* device instance cc_XD0_XDFFM_CKBB_XD0_XDFFM_SFB r0 *1 0,0
Ccc_XD0_XDFFM_CKBB_XD0_XDFFM_SFB XD0_XDFFM_CKBB XD0_XDFFM_SFB 1.8151e-17
* device instance cc_XD0_XDFFM_CKBB_XD0_XDFFQ_CKBB r0 *1 0,0
Ccc_XD0_XDFFM_CKBB_XD0_XDFFQ_CKBB XD0_XDFFM_CKBB XD0_XDFFQ_CKBB 1.8151e-17
* device instance cc_XD0_XDFFM_CKBB_XD0_XDFFQ_CLKB r0 *1 0,0
Ccc_XD0_XDFFM_CKBB_XD0_XDFFQ_CLKB XD0_XDFFM_CKBB XD0_XDFFQ_CLKB 2.4201e-17
* device instance cc_XD0_XDFFM_CKBB_XD0_XDFFQ_M r0 *1 0,0
Ccc_XD0_XDFFM_CKBB_XD0_XDFFQ_M XD0_XDFFM_CKBB XD0_XDFFQ_M 2.4201e-17
* device instance cc_XD0_XDFFM_CKBB_XD0_XDFFQ_MB r0 *1 0,0
Ccc_XD0_XDFFM_CKBB_XD0_XDFFQ_MB XD0_XDFFM_CKBB XD0_XDFFQ_MB 1.21e-17
* device instance cc_XD0_XDFFM_CKBB_XD0_XDFFQ_MFB r0 *1 0,0
Ccc_XD0_XDFFM_CKBB_XD0_XDFFQ_MFB XD0_XDFFM_CKBB XD0_XDFFQ_MFB 1.21e-17
* device instance cc_XD0_XDFFM_CKBB_XD0_XDFFQ_S r0 *1 0,0
Ccc_XD0_XDFFM_CKBB_XD0_XDFFQ_S XD0_XDFFM_CKBB XD0_XDFFQ_S 1.8151e-17
* device instance cc_XD0_XDFFM_CKBB_XD0_XDFFQ_SB r0 *1 0,0
Ccc_XD0_XDFFM_CKBB_XD0_XDFFQ_SB XD0_XDFFM_CKBB XD0_XDFFQ_SB 1.8151e-17
* device instance cc_XD0_XDFFM_CKBB_XD0_XDFFQ_SFB r0 *1 0,0
Ccc_XD0_XDFFM_CKBB_XD0_XDFFQ_SFB XD0_XDFFM_CKBB XD0_XDFFQ_SFB 1.21e-17
* device instance cc_XD0_XDFFM_CKBB_XD0_XNOR_midp r0 *1 0,0
Ccc_XD0_XDFFM_CKBB_XD0_XNOR_midp XD0_XDFFM_CKBB XD0_XNOR_midp 1.21e-17
* device instance cc_XD0_XDFFM_CKBB_XD0_dmodout r0 *1 0,0
Ccc_XD0_XDFFM_CKBB_XD0_dmodout XD0_XDFFM_CKBB XD0_dmodout 1.8151e-17
* device instance cc_XD0_XDFFM_CKBB_XD0_dq r0 *1 0,0
Ccc_XD0_XDFFM_CKBB_XD0_dq XD0_XDFFM_CKBB XD0_dq 1.21e-17
* device instance cc_XD0_XDFFM_CKBB_XD0_nm r0 *1 0,0
Ccc_XD0_XDFFM_CKBB_XD0_nm XD0_XDFFM_CKBB XD0_nm 1.8151e-17
* device instance cc_XD0_XDFFM_CKBB_XD0_nt r0 *1 0,0
Ccc_XD0_XDFFM_CKBB_XD0_nt XD0_XDFFM_CKBB XD0_nt 2.4201e-17
* device instance cc_XD0_XDFFM_CKBB_XD0_t1 r0 *1 0,0
Ccc_XD0_XDFFM_CKBB_XD0_t1 XD0_XDFFM_CKBB XD0_t1 1.21e-17
* device instance cc_XD0_XDFFM_CKBB_XD1_XDFFM_CKBB r0 *1 0,0
Ccc_XD0_XDFFM_CKBB_XD1_XDFFM_CKBB XD0_XDFFM_CKBB XD1_XDFFM_CKBB 1.8151e-17
* device instance cc_XD0_XDFFM_CKBB_XD1_XDFFM_CLKB r0 *1 0,0
Ccc_XD0_XDFFM_CKBB_XD1_XDFFM_CLKB XD0_XDFFM_CKBB XD1_XDFFM_CLKB 2.4201e-17
* device instance cc_XD0_XDFFM_CKBB_XD1_XDFFM_M r0 *1 0,0
Ccc_XD0_XDFFM_CKBB_XD1_XDFFM_M XD0_XDFFM_CKBB XD1_XDFFM_M 2.4201e-17
* device instance cc_XD0_XDFFM_CKBB_XD1_XDFFM_MB r0 *1 0,0
Ccc_XD0_XDFFM_CKBB_XD1_XDFFM_MB XD0_XDFFM_CKBB XD1_XDFFM_MB 1.21e-17
* device instance cc_XD0_XDFFM_CKBB_XD1_XDFFM_MFB r0 *1 0,0
Ccc_XD0_XDFFM_CKBB_XD1_XDFFM_MFB XD0_XDFFM_CKBB XD1_XDFFM_MFB 1.21e-17
* device instance cc_XD0_XDFFM_CKBB_XD1_XDFFM_S r0 *1 0,0
Ccc_XD0_XDFFM_CKBB_XD1_XDFFM_S XD0_XDFFM_CKBB XD1_XDFFM_S 1.8151e-17
* device instance cc_XD0_XDFFM_CKBB_XD1_XDFFM_SB r0 *1 0,0
Ccc_XD0_XDFFM_CKBB_XD1_XDFFM_SB XD0_XDFFM_CKBB XD1_XDFFM_SB 1.8151e-17
* device instance cc_XD0_XDFFM_CKBB_XD1_XDFFM_SFB r0 *1 0,0
Ccc_XD0_XDFFM_CKBB_XD1_XDFFM_SFB XD0_XDFFM_CKBB XD1_XDFFM_SFB 1.21e-17
* device instance cc_XD0_XDFFM_CKBB_XD1_XDFFQ_CKBB r0 *1 0,0
Ccc_XD0_XDFFM_CKBB_XD1_XDFFQ_CKBB XD0_XDFFM_CKBB XD1_XDFFQ_CKBB 1.8151e-17
* device instance cc_XD0_XDFFM_CKBB_XD1_XDFFQ_CLKB r0 *1 0,0
Ccc_XD0_XDFFM_CKBB_XD1_XDFFQ_CLKB XD0_XDFFM_CKBB XD1_XDFFQ_CLKB 2.4201e-17
* device instance cc_XD0_XDFFM_CKBB_XD1_XDFFQ_M r0 *1 0,0
Ccc_XD0_XDFFM_CKBB_XD1_XDFFQ_M XD0_XDFFM_CKBB XD1_XDFFQ_M 2.4201e-17
* device instance cc_XD0_XDFFM_CKBB_XD1_XDFFQ_MB r0 *1 0,0
Ccc_XD0_XDFFM_CKBB_XD1_XDFFQ_MB XD0_XDFFM_CKBB XD1_XDFFQ_MB 1.21e-17
* device instance cc_XD0_XDFFM_CKBB_XD1_XDFFQ_MFB r0 *1 0,0
Ccc_XD0_XDFFM_CKBB_XD1_XDFFQ_MFB XD0_XDFFM_CKBB XD1_XDFFQ_MFB 1.21e-17
* device instance cc_XD0_XDFFM_CKBB_XD1_XDFFQ_S r0 *1 0,0
Ccc_XD0_XDFFM_CKBB_XD1_XDFFQ_S XD0_XDFFM_CKBB XD1_XDFFQ_S 1.8151e-17
* device instance cc_XD0_XDFFM_CKBB_XD1_XDFFQ_SB r0 *1 0,0
Ccc_XD0_XDFFM_CKBB_XD1_XDFFQ_SB XD0_XDFFM_CKBB XD1_XDFFQ_SB 1.8151e-17
* device instance cc_XD0_XDFFM_CKBB_XD1_XDFFQ_SFB r0 *1 0,0
Ccc_XD0_XDFFM_CKBB_XD1_XDFFQ_SFB XD0_XDFFM_CKBB XD1_XDFFQ_SFB 1.21e-17
* device instance cc_XD0_XDFFM_CKBB_XD1_XN2_mid1 r0 *1 0,0
Ccc_XD0_XDFFM_CKBB_XD1_XN2_mid1 XD0_XDFFM_CKBB XD1_XN2_mid1 1.21e-17
* device instance cc_XD0_XDFFM_CKBB_XD1_XN3_mid1 r0 *1 0,0
Ccc_XD0_XDFFM_CKBB_XD1_XN3_mid1 XD0_XDFFM_CKBB XD1_XN3_mid1 1.21e-17
* device instance cc_XD0_XDFFM_CKBB_XD1_XN3_mid2 r0 *1 0,0
Ccc_XD0_XDFFM_CKBB_XD1_XN3_mid2 XD0_XDFFM_CKBB XD1_XN3_mid2 1.21e-17
* device instance cc_XD0_XDFFM_CKBB_XD1_dmodout r0 *1 0,0
Ccc_XD0_XDFFM_CKBB_XD1_dmodout XD0_XDFFM_CKBB XD1_dmodout 1.21e-17
* device instance cc_XD0_XDFFM_CKBB_XD1_dq r0 *1 0,0
Ccc_XD0_XDFFM_CKBB_XD1_dq XD0_XDFFM_CKBB XD1_dq 1.8151e-17
* device instance cc_XD0_XDFFM_CKBB_XD1_nm r0 *1 0,0
Ccc_XD0_XDFFM_CKBB_XD1_nm XD0_XDFFM_CKBB XD1_nm 1.21e-17
* device instance cc_XD0_XDFFM_CKBB_XD1_nt r0 *1 0,0
Ccc_XD0_XDFFM_CKBB_XD1_nt XD0_XDFFM_CKBB XD1_nt 1.21e-17
* device instance cc_XD0_XDFFM_CKBB_XD1_t1 r0 *1 0,0
Ccc_XD0_XDFFM_CKBB_XD1_t1 XD0_XDFFM_CKBB XD1_t1 1.21e-17
* device instance cc_XD0_XDFFM_CKBB_XD2_XDFFM_CKBB r0 *1 0,0
Ccc_XD0_XDFFM_CKBB_XD2_XDFFM_CKBB XD0_XDFFM_CKBB XD2_XDFFM_CKBB 1.8151e-17
* device instance cc_XD0_XDFFM_CKBB_XD2_XDFFM_CLKB r0 *1 0,0
Ccc_XD0_XDFFM_CKBB_XD2_XDFFM_CLKB XD0_XDFFM_CKBB XD2_XDFFM_CLKB 2.4201e-17
* device instance cc_XD0_XDFFM_CKBB_XD2_XDFFM_M r0 *1 0,0
Ccc_XD0_XDFFM_CKBB_XD2_XDFFM_M XD0_XDFFM_CKBB XD2_XDFFM_M 2.4201e-17
* device instance cc_XD0_XDFFM_CKBB_XD2_XDFFM_MB r0 *1 0,0
Ccc_XD0_XDFFM_CKBB_XD2_XDFFM_MB XD0_XDFFM_CKBB XD2_XDFFM_MB 1.21e-17
* device instance cc_XD0_XDFFM_CKBB_XD2_XDFFM_MFB r0 *1 0,0
Ccc_XD0_XDFFM_CKBB_XD2_XDFFM_MFB XD0_XDFFM_CKBB XD2_XDFFM_MFB 1.21e-17
* device instance cc_XD0_XDFFM_CKBB_XD2_XDFFM_S r0 *1 0,0
Ccc_XD0_XDFFM_CKBB_XD2_XDFFM_S XD0_XDFFM_CKBB XD2_XDFFM_S 1.8151e-17
* device instance cc_XD0_XDFFM_CKBB_XD2_XDFFM_SB r0 *1 0,0
Ccc_XD0_XDFFM_CKBB_XD2_XDFFM_SB XD0_XDFFM_CKBB XD2_XDFFM_SB 1.8151e-17
* device instance cc_XD0_XDFFM_CKBB_XD2_XDFFM_SFB r0 *1 0,0
Ccc_XD0_XDFFM_CKBB_XD2_XDFFM_SFB XD0_XDFFM_CKBB XD2_XDFFM_SFB 1.21e-17
* device instance cc_XD0_XDFFM_CKBB_XD2_XDFFQ_CKBB r0 *1 0,0
Ccc_XD0_XDFFM_CKBB_XD2_XDFFQ_CKBB XD0_XDFFM_CKBB XD2_XDFFQ_CKBB 1.8151e-17
* device instance cc_XD0_XDFFM_CKBB_XD2_XDFFQ_CLKB r0 *1 0,0
Ccc_XD0_XDFFM_CKBB_XD2_XDFFQ_CLKB XD0_XDFFM_CKBB XD2_XDFFQ_CLKB 2.4201e-17
* device instance cc_XD0_XDFFM_CKBB_XD2_XDFFQ_M r0 *1 0,0
Ccc_XD0_XDFFM_CKBB_XD2_XDFFQ_M XD0_XDFFM_CKBB XD2_XDFFQ_M 2.4201e-17
* device instance cc_XD0_XDFFM_CKBB_XD2_XDFFQ_MB r0 *1 0,0
Ccc_XD0_XDFFM_CKBB_XD2_XDFFQ_MB XD0_XDFFM_CKBB XD2_XDFFQ_MB 1.21e-17
* device instance cc_XD0_XDFFM_CKBB_XD2_XDFFQ_MFB r0 *1 0,0
Ccc_XD0_XDFFM_CKBB_XD2_XDFFQ_MFB XD0_XDFFM_CKBB XD2_XDFFQ_MFB 1.21e-17
* device instance cc_XD0_XDFFM_CKBB_XD2_XDFFQ_S r0 *1 0,0
Ccc_XD0_XDFFM_CKBB_XD2_XDFFQ_S XD0_XDFFM_CKBB XD2_XDFFQ_S 1.8151e-17
* device instance cc_XD0_XDFFM_CKBB_XD2_XDFFQ_SB r0 *1 0,0
Ccc_XD0_XDFFM_CKBB_XD2_XDFFQ_SB XD0_XDFFM_CKBB XD2_XDFFQ_SB 1.8151e-17
* device instance cc_XD0_XDFFM_CKBB_XD2_XDFFQ_SFB r0 *1 0,0
Ccc_XD0_XDFFM_CKBB_XD2_XDFFQ_SFB XD0_XDFFM_CKBB XD2_XDFFQ_SFB 1.21e-17
* device instance cc_XD0_XDFFM_CKBB_XD2_XN2_mid1 r0 *1 0,0
Ccc_XD0_XDFFM_CKBB_XD2_XN2_mid1 XD0_XDFFM_CKBB XD2_XN2_mid1 1.21e-17
* device instance cc_XD0_XDFFM_CKBB_XD2_XN3_mid1 r0 *1 0,0
Ccc_XD0_XDFFM_CKBB_XD2_XN3_mid1 XD0_XDFFM_CKBB XD2_XN3_mid1 1.21e-17
* device instance cc_XD0_XDFFM_CKBB_XD2_XN3_mid2 r0 *1 0,0
Ccc_XD0_XDFFM_CKBB_XD2_XN3_mid2 XD0_XDFFM_CKBB XD2_XN3_mid2 1.21e-17
* device instance cc_XD0_XDFFM_CKBB_XD2_dmodout r0 *1 0,0
Ccc_XD0_XDFFM_CKBB_XD2_dmodout XD0_XDFFM_CKBB XD2_dmodout 1.21e-17
* device instance cc_XD0_XDFFM_CKBB_XD2_dq r0 *1 0,0
Ccc_XD0_XDFFM_CKBB_XD2_dq XD0_XDFFM_CKBB XD2_dq 1.8151e-17
* device instance cc_XD0_XDFFM_CKBB_XD2_nm r0 *1 0,0
Ccc_XD0_XDFFM_CKBB_XD2_nm XD0_XDFFM_CKBB XD2_nm 1.21e-17
* device instance cc_XD0_XDFFM_CKBB_XD2_nt r0 *1 0,0
Ccc_XD0_XDFFM_CKBB_XD2_nt XD0_XDFFM_CKBB XD2_nt 1.21e-17
* device instance cc_XD0_XDFFM_CKBB_XD2_t1 r0 *1 0,0
Ccc_XD0_XDFFM_CKBB_XD2_t1 XD0_XDFFM_CKBB XD2_t1 1.21e-17
* device instance cc_XD0_XDFFM_CKBB_XD3_XDFFM_CKBB r0 *1 0,0
Ccc_XD0_XDFFM_CKBB_XD3_XDFFM_CKBB XD0_XDFFM_CKBB XD3_XDFFM_CKBB 1.8151e-17
* device instance cc_XD0_XDFFM_CKBB_XD3_XDFFM_CLKB r0 *1 0,0
Ccc_XD0_XDFFM_CKBB_XD3_XDFFM_CLKB XD0_XDFFM_CKBB XD3_XDFFM_CLKB 2.4201e-17
* device instance cc_XD0_XDFFM_CKBB_XD3_XDFFM_M r0 *1 0,0
Ccc_XD0_XDFFM_CKBB_XD3_XDFFM_M XD0_XDFFM_CKBB XD3_XDFFM_M 2.4201e-17
* device instance cc_XD0_XDFFM_CKBB_XD3_XDFFM_MB r0 *1 0,0
Ccc_XD0_XDFFM_CKBB_XD3_XDFFM_MB XD0_XDFFM_CKBB XD3_XDFFM_MB 1.21e-17
* device instance cc_XD0_XDFFM_CKBB_XD3_XDFFM_MFB r0 *1 0,0
Ccc_XD0_XDFFM_CKBB_XD3_XDFFM_MFB XD0_XDFFM_CKBB XD3_XDFFM_MFB 1.21e-17
* device instance cc_XD0_XDFFM_CKBB_XD3_XDFFM_S r0 *1 0,0
Ccc_XD0_XDFFM_CKBB_XD3_XDFFM_S XD0_XDFFM_CKBB XD3_XDFFM_S 1.8151e-17
* device instance cc_XD0_XDFFM_CKBB_XD3_XDFFM_SB r0 *1 0,0
Ccc_XD0_XDFFM_CKBB_XD3_XDFFM_SB XD0_XDFFM_CKBB XD3_XDFFM_SB 1.8151e-17
* device instance cc_XD0_XDFFM_CKBB_XD3_XDFFM_SFB r0 *1 0,0
Ccc_XD0_XDFFM_CKBB_XD3_XDFFM_SFB XD0_XDFFM_CKBB XD3_XDFFM_SFB 1.21e-17
* device instance cc_XD0_XDFFM_CKBB_XD3_XDFFQ_CKBB r0 *1 0,0
Ccc_XD0_XDFFM_CKBB_XD3_XDFFQ_CKBB XD0_XDFFM_CKBB XD3_XDFFQ_CKBB 1.8151e-17
* device instance cc_XD0_XDFFM_CKBB_XD3_XDFFQ_CLKB r0 *1 0,0
Ccc_XD0_XDFFM_CKBB_XD3_XDFFQ_CLKB XD0_XDFFM_CKBB XD3_XDFFQ_CLKB 2.4201e-17
* device instance cc_XD0_XDFFM_CKBB_XD3_XDFFQ_M r0 *1 0,0
Ccc_XD0_XDFFM_CKBB_XD3_XDFFQ_M XD0_XDFFM_CKBB XD3_XDFFQ_M 2.4201e-17
* device instance cc_XD0_XDFFM_CKBB_XD3_XDFFQ_MB r0 *1 0,0
Ccc_XD0_XDFFM_CKBB_XD3_XDFFQ_MB XD0_XDFFM_CKBB XD3_XDFFQ_MB 1.21e-17
* device instance cc_XD0_XDFFM_CKBB_XD3_XDFFQ_MFB r0 *1 0,0
Ccc_XD0_XDFFM_CKBB_XD3_XDFFQ_MFB XD0_XDFFM_CKBB XD3_XDFFQ_MFB 1.21e-17
* device instance cc_XD0_XDFFM_CKBB_XD3_XDFFQ_S r0 *1 0,0
Ccc_XD0_XDFFM_CKBB_XD3_XDFFQ_S XD0_XDFFM_CKBB XD3_XDFFQ_S 1.8151e-17
* device instance cc_XD0_XDFFM_CKBB_XD3_XDFFQ_SB r0 *1 0,0
Ccc_XD0_XDFFM_CKBB_XD3_XDFFQ_SB XD0_XDFFM_CKBB XD3_XDFFQ_SB 1.8151e-17
* device instance cc_XD0_XDFFM_CKBB_XD3_XDFFQ_SFB r0 *1 0,0
Ccc_XD0_XDFFM_CKBB_XD3_XDFFQ_SFB XD0_XDFFM_CKBB XD3_XDFFQ_SFB 1.21e-17
* device instance cc_XD0_XDFFM_CKBB_XD3_XN2_mid1 r0 *1 0,0
Ccc_XD0_XDFFM_CKBB_XD3_XN2_mid1 XD0_XDFFM_CKBB XD3_XN2_mid1 1.21e-17
* device instance cc_XD0_XDFFM_CKBB_XD3_XN3_mid1 r0 *1 0,0
Ccc_XD0_XDFFM_CKBB_XD3_XN3_mid1 XD0_XDFFM_CKBB XD3_XN3_mid1 1.21e-17
* device instance cc_XD0_XDFFM_CKBB_XD3_XN3_mid2 r0 *1 0,0
Ccc_XD0_XDFFM_CKBB_XD3_XN3_mid2 XD0_XDFFM_CKBB XD3_XN3_mid2 1.21e-17
* device instance cc_XD0_XDFFM_CKBB_XD3_dmodout r0 *1 0,0
Ccc_XD0_XDFFM_CKBB_XD3_dmodout XD0_XDFFM_CKBB XD3_dmodout 1.21e-17
* device instance cc_XD0_XDFFM_CKBB_XD3_dq r0 *1 0,0
Ccc_XD0_XDFFM_CKBB_XD3_dq XD0_XDFFM_CKBB XD3_dq 1.8151e-17
* device instance cc_XD0_XDFFM_CKBB_XD3_nm r0 *1 0,0
Ccc_XD0_XDFFM_CKBB_XD3_nm XD0_XDFFM_CKBB XD3_nm 1.21e-17
* device instance cc_XD0_XDFFM_CKBB_XD3_nt r0 *1 0,0
Ccc_XD0_XDFFM_CKBB_XD3_nt XD0_XDFFM_CKBB XD3_nt 1.21e-17
* device instance cc_XD0_XDFFM_CKBB_XD3_t1 r0 *1 0,0
Ccc_XD0_XDFFM_CKBB_XD3_t1 XD0_XDFFM_CKBB XD3_t1 1.21e-17
* device instance cc_XD0_XDFFM_CKBB_XD4_XDFFM_CKBB r0 *1 0,0
Ccc_XD0_XDFFM_CKBB_XD4_XDFFM_CKBB XD0_XDFFM_CKBB XD4_XDFFM_CKBB 1.8151e-17
* device instance cc_XD0_XDFFM_CKBB_XD4_XDFFM_CLKB r0 *1 0,0
Ccc_XD0_XDFFM_CKBB_XD4_XDFFM_CLKB XD0_XDFFM_CKBB XD4_XDFFM_CLKB 2.4201e-17
* device instance cc_XD0_XDFFM_CKBB_XD4_XDFFM_M r0 *1 0,0
Ccc_XD0_XDFFM_CKBB_XD4_XDFFM_M XD0_XDFFM_CKBB XD4_XDFFM_M 2.4201e-17
* device instance cc_XD0_XDFFM_CKBB_XD4_XDFFM_MB r0 *1 0,0
Ccc_XD0_XDFFM_CKBB_XD4_XDFFM_MB XD0_XDFFM_CKBB XD4_XDFFM_MB 1.21e-17
* device instance cc_XD0_XDFFM_CKBB_XD4_XDFFM_MFB r0 *1 0,0
Ccc_XD0_XDFFM_CKBB_XD4_XDFFM_MFB XD0_XDFFM_CKBB XD4_XDFFM_MFB 1.21e-17
* device instance cc_XD0_XDFFM_CKBB_XD4_XDFFM_S r0 *1 0,0
Ccc_XD0_XDFFM_CKBB_XD4_XDFFM_S XD0_XDFFM_CKBB XD4_XDFFM_S 1.8151e-17
* device instance cc_XD0_XDFFM_CKBB_XD4_XDFFM_SB r0 *1 0,0
Ccc_XD0_XDFFM_CKBB_XD4_XDFFM_SB XD0_XDFFM_CKBB XD4_XDFFM_SB 1.8151e-17
* device instance cc_XD0_XDFFM_CKBB_XD4_XDFFM_SFB r0 *1 0,0
Ccc_XD0_XDFFM_CKBB_XD4_XDFFM_SFB XD0_XDFFM_CKBB XD4_XDFFM_SFB 1.21e-17
* device instance cc_XD0_XDFFM_CKBB_XD4_XDFFQ_CKBB r0 *1 0,0
Ccc_XD0_XDFFM_CKBB_XD4_XDFFQ_CKBB XD0_XDFFM_CKBB XD4_XDFFQ_CKBB 1.8151e-17
* device instance cc_XD0_XDFFM_CKBB_XD4_XDFFQ_CLKB r0 *1 0,0
Ccc_XD0_XDFFM_CKBB_XD4_XDFFQ_CLKB XD0_XDFFM_CKBB XD4_XDFFQ_CLKB 2.4201e-17
* device instance cc_XD0_XDFFM_CKBB_XD4_XDFFQ_M r0 *1 0,0
Ccc_XD0_XDFFM_CKBB_XD4_XDFFQ_M XD0_XDFFM_CKBB XD4_XDFFQ_M 2.4201e-17
* device instance cc_XD0_XDFFM_CKBB_XD4_XDFFQ_MB r0 *1 0,0
Ccc_XD0_XDFFM_CKBB_XD4_XDFFQ_MB XD0_XDFFM_CKBB XD4_XDFFQ_MB 1.21e-17
* device instance cc_XD0_XDFFM_CKBB_XD4_XDFFQ_MFB r0 *1 0,0
Ccc_XD0_XDFFM_CKBB_XD4_XDFFQ_MFB XD0_XDFFM_CKBB XD4_XDFFQ_MFB 1.21e-17
* device instance cc_XD0_XDFFM_CKBB_XD4_XDFFQ_S r0 *1 0,0
Ccc_XD0_XDFFM_CKBB_XD4_XDFFQ_S XD0_XDFFM_CKBB XD4_XDFFQ_S 1.8151e-17
* device instance cc_XD0_XDFFM_CKBB_XD4_XDFFQ_SB r0 *1 0,0
Ccc_XD0_XDFFM_CKBB_XD4_XDFFQ_SB XD0_XDFFM_CKBB XD4_XDFFQ_SB 1.8151e-17
* device instance cc_XD0_XDFFM_CKBB_XD4_XDFFQ_SFB r0 *1 0,0
Ccc_XD0_XDFFM_CKBB_XD4_XDFFQ_SFB XD0_XDFFM_CKBB XD4_XDFFQ_SFB 1.21e-17
* device instance cc_XD0_XDFFM_CKBB_XD4_XN2_mid1 r0 *1 0,0
Ccc_XD0_XDFFM_CKBB_XD4_XN2_mid1 XD0_XDFFM_CKBB XD4_XN2_mid1 1.21e-17
* device instance cc_XD0_XDFFM_CKBB_XD4_XN3_mid1 r0 *1 0,0
Ccc_XD0_XDFFM_CKBB_XD4_XN3_mid1 XD0_XDFFM_CKBB XD4_XN3_mid1 1.21e-17
* device instance cc_XD0_XDFFM_CKBB_XD4_XN3_mid2 r0 *1 0,0
Ccc_XD0_XDFFM_CKBB_XD4_XN3_mid2 XD0_XDFFM_CKBB XD4_XN3_mid2 1.21e-17
* device instance cc_XD0_XDFFM_CKBB_XD4_dmodout r0 *1 0,0
Ccc_XD0_XDFFM_CKBB_XD4_dmodout XD0_XDFFM_CKBB XD4_dmodout 1.21e-17
* device instance cc_XD0_XDFFM_CKBB_XD4_dq r0 *1 0,0
Ccc_XD0_XDFFM_CKBB_XD4_dq XD0_XDFFM_CKBB XD4_dq 1.8151e-17
* device instance cc_XD0_XDFFM_CKBB_XD4_nm r0 *1 0,0
Ccc_XD0_XDFFM_CKBB_XD4_nm XD0_XDFFM_CKBB XD4_nm 1.21e-17
* device instance cc_XD0_XDFFM_CKBB_XD4_nt r0 *1 0,0
Ccc_XD0_XDFFM_CKBB_XD4_nt XD0_XDFFM_CKBB XD4_nt 1.21e-17
* device instance cc_XD0_XDFFM_CKBB_XD4_t1 r0 *1 0,0
Ccc_XD0_XDFFM_CKBB_XD4_t1 XD0_XDFFM_CKBB XD4_t1 1.21e-17
* device instance cc_XD0_XDFFM_CKBB_XD5_XDFFM_CKBB r0 *1 0,0
Ccc_XD0_XDFFM_CKBB_XD5_XDFFM_CKBB XD0_XDFFM_CKBB XD5_XDFFM_CKBB 1.8151e-17
* device instance cc_XD0_XDFFM_CKBB_XD5_XDFFM_CLKB r0 *1 0,0
Ccc_XD0_XDFFM_CKBB_XD5_XDFFM_CLKB XD0_XDFFM_CKBB XD5_XDFFM_CLKB 2.4201e-17
* device instance cc_XD0_XDFFM_CKBB_XD5_XDFFM_M r0 *1 0,0
Ccc_XD0_XDFFM_CKBB_XD5_XDFFM_M XD0_XDFFM_CKBB XD5_XDFFM_M 2.4201e-17
* device instance cc_XD0_XDFFM_CKBB_XD5_XDFFM_MB r0 *1 0,0
Ccc_XD0_XDFFM_CKBB_XD5_XDFFM_MB XD0_XDFFM_CKBB XD5_XDFFM_MB 1.21e-17
* device instance cc_XD0_XDFFM_CKBB_XD5_XDFFM_MFB r0 *1 0,0
Ccc_XD0_XDFFM_CKBB_XD5_XDFFM_MFB XD0_XDFFM_CKBB XD5_XDFFM_MFB 1.21e-17
* device instance cc_XD0_XDFFM_CKBB_XD5_XDFFM_S r0 *1 0,0
Ccc_XD0_XDFFM_CKBB_XD5_XDFFM_S XD0_XDFFM_CKBB XD5_XDFFM_S 1.8151e-17
* device instance cc_XD0_XDFFM_CKBB_XD5_XDFFM_SB r0 *1 0,0
Ccc_XD0_XDFFM_CKBB_XD5_XDFFM_SB XD0_XDFFM_CKBB XD5_XDFFM_SB 1.8151e-17
* device instance cc_XD0_XDFFM_CKBB_XD5_XDFFM_SFB r0 *1 0,0
Ccc_XD0_XDFFM_CKBB_XD5_XDFFM_SFB XD0_XDFFM_CKBB XD5_XDFFM_SFB 1.21e-17
* device instance cc_XD0_XDFFM_CKBB_XD5_XDFFQ_CKBB r0 *1 0,0
Ccc_XD0_XDFFM_CKBB_XD5_XDFFQ_CKBB XD0_XDFFM_CKBB XD5_XDFFQ_CKBB 1.8151e-17
* device instance cc_XD0_XDFFM_CKBB_XD5_XDFFQ_CLKB r0 *1 0,0
Ccc_XD0_XDFFM_CKBB_XD5_XDFFQ_CLKB XD0_XDFFM_CKBB XD5_XDFFQ_CLKB 2.4201e-17
* device instance cc_XD0_XDFFM_CKBB_XD5_XDFFQ_M r0 *1 0,0
Ccc_XD0_XDFFM_CKBB_XD5_XDFFQ_M XD0_XDFFM_CKBB XD5_XDFFQ_M 2.4201e-17
* device instance cc_XD0_XDFFM_CKBB_XD5_XDFFQ_MB r0 *1 0,0
Ccc_XD0_XDFFM_CKBB_XD5_XDFFQ_MB XD0_XDFFM_CKBB XD5_XDFFQ_MB 1.21e-17
* device instance cc_XD0_XDFFM_CKBB_XD5_XDFFQ_MFB r0 *1 0,0
Ccc_XD0_XDFFM_CKBB_XD5_XDFFQ_MFB XD0_XDFFM_CKBB XD5_XDFFQ_MFB 1.21e-17
* device instance cc_XD0_XDFFM_CKBB_XD5_XDFFQ_S r0 *1 0,0
Ccc_XD0_XDFFM_CKBB_XD5_XDFFQ_S XD0_XDFFM_CKBB XD5_XDFFQ_S 1.8151e-17
* device instance cc_XD0_XDFFM_CKBB_XD5_XDFFQ_SB r0 *1 0,0
Ccc_XD0_XDFFM_CKBB_XD5_XDFFQ_SB XD0_XDFFM_CKBB XD5_XDFFQ_SB 1.8151e-17
* device instance cc_XD0_XDFFM_CKBB_XD5_XDFFQ_SFB r0 *1 0,0
Ccc_XD0_XDFFM_CKBB_XD5_XDFFQ_SFB XD0_XDFFM_CKBB XD5_XDFFQ_SFB 1.21e-17
* device instance cc_XD0_XDFFM_CKBB_XD5_XN2_mid1 r0 *1 0,0
Ccc_XD0_XDFFM_CKBB_XD5_XN2_mid1 XD0_XDFFM_CKBB XD5_XN2_mid1 1.21e-17
* device instance cc_XD0_XDFFM_CKBB_XD5_XN3_mid1 r0 *1 0,0
Ccc_XD0_XDFFM_CKBB_XD5_XN3_mid1 XD0_XDFFM_CKBB XD5_XN3_mid1 1.21e-17
* device instance cc_XD0_XDFFM_CKBB_XD5_XN3_mid2 r0 *1 0,0
Ccc_XD0_XDFFM_CKBB_XD5_XN3_mid2 XD0_XDFFM_CKBB XD5_XN3_mid2 1.21e-17
* device instance cc_XD0_XDFFM_CKBB_XD5_dmodout r0 *1 0,0
Ccc_XD0_XDFFM_CKBB_XD5_dmodout XD0_XDFFM_CKBB XD5_dmodout 1.21e-17
* device instance cc_XD0_XDFFM_CKBB_XD5_dq r0 *1 0,0
Ccc_XD0_XDFFM_CKBB_XD5_dq XD0_XDFFM_CKBB XD5_dq 1.8151e-17
* device instance cc_XD0_XDFFM_CKBB_XD5_nm r0 *1 0,0
Ccc_XD0_XDFFM_CKBB_XD5_nm XD0_XDFFM_CKBB XD5_nm 1.21e-17
* device instance cc_XD0_XDFFM_CKBB_XD5_nt r0 *1 0,0
Ccc_XD0_XDFFM_CKBB_XD5_nt XD0_XDFFM_CKBB XD5_nt 1.21e-17
* device instance cc_XD0_XDFFM_CKBB_XD5_t1 r0 *1 0,0
Ccc_XD0_XDFFM_CKBB_XD5_t1 XD0_XDFFM_CKBB XD5_t1 1.21e-17
* device instance cc_XD0_XDFFM_CKBB_XFRT_CKBB r0 *1 0,0
Ccc_XD0_XDFFM_CKBB_XFRT_CKBB XD0_XDFFM_CKBB XFRT_CKBB 1.8151e-17
* device instance cc_XD0_XDFFM_CKBB_XFRT_CLKB r0 *1 0,0
Ccc_XD0_XDFFM_CKBB_XFRT_CLKB XD0_XDFFM_CKBB XFRT_CLKB 2.4201e-17
* device instance cc_XD0_XDFFM_CKBB_XFRT_M r0 *1 0,0
Ccc_XD0_XDFFM_CKBB_XFRT_M XD0_XDFFM_CKBB XFRT_M 2.4201e-17
* device instance cc_XD0_XDFFM_CKBB_XFRT_MB r0 *1 0,0
Ccc_XD0_XDFFM_CKBB_XFRT_MB XD0_XDFFM_CKBB XFRT_MB 1.21e-17
* device instance cc_XD0_XDFFM_CKBB_XFRT_MFB r0 *1 0,0
Ccc_XD0_XDFFM_CKBB_XFRT_MFB XD0_XDFFM_CKBB XFRT_MFB 1.21e-17
* device instance cc_XD0_XDFFM_CKBB_XFRT_S r0 *1 0,0
Ccc_XD0_XDFFM_CKBB_XFRT_S XD0_XDFFM_CKBB XFRT_S 1.8151e-17
* device instance cc_XD0_XDFFM_CKBB_XFRT_SB r0 *1 0,0
Ccc_XD0_XDFFM_CKBB_XFRT_SB XD0_XDFFM_CKBB XFRT_SB 1.8151e-17
* device instance cc_XD0_XDFFM_CKBB_XFRT_SFB r0 *1 0,0
Ccc_XD0_XDFFM_CKBB_XFRT_SFB XD0_XDFFM_CKBB XFRT_SFB 1.21e-17
* device instance cc_XD0_XDFFM_CKBB_ck1 r0 *1 0,0
Ccc_XD0_XDFFM_CKBB_ck1 XD0_XDFFM_CKBB ck1 3.0251e-17
* device instance cc_XD0_XDFFM_CKBB_ck2 r0 *1 0,0
Ccc_XD0_XDFFM_CKBB_ck2 XD0_XDFFM_CKBB ck2 3.0251e-17
* device instance cc_XD0_XDFFM_CKBB_ck3 r0 *1 0,0
Ccc_XD0_XDFFM_CKBB_ck3 XD0_XDFFM_CKBB ck3 3.0251e-17
* device instance cc_XD0_XDFFM_CKBB_ck4 r0 *1 0,0
Ccc_XD0_XDFFM_CKBB_ck4 XD0_XDFFM_CKBB ck4 3.0251e-17
* device instance cc_XD0_XDFFM_CKBB_ck5 r0 *1 0,0
Ccc_XD0_XDFFM_CKBB_ck5 XD0_XDFFM_CKBB ck5 3.0251e-17
* device instance cc_XD0_XDFFM_CKBB_mod0 r0 *1 0,0
Ccc_XD0_XDFFM_CKBB_mod0 XD0_XDFFM_CKBB mod0 2.4201e-17
* device instance cc_XD0_XDFFM_CKBB_mod1 r0 *1 0,0
Ccc_XD0_XDFFM_CKBB_mod1 XD0_XDFFM_CKBB mod1 2.4201e-17
* device instance cc_XD0_XDFFM_CKBB_mod2 r0 *1 0,0
Ccc_XD0_XDFFM_CKBB_mod2 XD0_XDFFM_CKBB mod2 2.4201e-17
* device instance cc_XD0_XDFFM_CKBB_mod3 r0 *1 0,0
Ccc_XD0_XDFFM_CKBB_mod3 XD0_XDFFM_CKBB mod3 2.4201e-17
* device instance cc_XD0_XDFFM_CKBB_mod4 r0 *1 0,0
Ccc_XD0_XDFFM_CKBB_mod4 XD0_XDFFM_CKBB mod4 2.4201e-17
* device instance cc_XD0_XDFFM_CKBB_net1 r0 *1 0,0
Ccc_XD0_XDFFM_CKBB_net1 XD0_XDFFM_CKBB net1 1.21e-17
* device instance cc_XD0_XDFFM_CLKB_XD0_XDFFM_M r0 *1 0,0
Ccc_XD0_XDFFM_CLKB_XD0_XDFFM_M XD0_XDFFM_CLKB XD0_XDFFM_M 4.2352e-17
* device instance cc_XD0_XDFFM_CLKB_XD0_XDFFM_MB r0 *1 0,0
Ccc_XD0_XDFFM_CLKB_XD0_XDFFM_MB XD0_XDFFM_CLKB XD0_XDFFM_MB 2.4201e-17
* device instance cc_XD0_XDFFM_CLKB_XD0_XDFFM_MFB r0 *1 0,0
Ccc_XD0_XDFFM_CLKB_XD0_XDFFM_MFB XD0_XDFFM_CLKB XD0_XDFFM_MFB 2.4201e-17
* device instance cc_XD0_XDFFM_CLKB_XD0_XDFFM_S r0 *1 0,0
Ccc_XD0_XDFFM_CLKB_XD0_XDFFM_S XD0_XDFFM_CLKB XD0_XDFFM_S 1.8151e-17
* device instance cc_XD0_XDFFM_CLKB_XD0_XDFFM_SB r0 *1 0,0
Ccc_XD0_XDFFM_CLKB_XD0_XDFFM_SB XD0_XDFFM_CLKB XD0_XDFFM_SB 1.8151e-17
* device instance cc_XD0_XDFFM_CLKB_XD0_XDFFM_SFB r0 *1 0,0
Ccc_XD0_XDFFM_CLKB_XD0_XDFFM_SFB XD0_XDFFM_CLKB XD0_XDFFM_SFB 1.21e-17
* device instance cc_XD0_XDFFM_CLKB_XD0_XDFFQ_CKBB r0 *1 0,0
Ccc_XD0_XDFFM_CLKB_XD0_XDFFQ_CKBB XD0_XDFFM_CLKB XD0_XDFFQ_CKBB 1.8151e-17
* device instance cc_XD0_XDFFM_CLKB_XD0_XDFFQ_CLKB r0 *1 0,0
Ccc_XD0_XDFFM_CLKB_XD0_XDFFQ_CLKB XD0_XDFFM_CLKB XD0_XDFFQ_CLKB 2.4201e-17
* device instance cc_XD0_XDFFM_CLKB_XD0_XDFFQ_M r0 *1 0,0
Ccc_XD0_XDFFM_CLKB_XD0_XDFFQ_M XD0_XDFFM_CLKB XD0_XDFFQ_M 2.4201e-17
* device instance cc_XD0_XDFFM_CLKB_XD0_XDFFQ_MB r0 *1 0,0
Ccc_XD0_XDFFM_CLKB_XD0_XDFFQ_MB XD0_XDFFM_CLKB XD0_XDFFQ_MB 1.21e-17
* device instance cc_XD0_XDFFM_CLKB_XD0_XDFFQ_MFB r0 *1 0,0
Ccc_XD0_XDFFM_CLKB_XD0_XDFFQ_MFB XD0_XDFFM_CLKB XD0_XDFFQ_MFB 1.21e-17
* device instance cc_XD0_XDFFM_CLKB_XD0_XDFFQ_S r0 *1 0,0
Ccc_XD0_XDFFM_CLKB_XD0_XDFFQ_S XD0_XDFFM_CLKB XD0_XDFFQ_S 1.8151e-17
* device instance cc_XD0_XDFFM_CLKB_XD0_XDFFQ_SB r0 *1 0,0
Ccc_XD0_XDFFM_CLKB_XD0_XDFFQ_SB XD0_XDFFM_CLKB XD0_XDFFQ_SB 1.8151e-17
* device instance cc_XD0_XDFFM_CLKB_XD0_XDFFQ_SFB r0 *1 0,0
Ccc_XD0_XDFFM_CLKB_XD0_XDFFQ_SFB XD0_XDFFM_CLKB XD0_XDFFQ_SFB 1.21e-17
* device instance cc_XD0_XDFFM_CLKB_XD0_XNOR_midp r0 *1 0,0
Ccc_XD0_XDFFM_CLKB_XD0_XNOR_midp XD0_XDFFM_CLKB XD0_XNOR_midp 1.21e-17
* device instance cc_XD0_XDFFM_CLKB_XD0_dmodout r0 *1 0,0
Ccc_XD0_XDFFM_CLKB_XD0_dmodout XD0_XDFFM_CLKB XD0_dmodout 1.8151e-17
* device instance cc_XD0_XDFFM_CLKB_XD0_dq r0 *1 0,0
Ccc_XD0_XDFFM_CLKB_XD0_dq XD0_XDFFM_CLKB XD0_dq 1.21e-17
* device instance cc_XD0_XDFFM_CLKB_XD0_nm r0 *1 0,0
Ccc_XD0_XDFFM_CLKB_XD0_nm XD0_XDFFM_CLKB XD0_nm 1.8151e-17
* device instance cc_XD0_XDFFM_CLKB_XD0_nt r0 *1 0,0
Ccc_XD0_XDFFM_CLKB_XD0_nt XD0_XDFFM_CLKB XD0_nt 2.4201e-17
* device instance cc_XD0_XDFFM_CLKB_XD0_t1 r0 *1 0,0
Ccc_XD0_XDFFM_CLKB_XD0_t1 XD0_XDFFM_CLKB XD0_t1 1.21e-17
* device instance cc_XD0_XDFFM_CLKB_XD1_XDFFM_CKBB r0 *1 0,0
Ccc_XD0_XDFFM_CLKB_XD1_XDFFM_CKBB XD0_XDFFM_CLKB XD1_XDFFM_CKBB 1.8151e-17
* device instance cc_XD0_XDFFM_CLKB_XD1_XDFFM_CLKB r0 *1 0,0
Ccc_XD0_XDFFM_CLKB_XD1_XDFFM_CLKB XD0_XDFFM_CLKB XD1_XDFFM_CLKB 2.4201e-17
* device instance cc_XD0_XDFFM_CLKB_XD1_XDFFM_M r0 *1 0,0
Ccc_XD0_XDFFM_CLKB_XD1_XDFFM_M XD0_XDFFM_CLKB XD1_XDFFM_M 2.4201e-17
* device instance cc_XD0_XDFFM_CLKB_XD1_XDFFM_MB r0 *1 0,0
Ccc_XD0_XDFFM_CLKB_XD1_XDFFM_MB XD0_XDFFM_CLKB XD1_XDFFM_MB 1.21e-17
* device instance cc_XD0_XDFFM_CLKB_XD1_XDFFM_MFB r0 *1 0,0
Ccc_XD0_XDFFM_CLKB_XD1_XDFFM_MFB XD0_XDFFM_CLKB XD1_XDFFM_MFB 1.21e-17
* device instance cc_XD0_XDFFM_CLKB_XD1_XDFFM_S r0 *1 0,0
Ccc_XD0_XDFFM_CLKB_XD1_XDFFM_S XD0_XDFFM_CLKB XD1_XDFFM_S 1.8151e-17
* device instance cc_XD0_XDFFM_CLKB_XD1_XDFFM_SB r0 *1 0,0
Ccc_XD0_XDFFM_CLKB_XD1_XDFFM_SB XD0_XDFFM_CLKB XD1_XDFFM_SB 1.8151e-17
* device instance cc_XD0_XDFFM_CLKB_XD1_XDFFM_SFB r0 *1 0,0
Ccc_XD0_XDFFM_CLKB_XD1_XDFFM_SFB XD0_XDFFM_CLKB XD1_XDFFM_SFB 1.21e-17
* device instance cc_XD0_XDFFM_CLKB_XD1_XDFFQ_CKBB r0 *1 0,0
Ccc_XD0_XDFFM_CLKB_XD1_XDFFQ_CKBB XD0_XDFFM_CLKB XD1_XDFFQ_CKBB 1.8151e-17
* device instance cc_XD0_XDFFM_CLKB_XD1_XDFFQ_CLKB r0 *1 0,0
Ccc_XD0_XDFFM_CLKB_XD1_XDFFQ_CLKB XD0_XDFFM_CLKB XD1_XDFFQ_CLKB 2.4201e-17
* device instance cc_XD0_XDFFM_CLKB_XD1_XDFFQ_M r0 *1 0,0
Ccc_XD0_XDFFM_CLKB_XD1_XDFFQ_M XD0_XDFFM_CLKB XD1_XDFFQ_M 2.4201e-17
* device instance cc_XD0_XDFFM_CLKB_XD1_XDFFQ_MB r0 *1 0,0
Ccc_XD0_XDFFM_CLKB_XD1_XDFFQ_MB XD0_XDFFM_CLKB XD1_XDFFQ_MB 1.21e-17
* device instance cc_XD0_XDFFM_CLKB_XD1_XDFFQ_MFB r0 *1 0,0
Ccc_XD0_XDFFM_CLKB_XD1_XDFFQ_MFB XD0_XDFFM_CLKB XD1_XDFFQ_MFB 1.21e-17
* device instance cc_XD0_XDFFM_CLKB_XD1_XDFFQ_S r0 *1 0,0
Ccc_XD0_XDFFM_CLKB_XD1_XDFFQ_S XD0_XDFFM_CLKB XD1_XDFFQ_S 1.8151e-17
* device instance cc_XD0_XDFFM_CLKB_XD1_XDFFQ_SB r0 *1 0,0
Ccc_XD0_XDFFM_CLKB_XD1_XDFFQ_SB XD0_XDFFM_CLKB XD1_XDFFQ_SB 1.8151e-17
* device instance cc_XD0_XDFFM_CLKB_XD1_XDFFQ_SFB r0 *1 0,0
Ccc_XD0_XDFFM_CLKB_XD1_XDFFQ_SFB XD0_XDFFM_CLKB XD1_XDFFQ_SFB 1.21e-17
* device instance cc_XD0_XDFFM_CLKB_XD1_XN2_mid1 r0 *1 0,0
Ccc_XD0_XDFFM_CLKB_XD1_XN2_mid1 XD0_XDFFM_CLKB XD1_XN2_mid1 1.21e-17
* device instance cc_XD0_XDFFM_CLKB_XD1_XN3_mid1 r0 *1 0,0
Ccc_XD0_XDFFM_CLKB_XD1_XN3_mid1 XD0_XDFFM_CLKB XD1_XN3_mid1 1.21e-17
* device instance cc_XD0_XDFFM_CLKB_XD1_XN3_mid2 r0 *1 0,0
Ccc_XD0_XDFFM_CLKB_XD1_XN3_mid2 XD0_XDFFM_CLKB XD1_XN3_mid2 1.21e-17
* device instance cc_XD0_XDFFM_CLKB_XD1_dmodout r0 *1 0,0
Ccc_XD0_XDFFM_CLKB_XD1_dmodout XD0_XDFFM_CLKB XD1_dmodout 1.21e-17
* device instance cc_XD0_XDFFM_CLKB_XD1_dq r0 *1 0,0
Ccc_XD0_XDFFM_CLKB_XD1_dq XD0_XDFFM_CLKB XD1_dq 1.8151e-17
* device instance cc_XD0_XDFFM_CLKB_XD1_nm r0 *1 0,0
Ccc_XD0_XDFFM_CLKB_XD1_nm XD0_XDFFM_CLKB XD1_nm 1.21e-17
* device instance cc_XD0_XDFFM_CLKB_XD1_nt r0 *1 0,0
Ccc_XD0_XDFFM_CLKB_XD1_nt XD0_XDFFM_CLKB XD1_nt 1.21e-17
* device instance cc_XD0_XDFFM_CLKB_XD1_t1 r0 *1 0,0
Ccc_XD0_XDFFM_CLKB_XD1_t1 XD0_XDFFM_CLKB XD1_t1 1.21e-17
* device instance cc_XD0_XDFFM_CLKB_XD2_XDFFM_CKBB r0 *1 0,0
Ccc_XD0_XDFFM_CLKB_XD2_XDFFM_CKBB XD0_XDFFM_CLKB XD2_XDFFM_CKBB 1.8151e-17
* device instance cc_XD0_XDFFM_CLKB_XD2_XDFFM_CLKB r0 *1 0,0
Ccc_XD0_XDFFM_CLKB_XD2_XDFFM_CLKB XD0_XDFFM_CLKB XD2_XDFFM_CLKB 2.4201e-17
* device instance cc_XD0_XDFFM_CLKB_XD2_XDFFM_M r0 *1 0,0
Ccc_XD0_XDFFM_CLKB_XD2_XDFFM_M XD0_XDFFM_CLKB XD2_XDFFM_M 2.4201e-17
* device instance cc_XD0_XDFFM_CLKB_XD2_XDFFM_MB r0 *1 0,0
Ccc_XD0_XDFFM_CLKB_XD2_XDFFM_MB XD0_XDFFM_CLKB XD2_XDFFM_MB 1.21e-17
* device instance cc_XD0_XDFFM_CLKB_XD2_XDFFM_MFB r0 *1 0,0
Ccc_XD0_XDFFM_CLKB_XD2_XDFFM_MFB XD0_XDFFM_CLKB XD2_XDFFM_MFB 1.21e-17
* device instance cc_XD0_XDFFM_CLKB_XD2_XDFFM_S r0 *1 0,0
Ccc_XD0_XDFFM_CLKB_XD2_XDFFM_S XD0_XDFFM_CLKB XD2_XDFFM_S 1.8151e-17
* device instance cc_XD0_XDFFM_CLKB_XD2_XDFFM_SB r0 *1 0,0
Ccc_XD0_XDFFM_CLKB_XD2_XDFFM_SB XD0_XDFFM_CLKB XD2_XDFFM_SB 1.8151e-17
* device instance cc_XD0_XDFFM_CLKB_XD2_XDFFM_SFB r0 *1 0,0
Ccc_XD0_XDFFM_CLKB_XD2_XDFFM_SFB XD0_XDFFM_CLKB XD2_XDFFM_SFB 1.21e-17
* device instance cc_XD0_XDFFM_CLKB_XD2_XDFFQ_CKBB r0 *1 0,0
Ccc_XD0_XDFFM_CLKB_XD2_XDFFQ_CKBB XD0_XDFFM_CLKB XD2_XDFFQ_CKBB 1.8151e-17
* device instance cc_XD0_XDFFM_CLKB_XD2_XDFFQ_CLKB r0 *1 0,0
Ccc_XD0_XDFFM_CLKB_XD2_XDFFQ_CLKB XD0_XDFFM_CLKB XD2_XDFFQ_CLKB 2.4201e-17
* device instance cc_XD0_XDFFM_CLKB_XD2_XDFFQ_M r0 *1 0,0
Ccc_XD0_XDFFM_CLKB_XD2_XDFFQ_M XD0_XDFFM_CLKB XD2_XDFFQ_M 2.4201e-17
* device instance cc_XD0_XDFFM_CLKB_XD2_XDFFQ_MB r0 *1 0,0
Ccc_XD0_XDFFM_CLKB_XD2_XDFFQ_MB XD0_XDFFM_CLKB XD2_XDFFQ_MB 1.21e-17
* device instance cc_XD0_XDFFM_CLKB_XD2_XDFFQ_MFB r0 *1 0,0
Ccc_XD0_XDFFM_CLKB_XD2_XDFFQ_MFB XD0_XDFFM_CLKB XD2_XDFFQ_MFB 1.21e-17
* device instance cc_XD0_XDFFM_CLKB_XD2_XDFFQ_S r0 *1 0,0
Ccc_XD0_XDFFM_CLKB_XD2_XDFFQ_S XD0_XDFFM_CLKB XD2_XDFFQ_S 1.8151e-17
* device instance cc_XD0_XDFFM_CLKB_XD2_XDFFQ_SB r0 *1 0,0
Ccc_XD0_XDFFM_CLKB_XD2_XDFFQ_SB XD0_XDFFM_CLKB XD2_XDFFQ_SB 1.8151e-17
* device instance cc_XD0_XDFFM_CLKB_XD2_XDFFQ_SFB r0 *1 0,0
Ccc_XD0_XDFFM_CLKB_XD2_XDFFQ_SFB XD0_XDFFM_CLKB XD2_XDFFQ_SFB 1.21e-17
* device instance cc_XD0_XDFFM_CLKB_XD2_XN2_mid1 r0 *1 0,0
Ccc_XD0_XDFFM_CLKB_XD2_XN2_mid1 XD0_XDFFM_CLKB XD2_XN2_mid1 1.21e-17
* device instance cc_XD0_XDFFM_CLKB_XD2_XN3_mid1 r0 *1 0,0
Ccc_XD0_XDFFM_CLKB_XD2_XN3_mid1 XD0_XDFFM_CLKB XD2_XN3_mid1 1.21e-17
* device instance cc_XD0_XDFFM_CLKB_XD2_XN3_mid2 r0 *1 0,0
Ccc_XD0_XDFFM_CLKB_XD2_XN3_mid2 XD0_XDFFM_CLKB XD2_XN3_mid2 1.21e-17
* device instance cc_XD0_XDFFM_CLKB_XD2_dmodout r0 *1 0,0
Ccc_XD0_XDFFM_CLKB_XD2_dmodout XD0_XDFFM_CLKB XD2_dmodout 1.21e-17
* device instance cc_XD0_XDFFM_CLKB_XD2_dq r0 *1 0,0
Ccc_XD0_XDFFM_CLKB_XD2_dq XD0_XDFFM_CLKB XD2_dq 1.8151e-17
* device instance cc_XD0_XDFFM_CLKB_XD2_nm r0 *1 0,0
Ccc_XD0_XDFFM_CLKB_XD2_nm XD0_XDFFM_CLKB XD2_nm 1.21e-17
* device instance cc_XD0_XDFFM_CLKB_XD2_nt r0 *1 0,0
Ccc_XD0_XDFFM_CLKB_XD2_nt XD0_XDFFM_CLKB XD2_nt 1.21e-17
* device instance cc_XD0_XDFFM_CLKB_XD2_t1 r0 *1 0,0
Ccc_XD0_XDFFM_CLKB_XD2_t1 XD0_XDFFM_CLKB XD2_t1 1.21e-17
* device instance cc_XD0_XDFFM_CLKB_XD3_XDFFM_CKBB r0 *1 0,0
Ccc_XD0_XDFFM_CLKB_XD3_XDFFM_CKBB XD0_XDFFM_CLKB XD3_XDFFM_CKBB 1.8151e-17
* device instance cc_XD0_XDFFM_CLKB_XD3_XDFFM_CLKB r0 *1 0,0
Ccc_XD0_XDFFM_CLKB_XD3_XDFFM_CLKB XD0_XDFFM_CLKB XD3_XDFFM_CLKB 2.4201e-17
* device instance cc_XD0_XDFFM_CLKB_XD3_XDFFM_M r0 *1 0,0
Ccc_XD0_XDFFM_CLKB_XD3_XDFFM_M XD0_XDFFM_CLKB XD3_XDFFM_M 2.4201e-17
* device instance cc_XD0_XDFFM_CLKB_XD3_XDFFM_MB r0 *1 0,0
Ccc_XD0_XDFFM_CLKB_XD3_XDFFM_MB XD0_XDFFM_CLKB XD3_XDFFM_MB 1.21e-17
* device instance cc_XD0_XDFFM_CLKB_XD3_XDFFM_MFB r0 *1 0,0
Ccc_XD0_XDFFM_CLKB_XD3_XDFFM_MFB XD0_XDFFM_CLKB XD3_XDFFM_MFB 1.21e-17
* device instance cc_XD0_XDFFM_CLKB_XD3_XDFFM_S r0 *1 0,0
Ccc_XD0_XDFFM_CLKB_XD3_XDFFM_S XD0_XDFFM_CLKB XD3_XDFFM_S 1.8151e-17
* device instance cc_XD0_XDFFM_CLKB_XD3_XDFFM_SB r0 *1 0,0
Ccc_XD0_XDFFM_CLKB_XD3_XDFFM_SB XD0_XDFFM_CLKB XD3_XDFFM_SB 1.8151e-17
* device instance cc_XD0_XDFFM_CLKB_XD3_XDFFM_SFB r0 *1 0,0
Ccc_XD0_XDFFM_CLKB_XD3_XDFFM_SFB XD0_XDFFM_CLKB XD3_XDFFM_SFB 1.21e-17
* device instance cc_XD0_XDFFM_CLKB_XD3_XDFFQ_CKBB r0 *1 0,0
Ccc_XD0_XDFFM_CLKB_XD3_XDFFQ_CKBB XD0_XDFFM_CLKB XD3_XDFFQ_CKBB 1.8151e-17
* device instance cc_XD0_XDFFM_CLKB_XD3_XDFFQ_CLKB r0 *1 0,0
Ccc_XD0_XDFFM_CLKB_XD3_XDFFQ_CLKB XD0_XDFFM_CLKB XD3_XDFFQ_CLKB 2.4201e-17
* device instance cc_XD0_XDFFM_CLKB_XD3_XDFFQ_M r0 *1 0,0
Ccc_XD0_XDFFM_CLKB_XD3_XDFFQ_M XD0_XDFFM_CLKB XD3_XDFFQ_M 2.4201e-17
* device instance cc_XD0_XDFFM_CLKB_XD3_XDFFQ_MB r0 *1 0,0
Ccc_XD0_XDFFM_CLKB_XD3_XDFFQ_MB XD0_XDFFM_CLKB XD3_XDFFQ_MB 1.21e-17
* device instance cc_XD0_XDFFM_CLKB_XD3_XDFFQ_MFB r0 *1 0,0
Ccc_XD0_XDFFM_CLKB_XD3_XDFFQ_MFB XD0_XDFFM_CLKB XD3_XDFFQ_MFB 1.21e-17
* device instance cc_XD0_XDFFM_CLKB_XD3_XDFFQ_S r0 *1 0,0
Ccc_XD0_XDFFM_CLKB_XD3_XDFFQ_S XD0_XDFFM_CLKB XD3_XDFFQ_S 1.8151e-17
* device instance cc_XD0_XDFFM_CLKB_XD3_XDFFQ_SB r0 *1 0,0
Ccc_XD0_XDFFM_CLKB_XD3_XDFFQ_SB XD0_XDFFM_CLKB XD3_XDFFQ_SB 1.8151e-17
* device instance cc_XD0_XDFFM_CLKB_XD3_XDFFQ_SFB r0 *1 0,0
Ccc_XD0_XDFFM_CLKB_XD3_XDFFQ_SFB XD0_XDFFM_CLKB XD3_XDFFQ_SFB 1.21e-17
* device instance cc_XD0_XDFFM_CLKB_XD3_XN2_mid1 r0 *1 0,0
Ccc_XD0_XDFFM_CLKB_XD3_XN2_mid1 XD0_XDFFM_CLKB XD3_XN2_mid1 1.21e-17
* device instance cc_XD0_XDFFM_CLKB_XD3_XN3_mid1 r0 *1 0,0
Ccc_XD0_XDFFM_CLKB_XD3_XN3_mid1 XD0_XDFFM_CLKB XD3_XN3_mid1 1.21e-17
* device instance cc_XD0_XDFFM_CLKB_XD3_XN3_mid2 r0 *1 0,0
Ccc_XD0_XDFFM_CLKB_XD3_XN3_mid2 XD0_XDFFM_CLKB XD3_XN3_mid2 1.21e-17
* device instance cc_XD0_XDFFM_CLKB_XD3_dmodout r0 *1 0,0
Ccc_XD0_XDFFM_CLKB_XD3_dmodout XD0_XDFFM_CLKB XD3_dmodout 1.21e-17
* device instance cc_XD0_XDFFM_CLKB_XD3_dq r0 *1 0,0
Ccc_XD0_XDFFM_CLKB_XD3_dq XD0_XDFFM_CLKB XD3_dq 1.8151e-17
* device instance cc_XD0_XDFFM_CLKB_XD3_nm r0 *1 0,0
Ccc_XD0_XDFFM_CLKB_XD3_nm XD0_XDFFM_CLKB XD3_nm 1.21e-17
* device instance cc_XD0_XDFFM_CLKB_XD3_nt r0 *1 0,0
Ccc_XD0_XDFFM_CLKB_XD3_nt XD0_XDFFM_CLKB XD3_nt 1.21e-17
* device instance cc_XD0_XDFFM_CLKB_XD3_t1 r0 *1 0,0
Ccc_XD0_XDFFM_CLKB_XD3_t1 XD0_XDFFM_CLKB XD3_t1 1.21e-17
* device instance cc_XD0_XDFFM_CLKB_XD4_XDFFM_CKBB r0 *1 0,0
Ccc_XD0_XDFFM_CLKB_XD4_XDFFM_CKBB XD0_XDFFM_CLKB XD4_XDFFM_CKBB 1.8151e-17
* device instance cc_XD0_XDFFM_CLKB_XD4_XDFFM_CLKB r0 *1 0,0
Ccc_XD0_XDFFM_CLKB_XD4_XDFFM_CLKB XD0_XDFFM_CLKB XD4_XDFFM_CLKB 2.4201e-17
* device instance cc_XD0_XDFFM_CLKB_XD4_XDFFM_M r0 *1 0,0
Ccc_XD0_XDFFM_CLKB_XD4_XDFFM_M XD0_XDFFM_CLKB XD4_XDFFM_M 2.4201e-17
* device instance cc_XD0_XDFFM_CLKB_XD4_XDFFM_MB r0 *1 0,0
Ccc_XD0_XDFFM_CLKB_XD4_XDFFM_MB XD0_XDFFM_CLKB XD4_XDFFM_MB 1.21e-17
* device instance cc_XD0_XDFFM_CLKB_XD4_XDFFM_MFB r0 *1 0,0
Ccc_XD0_XDFFM_CLKB_XD4_XDFFM_MFB XD0_XDFFM_CLKB XD4_XDFFM_MFB 1.21e-17
* device instance cc_XD0_XDFFM_CLKB_XD4_XDFFM_S r0 *1 0,0
Ccc_XD0_XDFFM_CLKB_XD4_XDFFM_S XD0_XDFFM_CLKB XD4_XDFFM_S 1.8151e-17
* device instance cc_XD0_XDFFM_CLKB_XD4_XDFFM_SB r0 *1 0,0
Ccc_XD0_XDFFM_CLKB_XD4_XDFFM_SB XD0_XDFFM_CLKB XD4_XDFFM_SB 1.8151e-17
* device instance cc_XD0_XDFFM_CLKB_XD4_XDFFM_SFB r0 *1 0,0
Ccc_XD0_XDFFM_CLKB_XD4_XDFFM_SFB XD0_XDFFM_CLKB XD4_XDFFM_SFB 1.21e-17
* device instance cc_XD0_XDFFM_CLKB_XD4_XDFFQ_CKBB r0 *1 0,0
Ccc_XD0_XDFFM_CLKB_XD4_XDFFQ_CKBB XD0_XDFFM_CLKB XD4_XDFFQ_CKBB 1.8151e-17
* device instance cc_XD0_XDFFM_CLKB_XD4_XDFFQ_CLKB r0 *1 0,0
Ccc_XD0_XDFFM_CLKB_XD4_XDFFQ_CLKB XD0_XDFFM_CLKB XD4_XDFFQ_CLKB 2.4201e-17
* device instance cc_XD0_XDFFM_CLKB_XD4_XDFFQ_M r0 *1 0,0
Ccc_XD0_XDFFM_CLKB_XD4_XDFFQ_M XD0_XDFFM_CLKB XD4_XDFFQ_M 2.4201e-17
* device instance cc_XD0_XDFFM_CLKB_XD4_XDFFQ_MB r0 *1 0,0
Ccc_XD0_XDFFM_CLKB_XD4_XDFFQ_MB XD0_XDFFM_CLKB XD4_XDFFQ_MB 1.21e-17
* device instance cc_XD0_XDFFM_CLKB_XD4_XDFFQ_MFB r0 *1 0,0
Ccc_XD0_XDFFM_CLKB_XD4_XDFFQ_MFB XD0_XDFFM_CLKB XD4_XDFFQ_MFB 1.21e-17
* device instance cc_XD0_XDFFM_CLKB_XD4_XDFFQ_S r0 *1 0,0
Ccc_XD0_XDFFM_CLKB_XD4_XDFFQ_S XD0_XDFFM_CLKB XD4_XDFFQ_S 1.8151e-17
* device instance cc_XD0_XDFFM_CLKB_XD4_XDFFQ_SB r0 *1 0,0
Ccc_XD0_XDFFM_CLKB_XD4_XDFFQ_SB XD0_XDFFM_CLKB XD4_XDFFQ_SB 1.8151e-17
* device instance cc_XD0_XDFFM_CLKB_XD4_XDFFQ_SFB r0 *1 0,0
Ccc_XD0_XDFFM_CLKB_XD4_XDFFQ_SFB XD0_XDFFM_CLKB XD4_XDFFQ_SFB 1.21e-17
* device instance cc_XD0_XDFFM_CLKB_XD4_XN2_mid1 r0 *1 0,0
Ccc_XD0_XDFFM_CLKB_XD4_XN2_mid1 XD0_XDFFM_CLKB XD4_XN2_mid1 1.21e-17
* device instance cc_XD0_XDFFM_CLKB_XD4_XN3_mid1 r0 *1 0,0
Ccc_XD0_XDFFM_CLKB_XD4_XN3_mid1 XD0_XDFFM_CLKB XD4_XN3_mid1 1.21e-17
* device instance cc_XD0_XDFFM_CLKB_XD4_XN3_mid2 r0 *1 0,0
Ccc_XD0_XDFFM_CLKB_XD4_XN3_mid2 XD0_XDFFM_CLKB XD4_XN3_mid2 1.21e-17
* device instance cc_XD0_XDFFM_CLKB_XD4_dmodout r0 *1 0,0
Ccc_XD0_XDFFM_CLKB_XD4_dmodout XD0_XDFFM_CLKB XD4_dmodout 1.21e-17
* device instance cc_XD0_XDFFM_CLKB_XD4_dq r0 *1 0,0
Ccc_XD0_XDFFM_CLKB_XD4_dq XD0_XDFFM_CLKB XD4_dq 1.8151e-17
* device instance cc_XD0_XDFFM_CLKB_XD4_nm r0 *1 0,0
Ccc_XD0_XDFFM_CLKB_XD4_nm XD0_XDFFM_CLKB XD4_nm 1.21e-17
* device instance cc_XD0_XDFFM_CLKB_XD4_nt r0 *1 0,0
Ccc_XD0_XDFFM_CLKB_XD4_nt XD0_XDFFM_CLKB XD4_nt 1.21e-17
* device instance cc_XD0_XDFFM_CLKB_XD4_t1 r0 *1 0,0
Ccc_XD0_XDFFM_CLKB_XD4_t1 XD0_XDFFM_CLKB XD4_t1 1.21e-17
* device instance cc_XD0_XDFFM_CLKB_XD5_XDFFM_CKBB r0 *1 0,0
Ccc_XD0_XDFFM_CLKB_XD5_XDFFM_CKBB XD0_XDFFM_CLKB XD5_XDFFM_CKBB 1.8151e-17
* device instance cc_XD0_XDFFM_CLKB_XD5_XDFFM_CLKB r0 *1 0,0
Ccc_XD0_XDFFM_CLKB_XD5_XDFFM_CLKB XD0_XDFFM_CLKB XD5_XDFFM_CLKB 2.4201e-17
* device instance cc_XD0_XDFFM_CLKB_XD5_XDFFM_M r0 *1 0,0
Ccc_XD0_XDFFM_CLKB_XD5_XDFFM_M XD0_XDFFM_CLKB XD5_XDFFM_M 2.4201e-17
* device instance cc_XD0_XDFFM_CLKB_XD5_XDFFM_MB r0 *1 0,0
Ccc_XD0_XDFFM_CLKB_XD5_XDFFM_MB XD0_XDFFM_CLKB XD5_XDFFM_MB 1.21e-17
* device instance cc_XD0_XDFFM_CLKB_XD5_XDFFM_MFB r0 *1 0,0
Ccc_XD0_XDFFM_CLKB_XD5_XDFFM_MFB XD0_XDFFM_CLKB XD5_XDFFM_MFB 1.21e-17
* device instance cc_XD0_XDFFM_CLKB_XD5_XDFFM_S r0 *1 0,0
Ccc_XD0_XDFFM_CLKB_XD5_XDFFM_S XD0_XDFFM_CLKB XD5_XDFFM_S 1.8151e-17
* device instance cc_XD0_XDFFM_CLKB_XD5_XDFFM_SB r0 *1 0,0
Ccc_XD0_XDFFM_CLKB_XD5_XDFFM_SB XD0_XDFFM_CLKB XD5_XDFFM_SB 1.8151e-17
* device instance cc_XD0_XDFFM_CLKB_XD5_XDFFM_SFB r0 *1 0,0
Ccc_XD0_XDFFM_CLKB_XD5_XDFFM_SFB XD0_XDFFM_CLKB XD5_XDFFM_SFB 1.21e-17
* device instance cc_XD0_XDFFM_CLKB_XD5_XDFFQ_CKBB r0 *1 0,0
Ccc_XD0_XDFFM_CLKB_XD5_XDFFQ_CKBB XD0_XDFFM_CLKB XD5_XDFFQ_CKBB 1.8151e-17
* device instance cc_XD0_XDFFM_CLKB_XD5_XDFFQ_CLKB r0 *1 0,0
Ccc_XD0_XDFFM_CLKB_XD5_XDFFQ_CLKB XD0_XDFFM_CLKB XD5_XDFFQ_CLKB 2.4201e-17
* device instance cc_XD0_XDFFM_CLKB_XD5_XDFFQ_M r0 *1 0,0
Ccc_XD0_XDFFM_CLKB_XD5_XDFFQ_M XD0_XDFFM_CLKB XD5_XDFFQ_M 2.4201e-17
* device instance cc_XD0_XDFFM_CLKB_XD5_XDFFQ_MB r0 *1 0,0
Ccc_XD0_XDFFM_CLKB_XD5_XDFFQ_MB XD0_XDFFM_CLKB XD5_XDFFQ_MB 1.21e-17
* device instance cc_XD0_XDFFM_CLKB_XD5_XDFFQ_MFB r0 *1 0,0
Ccc_XD0_XDFFM_CLKB_XD5_XDFFQ_MFB XD0_XDFFM_CLKB XD5_XDFFQ_MFB 1.21e-17
* device instance cc_XD0_XDFFM_CLKB_XD5_XDFFQ_S r0 *1 0,0
Ccc_XD0_XDFFM_CLKB_XD5_XDFFQ_S XD0_XDFFM_CLKB XD5_XDFFQ_S 1.8151e-17
* device instance cc_XD0_XDFFM_CLKB_XD5_XDFFQ_SB r0 *1 0,0
Ccc_XD0_XDFFM_CLKB_XD5_XDFFQ_SB XD0_XDFFM_CLKB XD5_XDFFQ_SB 1.8151e-17
* device instance cc_XD0_XDFFM_CLKB_XD5_XDFFQ_SFB r0 *1 0,0
Ccc_XD0_XDFFM_CLKB_XD5_XDFFQ_SFB XD0_XDFFM_CLKB XD5_XDFFQ_SFB 1.21e-17
* device instance cc_XD0_XDFFM_CLKB_XD5_XN2_mid1 r0 *1 0,0
Ccc_XD0_XDFFM_CLKB_XD5_XN2_mid1 XD0_XDFFM_CLKB XD5_XN2_mid1 1.21e-17
* device instance cc_XD0_XDFFM_CLKB_XD5_XN3_mid1 r0 *1 0,0
Ccc_XD0_XDFFM_CLKB_XD5_XN3_mid1 XD0_XDFFM_CLKB XD5_XN3_mid1 1.21e-17
* device instance cc_XD0_XDFFM_CLKB_XD5_XN3_mid2 r0 *1 0,0
Ccc_XD0_XDFFM_CLKB_XD5_XN3_mid2 XD0_XDFFM_CLKB XD5_XN3_mid2 1.21e-17
* device instance cc_XD0_XDFFM_CLKB_XD5_dmodout r0 *1 0,0
Ccc_XD0_XDFFM_CLKB_XD5_dmodout XD0_XDFFM_CLKB XD5_dmodout 1.21e-17
* device instance cc_XD0_XDFFM_CLKB_XD5_dq r0 *1 0,0
Ccc_XD0_XDFFM_CLKB_XD5_dq XD0_XDFFM_CLKB XD5_dq 1.8151e-17
* device instance cc_XD0_XDFFM_CLKB_XD5_nm r0 *1 0,0
Ccc_XD0_XDFFM_CLKB_XD5_nm XD0_XDFFM_CLKB XD5_nm 1.21e-17
* device instance cc_XD0_XDFFM_CLKB_XD5_nt r0 *1 0,0
Ccc_XD0_XDFFM_CLKB_XD5_nt XD0_XDFFM_CLKB XD5_nt 1.21e-17
* device instance cc_XD0_XDFFM_CLKB_XD5_t1 r0 *1 0,0
Ccc_XD0_XDFFM_CLKB_XD5_t1 XD0_XDFFM_CLKB XD5_t1 1.21e-17
* device instance cc_XD0_XDFFM_CLKB_XFRT_CKBB r0 *1 0,0
Ccc_XD0_XDFFM_CLKB_XFRT_CKBB XD0_XDFFM_CLKB XFRT_CKBB 1.8151e-17
* device instance cc_XD0_XDFFM_CLKB_XFRT_CLKB r0 *1 0,0
Ccc_XD0_XDFFM_CLKB_XFRT_CLKB XD0_XDFFM_CLKB XFRT_CLKB 2.4201e-17
* device instance cc_XD0_XDFFM_CLKB_XFRT_M r0 *1 0,0
Ccc_XD0_XDFFM_CLKB_XFRT_M XD0_XDFFM_CLKB XFRT_M 2.4201e-17
* device instance cc_XD0_XDFFM_CLKB_XFRT_MB r0 *1 0,0
Ccc_XD0_XDFFM_CLKB_XFRT_MB XD0_XDFFM_CLKB XFRT_MB 1.21e-17
* device instance cc_XD0_XDFFM_CLKB_XFRT_MFB r0 *1 0,0
Ccc_XD0_XDFFM_CLKB_XFRT_MFB XD0_XDFFM_CLKB XFRT_MFB 1.21e-17
* device instance cc_XD0_XDFFM_CLKB_XFRT_S r0 *1 0,0
Ccc_XD0_XDFFM_CLKB_XFRT_S XD0_XDFFM_CLKB XFRT_S 1.8151e-17
* device instance cc_XD0_XDFFM_CLKB_XFRT_SB r0 *1 0,0
Ccc_XD0_XDFFM_CLKB_XFRT_SB XD0_XDFFM_CLKB XFRT_SB 1.8151e-17
* device instance cc_XD0_XDFFM_CLKB_XFRT_SFB r0 *1 0,0
Ccc_XD0_XDFFM_CLKB_XFRT_SFB XD0_XDFFM_CLKB XFRT_SFB 1.21e-17
* device instance cc_XD0_XDFFM_CLKB_ck1 r0 *1 0,0
Ccc_XD0_XDFFM_CLKB_ck1 XD0_XDFFM_CLKB ck1 3.0251e-17
* device instance cc_XD0_XDFFM_CLKB_ck2 r0 *1 0,0
Ccc_XD0_XDFFM_CLKB_ck2 XD0_XDFFM_CLKB ck2 3.0251e-17
* device instance cc_XD0_XDFFM_CLKB_ck3 r0 *1 0,0
Ccc_XD0_XDFFM_CLKB_ck3 XD0_XDFFM_CLKB ck3 3.0251e-17
* device instance cc_XD0_XDFFM_CLKB_ck4 r0 *1 0,0
Ccc_XD0_XDFFM_CLKB_ck4 XD0_XDFFM_CLKB ck4 3.0251e-17
* device instance cc_XD0_XDFFM_CLKB_ck5 r0 *1 0,0
Ccc_XD0_XDFFM_CLKB_ck5 XD0_XDFFM_CLKB ck5 3.0251e-17
* device instance cc_XD0_XDFFM_CLKB_mod0 r0 *1 0,0
Ccc_XD0_XDFFM_CLKB_mod0 XD0_XDFFM_CLKB mod0 2.4201e-17
* device instance cc_XD0_XDFFM_CLKB_mod1 r0 *1 0,0
Ccc_XD0_XDFFM_CLKB_mod1 XD0_XDFFM_CLKB mod1 2.4201e-17
* device instance cc_XD0_XDFFM_CLKB_mod2 r0 *1 0,0
Ccc_XD0_XDFFM_CLKB_mod2 XD0_XDFFM_CLKB mod2 2.4201e-17
* device instance cc_XD0_XDFFM_CLKB_mod3 r0 *1 0,0
Ccc_XD0_XDFFM_CLKB_mod3 XD0_XDFFM_CLKB mod3 2.4201e-17
* device instance cc_XD0_XDFFM_CLKB_mod4 r0 *1 0,0
Ccc_XD0_XDFFM_CLKB_mod4 XD0_XDFFM_CLKB mod4 2.4201e-17
* device instance cc_XD0_XDFFM_CLKB_net1 r0 *1 0,0
Ccc_XD0_XDFFM_CLKB_net1 XD0_XDFFM_CLKB net1 1.21e-17
* device instance cc_XD0_XDFFM_M_XD0_XDFFM_MB r0 *1 0,0
Ccc_XD0_XDFFM_M_XD0_XDFFM_MB XD0_XDFFM_M XD0_XDFFM_MB 2.4201e-17
* device instance cc_XD0_XDFFM_M_XD0_XDFFM_MFB r0 *1 0,0
Ccc_XD0_XDFFM_M_XD0_XDFFM_MFB XD0_XDFFM_M XD0_XDFFM_MFB 3.4688e-17
* device instance cc_XD0_XDFFM_M_XD0_XDFFM_S r0 *1 0,0
Ccc_XD0_XDFFM_M_XD0_XDFFM_S XD0_XDFFM_M XD0_XDFFM_S 2.8638e-17
* device instance cc_XD0_XDFFM_M_XD0_XDFFM_SB r0 *1 0,0
Ccc_XD0_XDFFM_M_XD0_XDFFM_SB XD0_XDFFM_M XD0_XDFFM_SB 1.8151e-17
* device instance cc_XD0_XDFFM_M_XD0_XDFFM_SFB r0 *1 0,0
Ccc_XD0_XDFFM_M_XD0_XDFFM_SFB XD0_XDFFM_M XD0_XDFFM_SFB 1.21e-17
* device instance cc_XD0_XDFFM_M_XD0_XDFFQ_CKBB r0 *1 0,0
Ccc_XD0_XDFFM_M_XD0_XDFFQ_CKBB XD0_XDFFM_M XD0_XDFFQ_CKBB 1.8151e-17
* device instance cc_XD0_XDFFM_M_XD0_XDFFQ_CLKB r0 *1 0,0
Ccc_XD0_XDFFM_M_XD0_XDFFQ_CLKB XD0_XDFFM_M XD0_XDFFQ_CLKB 2.4201e-17
* device instance cc_XD0_XDFFM_M_XD0_XDFFQ_M r0 *1 0,0
Ccc_XD0_XDFFM_M_XD0_XDFFQ_M XD0_XDFFM_M XD0_XDFFQ_M 2.4201e-17
* device instance cc_XD0_XDFFM_M_XD0_XDFFQ_MB r0 *1 0,0
Ccc_XD0_XDFFM_M_XD0_XDFFQ_MB XD0_XDFFM_M XD0_XDFFQ_MB 1.21e-17
* device instance cc_XD0_XDFFM_M_XD0_XDFFQ_MFB r0 *1 0,0
Ccc_XD0_XDFFM_M_XD0_XDFFQ_MFB XD0_XDFFM_M XD0_XDFFQ_MFB 1.21e-17
* device instance cc_XD0_XDFFM_M_XD0_XDFFQ_S r0 *1 0,0
Ccc_XD0_XDFFM_M_XD0_XDFFQ_S XD0_XDFFM_M XD0_XDFFQ_S 1.8151e-17
* device instance cc_XD0_XDFFM_M_XD0_XDFFQ_SB r0 *1 0,0
Ccc_XD0_XDFFM_M_XD0_XDFFQ_SB XD0_XDFFM_M XD0_XDFFQ_SB 1.8151e-17
* device instance cc_XD0_XDFFM_M_XD0_XDFFQ_SFB r0 *1 0,0
Ccc_XD0_XDFFM_M_XD0_XDFFQ_SFB XD0_XDFFM_M XD0_XDFFQ_SFB 1.21e-17
* device instance cc_XD0_XDFFM_M_XD0_XNOR_midp r0 *1 0,0
Ccc_XD0_XDFFM_M_XD0_XNOR_midp XD0_XDFFM_M XD0_XNOR_midp 1.21e-17
* device instance cc_XD0_XDFFM_M_XD0_dmodout r0 *1 0,0
Ccc_XD0_XDFFM_M_XD0_dmodout XD0_XDFFM_M XD0_dmodout 2.8638e-17
* device instance cc_XD0_XDFFM_M_XD0_dq r0 *1 0,0
Ccc_XD0_XDFFM_M_XD0_dq XD0_XDFFM_M XD0_dq 1.21e-17
* device instance cc_XD0_XDFFM_M_XD0_nm r0 *1 0,0
Ccc_XD0_XDFFM_M_XD0_nm XD0_XDFFM_M XD0_nm 1.8151e-17
* device instance cc_XD0_XDFFM_M_XD0_nt r0 *1 0,0
Ccc_XD0_XDFFM_M_XD0_nt XD0_XDFFM_M XD0_nt 2.4201e-17
* device instance cc_XD0_XDFFM_M_XD0_t1 r0 *1 0,0
Ccc_XD0_XDFFM_M_XD0_t1 XD0_XDFFM_M XD0_t1 1.21e-17
* device instance cc_XD0_XDFFM_M_XD1_XDFFM_CKBB r0 *1 0,0
Ccc_XD0_XDFFM_M_XD1_XDFFM_CKBB XD0_XDFFM_M XD1_XDFFM_CKBB 1.8151e-17
* device instance cc_XD0_XDFFM_M_XD1_XDFFM_CLKB r0 *1 0,0
Ccc_XD0_XDFFM_M_XD1_XDFFM_CLKB XD0_XDFFM_M XD1_XDFFM_CLKB 2.4201e-17
* device instance cc_XD0_XDFFM_M_XD1_XDFFM_M r0 *1 0,0
Ccc_XD0_XDFFM_M_XD1_XDFFM_M XD0_XDFFM_M XD1_XDFFM_M 2.4201e-17
* device instance cc_XD0_XDFFM_M_XD1_XDFFM_MB r0 *1 0,0
Ccc_XD0_XDFFM_M_XD1_XDFFM_MB XD0_XDFFM_M XD1_XDFFM_MB 1.21e-17
* device instance cc_XD0_XDFFM_M_XD1_XDFFM_MFB r0 *1 0,0
Ccc_XD0_XDFFM_M_XD1_XDFFM_MFB XD0_XDFFM_M XD1_XDFFM_MFB 1.21e-17
* device instance cc_XD0_XDFFM_M_XD1_XDFFM_S r0 *1 0,0
Ccc_XD0_XDFFM_M_XD1_XDFFM_S XD0_XDFFM_M XD1_XDFFM_S 1.8151e-17
* device instance cc_XD0_XDFFM_M_XD1_XDFFM_SB r0 *1 0,0
Ccc_XD0_XDFFM_M_XD1_XDFFM_SB XD0_XDFFM_M XD1_XDFFM_SB 1.8151e-17
* device instance cc_XD0_XDFFM_M_XD1_XDFFM_SFB r0 *1 0,0
Ccc_XD0_XDFFM_M_XD1_XDFFM_SFB XD0_XDFFM_M XD1_XDFFM_SFB 1.21e-17
* device instance cc_XD0_XDFFM_M_XD1_XDFFQ_CKBB r0 *1 0,0
Ccc_XD0_XDFFM_M_XD1_XDFFQ_CKBB XD0_XDFFM_M XD1_XDFFQ_CKBB 1.8151e-17
* device instance cc_XD0_XDFFM_M_XD1_XDFFQ_CLKB r0 *1 0,0
Ccc_XD0_XDFFM_M_XD1_XDFFQ_CLKB XD0_XDFFM_M XD1_XDFFQ_CLKB 2.4201e-17
* device instance cc_XD0_XDFFM_M_XD1_XDFFQ_M r0 *1 0,0
Ccc_XD0_XDFFM_M_XD1_XDFFQ_M XD0_XDFFM_M XD1_XDFFQ_M 2.4201e-17
* device instance cc_XD0_XDFFM_M_XD1_XDFFQ_MB r0 *1 0,0
Ccc_XD0_XDFFM_M_XD1_XDFFQ_MB XD0_XDFFM_M XD1_XDFFQ_MB 1.21e-17
* device instance cc_XD0_XDFFM_M_XD1_XDFFQ_MFB r0 *1 0,0
Ccc_XD0_XDFFM_M_XD1_XDFFQ_MFB XD0_XDFFM_M XD1_XDFFQ_MFB 1.21e-17
* device instance cc_XD0_XDFFM_M_XD1_XDFFQ_S r0 *1 0,0
Ccc_XD0_XDFFM_M_XD1_XDFFQ_S XD0_XDFFM_M XD1_XDFFQ_S 1.8151e-17
* device instance cc_XD0_XDFFM_M_XD1_XDFFQ_SB r0 *1 0,0
Ccc_XD0_XDFFM_M_XD1_XDFFQ_SB XD0_XDFFM_M XD1_XDFFQ_SB 1.8151e-17
* device instance cc_XD0_XDFFM_M_XD1_XDFFQ_SFB r0 *1 0,0
Ccc_XD0_XDFFM_M_XD1_XDFFQ_SFB XD0_XDFFM_M XD1_XDFFQ_SFB 1.21e-17
* device instance cc_XD0_XDFFM_M_XD1_XN2_mid1 r0 *1 0,0
Ccc_XD0_XDFFM_M_XD1_XN2_mid1 XD0_XDFFM_M XD1_XN2_mid1 1.21e-17
* device instance cc_XD0_XDFFM_M_XD1_XN3_mid1 r0 *1 0,0
Ccc_XD0_XDFFM_M_XD1_XN3_mid1 XD0_XDFFM_M XD1_XN3_mid1 1.21e-17
* device instance cc_XD0_XDFFM_M_XD1_XN3_mid2 r0 *1 0,0
Ccc_XD0_XDFFM_M_XD1_XN3_mid2 XD0_XDFFM_M XD1_XN3_mid2 1.21e-17
* device instance cc_XD0_XDFFM_M_XD1_dmodout r0 *1 0,0
Ccc_XD0_XDFFM_M_XD1_dmodout XD0_XDFFM_M XD1_dmodout 1.21e-17
* device instance cc_XD0_XDFFM_M_XD1_dq r0 *1 0,0
Ccc_XD0_XDFFM_M_XD1_dq XD0_XDFFM_M XD1_dq 1.8151e-17
* device instance cc_XD0_XDFFM_M_XD1_nm r0 *1 0,0
Ccc_XD0_XDFFM_M_XD1_nm XD0_XDFFM_M XD1_nm 1.21e-17
* device instance cc_XD0_XDFFM_M_XD1_nt r0 *1 0,0
Ccc_XD0_XDFFM_M_XD1_nt XD0_XDFFM_M XD1_nt 1.21e-17
* device instance cc_XD0_XDFFM_M_XD1_t1 r0 *1 0,0
Ccc_XD0_XDFFM_M_XD1_t1 XD0_XDFFM_M XD1_t1 1.21e-17
* device instance cc_XD0_XDFFM_M_XD2_XDFFM_CKBB r0 *1 0,0
Ccc_XD0_XDFFM_M_XD2_XDFFM_CKBB XD0_XDFFM_M XD2_XDFFM_CKBB 1.8151e-17
* device instance cc_XD0_XDFFM_M_XD2_XDFFM_CLKB r0 *1 0,0
Ccc_XD0_XDFFM_M_XD2_XDFFM_CLKB XD0_XDFFM_M XD2_XDFFM_CLKB 2.4201e-17
* device instance cc_XD0_XDFFM_M_XD2_XDFFM_M r0 *1 0,0
Ccc_XD0_XDFFM_M_XD2_XDFFM_M XD0_XDFFM_M XD2_XDFFM_M 2.4201e-17
* device instance cc_XD0_XDFFM_M_XD2_XDFFM_MB r0 *1 0,0
Ccc_XD0_XDFFM_M_XD2_XDFFM_MB XD0_XDFFM_M XD2_XDFFM_MB 1.21e-17
* device instance cc_XD0_XDFFM_M_XD2_XDFFM_MFB r0 *1 0,0
Ccc_XD0_XDFFM_M_XD2_XDFFM_MFB XD0_XDFFM_M XD2_XDFFM_MFB 1.21e-17
* device instance cc_XD0_XDFFM_M_XD2_XDFFM_S r0 *1 0,0
Ccc_XD0_XDFFM_M_XD2_XDFFM_S XD0_XDFFM_M XD2_XDFFM_S 1.8151e-17
* device instance cc_XD0_XDFFM_M_XD2_XDFFM_SB r0 *1 0,0
Ccc_XD0_XDFFM_M_XD2_XDFFM_SB XD0_XDFFM_M XD2_XDFFM_SB 1.8151e-17
* device instance cc_XD0_XDFFM_M_XD2_XDFFM_SFB r0 *1 0,0
Ccc_XD0_XDFFM_M_XD2_XDFFM_SFB XD0_XDFFM_M XD2_XDFFM_SFB 1.21e-17
* device instance cc_XD0_XDFFM_M_XD2_XDFFQ_CKBB r0 *1 0,0
Ccc_XD0_XDFFM_M_XD2_XDFFQ_CKBB XD0_XDFFM_M XD2_XDFFQ_CKBB 1.8151e-17
* device instance cc_XD0_XDFFM_M_XD2_XDFFQ_CLKB r0 *1 0,0
Ccc_XD0_XDFFM_M_XD2_XDFFQ_CLKB XD0_XDFFM_M XD2_XDFFQ_CLKB 2.4201e-17
* device instance cc_XD0_XDFFM_M_XD2_XDFFQ_M r0 *1 0,0
Ccc_XD0_XDFFM_M_XD2_XDFFQ_M XD0_XDFFM_M XD2_XDFFQ_M 2.4201e-17
* device instance cc_XD0_XDFFM_M_XD2_XDFFQ_MB r0 *1 0,0
Ccc_XD0_XDFFM_M_XD2_XDFFQ_MB XD0_XDFFM_M XD2_XDFFQ_MB 1.21e-17
* device instance cc_XD0_XDFFM_M_XD2_XDFFQ_MFB r0 *1 0,0
Ccc_XD0_XDFFM_M_XD2_XDFFQ_MFB XD0_XDFFM_M XD2_XDFFQ_MFB 1.21e-17
* device instance cc_XD0_XDFFM_M_XD2_XDFFQ_S r0 *1 0,0
Ccc_XD0_XDFFM_M_XD2_XDFFQ_S XD0_XDFFM_M XD2_XDFFQ_S 1.8151e-17
* device instance cc_XD0_XDFFM_M_XD2_XDFFQ_SB r0 *1 0,0
Ccc_XD0_XDFFM_M_XD2_XDFFQ_SB XD0_XDFFM_M XD2_XDFFQ_SB 1.8151e-17
* device instance cc_XD0_XDFFM_M_XD2_XDFFQ_SFB r0 *1 0,0
Ccc_XD0_XDFFM_M_XD2_XDFFQ_SFB XD0_XDFFM_M XD2_XDFFQ_SFB 1.21e-17
* device instance cc_XD0_XDFFM_M_XD2_XN2_mid1 r0 *1 0,0
Ccc_XD0_XDFFM_M_XD2_XN2_mid1 XD0_XDFFM_M XD2_XN2_mid1 1.21e-17
* device instance cc_XD0_XDFFM_M_XD2_XN3_mid1 r0 *1 0,0
Ccc_XD0_XDFFM_M_XD2_XN3_mid1 XD0_XDFFM_M XD2_XN3_mid1 1.21e-17
* device instance cc_XD0_XDFFM_M_XD2_XN3_mid2 r0 *1 0,0
Ccc_XD0_XDFFM_M_XD2_XN3_mid2 XD0_XDFFM_M XD2_XN3_mid2 1.21e-17
* device instance cc_XD0_XDFFM_M_XD2_dmodout r0 *1 0,0
Ccc_XD0_XDFFM_M_XD2_dmodout XD0_XDFFM_M XD2_dmodout 1.21e-17
* device instance cc_XD0_XDFFM_M_XD2_dq r0 *1 0,0
Ccc_XD0_XDFFM_M_XD2_dq XD0_XDFFM_M XD2_dq 1.8151e-17
* device instance cc_XD0_XDFFM_M_XD2_nm r0 *1 0,0
Ccc_XD0_XDFFM_M_XD2_nm XD0_XDFFM_M XD2_nm 1.21e-17
* device instance cc_XD0_XDFFM_M_XD2_nt r0 *1 0,0
Ccc_XD0_XDFFM_M_XD2_nt XD0_XDFFM_M XD2_nt 1.21e-17
* device instance cc_XD0_XDFFM_M_XD2_t1 r0 *1 0,0
Ccc_XD0_XDFFM_M_XD2_t1 XD0_XDFFM_M XD2_t1 1.21e-17
* device instance cc_XD0_XDFFM_M_XD3_XDFFM_CKBB r0 *1 0,0
Ccc_XD0_XDFFM_M_XD3_XDFFM_CKBB XD0_XDFFM_M XD3_XDFFM_CKBB 1.8151e-17
* device instance cc_XD0_XDFFM_M_XD3_XDFFM_CLKB r0 *1 0,0
Ccc_XD0_XDFFM_M_XD3_XDFFM_CLKB XD0_XDFFM_M XD3_XDFFM_CLKB 2.4201e-17
* device instance cc_XD0_XDFFM_M_XD3_XDFFM_M r0 *1 0,0
Ccc_XD0_XDFFM_M_XD3_XDFFM_M XD0_XDFFM_M XD3_XDFFM_M 2.4201e-17
* device instance cc_XD0_XDFFM_M_XD3_XDFFM_MB r0 *1 0,0
Ccc_XD0_XDFFM_M_XD3_XDFFM_MB XD0_XDFFM_M XD3_XDFFM_MB 1.21e-17
* device instance cc_XD0_XDFFM_M_XD3_XDFFM_MFB r0 *1 0,0
Ccc_XD0_XDFFM_M_XD3_XDFFM_MFB XD0_XDFFM_M XD3_XDFFM_MFB 1.21e-17
* device instance cc_XD0_XDFFM_M_XD3_XDFFM_S r0 *1 0,0
Ccc_XD0_XDFFM_M_XD3_XDFFM_S XD0_XDFFM_M XD3_XDFFM_S 1.8151e-17
* device instance cc_XD0_XDFFM_M_XD3_XDFFM_SB r0 *1 0,0
Ccc_XD0_XDFFM_M_XD3_XDFFM_SB XD0_XDFFM_M XD3_XDFFM_SB 1.8151e-17
* device instance cc_XD0_XDFFM_M_XD3_XDFFM_SFB r0 *1 0,0
Ccc_XD0_XDFFM_M_XD3_XDFFM_SFB XD0_XDFFM_M XD3_XDFFM_SFB 1.21e-17
* device instance cc_XD0_XDFFM_M_XD3_XDFFQ_CKBB r0 *1 0,0
Ccc_XD0_XDFFM_M_XD3_XDFFQ_CKBB XD0_XDFFM_M XD3_XDFFQ_CKBB 1.8151e-17
* device instance cc_XD0_XDFFM_M_XD3_XDFFQ_CLKB r0 *1 0,0
Ccc_XD0_XDFFM_M_XD3_XDFFQ_CLKB XD0_XDFFM_M XD3_XDFFQ_CLKB 2.4201e-17
* device instance cc_XD0_XDFFM_M_XD3_XDFFQ_M r0 *1 0,0
Ccc_XD0_XDFFM_M_XD3_XDFFQ_M XD0_XDFFM_M XD3_XDFFQ_M 2.4201e-17
* device instance cc_XD0_XDFFM_M_XD3_XDFFQ_MB r0 *1 0,0
Ccc_XD0_XDFFM_M_XD3_XDFFQ_MB XD0_XDFFM_M XD3_XDFFQ_MB 1.21e-17
* device instance cc_XD0_XDFFM_M_XD3_XDFFQ_MFB r0 *1 0,0
Ccc_XD0_XDFFM_M_XD3_XDFFQ_MFB XD0_XDFFM_M XD3_XDFFQ_MFB 1.21e-17
* device instance cc_XD0_XDFFM_M_XD3_XDFFQ_S r0 *1 0,0
Ccc_XD0_XDFFM_M_XD3_XDFFQ_S XD0_XDFFM_M XD3_XDFFQ_S 1.8151e-17
* device instance cc_XD0_XDFFM_M_XD3_XDFFQ_SB r0 *1 0,0
Ccc_XD0_XDFFM_M_XD3_XDFFQ_SB XD0_XDFFM_M XD3_XDFFQ_SB 1.8151e-17
* device instance cc_XD0_XDFFM_M_XD3_XDFFQ_SFB r0 *1 0,0
Ccc_XD0_XDFFM_M_XD3_XDFFQ_SFB XD0_XDFFM_M XD3_XDFFQ_SFB 1.21e-17
* device instance cc_XD0_XDFFM_M_XD3_XN2_mid1 r0 *1 0,0
Ccc_XD0_XDFFM_M_XD3_XN2_mid1 XD0_XDFFM_M XD3_XN2_mid1 1.21e-17
* device instance cc_XD0_XDFFM_M_XD3_XN3_mid1 r0 *1 0,0
Ccc_XD0_XDFFM_M_XD3_XN3_mid1 XD0_XDFFM_M XD3_XN3_mid1 1.21e-17
* device instance cc_XD0_XDFFM_M_XD3_XN3_mid2 r0 *1 0,0
Ccc_XD0_XDFFM_M_XD3_XN3_mid2 XD0_XDFFM_M XD3_XN3_mid2 1.21e-17
* device instance cc_XD0_XDFFM_M_XD3_dmodout r0 *1 0,0
Ccc_XD0_XDFFM_M_XD3_dmodout XD0_XDFFM_M XD3_dmodout 1.21e-17
* device instance cc_XD0_XDFFM_M_XD3_dq r0 *1 0,0
Ccc_XD0_XDFFM_M_XD3_dq XD0_XDFFM_M XD3_dq 1.8151e-17
* device instance cc_XD0_XDFFM_M_XD3_nm r0 *1 0,0
Ccc_XD0_XDFFM_M_XD3_nm XD0_XDFFM_M XD3_nm 1.21e-17
* device instance cc_XD0_XDFFM_M_XD3_nt r0 *1 0,0
Ccc_XD0_XDFFM_M_XD3_nt XD0_XDFFM_M XD3_nt 1.21e-17
* device instance cc_XD0_XDFFM_M_XD3_t1 r0 *1 0,0
Ccc_XD0_XDFFM_M_XD3_t1 XD0_XDFFM_M XD3_t1 1.21e-17
* device instance cc_XD0_XDFFM_M_XD4_XDFFM_CKBB r0 *1 0,0
Ccc_XD0_XDFFM_M_XD4_XDFFM_CKBB XD0_XDFFM_M XD4_XDFFM_CKBB 1.8151e-17
* device instance cc_XD0_XDFFM_M_XD4_XDFFM_CLKB r0 *1 0,0
Ccc_XD0_XDFFM_M_XD4_XDFFM_CLKB XD0_XDFFM_M XD4_XDFFM_CLKB 2.4201e-17
* device instance cc_XD0_XDFFM_M_XD4_XDFFM_M r0 *1 0,0
Ccc_XD0_XDFFM_M_XD4_XDFFM_M XD0_XDFFM_M XD4_XDFFM_M 2.4201e-17
* device instance cc_XD0_XDFFM_M_XD4_XDFFM_MB r0 *1 0,0
Ccc_XD0_XDFFM_M_XD4_XDFFM_MB XD0_XDFFM_M XD4_XDFFM_MB 1.21e-17
* device instance cc_XD0_XDFFM_M_XD4_XDFFM_MFB r0 *1 0,0
Ccc_XD0_XDFFM_M_XD4_XDFFM_MFB XD0_XDFFM_M XD4_XDFFM_MFB 1.21e-17
* device instance cc_XD0_XDFFM_M_XD4_XDFFM_S r0 *1 0,0
Ccc_XD0_XDFFM_M_XD4_XDFFM_S XD0_XDFFM_M XD4_XDFFM_S 1.8151e-17
* device instance cc_XD0_XDFFM_M_XD4_XDFFM_SB r0 *1 0,0
Ccc_XD0_XDFFM_M_XD4_XDFFM_SB XD0_XDFFM_M XD4_XDFFM_SB 1.8151e-17
* device instance cc_XD0_XDFFM_M_XD4_XDFFM_SFB r0 *1 0,0
Ccc_XD0_XDFFM_M_XD4_XDFFM_SFB XD0_XDFFM_M XD4_XDFFM_SFB 1.21e-17
* device instance cc_XD0_XDFFM_M_XD4_XDFFQ_CKBB r0 *1 0,0
Ccc_XD0_XDFFM_M_XD4_XDFFQ_CKBB XD0_XDFFM_M XD4_XDFFQ_CKBB 1.8151e-17
* device instance cc_XD0_XDFFM_M_XD4_XDFFQ_CLKB r0 *1 0,0
Ccc_XD0_XDFFM_M_XD4_XDFFQ_CLKB XD0_XDFFM_M XD4_XDFFQ_CLKB 2.4201e-17
* device instance cc_XD0_XDFFM_M_XD4_XDFFQ_M r0 *1 0,0
Ccc_XD0_XDFFM_M_XD4_XDFFQ_M XD0_XDFFM_M XD4_XDFFQ_M 2.4201e-17
* device instance cc_XD0_XDFFM_M_XD4_XDFFQ_MB r0 *1 0,0
Ccc_XD0_XDFFM_M_XD4_XDFFQ_MB XD0_XDFFM_M XD4_XDFFQ_MB 1.21e-17
* device instance cc_XD0_XDFFM_M_XD4_XDFFQ_MFB r0 *1 0,0
Ccc_XD0_XDFFM_M_XD4_XDFFQ_MFB XD0_XDFFM_M XD4_XDFFQ_MFB 1.21e-17
* device instance cc_XD0_XDFFM_M_XD4_XDFFQ_S r0 *1 0,0
Ccc_XD0_XDFFM_M_XD4_XDFFQ_S XD0_XDFFM_M XD4_XDFFQ_S 1.8151e-17
* device instance cc_XD0_XDFFM_M_XD4_XDFFQ_SB r0 *1 0,0
Ccc_XD0_XDFFM_M_XD4_XDFFQ_SB XD0_XDFFM_M XD4_XDFFQ_SB 1.8151e-17
* device instance cc_XD0_XDFFM_M_XD4_XDFFQ_SFB r0 *1 0,0
Ccc_XD0_XDFFM_M_XD4_XDFFQ_SFB XD0_XDFFM_M XD4_XDFFQ_SFB 1.21e-17
* device instance cc_XD0_XDFFM_M_XD4_XN2_mid1 r0 *1 0,0
Ccc_XD0_XDFFM_M_XD4_XN2_mid1 XD0_XDFFM_M XD4_XN2_mid1 1.21e-17
* device instance cc_XD0_XDFFM_M_XD4_XN3_mid1 r0 *1 0,0
Ccc_XD0_XDFFM_M_XD4_XN3_mid1 XD0_XDFFM_M XD4_XN3_mid1 1.21e-17
* device instance cc_XD0_XDFFM_M_XD4_XN3_mid2 r0 *1 0,0
Ccc_XD0_XDFFM_M_XD4_XN3_mid2 XD0_XDFFM_M XD4_XN3_mid2 1.21e-17
* device instance cc_XD0_XDFFM_M_XD4_dmodout r0 *1 0,0
Ccc_XD0_XDFFM_M_XD4_dmodout XD0_XDFFM_M XD4_dmodout 1.21e-17
* device instance cc_XD0_XDFFM_M_XD4_dq r0 *1 0,0
Ccc_XD0_XDFFM_M_XD4_dq XD0_XDFFM_M XD4_dq 1.8151e-17
* device instance cc_XD0_XDFFM_M_XD4_nm r0 *1 0,0
Ccc_XD0_XDFFM_M_XD4_nm XD0_XDFFM_M XD4_nm 1.21e-17
* device instance cc_XD0_XDFFM_M_XD4_nt r0 *1 0,0
Ccc_XD0_XDFFM_M_XD4_nt XD0_XDFFM_M XD4_nt 1.21e-17
* device instance cc_XD0_XDFFM_M_XD4_t1 r0 *1 0,0
Ccc_XD0_XDFFM_M_XD4_t1 XD0_XDFFM_M XD4_t1 1.21e-17
* device instance cc_XD0_XDFFM_M_XD5_XDFFM_CKBB r0 *1 0,0
Ccc_XD0_XDFFM_M_XD5_XDFFM_CKBB XD0_XDFFM_M XD5_XDFFM_CKBB 1.8151e-17
* device instance cc_XD0_XDFFM_M_XD5_XDFFM_CLKB r0 *1 0,0
Ccc_XD0_XDFFM_M_XD5_XDFFM_CLKB XD0_XDFFM_M XD5_XDFFM_CLKB 2.4201e-17
* device instance cc_XD0_XDFFM_M_XD5_XDFFM_M r0 *1 0,0
Ccc_XD0_XDFFM_M_XD5_XDFFM_M XD0_XDFFM_M XD5_XDFFM_M 2.4201e-17
* device instance cc_XD0_XDFFM_M_XD5_XDFFM_MB r0 *1 0,0
Ccc_XD0_XDFFM_M_XD5_XDFFM_MB XD0_XDFFM_M XD5_XDFFM_MB 1.21e-17
* device instance cc_XD0_XDFFM_M_XD5_XDFFM_MFB r0 *1 0,0
Ccc_XD0_XDFFM_M_XD5_XDFFM_MFB XD0_XDFFM_M XD5_XDFFM_MFB 1.21e-17
* device instance cc_XD0_XDFFM_M_XD5_XDFFM_S r0 *1 0,0
Ccc_XD0_XDFFM_M_XD5_XDFFM_S XD0_XDFFM_M XD5_XDFFM_S 1.8151e-17
* device instance cc_XD0_XDFFM_M_XD5_XDFFM_SB r0 *1 0,0
Ccc_XD0_XDFFM_M_XD5_XDFFM_SB XD0_XDFFM_M XD5_XDFFM_SB 1.8151e-17
* device instance cc_XD0_XDFFM_M_XD5_XDFFM_SFB r0 *1 0,0
Ccc_XD0_XDFFM_M_XD5_XDFFM_SFB XD0_XDFFM_M XD5_XDFFM_SFB 1.21e-17
* device instance cc_XD0_XDFFM_M_XD5_XDFFQ_CKBB r0 *1 0,0
Ccc_XD0_XDFFM_M_XD5_XDFFQ_CKBB XD0_XDFFM_M XD5_XDFFQ_CKBB 1.8151e-17
* device instance cc_XD0_XDFFM_M_XD5_XDFFQ_CLKB r0 *1 0,0
Ccc_XD0_XDFFM_M_XD5_XDFFQ_CLKB XD0_XDFFM_M XD5_XDFFQ_CLKB 2.4201e-17
* device instance cc_XD0_XDFFM_M_XD5_XDFFQ_M r0 *1 0,0
Ccc_XD0_XDFFM_M_XD5_XDFFQ_M XD0_XDFFM_M XD5_XDFFQ_M 2.4201e-17
* device instance cc_XD0_XDFFM_M_XD5_XDFFQ_MB r0 *1 0,0
Ccc_XD0_XDFFM_M_XD5_XDFFQ_MB XD0_XDFFM_M XD5_XDFFQ_MB 1.21e-17
* device instance cc_XD0_XDFFM_M_XD5_XDFFQ_MFB r0 *1 0,0
Ccc_XD0_XDFFM_M_XD5_XDFFQ_MFB XD0_XDFFM_M XD5_XDFFQ_MFB 1.21e-17
* device instance cc_XD0_XDFFM_M_XD5_XDFFQ_S r0 *1 0,0
Ccc_XD0_XDFFM_M_XD5_XDFFQ_S XD0_XDFFM_M XD5_XDFFQ_S 1.8151e-17
* device instance cc_XD0_XDFFM_M_XD5_XDFFQ_SB r0 *1 0,0
Ccc_XD0_XDFFM_M_XD5_XDFFQ_SB XD0_XDFFM_M XD5_XDFFQ_SB 1.8151e-17
* device instance cc_XD0_XDFFM_M_XD5_XDFFQ_SFB r0 *1 0,0
Ccc_XD0_XDFFM_M_XD5_XDFFQ_SFB XD0_XDFFM_M XD5_XDFFQ_SFB 1.21e-17
* device instance cc_XD0_XDFFM_M_XD5_XN2_mid1 r0 *1 0,0
Ccc_XD0_XDFFM_M_XD5_XN2_mid1 XD0_XDFFM_M XD5_XN2_mid1 1.21e-17
* device instance cc_XD0_XDFFM_M_XD5_XN3_mid1 r0 *1 0,0
Ccc_XD0_XDFFM_M_XD5_XN3_mid1 XD0_XDFFM_M XD5_XN3_mid1 1.21e-17
* device instance cc_XD0_XDFFM_M_XD5_XN3_mid2 r0 *1 0,0
Ccc_XD0_XDFFM_M_XD5_XN3_mid2 XD0_XDFFM_M XD5_XN3_mid2 1.21e-17
* device instance cc_XD0_XDFFM_M_XD5_dmodout r0 *1 0,0
Ccc_XD0_XDFFM_M_XD5_dmodout XD0_XDFFM_M XD5_dmodout 1.21e-17
* device instance cc_XD0_XDFFM_M_XD5_dq r0 *1 0,0
Ccc_XD0_XDFFM_M_XD5_dq XD0_XDFFM_M XD5_dq 1.8151e-17
* device instance cc_XD0_XDFFM_M_XD5_nm r0 *1 0,0
Ccc_XD0_XDFFM_M_XD5_nm XD0_XDFFM_M XD5_nm 1.21e-17
* device instance cc_XD0_XDFFM_M_XD5_nt r0 *1 0,0
Ccc_XD0_XDFFM_M_XD5_nt XD0_XDFFM_M XD5_nt 1.21e-17
* device instance cc_XD0_XDFFM_M_XD5_t1 r0 *1 0,0
Ccc_XD0_XDFFM_M_XD5_t1 XD0_XDFFM_M XD5_t1 1.21e-17
* device instance cc_XD0_XDFFM_M_XFRT_CKBB r0 *1 0,0
Ccc_XD0_XDFFM_M_XFRT_CKBB XD0_XDFFM_M XFRT_CKBB 1.8151e-17
* device instance cc_XD0_XDFFM_M_XFRT_CLKB r0 *1 0,0
Ccc_XD0_XDFFM_M_XFRT_CLKB XD0_XDFFM_M XFRT_CLKB 2.4201e-17
* device instance cc_XD0_XDFFM_M_XFRT_M r0 *1 0,0
Ccc_XD0_XDFFM_M_XFRT_M XD0_XDFFM_M XFRT_M 2.4201e-17
* device instance cc_XD0_XDFFM_M_XFRT_MB r0 *1 0,0
Ccc_XD0_XDFFM_M_XFRT_MB XD0_XDFFM_M XFRT_MB 1.21e-17
* device instance cc_XD0_XDFFM_M_XFRT_MFB r0 *1 0,0
Ccc_XD0_XDFFM_M_XFRT_MFB XD0_XDFFM_M XFRT_MFB 1.21e-17
* device instance cc_XD0_XDFFM_M_XFRT_S r0 *1 0,0
Ccc_XD0_XDFFM_M_XFRT_S XD0_XDFFM_M XFRT_S 1.8151e-17
* device instance cc_XD0_XDFFM_M_XFRT_SB r0 *1 0,0
Ccc_XD0_XDFFM_M_XFRT_SB XD0_XDFFM_M XFRT_SB 1.8151e-17
* device instance cc_XD0_XDFFM_M_XFRT_SFB r0 *1 0,0
Ccc_XD0_XDFFM_M_XFRT_SFB XD0_XDFFM_M XFRT_SFB 1.21e-17
* device instance cc_XD0_XDFFM_M_ck1 r0 *1 0,0
Ccc_XD0_XDFFM_M_ck1 XD0_XDFFM_M ck1 3.0251e-17
* device instance cc_XD0_XDFFM_M_ck2 r0 *1 0,0
Ccc_XD0_XDFFM_M_ck2 XD0_XDFFM_M ck2 3.0251e-17
* device instance cc_XD0_XDFFM_M_ck3 r0 *1 0,0
Ccc_XD0_XDFFM_M_ck3 XD0_XDFFM_M ck3 3.0251e-17
* device instance cc_XD0_XDFFM_M_ck4 r0 *1 0,0
Ccc_XD0_XDFFM_M_ck4 XD0_XDFFM_M ck4 3.0251e-17
* device instance cc_XD0_XDFFM_M_ck5 r0 *1 0,0
Ccc_XD0_XDFFM_M_ck5 XD0_XDFFM_M ck5 3.0251e-17
* device instance cc_XD0_XDFFM_M_mod0 r0 *1 0,0
Ccc_XD0_XDFFM_M_mod0 XD0_XDFFM_M mod0 2.4201e-17
* device instance cc_XD0_XDFFM_M_mod1 r0 *1 0,0
Ccc_XD0_XDFFM_M_mod1 XD0_XDFFM_M mod1 2.4201e-17
* device instance cc_XD0_XDFFM_M_mod2 r0 *1 0,0
Ccc_XD0_XDFFM_M_mod2 XD0_XDFFM_M mod2 2.4201e-17
* device instance cc_XD0_XDFFM_M_mod3 r0 *1 0,0
Ccc_XD0_XDFFM_M_mod3 XD0_XDFFM_M mod3 2.4201e-17
* device instance cc_XD0_XDFFM_M_mod4 r0 *1 0,0
Ccc_XD0_XDFFM_M_mod4 XD0_XDFFM_M mod4 2.4201e-17
* device instance cc_XD0_XDFFM_M_net1 r0 *1 0,0
Ccc_XD0_XDFFM_M_net1 XD0_XDFFM_M net1 1.21e-17
* device instance cc_XD0_XDFFM_MB_XD0_XDFFM_MFB r0 *1 0,0
Ccc_XD0_XDFFM_MB_XD0_XDFFM_MFB XD0_XDFFM_MB XD0_XDFFM_MFB 1.21e-17
* device instance cc_XD0_XDFFM_MB_XD0_XDFFM_S r0 *1 0,0
Ccc_XD0_XDFFM_MB_XD0_XDFFM_S XD0_XDFFM_MB XD0_XDFFM_S 1.8151e-17
* device instance cc_XD0_XDFFM_MB_XD0_XDFFM_SB r0 *1 0,0
Ccc_XD0_XDFFM_MB_XD0_XDFFM_SB XD0_XDFFM_MB XD0_XDFFM_SB 1.8151e-17
* device instance cc_XD0_XDFFM_MB_XD0_XDFFM_SFB r0 *1 0,0
Ccc_XD0_XDFFM_MB_XD0_XDFFM_SFB XD0_XDFFM_MB XD0_XDFFM_SFB 1.21e-17
* device instance cc_XD0_XDFFM_MB_XD0_XDFFQ_CKBB r0 *1 0,0
Ccc_XD0_XDFFM_MB_XD0_XDFFQ_CKBB XD0_XDFFM_MB XD0_XDFFQ_CKBB 1.8151e-17
* device instance cc_XD0_XDFFM_MB_XD0_XDFFQ_CLKB r0 *1 0,0
Ccc_XD0_XDFFM_MB_XD0_XDFFQ_CLKB XD0_XDFFM_MB XD0_XDFFQ_CLKB 2.4201e-17
* device instance cc_XD0_XDFFM_MB_XD0_XDFFQ_M r0 *1 0,0
Ccc_XD0_XDFFM_MB_XD0_XDFFQ_M XD0_XDFFM_MB XD0_XDFFQ_M 2.4201e-17
* device instance cc_XD0_XDFFM_MB_XD0_XDFFQ_MB r0 *1 0,0
Ccc_XD0_XDFFM_MB_XD0_XDFFQ_MB XD0_XDFFM_MB XD0_XDFFQ_MB 1.21e-17
* device instance cc_XD0_XDFFM_MB_XD0_XDFFQ_MFB r0 *1 0,0
Ccc_XD0_XDFFM_MB_XD0_XDFFQ_MFB XD0_XDFFM_MB XD0_XDFFQ_MFB 1.21e-17
* device instance cc_XD0_XDFFM_MB_XD0_XDFFQ_S r0 *1 0,0
Ccc_XD0_XDFFM_MB_XD0_XDFFQ_S XD0_XDFFM_MB XD0_XDFFQ_S 1.8151e-17
* device instance cc_XD0_XDFFM_MB_XD0_XDFFQ_SB r0 *1 0,0
Ccc_XD0_XDFFM_MB_XD0_XDFFQ_SB XD0_XDFFM_MB XD0_XDFFQ_SB 1.8151e-17
* device instance cc_XD0_XDFFM_MB_XD0_XDFFQ_SFB r0 *1 0,0
Ccc_XD0_XDFFM_MB_XD0_XDFFQ_SFB XD0_XDFFM_MB XD0_XDFFQ_SFB 1.21e-17
* device instance cc_XD0_XDFFM_MB_XD0_XNOR_midp r0 *1 0,0
Ccc_XD0_XDFFM_MB_XD0_XNOR_midp XD0_XDFFM_MB XD0_XNOR_midp 1.21e-17
* device instance cc_XD0_XDFFM_MB_XD0_dmodout r0 *1 0,0
Ccc_XD0_XDFFM_MB_XD0_dmodout XD0_XDFFM_MB XD0_dmodout 1.21e-17
* device instance cc_XD0_XDFFM_MB_XD0_dq r0 *1 0,0
Ccc_XD0_XDFFM_MB_XD0_dq XD0_XDFFM_MB XD0_dq 1.21e-17
* device instance cc_XD0_XDFFM_MB_XD0_nm r0 *1 0,0
Ccc_XD0_XDFFM_MB_XD0_nm XD0_XDFFM_MB XD0_nm 1.8151e-17
* device instance cc_XD0_XDFFM_MB_XD0_nt r0 *1 0,0
Ccc_XD0_XDFFM_MB_XD0_nt XD0_XDFFM_MB XD0_nt 2.4201e-17
* device instance cc_XD0_XDFFM_MB_XD0_t1 r0 *1 0,0
Ccc_XD0_XDFFM_MB_XD0_t1 XD0_XDFFM_MB XD0_t1 1.21e-17
* device instance cc_XD0_XDFFM_MB_XD1_XDFFM_CKBB r0 *1 0,0
Ccc_XD0_XDFFM_MB_XD1_XDFFM_CKBB XD0_XDFFM_MB XD1_XDFFM_CKBB 1.8151e-17
* device instance cc_XD0_XDFFM_MB_XD1_XDFFM_CLKB r0 *1 0,0
Ccc_XD0_XDFFM_MB_XD1_XDFFM_CLKB XD0_XDFFM_MB XD1_XDFFM_CLKB 2.4201e-17
* device instance cc_XD0_XDFFM_MB_XD1_XDFFM_M r0 *1 0,0
Ccc_XD0_XDFFM_MB_XD1_XDFFM_M XD0_XDFFM_MB XD1_XDFFM_M 2.4201e-17
* device instance cc_XD0_XDFFM_MB_XD1_XDFFM_MB r0 *1 0,0
Ccc_XD0_XDFFM_MB_XD1_XDFFM_MB XD0_XDFFM_MB XD1_XDFFM_MB 1.21e-17
* device instance cc_XD0_XDFFM_MB_XD1_XDFFM_MFB r0 *1 0,0
Ccc_XD0_XDFFM_MB_XD1_XDFFM_MFB XD0_XDFFM_MB XD1_XDFFM_MFB 1.21e-17
* device instance cc_XD0_XDFFM_MB_XD1_XDFFM_S r0 *1 0,0
Ccc_XD0_XDFFM_MB_XD1_XDFFM_S XD0_XDFFM_MB XD1_XDFFM_S 1.8151e-17
* device instance cc_XD0_XDFFM_MB_XD1_XDFFM_SB r0 *1 0,0
Ccc_XD0_XDFFM_MB_XD1_XDFFM_SB XD0_XDFFM_MB XD1_XDFFM_SB 1.8151e-17
* device instance cc_XD0_XDFFM_MB_XD1_XDFFM_SFB r0 *1 0,0
Ccc_XD0_XDFFM_MB_XD1_XDFFM_SFB XD0_XDFFM_MB XD1_XDFFM_SFB 1.21e-17
* device instance cc_XD0_XDFFM_MB_XD1_XDFFQ_CKBB r0 *1 0,0
Ccc_XD0_XDFFM_MB_XD1_XDFFQ_CKBB XD0_XDFFM_MB XD1_XDFFQ_CKBB 1.8151e-17
* device instance cc_XD0_XDFFM_MB_XD1_XDFFQ_CLKB r0 *1 0,0
Ccc_XD0_XDFFM_MB_XD1_XDFFQ_CLKB XD0_XDFFM_MB XD1_XDFFQ_CLKB 2.4201e-17
* device instance cc_XD0_XDFFM_MB_XD1_XDFFQ_M r0 *1 0,0
Ccc_XD0_XDFFM_MB_XD1_XDFFQ_M XD0_XDFFM_MB XD1_XDFFQ_M 2.4201e-17
* device instance cc_XD0_XDFFM_MB_XD1_XDFFQ_MB r0 *1 0,0
Ccc_XD0_XDFFM_MB_XD1_XDFFQ_MB XD0_XDFFM_MB XD1_XDFFQ_MB 1.21e-17
* device instance cc_XD0_XDFFM_MB_XD1_XDFFQ_MFB r0 *1 0,0
Ccc_XD0_XDFFM_MB_XD1_XDFFQ_MFB XD0_XDFFM_MB XD1_XDFFQ_MFB 1.21e-17
* device instance cc_XD0_XDFFM_MB_XD1_XDFFQ_S r0 *1 0,0
Ccc_XD0_XDFFM_MB_XD1_XDFFQ_S XD0_XDFFM_MB XD1_XDFFQ_S 1.8151e-17
* device instance cc_XD0_XDFFM_MB_XD1_XDFFQ_SB r0 *1 0,0
Ccc_XD0_XDFFM_MB_XD1_XDFFQ_SB XD0_XDFFM_MB XD1_XDFFQ_SB 1.8151e-17
* device instance cc_XD0_XDFFM_MB_XD1_XDFFQ_SFB r0 *1 0,0
Ccc_XD0_XDFFM_MB_XD1_XDFFQ_SFB XD0_XDFFM_MB XD1_XDFFQ_SFB 1.21e-17
* device instance cc_XD0_XDFFM_MB_XD1_XN2_mid1 r0 *1 0,0
Ccc_XD0_XDFFM_MB_XD1_XN2_mid1 XD0_XDFFM_MB XD1_XN2_mid1 1.21e-17
* device instance cc_XD0_XDFFM_MB_XD1_XN3_mid1 r0 *1 0,0
Ccc_XD0_XDFFM_MB_XD1_XN3_mid1 XD0_XDFFM_MB XD1_XN3_mid1 1.21e-17
* device instance cc_XD0_XDFFM_MB_XD1_XN3_mid2 r0 *1 0,0
Ccc_XD0_XDFFM_MB_XD1_XN3_mid2 XD0_XDFFM_MB XD1_XN3_mid2 1.21e-17
* device instance cc_XD0_XDFFM_MB_XD1_dmodout r0 *1 0,0
Ccc_XD0_XDFFM_MB_XD1_dmodout XD0_XDFFM_MB XD1_dmodout 1.21e-17
* device instance cc_XD0_XDFFM_MB_XD1_dq r0 *1 0,0
Ccc_XD0_XDFFM_MB_XD1_dq XD0_XDFFM_MB XD1_dq 1.8151e-17
* device instance cc_XD0_XDFFM_MB_XD1_nm r0 *1 0,0
Ccc_XD0_XDFFM_MB_XD1_nm XD0_XDFFM_MB XD1_nm 1.21e-17
* device instance cc_XD0_XDFFM_MB_XD1_nt r0 *1 0,0
Ccc_XD0_XDFFM_MB_XD1_nt XD0_XDFFM_MB XD1_nt 1.21e-17
* device instance cc_XD0_XDFFM_MB_XD1_t1 r0 *1 0,0
Ccc_XD0_XDFFM_MB_XD1_t1 XD0_XDFFM_MB XD1_t1 1.21e-17
* device instance cc_XD0_XDFFM_MB_XD2_XDFFM_CKBB r0 *1 0,0
Ccc_XD0_XDFFM_MB_XD2_XDFFM_CKBB XD0_XDFFM_MB XD2_XDFFM_CKBB 1.8151e-17
* device instance cc_XD0_XDFFM_MB_XD2_XDFFM_CLKB r0 *1 0,0
Ccc_XD0_XDFFM_MB_XD2_XDFFM_CLKB XD0_XDFFM_MB XD2_XDFFM_CLKB 2.4201e-17
* device instance cc_XD0_XDFFM_MB_XD2_XDFFM_M r0 *1 0,0
Ccc_XD0_XDFFM_MB_XD2_XDFFM_M XD0_XDFFM_MB XD2_XDFFM_M 2.4201e-17
* device instance cc_XD0_XDFFM_MB_XD2_XDFFM_MB r0 *1 0,0
Ccc_XD0_XDFFM_MB_XD2_XDFFM_MB XD0_XDFFM_MB XD2_XDFFM_MB 1.21e-17
* device instance cc_XD0_XDFFM_MB_XD2_XDFFM_MFB r0 *1 0,0
Ccc_XD0_XDFFM_MB_XD2_XDFFM_MFB XD0_XDFFM_MB XD2_XDFFM_MFB 1.21e-17
* device instance cc_XD0_XDFFM_MB_XD2_XDFFM_S r0 *1 0,0
Ccc_XD0_XDFFM_MB_XD2_XDFFM_S XD0_XDFFM_MB XD2_XDFFM_S 1.8151e-17
* device instance cc_XD0_XDFFM_MB_XD2_XDFFM_SB r0 *1 0,0
Ccc_XD0_XDFFM_MB_XD2_XDFFM_SB XD0_XDFFM_MB XD2_XDFFM_SB 1.8151e-17
* device instance cc_XD0_XDFFM_MB_XD2_XDFFM_SFB r0 *1 0,0
Ccc_XD0_XDFFM_MB_XD2_XDFFM_SFB XD0_XDFFM_MB XD2_XDFFM_SFB 1.21e-17
* device instance cc_XD0_XDFFM_MB_XD2_XDFFQ_CKBB r0 *1 0,0
Ccc_XD0_XDFFM_MB_XD2_XDFFQ_CKBB XD0_XDFFM_MB XD2_XDFFQ_CKBB 1.8151e-17
* device instance cc_XD0_XDFFM_MB_XD2_XDFFQ_CLKB r0 *1 0,0
Ccc_XD0_XDFFM_MB_XD2_XDFFQ_CLKB XD0_XDFFM_MB XD2_XDFFQ_CLKB 2.4201e-17
* device instance cc_XD0_XDFFM_MB_XD2_XDFFQ_M r0 *1 0,0
Ccc_XD0_XDFFM_MB_XD2_XDFFQ_M XD0_XDFFM_MB XD2_XDFFQ_M 2.4201e-17
* device instance cc_XD0_XDFFM_MB_XD2_XDFFQ_MB r0 *1 0,0
Ccc_XD0_XDFFM_MB_XD2_XDFFQ_MB XD0_XDFFM_MB XD2_XDFFQ_MB 1.21e-17
* device instance cc_XD0_XDFFM_MB_XD2_XDFFQ_MFB r0 *1 0,0
Ccc_XD0_XDFFM_MB_XD2_XDFFQ_MFB XD0_XDFFM_MB XD2_XDFFQ_MFB 1.21e-17
* device instance cc_XD0_XDFFM_MB_XD2_XDFFQ_S r0 *1 0,0
Ccc_XD0_XDFFM_MB_XD2_XDFFQ_S XD0_XDFFM_MB XD2_XDFFQ_S 1.8151e-17
* device instance cc_XD0_XDFFM_MB_XD2_XDFFQ_SB r0 *1 0,0
Ccc_XD0_XDFFM_MB_XD2_XDFFQ_SB XD0_XDFFM_MB XD2_XDFFQ_SB 1.8151e-17
* device instance cc_XD0_XDFFM_MB_XD2_XDFFQ_SFB r0 *1 0,0
Ccc_XD0_XDFFM_MB_XD2_XDFFQ_SFB XD0_XDFFM_MB XD2_XDFFQ_SFB 1.21e-17
* device instance cc_XD0_XDFFM_MB_XD2_XN2_mid1 r0 *1 0,0
Ccc_XD0_XDFFM_MB_XD2_XN2_mid1 XD0_XDFFM_MB XD2_XN2_mid1 1.21e-17
* device instance cc_XD0_XDFFM_MB_XD2_XN3_mid1 r0 *1 0,0
Ccc_XD0_XDFFM_MB_XD2_XN3_mid1 XD0_XDFFM_MB XD2_XN3_mid1 1.21e-17
* device instance cc_XD0_XDFFM_MB_XD2_XN3_mid2 r0 *1 0,0
Ccc_XD0_XDFFM_MB_XD2_XN3_mid2 XD0_XDFFM_MB XD2_XN3_mid2 1.21e-17
* device instance cc_XD0_XDFFM_MB_XD2_dmodout r0 *1 0,0
Ccc_XD0_XDFFM_MB_XD2_dmodout XD0_XDFFM_MB XD2_dmodout 1.21e-17
* device instance cc_XD0_XDFFM_MB_XD2_dq r0 *1 0,0
Ccc_XD0_XDFFM_MB_XD2_dq XD0_XDFFM_MB XD2_dq 1.8151e-17
* device instance cc_XD0_XDFFM_MB_XD2_nm r0 *1 0,0
Ccc_XD0_XDFFM_MB_XD2_nm XD0_XDFFM_MB XD2_nm 1.21e-17
* device instance cc_XD0_XDFFM_MB_XD2_nt r0 *1 0,0
Ccc_XD0_XDFFM_MB_XD2_nt XD0_XDFFM_MB XD2_nt 1.21e-17
* device instance cc_XD0_XDFFM_MB_XD2_t1 r0 *1 0,0
Ccc_XD0_XDFFM_MB_XD2_t1 XD0_XDFFM_MB XD2_t1 1.21e-17
* device instance cc_XD0_XDFFM_MB_XD3_XDFFM_CKBB r0 *1 0,0
Ccc_XD0_XDFFM_MB_XD3_XDFFM_CKBB XD0_XDFFM_MB XD3_XDFFM_CKBB 1.8151e-17
* device instance cc_XD0_XDFFM_MB_XD3_XDFFM_CLKB r0 *1 0,0
Ccc_XD0_XDFFM_MB_XD3_XDFFM_CLKB XD0_XDFFM_MB XD3_XDFFM_CLKB 2.4201e-17
* device instance cc_XD0_XDFFM_MB_XD3_XDFFM_M r0 *1 0,0
Ccc_XD0_XDFFM_MB_XD3_XDFFM_M XD0_XDFFM_MB XD3_XDFFM_M 2.4201e-17
* device instance cc_XD0_XDFFM_MB_XD3_XDFFM_MB r0 *1 0,0
Ccc_XD0_XDFFM_MB_XD3_XDFFM_MB XD0_XDFFM_MB XD3_XDFFM_MB 1.21e-17
* device instance cc_XD0_XDFFM_MB_XD3_XDFFM_MFB r0 *1 0,0
Ccc_XD0_XDFFM_MB_XD3_XDFFM_MFB XD0_XDFFM_MB XD3_XDFFM_MFB 1.21e-17
* device instance cc_XD0_XDFFM_MB_XD3_XDFFM_S r0 *1 0,0
Ccc_XD0_XDFFM_MB_XD3_XDFFM_S XD0_XDFFM_MB XD3_XDFFM_S 1.8151e-17
* device instance cc_XD0_XDFFM_MB_XD3_XDFFM_SB r0 *1 0,0
Ccc_XD0_XDFFM_MB_XD3_XDFFM_SB XD0_XDFFM_MB XD3_XDFFM_SB 1.8151e-17
* device instance cc_XD0_XDFFM_MB_XD3_XDFFM_SFB r0 *1 0,0
Ccc_XD0_XDFFM_MB_XD3_XDFFM_SFB XD0_XDFFM_MB XD3_XDFFM_SFB 1.21e-17
* device instance cc_XD0_XDFFM_MB_XD3_XDFFQ_CKBB r0 *1 0,0
Ccc_XD0_XDFFM_MB_XD3_XDFFQ_CKBB XD0_XDFFM_MB XD3_XDFFQ_CKBB 1.8151e-17
* device instance cc_XD0_XDFFM_MB_XD3_XDFFQ_CLKB r0 *1 0,0
Ccc_XD0_XDFFM_MB_XD3_XDFFQ_CLKB XD0_XDFFM_MB XD3_XDFFQ_CLKB 2.4201e-17
* device instance cc_XD0_XDFFM_MB_XD3_XDFFQ_M r0 *1 0,0
Ccc_XD0_XDFFM_MB_XD3_XDFFQ_M XD0_XDFFM_MB XD3_XDFFQ_M 2.4201e-17
* device instance cc_XD0_XDFFM_MB_XD3_XDFFQ_MB r0 *1 0,0
Ccc_XD0_XDFFM_MB_XD3_XDFFQ_MB XD0_XDFFM_MB XD3_XDFFQ_MB 1.21e-17
* device instance cc_XD0_XDFFM_MB_XD3_XDFFQ_MFB r0 *1 0,0
Ccc_XD0_XDFFM_MB_XD3_XDFFQ_MFB XD0_XDFFM_MB XD3_XDFFQ_MFB 1.21e-17
* device instance cc_XD0_XDFFM_MB_XD3_XDFFQ_S r0 *1 0,0
Ccc_XD0_XDFFM_MB_XD3_XDFFQ_S XD0_XDFFM_MB XD3_XDFFQ_S 1.8151e-17
* device instance cc_XD0_XDFFM_MB_XD3_XDFFQ_SB r0 *1 0,0
Ccc_XD0_XDFFM_MB_XD3_XDFFQ_SB XD0_XDFFM_MB XD3_XDFFQ_SB 1.8151e-17
* device instance cc_XD0_XDFFM_MB_XD3_XDFFQ_SFB r0 *1 0,0
Ccc_XD0_XDFFM_MB_XD3_XDFFQ_SFB XD0_XDFFM_MB XD3_XDFFQ_SFB 1.21e-17
* device instance cc_XD0_XDFFM_MB_XD3_XN2_mid1 r0 *1 0,0
Ccc_XD0_XDFFM_MB_XD3_XN2_mid1 XD0_XDFFM_MB XD3_XN2_mid1 1.21e-17
* device instance cc_XD0_XDFFM_MB_XD3_XN3_mid1 r0 *1 0,0
Ccc_XD0_XDFFM_MB_XD3_XN3_mid1 XD0_XDFFM_MB XD3_XN3_mid1 1.21e-17
* device instance cc_XD0_XDFFM_MB_XD3_XN3_mid2 r0 *1 0,0
Ccc_XD0_XDFFM_MB_XD3_XN3_mid2 XD0_XDFFM_MB XD3_XN3_mid2 1.21e-17
* device instance cc_XD0_XDFFM_MB_XD3_dmodout r0 *1 0,0
Ccc_XD0_XDFFM_MB_XD3_dmodout XD0_XDFFM_MB XD3_dmodout 1.21e-17
* device instance cc_XD0_XDFFM_MB_XD3_dq r0 *1 0,0
Ccc_XD0_XDFFM_MB_XD3_dq XD0_XDFFM_MB XD3_dq 1.8151e-17
* device instance cc_XD0_XDFFM_MB_XD3_nm r0 *1 0,0
Ccc_XD0_XDFFM_MB_XD3_nm XD0_XDFFM_MB XD3_nm 1.21e-17
* device instance cc_XD0_XDFFM_MB_XD3_nt r0 *1 0,0
Ccc_XD0_XDFFM_MB_XD3_nt XD0_XDFFM_MB XD3_nt 1.21e-17
* device instance cc_XD0_XDFFM_MB_XD3_t1 r0 *1 0,0
Ccc_XD0_XDFFM_MB_XD3_t1 XD0_XDFFM_MB XD3_t1 1.21e-17
* device instance cc_XD0_XDFFM_MB_XD4_XDFFM_CKBB r0 *1 0,0
Ccc_XD0_XDFFM_MB_XD4_XDFFM_CKBB XD0_XDFFM_MB XD4_XDFFM_CKBB 1.8151e-17
* device instance cc_XD0_XDFFM_MB_XD4_XDFFM_CLKB r0 *1 0,0
Ccc_XD0_XDFFM_MB_XD4_XDFFM_CLKB XD0_XDFFM_MB XD4_XDFFM_CLKB 2.4201e-17
* device instance cc_XD0_XDFFM_MB_XD4_XDFFM_M r0 *1 0,0
Ccc_XD0_XDFFM_MB_XD4_XDFFM_M XD0_XDFFM_MB XD4_XDFFM_M 2.4201e-17
* device instance cc_XD0_XDFFM_MB_XD4_XDFFM_MB r0 *1 0,0
Ccc_XD0_XDFFM_MB_XD4_XDFFM_MB XD0_XDFFM_MB XD4_XDFFM_MB 1.21e-17
* device instance cc_XD0_XDFFM_MB_XD4_XDFFM_MFB r0 *1 0,0
Ccc_XD0_XDFFM_MB_XD4_XDFFM_MFB XD0_XDFFM_MB XD4_XDFFM_MFB 1.21e-17
* device instance cc_XD0_XDFFM_MB_XD4_XDFFM_S r0 *1 0,0
Ccc_XD0_XDFFM_MB_XD4_XDFFM_S XD0_XDFFM_MB XD4_XDFFM_S 1.8151e-17
* device instance cc_XD0_XDFFM_MB_XD4_XDFFM_SB r0 *1 0,0
Ccc_XD0_XDFFM_MB_XD4_XDFFM_SB XD0_XDFFM_MB XD4_XDFFM_SB 1.8151e-17
* device instance cc_XD0_XDFFM_MB_XD4_XDFFM_SFB r0 *1 0,0
Ccc_XD0_XDFFM_MB_XD4_XDFFM_SFB XD0_XDFFM_MB XD4_XDFFM_SFB 1.21e-17
* device instance cc_XD0_XDFFM_MB_XD4_XDFFQ_CKBB r0 *1 0,0
Ccc_XD0_XDFFM_MB_XD4_XDFFQ_CKBB XD0_XDFFM_MB XD4_XDFFQ_CKBB 1.8151e-17
* device instance cc_XD0_XDFFM_MB_XD4_XDFFQ_CLKB r0 *1 0,0
Ccc_XD0_XDFFM_MB_XD4_XDFFQ_CLKB XD0_XDFFM_MB XD4_XDFFQ_CLKB 2.4201e-17
* device instance cc_XD0_XDFFM_MB_XD4_XDFFQ_M r0 *1 0,0
Ccc_XD0_XDFFM_MB_XD4_XDFFQ_M XD0_XDFFM_MB XD4_XDFFQ_M 2.4201e-17
* device instance cc_XD0_XDFFM_MB_XD4_XDFFQ_MB r0 *1 0,0
Ccc_XD0_XDFFM_MB_XD4_XDFFQ_MB XD0_XDFFM_MB XD4_XDFFQ_MB 1.21e-17
* device instance cc_XD0_XDFFM_MB_XD4_XDFFQ_MFB r0 *1 0,0
Ccc_XD0_XDFFM_MB_XD4_XDFFQ_MFB XD0_XDFFM_MB XD4_XDFFQ_MFB 1.21e-17
* device instance cc_XD0_XDFFM_MB_XD4_XDFFQ_S r0 *1 0,0
Ccc_XD0_XDFFM_MB_XD4_XDFFQ_S XD0_XDFFM_MB XD4_XDFFQ_S 1.8151e-17
* device instance cc_XD0_XDFFM_MB_XD4_XDFFQ_SB r0 *1 0,0
Ccc_XD0_XDFFM_MB_XD4_XDFFQ_SB XD0_XDFFM_MB XD4_XDFFQ_SB 1.8151e-17
* device instance cc_XD0_XDFFM_MB_XD4_XDFFQ_SFB r0 *1 0,0
Ccc_XD0_XDFFM_MB_XD4_XDFFQ_SFB XD0_XDFFM_MB XD4_XDFFQ_SFB 1.21e-17
* device instance cc_XD0_XDFFM_MB_XD4_XN2_mid1 r0 *1 0,0
Ccc_XD0_XDFFM_MB_XD4_XN2_mid1 XD0_XDFFM_MB XD4_XN2_mid1 1.21e-17
* device instance cc_XD0_XDFFM_MB_XD4_XN3_mid1 r0 *1 0,0
Ccc_XD0_XDFFM_MB_XD4_XN3_mid1 XD0_XDFFM_MB XD4_XN3_mid1 1.21e-17
* device instance cc_XD0_XDFFM_MB_XD4_XN3_mid2 r0 *1 0,0
Ccc_XD0_XDFFM_MB_XD4_XN3_mid2 XD0_XDFFM_MB XD4_XN3_mid2 1.21e-17
* device instance cc_XD0_XDFFM_MB_XD4_dmodout r0 *1 0,0
Ccc_XD0_XDFFM_MB_XD4_dmodout XD0_XDFFM_MB XD4_dmodout 1.21e-17
* device instance cc_XD0_XDFFM_MB_XD4_dq r0 *1 0,0
Ccc_XD0_XDFFM_MB_XD4_dq XD0_XDFFM_MB XD4_dq 1.8151e-17
* device instance cc_XD0_XDFFM_MB_XD4_nm r0 *1 0,0
Ccc_XD0_XDFFM_MB_XD4_nm XD0_XDFFM_MB XD4_nm 1.21e-17
* device instance cc_XD0_XDFFM_MB_XD4_nt r0 *1 0,0
Ccc_XD0_XDFFM_MB_XD4_nt XD0_XDFFM_MB XD4_nt 1.21e-17
* device instance cc_XD0_XDFFM_MB_XD4_t1 r0 *1 0,0
Ccc_XD0_XDFFM_MB_XD4_t1 XD0_XDFFM_MB XD4_t1 1.21e-17
* device instance cc_XD0_XDFFM_MB_XD5_XDFFM_CKBB r0 *1 0,0
Ccc_XD0_XDFFM_MB_XD5_XDFFM_CKBB XD0_XDFFM_MB XD5_XDFFM_CKBB 1.8151e-17
* device instance cc_XD0_XDFFM_MB_XD5_XDFFM_CLKB r0 *1 0,0
Ccc_XD0_XDFFM_MB_XD5_XDFFM_CLKB XD0_XDFFM_MB XD5_XDFFM_CLKB 2.4201e-17
* device instance cc_XD0_XDFFM_MB_XD5_XDFFM_M r0 *1 0,0
Ccc_XD0_XDFFM_MB_XD5_XDFFM_M XD0_XDFFM_MB XD5_XDFFM_M 2.4201e-17
* device instance cc_XD0_XDFFM_MB_XD5_XDFFM_MB r0 *1 0,0
Ccc_XD0_XDFFM_MB_XD5_XDFFM_MB XD0_XDFFM_MB XD5_XDFFM_MB 1.21e-17
* device instance cc_XD0_XDFFM_MB_XD5_XDFFM_MFB r0 *1 0,0
Ccc_XD0_XDFFM_MB_XD5_XDFFM_MFB XD0_XDFFM_MB XD5_XDFFM_MFB 1.21e-17
* device instance cc_XD0_XDFFM_MB_XD5_XDFFM_S r0 *1 0,0
Ccc_XD0_XDFFM_MB_XD5_XDFFM_S XD0_XDFFM_MB XD5_XDFFM_S 1.8151e-17
* device instance cc_XD0_XDFFM_MB_XD5_XDFFM_SB r0 *1 0,0
Ccc_XD0_XDFFM_MB_XD5_XDFFM_SB XD0_XDFFM_MB XD5_XDFFM_SB 1.8151e-17
* device instance cc_XD0_XDFFM_MB_XD5_XDFFM_SFB r0 *1 0,0
Ccc_XD0_XDFFM_MB_XD5_XDFFM_SFB XD0_XDFFM_MB XD5_XDFFM_SFB 1.21e-17
* device instance cc_XD0_XDFFM_MB_XD5_XDFFQ_CKBB r0 *1 0,0
Ccc_XD0_XDFFM_MB_XD5_XDFFQ_CKBB XD0_XDFFM_MB XD5_XDFFQ_CKBB 1.8151e-17
* device instance cc_XD0_XDFFM_MB_XD5_XDFFQ_CLKB r0 *1 0,0
Ccc_XD0_XDFFM_MB_XD5_XDFFQ_CLKB XD0_XDFFM_MB XD5_XDFFQ_CLKB 2.4201e-17
* device instance cc_XD0_XDFFM_MB_XD5_XDFFQ_M r0 *1 0,0
Ccc_XD0_XDFFM_MB_XD5_XDFFQ_M XD0_XDFFM_MB XD5_XDFFQ_M 2.4201e-17
* device instance cc_XD0_XDFFM_MB_XD5_XDFFQ_MB r0 *1 0,0
Ccc_XD0_XDFFM_MB_XD5_XDFFQ_MB XD0_XDFFM_MB XD5_XDFFQ_MB 1.21e-17
* device instance cc_XD0_XDFFM_MB_XD5_XDFFQ_MFB r0 *1 0,0
Ccc_XD0_XDFFM_MB_XD5_XDFFQ_MFB XD0_XDFFM_MB XD5_XDFFQ_MFB 1.21e-17
* device instance cc_XD0_XDFFM_MB_XD5_XDFFQ_S r0 *1 0,0
Ccc_XD0_XDFFM_MB_XD5_XDFFQ_S XD0_XDFFM_MB XD5_XDFFQ_S 1.8151e-17
* device instance cc_XD0_XDFFM_MB_XD5_XDFFQ_SB r0 *1 0,0
Ccc_XD0_XDFFM_MB_XD5_XDFFQ_SB XD0_XDFFM_MB XD5_XDFFQ_SB 1.8151e-17
* device instance cc_XD0_XDFFM_MB_XD5_XDFFQ_SFB r0 *1 0,0
Ccc_XD0_XDFFM_MB_XD5_XDFFQ_SFB XD0_XDFFM_MB XD5_XDFFQ_SFB 1.21e-17
* device instance cc_XD0_XDFFM_MB_XD5_XN2_mid1 r0 *1 0,0
Ccc_XD0_XDFFM_MB_XD5_XN2_mid1 XD0_XDFFM_MB XD5_XN2_mid1 1.21e-17
* device instance cc_XD0_XDFFM_MB_XD5_XN3_mid1 r0 *1 0,0
Ccc_XD0_XDFFM_MB_XD5_XN3_mid1 XD0_XDFFM_MB XD5_XN3_mid1 1.21e-17
* device instance cc_XD0_XDFFM_MB_XD5_XN3_mid2 r0 *1 0,0
Ccc_XD0_XDFFM_MB_XD5_XN3_mid2 XD0_XDFFM_MB XD5_XN3_mid2 1.21e-17
* device instance cc_XD0_XDFFM_MB_XD5_dmodout r0 *1 0,0
Ccc_XD0_XDFFM_MB_XD5_dmodout XD0_XDFFM_MB XD5_dmodout 1.21e-17
* device instance cc_XD0_XDFFM_MB_XD5_dq r0 *1 0,0
Ccc_XD0_XDFFM_MB_XD5_dq XD0_XDFFM_MB XD5_dq 1.8151e-17
* device instance cc_XD0_XDFFM_MB_XD5_nm r0 *1 0,0
Ccc_XD0_XDFFM_MB_XD5_nm XD0_XDFFM_MB XD5_nm 1.21e-17
* device instance cc_XD0_XDFFM_MB_XD5_nt r0 *1 0,0
Ccc_XD0_XDFFM_MB_XD5_nt XD0_XDFFM_MB XD5_nt 1.21e-17
* device instance cc_XD0_XDFFM_MB_XD5_t1 r0 *1 0,0
Ccc_XD0_XDFFM_MB_XD5_t1 XD0_XDFFM_MB XD5_t1 1.21e-17
* device instance cc_XD0_XDFFM_MB_XFRT_CKBB r0 *1 0,0
Ccc_XD0_XDFFM_MB_XFRT_CKBB XD0_XDFFM_MB XFRT_CKBB 1.8151e-17
* device instance cc_XD0_XDFFM_MB_XFRT_CLKB r0 *1 0,0
Ccc_XD0_XDFFM_MB_XFRT_CLKB XD0_XDFFM_MB XFRT_CLKB 2.4201e-17
* device instance cc_XD0_XDFFM_MB_XFRT_M r0 *1 0,0
Ccc_XD0_XDFFM_MB_XFRT_M XD0_XDFFM_MB XFRT_M 2.4201e-17
* device instance cc_XD0_XDFFM_MB_XFRT_MB r0 *1 0,0
Ccc_XD0_XDFFM_MB_XFRT_MB XD0_XDFFM_MB XFRT_MB 1.21e-17
* device instance cc_XD0_XDFFM_MB_XFRT_MFB r0 *1 0,0
Ccc_XD0_XDFFM_MB_XFRT_MFB XD0_XDFFM_MB XFRT_MFB 1.21e-17
* device instance cc_XD0_XDFFM_MB_XFRT_S r0 *1 0,0
Ccc_XD0_XDFFM_MB_XFRT_S XD0_XDFFM_MB XFRT_S 1.8151e-17
* device instance cc_XD0_XDFFM_MB_XFRT_SB r0 *1 0,0
Ccc_XD0_XDFFM_MB_XFRT_SB XD0_XDFFM_MB XFRT_SB 1.8151e-17
* device instance cc_XD0_XDFFM_MB_XFRT_SFB r0 *1 0,0
Ccc_XD0_XDFFM_MB_XFRT_SFB XD0_XDFFM_MB XFRT_SFB 1.21e-17
* device instance cc_XD0_XDFFM_MB_ck1 r0 *1 0,0
Ccc_XD0_XDFFM_MB_ck1 XD0_XDFFM_MB ck1 3.0251e-17
* device instance cc_XD0_XDFFM_MB_ck2 r0 *1 0,0
Ccc_XD0_XDFFM_MB_ck2 XD0_XDFFM_MB ck2 3.0251e-17
* device instance cc_XD0_XDFFM_MB_ck3 r0 *1 0,0
Ccc_XD0_XDFFM_MB_ck3 XD0_XDFFM_MB ck3 3.0251e-17
* device instance cc_XD0_XDFFM_MB_ck4 r0 *1 0,0
Ccc_XD0_XDFFM_MB_ck4 XD0_XDFFM_MB ck4 3.0251e-17
* device instance cc_XD0_XDFFM_MB_ck5 r0 *1 0,0
Ccc_XD0_XDFFM_MB_ck5 XD0_XDFFM_MB ck5 3.0251e-17
* device instance cc_XD0_XDFFM_MB_mod0 r0 *1 0,0
Ccc_XD0_XDFFM_MB_mod0 XD0_XDFFM_MB mod0 2.4201e-17
* device instance cc_XD0_XDFFM_MB_mod1 r0 *1 0,0
Ccc_XD0_XDFFM_MB_mod1 XD0_XDFFM_MB mod1 2.4201e-17
* device instance cc_XD0_XDFFM_MB_mod2 r0 *1 0,0
Ccc_XD0_XDFFM_MB_mod2 XD0_XDFFM_MB mod2 2.4201e-17
* device instance cc_XD0_XDFFM_MB_mod3 r0 *1 0,0
Ccc_XD0_XDFFM_MB_mod3 XD0_XDFFM_MB mod3 2.4201e-17
* device instance cc_XD0_XDFFM_MB_mod4 r0 *1 0,0
Ccc_XD0_XDFFM_MB_mod4 XD0_XDFFM_MB mod4 2.4201e-17
* device instance cc_XD0_XDFFM_MB_net1 r0 *1 0,0
Ccc_XD0_XDFFM_MB_net1 XD0_XDFFM_MB net1 1.21e-17
* device instance cc_XD0_XDFFM_MFB_XD0_XDFFM_S r0 *1 0,0
Ccc_XD0_XDFFM_MFB_XD0_XDFFM_S XD0_XDFFM_MFB XD0_XDFFM_S 1.8151e-17
* device instance cc_XD0_XDFFM_MFB_XD0_XDFFM_SB r0 *1 0,0
Ccc_XD0_XDFFM_MFB_XD0_XDFFM_SB XD0_XDFFM_MFB XD0_XDFFM_SB 1.8151e-17
* device instance cc_XD0_XDFFM_MFB_XD0_XDFFM_SFB r0 *1 0,0
Ccc_XD0_XDFFM_MFB_XD0_XDFFM_SFB XD0_XDFFM_MFB XD0_XDFFM_SFB 1.21e-17
* device instance cc_XD0_XDFFM_MFB_XD0_XDFFQ_CKBB r0 *1 0,0
Ccc_XD0_XDFFM_MFB_XD0_XDFFQ_CKBB XD0_XDFFM_MFB XD0_XDFFQ_CKBB 1.8151e-17
* device instance cc_XD0_XDFFM_MFB_XD0_XDFFQ_CLKB r0 *1 0,0
Ccc_XD0_XDFFM_MFB_XD0_XDFFQ_CLKB XD0_XDFFM_MFB XD0_XDFFQ_CLKB 2.4201e-17
* device instance cc_XD0_XDFFM_MFB_XD0_XDFFQ_M r0 *1 0,0
Ccc_XD0_XDFFM_MFB_XD0_XDFFQ_M XD0_XDFFM_MFB XD0_XDFFQ_M 2.4201e-17
* device instance cc_XD0_XDFFM_MFB_XD0_XDFFQ_MB r0 *1 0,0
Ccc_XD0_XDFFM_MFB_XD0_XDFFQ_MB XD0_XDFFM_MFB XD0_XDFFQ_MB 1.21e-17
* device instance cc_XD0_XDFFM_MFB_XD0_XDFFQ_MFB r0 *1 0,0
Ccc_XD0_XDFFM_MFB_XD0_XDFFQ_MFB XD0_XDFFM_MFB XD0_XDFFQ_MFB 1.21e-17
* device instance cc_XD0_XDFFM_MFB_XD0_XDFFQ_S r0 *1 0,0
Ccc_XD0_XDFFM_MFB_XD0_XDFFQ_S XD0_XDFFM_MFB XD0_XDFFQ_S 1.8151e-17
* device instance cc_XD0_XDFFM_MFB_XD0_XDFFQ_SB r0 *1 0,0
Ccc_XD0_XDFFM_MFB_XD0_XDFFQ_SB XD0_XDFFM_MFB XD0_XDFFQ_SB 1.8151e-17
* device instance cc_XD0_XDFFM_MFB_XD0_XDFFQ_SFB r0 *1 0,0
Ccc_XD0_XDFFM_MFB_XD0_XDFFQ_SFB XD0_XDFFM_MFB XD0_XDFFQ_SFB 1.21e-17
* device instance cc_XD0_XDFFM_MFB_XD0_XNOR_midp r0 *1 0,0
Ccc_XD0_XDFFM_MFB_XD0_XNOR_midp XD0_XDFFM_MFB XD0_XNOR_midp 1.21e-17
* device instance cc_XD0_XDFFM_MFB_XD0_dmodout r0 *1 0,0
Ccc_XD0_XDFFM_MFB_XD0_dmodout XD0_XDFFM_MFB XD0_dmodout 1.21e-17
* device instance cc_XD0_XDFFM_MFB_XD0_dq r0 *1 0,0
Ccc_XD0_XDFFM_MFB_XD0_dq XD0_XDFFM_MFB XD0_dq 1.21e-17
* device instance cc_XD0_XDFFM_MFB_XD0_nm r0 *1 0,0
Ccc_XD0_XDFFM_MFB_XD0_nm XD0_XDFFM_MFB XD0_nm 1.8151e-17
* device instance cc_XD0_XDFFM_MFB_XD0_nt r0 *1 0,0
Ccc_XD0_XDFFM_MFB_XD0_nt XD0_XDFFM_MFB XD0_nt 2.4201e-17
* device instance cc_XD0_XDFFM_MFB_XD0_t1 r0 *1 0,0
Ccc_XD0_XDFFM_MFB_XD0_t1 XD0_XDFFM_MFB XD0_t1 1.21e-17
* device instance cc_XD0_XDFFM_MFB_XD1_XDFFM_CKBB r0 *1 0,0
Ccc_XD0_XDFFM_MFB_XD1_XDFFM_CKBB XD0_XDFFM_MFB XD1_XDFFM_CKBB 1.8151e-17
* device instance cc_XD0_XDFFM_MFB_XD1_XDFFM_CLKB r0 *1 0,0
Ccc_XD0_XDFFM_MFB_XD1_XDFFM_CLKB XD0_XDFFM_MFB XD1_XDFFM_CLKB 2.4201e-17
* device instance cc_XD0_XDFFM_MFB_XD1_XDFFM_M r0 *1 0,0
Ccc_XD0_XDFFM_MFB_XD1_XDFFM_M XD0_XDFFM_MFB XD1_XDFFM_M 2.4201e-17
* device instance cc_XD0_XDFFM_MFB_XD1_XDFFM_MB r0 *1 0,0
Ccc_XD0_XDFFM_MFB_XD1_XDFFM_MB XD0_XDFFM_MFB XD1_XDFFM_MB 1.21e-17
* device instance cc_XD0_XDFFM_MFB_XD1_XDFFM_MFB r0 *1 0,0
Ccc_XD0_XDFFM_MFB_XD1_XDFFM_MFB XD0_XDFFM_MFB XD1_XDFFM_MFB 1.21e-17
* device instance cc_XD0_XDFFM_MFB_XD1_XDFFM_S r0 *1 0,0
Ccc_XD0_XDFFM_MFB_XD1_XDFFM_S XD0_XDFFM_MFB XD1_XDFFM_S 1.8151e-17
* device instance cc_XD0_XDFFM_MFB_XD1_XDFFM_SB r0 *1 0,0
Ccc_XD0_XDFFM_MFB_XD1_XDFFM_SB XD0_XDFFM_MFB XD1_XDFFM_SB 1.8151e-17
* device instance cc_XD0_XDFFM_MFB_XD1_XDFFM_SFB r0 *1 0,0
Ccc_XD0_XDFFM_MFB_XD1_XDFFM_SFB XD0_XDFFM_MFB XD1_XDFFM_SFB 1.21e-17
* device instance cc_XD0_XDFFM_MFB_XD1_XDFFQ_CKBB r0 *1 0,0
Ccc_XD0_XDFFM_MFB_XD1_XDFFQ_CKBB XD0_XDFFM_MFB XD1_XDFFQ_CKBB 1.8151e-17
* device instance cc_XD0_XDFFM_MFB_XD1_XDFFQ_CLKB r0 *1 0,0
Ccc_XD0_XDFFM_MFB_XD1_XDFFQ_CLKB XD0_XDFFM_MFB XD1_XDFFQ_CLKB 2.4201e-17
* device instance cc_XD0_XDFFM_MFB_XD1_XDFFQ_M r0 *1 0,0
Ccc_XD0_XDFFM_MFB_XD1_XDFFQ_M XD0_XDFFM_MFB XD1_XDFFQ_M 2.4201e-17
* device instance cc_XD0_XDFFM_MFB_XD1_XDFFQ_MB r0 *1 0,0
Ccc_XD0_XDFFM_MFB_XD1_XDFFQ_MB XD0_XDFFM_MFB XD1_XDFFQ_MB 1.21e-17
* device instance cc_XD0_XDFFM_MFB_XD1_XDFFQ_MFB r0 *1 0,0
Ccc_XD0_XDFFM_MFB_XD1_XDFFQ_MFB XD0_XDFFM_MFB XD1_XDFFQ_MFB 1.21e-17
* device instance cc_XD0_XDFFM_MFB_XD1_XDFFQ_S r0 *1 0,0
Ccc_XD0_XDFFM_MFB_XD1_XDFFQ_S XD0_XDFFM_MFB XD1_XDFFQ_S 1.8151e-17
* device instance cc_XD0_XDFFM_MFB_XD1_XDFFQ_SB r0 *1 0,0
Ccc_XD0_XDFFM_MFB_XD1_XDFFQ_SB XD0_XDFFM_MFB XD1_XDFFQ_SB 1.8151e-17
* device instance cc_XD0_XDFFM_MFB_XD1_XDFFQ_SFB r0 *1 0,0
Ccc_XD0_XDFFM_MFB_XD1_XDFFQ_SFB XD0_XDFFM_MFB XD1_XDFFQ_SFB 1.21e-17
* device instance cc_XD0_XDFFM_MFB_XD1_XN2_mid1 r0 *1 0,0
Ccc_XD0_XDFFM_MFB_XD1_XN2_mid1 XD0_XDFFM_MFB XD1_XN2_mid1 1.21e-17
* device instance cc_XD0_XDFFM_MFB_XD1_XN3_mid1 r0 *1 0,0
Ccc_XD0_XDFFM_MFB_XD1_XN3_mid1 XD0_XDFFM_MFB XD1_XN3_mid1 1.21e-17
* device instance cc_XD0_XDFFM_MFB_XD1_XN3_mid2 r0 *1 0,0
Ccc_XD0_XDFFM_MFB_XD1_XN3_mid2 XD0_XDFFM_MFB XD1_XN3_mid2 1.21e-17
* device instance cc_XD0_XDFFM_MFB_XD1_dmodout r0 *1 0,0
Ccc_XD0_XDFFM_MFB_XD1_dmodout XD0_XDFFM_MFB XD1_dmodout 1.21e-17
* device instance cc_XD0_XDFFM_MFB_XD1_dq r0 *1 0,0
Ccc_XD0_XDFFM_MFB_XD1_dq XD0_XDFFM_MFB XD1_dq 1.8151e-17
* device instance cc_XD0_XDFFM_MFB_XD1_nm r0 *1 0,0
Ccc_XD0_XDFFM_MFB_XD1_nm XD0_XDFFM_MFB XD1_nm 1.21e-17
* device instance cc_XD0_XDFFM_MFB_XD1_nt r0 *1 0,0
Ccc_XD0_XDFFM_MFB_XD1_nt XD0_XDFFM_MFB XD1_nt 1.21e-17
* device instance cc_XD0_XDFFM_MFB_XD1_t1 r0 *1 0,0
Ccc_XD0_XDFFM_MFB_XD1_t1 XD0_XDFFM_MFB XD1_t1 1.21e-17
* device instance cc_XD0_XDFFM_MFB_XD2_XDFFM_CKBB r0 *1 0,0
Ccc_XD0_XDFFM_MFB_XD2_XDFFM_CKBB XD0_XDFFM_MFB XD2_XDFFM_CKBB 1.8151e-17
* device instance cc_XD0_XDFFM_MFB_XD2_XDFFM_CLKB r0 *1 0,0
Ccc_XD0_XDFFM_MFB_XD2_XDFFM_CLKB XD0_XDFFM_MFB XD2_XDFFM_CLKB 2.4201e-17
* device instance cc_XD0_XDFFM_MFB_XD2_XDFFM_M r0 *1 0,0
Ccc_XD0_XDFFM_MFB_XD2_XDFFM_M XD0_XDFFM_MFB XD2_XDFFM_M 2.4201e-17
* device instance cc_XD0_XDFFM_MFB_XD2_XDFFM_MB r0 *1 0,0
Ccc_XD0_XDFFM_MFB_XD2_XDFFM_MB XD0_XDFFM_MFB XD2_XDFFM_MB 1.21e-17
* device instance cc_XD0_XDFFM_MFB_XD2_XDFFM_MFB r0 *1 0,0
Ccc_XD0_XDFFM_MFB_XD2_XDFFM_MFB XD0_XDFFM_MFB XD2_XDFFM_MFB 1.21e-17
* device instance cc_XD0_XDFFM_MFB_XD2_XDFFM_S r0 *1 0,0
Ccc_XD0_XDFFM_MFB_XD2_XDFFM_S XD0_XDFFM_MFB XD2_XDFFM_S 1.8151e-17
* device instance cc_XD0_XDFFM_MFB_XD2_XDFFM_SB r0 *1 0,0
Ccc_XD0_XDFFM_MFB_XD2_XDFFM_SB XD0_XDFFM_MFB XD2_XDFFM_SB 1.8151e-17
* device instance cc_XD0_XDFFM_MFB_XD2_XDFFM_SFB r0 *1 0,0
Ccc_XD0_XDFFM_MFB_XD2_XDFFM_SFB XD0_XDFFM_MFB XD2_XDFFM_SFB 1.21e-17
* device instance cc_XD0_XDFFM_MFB_XD2_XDFFQ_CKBB r0 *1 0,0
Ccc_XD0_XDFFM_MFB_XD2_XDFFQ_CKBB XD0_XDFFM_MFB XD2_XDFFQ_CKBB 1.8151e-17
* device instance cc_XD0_XDFFM_MFB_XD2_XDFFQ_CLKB r0 *1 0,0
Ccc_XD0_XDFFM_MFB_XD2_XDFFQ_CLKB XD0_XDFFM_MFB XD2_XDFFQ_CLKB 2.4201e-17
* device instance cc_XD0_XDFFM_MFB_XD2_XDFFQ_M r0 *1 0,0
Ccc_XD0_XDFFM_MFB_XD2_XDFFQ_M XD0_XDFFM_MFB XD2_XDFFQ_M 2.4201e-17
* device instance cc_XD0_XDFFM_MFB_XD2_XDFFQ_MB r0 *1 0,0
Ccc_XD0_XDFFM_MFB_XD2_XDFFQ_MB XD0_XDFFM_MFB XD2_XDFFQ_MB 1.21e-17
* device instance cc_XD0_XDFFM_MFB_XD2_XDFFQ_MFB r0 *1 0,0
Ccc_XD0_XDFFM_MFB_XD2_XDFFQ_MFB XD0_XDFFM_MFB XD2_XDFFQ_MFB 1.21e-17
* device instance cc_XD0_XDFFM_MFB_XD2_XDFFQ_S r0 *1 0,0
Ccc_XD0_XDFFM_MFB_XD2_XDFFQ_S XD0_XDFFM_MFB XD2_XDFFQ_S 1.8151e-17
* device instance cc_XD0_XDFFM_MFB_XD2_XDFFQ_SB r0 *1 0,0
Ccc_XD0_XDFFM_MFB_XD2_XDFFQ_SB XD0_XDFFM_MFB XD2_XDFFQ_SB 1.8151e-17
* device instance cc_XD0_XDFFM_MFB_XD2_XDFFQ_SFB r0 *1 0,0
Ccc_XD0_XDFFM_MFB_XD2_XDFFQ_SFB XD0_XDFFM_MFB XD2_XDFFQ_SFB 1.21e-17
* device instance cc_XD0_XDFFM_MFB_XD2_XN2_mid1 r0 *1 0,0
Ccc_XD0_XDFFM_MFB_XD2_XN2_mid1 XD0_XDFFM_MFB XD2_XN2_mid1 1.21e-17
* device instance cc_XD0_XDFFM_MFB_XD2_XN3_mid1 r0 *1 0,0
Ccc_XD0_XDFFM_MFB_XD2_XN3_mid1 XD0_XDFFM_MFB XD2_XN3_mid1 1.21e-17
* device instance cc_XD0_XDFFM_MFB_XD2_XN3_mid2 r0 *1 0,0
Ccc_XD0_XDFFM_MFB_XD2_XN3_mid2 XD0_XDFFM_MFB XD2_XN3_mid2 1.21e-17
* device instance cc_XD0_XDFFM_MFB_XD2_dmodout r0 *1 0,0
Ccc_XD0_XDFFM_MFB_XD2_dmodout XD0_XDFFM_MFB XD2_dmodout 1.21e-17
* device instance cc_XD0_XDFFM_MFB_XD2_dq r0 *1 0,0
Ccc_XD0_XDFFM_MFB_XD2_dq XD0_XDFFM_MFB XD2_dq 1.8151e-17
* device instance cc_XD0_XDFFM_MFB_XD2_nm r0 *1 0,0
Ccc_XD0_XDFFM_MFB_XD2_nm XD0_XDFFM_MFB XD2_nm 1.21e-17
* device instance cc_XD0_XDFFM_MFB_XD2_nt r0 *1 0,0
Ccc_XD0_XDFFM_MFB_XD2_nt XD0_XDFFM_MFB XD2_nt 1.21e-17
* device instance cc_XD0_XDFFM_MFB_XD2_t1 r0 *1 0,0
Ccc_XD0_XDFFM_MFB_XD2_t1 XD0_XDFFM_MFB XD2_t1 1.21e-17
* device instance cc_XD0_XDFFM_MFB_XD3_XDFFM_CKBB r0 *1 0,0
Ccc_XD0_XDFFM_MFB_XD3_XDFFM_CKBB XD0_XDFFM_MFB XD3_XDFFM_CKBB 1.8151e-17
* device instance cc_XD0_XDFFM_MFB_XD3_XDFFM_CLKB r0 *1 0,0
Ccc_XD0_XDFFM_MFB_XD3_XDFFM_CLKB XD0_XDFFM_MFB XD3_XDFFM_CLKB 2.4201e-17
* device instance cc_XD0_XDFFM_MFB_XD3_XDFFM_M r0 *1 0,0
Ccc_XD0_XDFFM_MFB_XD3_XDFFM_M XD0_XDFFM_MFB XD3_XDFFM_M 2.4201e-17
* device instance cc_XD0_XDFFM_MFB_XD3_XDFFM_MB r0 *1 0,0
Ccc_XD0_XDFFM_MFB_XD3_XDFFM_MB XD0_XDFFM_MFB XD3_XDFFM_MB 1.21e-17
* device instance cc_XD0_XDFFM_MFB_XD3_XDFFM_MFB r0 *1 0,0
Ccc_XD0_XDFFM_MFB_XD3_XDFFM_MFB XD0_XDFFM_MFB XD3_XDFFM_MFB 1.21e-17
* device instance cc_XD0_XDFFM_MFB_XD3_XDFFM_S r0 *1 0,0
Ccc_XD0_XDFFM_MFB_XD3_XDFFM_S XD0_XDFFM_MFB XD3_XDFFM_S 1.8151e-17
* device instance cc_XD0_XDFFM_MFB_XD3_XDFFM_SB r0 *1 0,0
Ccc_XD0_XDFFM_MFB_XD3_XDFFM_SB XD0_XDFFM_MFB XD3_XDFFM_SB 1.8151e-17
* device instance cc_XD0_XDFFM_MFB_XD3_XDFFM_SFB r0 *1 0,0
Ccc_XD0_XDFFM_MFB_XD3_XDFFM_SFB XD0_XDFFM_MFB XD3_XDFFM_SFB 1.21e-17
* device instance cc_XD0_XDFFM_MFB_XD3_XDFFQ_CKBB r0 *1 0,0
Ccc_XD0_XDFFM_MFB_XD3_XDFFQ_CKBB XD0_XDFFM_MFB XD3_XDFFQ_CKBB 1.8151e-17
* device instance cc_XD0_XDFFM_MFB_XD3_XDFFQ_CLKB r0 *1 0,0
Ccc_XD0_XDFFM_MFB_XD3_XDFFQ_CLKB XD0_XDFFM_MFB XD3_XDFFQ_CLKB 2.4201e-17
* device instance cc_XD0_XDFFM_MFB_XD3_XDFFQ_M r0 *1 0,0
Ccc_XD0_XDFFM_MFB_XD3_XDFFQ_M XD0_XDFFM_MFB XD3_XDFFQ_M 2.4201e-17
* device instance cc_XD0_XDFFM_MFB_XD3_XDFFQ_MB r0 *1 0,0
Ccc_XD0_XDFFM_MFB_XD3_XDFFQ_MB XD0_XDFFM_MFB XD3_XDFFQ_MB 1.21e-17
* device instance cc_XD0_XDFFM_MFB_XD3_XDFFQ_MFB r0 *1 0,0
Ccc_XD0_XDFFM_MFB_XD3_XDFFQ_MFB XD0_XDFFM_MFB XD3_XDFFQ_MFB 1.21e-17
* device instance cc_XD0_XDFFM_MFB_XD3_XDFFQ_S r0 *1 0,0
Ccc_XD0_XDFFM_MFB_XD3_XDFFQ_S XD0_XDFFM_MFB XD3_XDFFQ_S 1.8151e-17
* device instance cc_XD0_XDFFM_MFB_XD3_XDFFQ_SB r0 *1 0,0
Ccc_XD0_XDFFM_MFB_XD3_XDFFQ_SB XD0_XDFFM_MFB XD3_XDFFQ_SB 1.8151e-17
* device instance cc_XD0_XDFFM_MFB_XD3_XDFFQ_SFB r0 *1 0,0
Ccc_XD0_XDFFM_MFB_XD3_XDFFQ_SFB XD0_XDFFM_MFB XD3_XDFFQ_SFB 1.21e-17
* device instance cc_XD0_XDFFM_MFB_XD3_XN2_mid1 r0 *1 0,0
Ccc_XD0_XDFFM_MFB_XD3_XN2_mid1 XD0_XDFFM_MFB XD3_XN2_mid1 1.21e-17
* device instance cc_XD0_XDFFM_MFB_XD3_XN3_mid1 r0 *1 0,0
Ccc_XD0_XDFFM_MFB_XD3_XN3_mid1 XD0_XDFFM_MFB XD3_XN3_mid1 1.21e-17
* device instance cc_XD0_XDFFM_MFB_XD3_XN3_mid2 r0 *1 0,0
Ccc_XD0_XDFFM_MFB_XD3_XN3_mid2 XD0_XDFFM_MFB XD3_XN3_mid2 1.21e-17
* device instance cc_XD0_XDFFM_MFB_XD3_dmodout r0 *1 0,0
Ccc_XD0_XDFFM_MFB_XD3_dmodout XD0_XDFFM_MFB XD3_dmodout 1.21e-17
* device instance cc_XD0_XDFFM_MFB_XD3_dq r0 *1 0,0
Ccc_XD0_XDFFM_MFB_XD3_dq XD0_XDFFM_MFB XD3_dq 1.8151e-17
* device instance cc_XD0_XDFFM_MFB_XD3_nm r0 *1 0,0
Ccc_XD0_XDFFM_MFB_XD3_nm XD0_XDFFM_MFB XD3_nm 1.21e-17
* device instance cc_XD0_XDFFM_MFB_XD3_nt r0 *1 0,0
Ccc_XD0_XDFFM_MFB_XD3_nt XD0_XDFFM_MFB XD3_nt 1.21e-17
* device instance cc_XD0_XDFFM_MFB_XD3_t1 r0 *1 0,0
Ccc_XD0_XDFFM_MFB_XD3_t1 XD0_XDFFM_MFB XD3_t1 1.21e-17
* device instance cc_XD0_XDFFM_MFB_XD4_XDFFM_CKBB r0 *1 0,0
Ccc_XD0_XDFFM_MFB_XD4_XDFFM_CKBB XD0_XDFFM_MFB XD4_XDFFM_CKBB 1.8151e-17
* device instance cc_XD0_XDFFM_MFB_XD4_XDFFM_CLKB r0 *1 0,0
Ccc_XD0_XDFFM_MFB_XD4_XDFFM_CLKB XD0_XDFFM_MFB XD4_XDFFM_CLKB 2.4201e-17
* device instance cc_XD0_XDFFM_MFB_XD4_XDFFM_M r0 *1 0,0
Ccc_XD0_XDFFM_MFB_XD4_XDFFM_M XD0_XDFFM_MFB XD4_XDFFM_M 2.4201e-17
* device instance cc_XD0_XDFFM_MFB_XD4_XDFFM_MB r0 *1 0,0
Ccc_XD0_XDFFM_MFB_XD4_XDFFM_MB XD0_XDFFM_MFB XD4_XDFFM_MB 1.21e-17
* device instance cc_XD0_XDFFM_MFB_XD4_XDFFM_MFB r0 *1 0,0
Ccc_XD0_XDFFM_MFB_XD4_XDFFM_MFB XD0_XDFFM_MFB XD4_XDFFM_MFB 1.21e-17
* device instance cc_XD0_XDFFM_MFB_XD4_XDFFM_S r0 *1 0,0
Ccc_XD0_XDFFM_MFB_XD4_XDFFM_S XD0_XDFFM_MFB XD4_XDFFM_S 1.8151e-17
* device instance cc_XD0_XDFFM_MFB_XD4_XDFFM_SB r0 *1 0,0
Ccc_XD0_XDFFM_MFB_XD4_XDFFM_SB XD0_XDFFM_MFB XD4_XDFFM_SB 1.8151e-17
* device instance cc_XD0_XDFFM_MFB_XD4_XDFFM_SFB r0 *1 0,0
Ccc_XD0_XDFFM_MFB_XD4_XDFFM_SFB XD0_XDFFM_MFB XD4_XDFFM_SFB 1.21e-17
* device instance cc_XD0_XDFFM_MFB_XD4_XDFFQ_CKBB r0 *1 0,0
Ccc_XD0_XDFFM_MFB_XD4_XDFFQ_CKBB XD0_XDFFM_MFB XD4_XDFFQ_CKBB 1.8151e-17
* device instance cc_XD0_XDFFM_MFB_XD4_XDFFQ_CLKB r0 *1 0,0
Ccc_XD0_XDFFM_MFB_XD4_XDFFQ_CLKB XD0_XDFFM_MFB XD4_XDFFQ_CLKB 2.4201e-17
* device instance cc_XD0_XDFFM_MFB_XD4_XDFFQ_M r0 *1 0,0
Ccc_XD0_XDFFM_MFB_XD4_XDFFQ_M XD0_XDFFM_MFB XD4_XDFFQ_M 2.4201e-17
* device instance cc_XD0_XDFFM_MFB_XD4_XDFFQ_MB r0 *1 0,0
Ccc_XD0_XDFFM_MFB_XD4_XDFFQ_MB XD0_XDFFM_MFB XD4_XDFFQ_MB 1.21e-17
* device instance cc_XD0_XDFFM_MFB_XD4_XDFFQ_MFB r0 *1 0,0
Ccc_XD0_XDFFM_MFB_XD4_XDFFQ_MFB XD0_XDFFM_MFB XD4_XDFFQ_MFB 1.21e-17
* device instance cc_XD0_XDFFM_MFB_XD4_XDFFQ_S r0 *1 0,0
Ccc_XD0_XDFFM_MFB_XD4_XDFFQ_S XD0_XDFFM_MFB XD4_XDFFQ_S 1.8151e-17
* device instance cc_XD0_XDFFM_MFB_XD4_XDFFQ_SB r0 *1 0,0
Ccc_XD0_XDFFM_MFB_XD4_XDFFQ_SB XD0_XDFFM_MFB XD4_XDFFQ_SB 1.8151e-17
* device instance cc_XD0_XDFFM_MFB_XD4_XDFFQ_SFB r0 *1 0,0
Ccc_XD0_XDFFM_MFB_XD4_XDFFQ_SFB XD0_XDFFM_MFB XD4_XDFFQ_SFB 1.21e-17
* device instance cc_XD0_XDFFM_MFB_XD4_XN2_mid1 r0 *1 0,0
Ccc_XD0_XDFFM_MFB_XD4_XN2_mid1 XD0_XDFFM_MFB XD4_XN2_mid1 1.21e-17
* device instance cc_XD0_XDFFM_MFB_XD4_XN3_mid1 r0 *1 0,0
Ccc_XD0_XDFFM_MFB_XD4_XN3_mid1 XD0_XDFFM_MFB XD4_XN3_mid1 1.21e-17
* device instance cc_XD0_XDFFM_MFB_XD4_XN3_mid2 r0 *1 0,0
Ccc_XD0_XDFFM_MFB_XD4_XN3_mid2 XD0_XDFFM_MFB XD4_XN3_mid2 1.21e-17
* device instance cc_XD0_XDFFM_MFB_XD4_dmodout r0 *1 0,0
Ccc_XD0_XDFFM_MFB_XD4_dmodout XD0_XDFFM_MFB XD4_dmodout 1.21e-17
* device instance cc_XD0_XDFFM_MFB_XD4_dq r0 *1 0,0
Ccc_XD0_XDFFM_MFB_XD4_dq XD0_XDFFM_MFB XD4_dq 1.8151e-17
* device instance cc_XD0_XDFFM_MFB_XD4_nm r0 *1 0,0
Ccc_XD0_XDFFM_MFB_XD4_nm XD0_XDFFM_MFB XD4_nm 1.21e-17
* device instance cc_XD0_XDFFM_MFB_XD4_nt r0 *1 0,0
Ccc_XD0_XDFFM_MFB_XD4_nt XD0_XDFFM_MFB XD4_nt 1.21e-17
* device instance cc_XD0_XDFFM_MFB_XD4_t1 r0 *1 0,0
Ccc_XD0_XDFFM_MFB_XD4_t1 XD0_XDFFM_MFB XD4_t1 1.21e-17
* device instance cc_XD0_XDFFM_MFB_XD5_XDFFM_CKBB r0 *1 0,0
Ccc_XD0_XDFFM_MFB_XD5_XDFFM_CKBB XD0_XDFFM_MFB XD5_XDFFM_CKBB 1.8151e-17
* device instance cc_XD0_XDFFM_MFB_XD5_XDFFM_CLKB r0 *1 0,0
Ccc_XD0_XDFFM_MFB_XD5_XDFFM_CLKB XD0_XDFFM_MFB XD5_XDFFM_CLKB 2.4201e-17
* device instance cc_XD0_XDFFM_MFB_XD5_XDFFM_M r0 *1 0,0
Ccc_XD0_XDFFM_MFB_XD5_XDFFM_M XD0_XDFFM_MFB XD5_XDFFM_M 2.4201e-17
* device instance cc_XD0_XDFFM_MFB_XD5_XDFFM_MB r0 *1 0,0
Ccc_XD0_XDFFM_MFB_XD5_XDFFM_MB XD0_XDFFM_MFB XD5_XDFFM_MB 1.21e-17
* device instance cc_XD0_XDFFM_MFB_XD5_XDFFM_MFB r0 *1 0,0
Ccc_XD0_XDFFM_MFB_XD5_XDFFM_MFB XD0_XDFFM_MFB XD5_XDFFM_MFB 1.21e-17
* device instance cc_XD0_XDFFM_MFB_XD5_XDFFM_S r0 *1 0,0
Ccc_XD0_XDFFM_MFB_XD5_XDFFM_S XD0_XDFFM_MFB XD5_XDFFM_S 1.8151e-17
* device instance cc_XD0_XDFFM_MFB_XD5_XDFFM_SB r0 *1 0,0
Ccc_XD0_XDFFM_MFB_XD5_XDFFM_SB XD0_XDFFM_MFB XD5_XDFFM_SB 1.8151e-17
* device instance cc_XD0_XDFFM_MFB_XD5_XDFFM_SFB r0 *1 0,0
Ccc_XD0_XDFFM_MFB_XD5_XDFFM_SFB XD0_XDFFM_MFB XD5_XDFFM_SFB 1.21e-17
* device instance cc_XD0_XDFFM_MFB_XD5_XDFFQ_CKBB r0 *1 0,0
Ccc_XD0_XDFFM_MFB_XD5_XDFFQ_CKBB XD0_XDFFM_MFB XD5_XDFFQ_CKBB 1.8151e-17
* device instance cc_XD0_XDFFM_MFB_XD5_XDFFQ_CLKB r0 *1 0,0
Ccc_XD0_XDFFM_MFB_XD5_XDFFQ_CLKB XD0_XDFFM_MFB XD5_XDFFQ_CLKB 2.4201e-17
* device instance cc_XD0_XDFFM_MFB_XD5_XDFFQ_M r0 *1 0,0
Ccc_XD0_XDFFM_MFB_XD5_XDFFQ_M XD0_XDFFM_MFB XD5_XDFFQ_M 2.4201e-17
* device instance cc_XD0_XDFFM_MFB_XD5_XDFFQ_MB r0 *1 0,0
Ccc_XD0_XDFFM_MFB_XD5_XDFFQ_MB XD0_XDFFM_MFB XD5_XDFFQ_MB 1.21e-17
* device instance cc_XD0_XDFFM_MFB_XD5_XDFFQ_MFB r0 *1 0,0
Ccc_XD0_XDFFM_MFB_XD5_XDFFQ_MFB XD0_XDFFM_MFB XD5_XDFFQ_MFB 1.21e-17
* device instance cc_XD0_XDFFM_MFB_XD5_XDFFQ_S r0 *1 0,0
Ccc_XD0_XDFFM_MFB_XD5_XDFFQ_S XD0_XDFFM_MFB XD5_XDFFQ_S 1.8151e-17
* device instance cc_XD0_XDFFM_MFB_XD5_XDFFQ_SB r0 *1 0,0
Ccc_XD0_XDFFM_MFB_XD5_XDFFQ_SB XD0_XDFFM_MFB XD5_XDFFQ_SB 1.8151e-17
* device instance cc_XD0_XDFFM_MFB_XD5_XDFFQ_SFB r0 *1 0,0
Ccc_XD0_XDFFM_MFB_XD5_XDFFQ_SFB XD0_XDFFM_MFB XD5_XDFFQ_SFB 1.21e-17
* device instance cc_XD0_XDFFM_MFB_XD5_XN2_mid1 r0 *1 0,0
Ccc_XD0_XDFFM_MFB_XD5_XN2_mid1 XD0_XDFFM_MFB XD5_XN2_mid1 1.21e-17
* device instance cc_XD0_XDFFM_MFB_XD5_XN3_mid1 r0 *1 0,0
Ccc_XD0_XDFFM_MFB_XD5_XN3_mid1 XD0_XDFFM_MFB XD5_XN3_mid1 1.21e-17
* device instance cc_XD0_XDFFM_MFB_XD5_XN3_mid2 r0 *1 0,0
Ccc_XD0_XDFFM_MFB_XD5_XN3_mid2 XD0_XDFFM_MFB XD5_XN3_mid2 1.21e-17
* device instance cc_XD0_XDFFM_MFB_XD5_dmodout r0 *1 0,0
Ccc_XD0_XDFFM_MFB_XD5_dmodout XD0_XDFFM_MFB XD5_dmodout 1.21e-17
* device instance cc_XD0_XDFFM_MFB_XD5_dq r0 *1 0,0
Ccc_XD0_XDFFM_MFB_XD5_dq XD0_XDFFM_MFB XD5_dq 1.8151e-17
* device instance cc_XD0_XDFFM_MFB_XD5_nm r0 *1 0,0
Ccc_XD0_XDFFM_MFB_XD5_nm XD0_XDFFM_MFB XD5_nm 1.21e-17
* device instance cc_XD0_XDFFM_MFB_XD5_nt r0 *1 0,0
Ccc_XD0_XDFFM_MFB_XD5_nt XD0_XDFFM_MFB XD5_nt 1.21e-17
* device instance cc_XD0_XDFFM_MFB_XD5_t1 r0 *1 0,0
Ccc_XD0_XDFFM_MFB_XD5_t1 XD0_XDFFM_MFB XD5_t1 1.21e-17
* device instance cc_XD0_XDFFM_MFB_XFRT_CKBB r0 *1 0,0
Ccc_XD0_XDFFM_MFB_XFRT_CKBB XD0_XDFFM_MFB XFRT_CKBB 1.8151e-17
* device instance cc_XD0_XDFFM_MFB_XFRT_CLKB r0 *1 0,0
Ccc_XD0_XDFFM_MFB_XFRT_CLKB XD0_XDFFM_MFB XFRT_CLKB 2.4201e-17
* device instance cc_XD0_XDFFM_MFB_XFRT_M r0 *1 0,0
Ccc_XD0_XDFFM_MFB_XFRT_M XD0_XDFFM_MFB XFRT_M 2.4201e-17
* device instance cc_XD0_XDFFM_MFB_XFRT_MB r0 *1 0,0
Ccc_XD0_XDFFM_MFB_XFRT_MB XD0_XDFFM_MFB XFRT_MB 1.21e-17
* device instance cc_XD0_XDFFM_MFB_XFRT_MFB r0 *1 0,0
Ccc_XD0_XDFFM_MFB_XFRT_MFB XD0_XDFFM_MFB XFRT_MFB 1.21e-17
* device instance cc_XD0_XDFFM_MFB_XFRT_S r0 *1 0,0
Ccc_XD0_XDFFM_MFB_XFRT_S XD0_XDFFM_MFB XFRT_S 1.8151e-17
* device instance cc_XD0_XDFFM_MFB_XFRT_SB r0 *1 0,0
Ccc_XD0_XDFFM_MFB_XFRT_SB XD0_XDFFM_MFB XFRT_SB 1.8151e-17
* device instance cc_XD0_XDFFM_MFB_XFRT_SFB r0 *1 0,0
Ccc_XD0_XDFFM_MFB_XFRT_SFB XD0_XDFFM_MFB XFRT_SFB 1.21e-17
* device instance cc_XD0_XDFFM_MFB_ck1 r0 *1 0,0
Ccc_XD0_XDFFM_MFB_ck1 XD0_XDFFM_MFB ck1 3.0251e-17
* device instance cc_XD0_XDFFM_MFB_ck2 r0 *1 0,0
Ccc_XD0_XDFFM_MFB_ck2 XD0_XDFFM_MFB ck2 3.0251e-17
* device instance cc_XD0_XDFFM_MFB_ck3 r0 *1 0,0
Ccc_XD0_XDFFM_MFB_ck3 XD0_XDFFM_MFB ck3 3.0251e-17
* device instance cc_XD0_XDFFM_MFB_ck4 r0 *1 0,0
Ccc_XD0_XDFFM_MFB_ck4 XD0_XDFFM_MFB ck4 3.0251e-17
* device instance cc_XD0_XDFFM_MFB_ck5 r0 *1 0,0
Ccc_XD0_XDFFM_MFB_ck5 XD0_XDFFM_MFB ck5 3.0251e-17
* device instance cc_XD0_XDFFM_MFB_mod0 r0 *1 0,0
Ccc_XD0_XDFFM_MFB_mod0 XD0_XDFFM_MFB mod0 2.4201e-17
* device instance cc_XD0_XDFFM_MFB_mod1 r0 *1 0,0
Ccc_XD0_XDFFM_MFB_mod1 XD0_XDFFM_MFB mod1 2.4201e-17
* device instance cc_XD0_XDFFM_MFB_mod2 r0 *1 0,0
Ccc_XD0_XDFFM_MFB_mod2 XD0_XDFFM_MFB mod2 2.4201e-17
* device instance cc_XD0_XDFFM_MFB_mod3 r0 *1 0,0
Ccc_XD0_XDFFM_MFB_mod3 XD0_XDFFM_MFB mod3 2.4201e-17
* device instance cc_XD0_XDFFM_MFB_mod4 r0 *1 0,0
Ccc_XD0_XDFFM_MFB_mod4 XD0_XDFFM_MFB mod4 2.4201e-17
* device instance cc_XD0_XDFFM_MFB_net1 r0 *1 0,0
Ccc_XD0_XDFFM_MFB_net1 XD0_XDFFM_MFB net1 1.21e-17
* device instance cc_XD0_XDFFM_S_XD0_XDFFM_SB r0 *1 0,0
Ccc_XD0_XDFFM_S_XD0_XDFFM_SB XD0_XDFFM_S XD0_XDFFM_SB 3.0251e-17
* device instance cc_XD0_XDFFM_S_XD0_XDFFM_SFB r0 *1 0,0
Ccc_XD0_XDFFM_S_XD0_XDFFM_SFB XD0_XDFFM_S XD0_XDFFM_SFB 3.4688e-17
* device instance cc_XD0_XDFFM_S_XD0_XDFFQ_CKBB r0 *1 0,0
Ccc_XD0_XDFFM_S_XD0_XDFFQ_CKBB XD0_XDFFM_S XD0_XDFFQ_CKBB 1.8151e-17
* device instance cc_XD0_XDFFM_S_XD0_XDFFQ_CLKB r0 *1 0,0
Ccc_XD0_XDFFM_S_XD0_XDFFQ_CLKB XD0_XDFFM_S XD0_XDFFQ_CLKB 2.4201e-17
* device instance cc_XD0_XDFFM_S_XD0_XDFFQ_M r0 *1 0,0
Ccc_XD0_XDFFM_S_XD0_XDFFQ_M XD0_XDFFM_S XD0_XDFFQ_M 2.4201e-17
* device instance cc_XD0_XDFFM_S_XD0_XDFFQ_MB r0 *1 0,0
Ccc_XD0_XDFFM_S_XD0_XDFFQ_MB XD0_XDFFM_S XD0_XDFFQ_MB 1.21e-17
* device instance cc_XD0_XDFFM_S_XD0_XDFFQ_MFB r0 *1 0,0
Ccc_XD0_XDFFM_S_XD0_XDFFQ_MFB XD0_XDFFM_S XD0_XDFFQ_MFB 1.21e-17
* device instance cc_XD0_XDFFM_S_XD0_XDFFQ_S r0 *1 0,0
Ccc_XD0_XDFFM_S_XD0_XDFFQ_S XD0_XDFFM_S XD0_XDFFQ_S 1.8151e-17
* device instance cc_XD0_XDFFM_S_XD0_XDFFQ_SB r0 *1 0,0
Ccc_XD0_XDFFM_S_XD0_XDFFQ_SB XD0_XDFFM_S XD0_XDFFQ_SB 1.8151e-17
* device instance cc_XD0_XDFFM_S_XD0_XDFFQ_SFB r0 *1 0,0
Ccc_XD0_XDFFM_S_XD0_XDFFQ_SFB XD0_XDFFM_S XD0_XDFFQ_SFB 1.21e-17
* device instance cc_XD0_XDFFM_S_XD0_XNOR_midp r0 *1 0,0
Ccc_XD0_XDFFM_S_XD0_XNOR_midp XD0_XDFFM_S XD0_XNOR_midp 1.21e-17
* device instance cc_XD0_XDFFM_S_XD0_dmodout r0 *1 0,0
Ccc_XD0_XDFFM_S_XD0_dmodout XD0_XDFFM_S XD0_dmodout 1.21e-17
* device instance cc_XD0_XDFFM_S_XD0_dq r0 *1 0,0
Ccc_XD0_XDFFM_S_XD0_dq XD0_XDFFM_S XD0_dq 1.21e-17
* device instance cc_XD0_XDFFM_S_XD0_nm r0 *1 0,0
Ccc_XD0_XDFFM_S_XD0_nm XD0_XDFFM_S XD0_nm 1.8151e-17
* device instance cc_XD0_XDFFM_S_XD0_nt r0 *1 0,0
Ccc_XD0_XDFFM_S_XD0_nt XD0_XDFFM_S XD0_nt 2.4201e-17
* device instance cc_XD0_XDFFM_S_XD0_t1 r0 *1 0,0
Ccc_XD0_XDFFM_S_XD0_t1 XD0_XDFFM_S XD0_t1 1.21e-17
* device instance cc_XD0_XDFFM_S_XD1_XDFFM_CKBB r0 *1 0,0
Ccc_XD0_XDFFM_S_XD1_XDFFM_CKBB XD0_XDFFM_S XD1_XDFFM_CKBB 1.8151e-17
* device instance cc_XD0_XDFFM_S_XD1_XDFFM_CLKB r0 *1 0,0
Ccc_XD0_XDFFM_S_XD1_XDFFM_CLKB XD0_XDFFM_S XD1_XDFFM_CLKB 2.4201e-17
* device instance cc_XD0_XDFFM_S_XD1_XDFFM_M r0 *1 0,0
Ccc_XD0_XDFFM_S_XD1_XDFFM_M XD0_XDFFM_S XD1_XDFFM_M 2.4201e-17
* device instance cc_XD0_XDFFM_S_XD1_XDFFM_MB r0 *1 0,0
Ccc_XD0_XDFFM_S_XD1_XDFFM_MB XD0_XDFFM_S XD1_XDFFM_MB 1.21e-17
* device instance cc_XD0_XDFFM_S_XD1_XDFFM_MFB r0 *1 0,0
Ccc_XD0_XDFFM_S_XD1_XDFFM_MFB XD0_XDFFM_S XD1_XDFFM_MFB 1.21e-17
* device instance cc_XD0_XDFFM_S_XD1_XDFFM_S r0 *1 0,0
Ccc_XD0_XDFFM_S_XD1_XDFFM_S XD0_XDFFM_S XD1_XDFFM_S 1.8151e-17
* device instance cc_XD0_XDFFM_S_XD1_XDFFM_SB r0 *1 0,0
Ccc_XD0_XDFFM_S_XD1_XDFFM_SB XD0_XDFFM_S XD1_XDFFM_SB 1.8151e-17
* device instance cc_XD0_XDFFM_S_XD1_XDFFM_SFB r0 *1 0,0
Ccc_XD0_XDFFM_S_XD1_XDFFM_SFB XD0_XDFFM_S XD1_XDFFM_SFB 1.21e-17
* device instance cc_XD0_XDFFM_S_XD1_XDFFQ_CKBB r0 *1 0,0
Ccc_XD0_XDFFM_S_XD1_XDFFQ_CKBB XD0_XDFFM_S XD1_XDFFQ_CKBB 1.8151e-17
* device instance cc_XD0_XDFFM_S_XD1_XDFFQ_CLKB r0 *1 0,0
Ccc_XD0_XDFFM_S_XD1_XDFFQ_CLKB XD0_XDFFM_S XD1_XDFFQ_CLKB 2.4201e-17
* device instance cc_XD0_XDFFM_S_XD1_XDFFQ_M r0 *1 0,0
Ccc_XD0_XDFFM_S_XD1_XDFFQ_M XD0_XDFFM_S XD1_XDFFQ_M 2.4201e-17
* device instance cc_XD0_XDFFM_S_XD1_XDFFQ_MB r0 *1 0,0
Ccc_XD0_XDFFM_S_XD1_XDFFQ_MB XD0_XDFFM_S XD1_XDFFQ_MB 1.21e-17
* device instance cc_XD0_XDFFM_S_XD1_XDFFQ_MFB r0 *1 0,0
Ccc_XD0_XDFFM_S_XD1_XDFFQ_MFB XD0_XDFFM_S XD1_XDFFQ_MFB 1.21e-17
* device instance cc_XD0_XDFFM_S_XD1_XDFFQ_S r0 *1 0,0
Ccc_XD0_XDFFM_S_XD1_XDFFQ_S XD0_XDFFM_S XD1_XDFFQ_S 1.8151e-17
* device instance cc_XD0_XDFFM_S_XD1_XDFFQ_SB r0 *1 0,0
Ccc_XD0_XDFFM_S_XD1_XDFFQ_SB XD0_XDFFM_S XD1_XDFFQ_SB 1.8151e-17
* device instance cc_XD0_XDFFM_S_XD1_XDFFQ_SFB r0 *1 0,0
Ccc_XD0_XDFFM_S_XD1_XDFFQ_SFB XD0_XDFFM_S XD1_XDFFQ_SFB 1.21e-17
* device instance cc_XD0_XDFFM_S_XD1_XN2_mid1 r0 *1 0,0
Ccc_XD0_XDFFM_S_XD1_XN2_mid1 XD0_XDFFM_S XD1_XN2_mid1 1.21e-17
* device instance cc_XD0_XDFFM_S_XD1_XN3_mid1 r0 *1 0,0
Ccc_XD0_XDFFM_S_XD1_XN3_mid1 XD0_XDFFM_S XD1_XN3_mid1 1.21e-17
* device instance cc_XD0_XDFFM_S_XD1_XN3_mid2 r0 *1 0,0
Ccc_XD0_XDFFM_S_XD1_XN3_mid2 XD0_XDFFM_S XD1_XN3_mid2 1.21e-17
* device instance cc_XD0_XDFFM_S_XD1_dmodout r0 *1 0,0
Ccc_XD0_XDFFM_S_XD1_dmodout XD0_XDFFM_S XD1_dmodout 1.21e-17
* device instance cc_XD0_XDFFM_S_XD1_dq r0 *1 0,0
Ccc_XD0_XDFFM_S_XD1_dq XD0_XDFFM_S XD1_dq 1.8151e-17
* device instance cc_XD0_XDFFM_S_XD1_nm r0 *1 0,0
Ccc_XD0_XDFFM_S_XD1_nm XD0_XDFFM_S XD1_nm 1.21e-17
* device instance cc_XD0_XDFFM_S_XD1_nt r0 *1 0,0
Ccc_XD0_XDFFM_S_XD1_nt XD0_XDFFM_S XD1_nt 1.21e-17
* device instance cc_XD0_XDFFM_S_XD1_t1 r0 *1 0,0
Ccc_XD0_XDFFM_S_XD1_t1 XD0_XDFFM_S XD1_t1 1.21e-17
* device instance cc_XD0_XDFFM_S_XD2_XDFFM_CKBB r0 *1 0,0
Ccc_XD0_XDFFM_S_XD2_XDFFM_CKBB XD0_XDFFM_S XD2_XDFFM_CKBB 1.8151e-17
* device instance cc_XD0_XDFFM_S_XD2_XDFFM_CLKB r0 *1 0,0
Ccc_XD0_XDFFM_S_XD2_XDFFM_CLKB XD0_XDFFM_S XD2_XDFFM_CLKB 2.4201e-17
* device instance cc_XD0_XDFFM_S_XD2_XDFFM_M r0 *1 0,0
Ccc_XD0_XDFFM_S_XD2_XDFFM_M XD0_XDFFM_S XD2_XDFFM_M 2.4201e-17
* device instance cc_XD0_XDFFM_S_XD2_XDFFM_MB r0 *1 0,0
Ccc_XD0_XDFFM_S_XD2_XDFFM_MB XD0_XDFFM_S XD2_XDFFM_MB 1.21e-17
* device instance cc_XD0_XDFFM_S_XD2_XDFFM_MFB r0 *1 0,0
Ccc_XD0_XDFFM_S_XD2_XDFFM_MFB XD0_XDFFM_S XD2_XDFFM_MFB 1.21e-17
* device instance cc_XD0_XDFFM_S_XD2_XDFFM_S r0 *1 0,0
Ccc_XD0_XDFFM_S_XD2_XDFFM_S XD0_XDFFM_S XD2_XDFFM_S 1.8151e-17
* device instance cc_XD0_XDFFM_S_XD2_XDFFM_SB r0 *1 0,0
Ccc_XD0_XDFFM_S_XD2_XDFFM_SB XD0_XDFFM_S XD2_XDFFM_SB 1.8151e-17
* device instance cc_XD0_XDFFM_S_XD2_XDFFM_SFB r0 *1 0,0
Ccc_XD0_XDFFM_S_XD2_XDFFM_SFB XD0_XDFFM_S XD2_XDFFM_SFB 1.21e-17
* device instance cc_XD0_XDFFM_S_XD2_XDFFQ_CKBB r0 *1 0,0
Ccc_XD0_XDFFM_S_XD2_XDFFQ_CKBB XD0_XDFFM_S XD2_XDFFQ_CKBB 1.8151e-17
* device instance cc_XD0_XDFFM_S_XD2_XDFFQ_CLKB r0 *1 0,0
Ccc_XD0_XDFFM_S_XD2_XDFFQ_CLKB XD0_XDFFM_S XD2_XDFFQ_CLKB 2.4201e-17
* device instance cc_XD0_XDFFM_S_XD2_XDFFQ_M r0 *1 0,0
Ccc_XD0_XDFFM_S_XD2_XDFFQ_M XD0_XDFFM_S XD2_XDFFQ_M 2.4201e-17
* device instance cc_XD0_XDFFM_S_XD2_XDFFQ_MB r0 *1 0,0
Ccc_XD0_XDFFM_S_XD2_XDFFQ_MB XD0_XDFFM_S XD2_XDFFQ_MB 1.21e-17
* device instance cc_XD0_XDFFM_S_XD2_XDFFQ_MFB r0 *1 0,0
Ccc_XD0_XDFFM_S_XD2_XDFFQ_MFB XD0_XDFFM_S XD2_XDFFQ_MFB 1.21e-17
* device instance cc_XD0_XDFFM_S_XD2_XDFFQ_S r0 *1 0,0
Ccc_XD0_XDFFM_S_XD2_XDFFQ_S XD0_XDFFM_S XD2_XDFFQ_S 1.8151e-17
* device instance cc_XD0_XDFFM_S_XD2_XDFFQ_SB r0 *1 0,0
Ccc_XD0_XDFFM_S_XD2_XDFFQ_SB XD0_XDFFM_S XD2_XDFFQ_SB 1.8151e-17
* device instance cc_XD0_XDFFM_S_XD2_XDFFQ_SFB r0 *1 0,0
Ccc_XD0_XDFFM_S_XD2_XDFFQ_SFB XD0_XDFFM_S XD2_XDFFQ_SFB 1.21e-17
* device instance cc_XD0_XDFFM_S_XD2_XN2_mid1 r0 *1 0,0
Ccc_XD0_XDFFM_S_XD2_XN2_mid1 XD0_XDFFM_S XD2_XN2_mid1 1.21e-17
* device instance cc_XD0_XDFFM_S_XD2_XN3_mid1 r0 *1 0,0
Ccc_XD0_XDFFM_S_XD2_XN3_mid1 XD0_XDFFM_S XD2_XN3_mid1 1.21e-17
* device instance cc_XD0_XDFFM_S_XD2_XN3_mid2 r0 *1 0,0
Ccc_XD0_XDFFM_S_XD2_XN3_mid2 XD0_XDFFM_S XD2_XN3_mid2 1.21e-17
* device instance cc_XD0_XDFFM_S_XD2_dmodout r0 *1 0,0
Ccc_XD0_XDFFM_S_XD2_dmodout XD0_XDFFM_S XD2_dmodout 1.21e-17
* device instance cc_XD0_XDFFM_S_XD2_dq r0 *1 0,0
Ccc_XD0_XDFFM_S_XD2_dq XD0_XDFFM_S XD2_dq 1.8151e-17
* device instance cc_XD0_XDFFM_S_XD2_nm r0 *1 0,0
Ccc_XD0_XDFFM_S_XD2_nm XD0_XDFFM_S XD2_nm 1.21e-17
* device instance cc_XD0_XDFFM_S_XD2_nt r0 *1 0,0
Ccc_XD0_XDFFM_S_XD2_nt XD0_XDFFM_S XD2_nt 1.21e-17
* device instance cc_XD0_XDFFM_S_XD2_t1 r0 *1 0,0
Ccc_XD0_XDFFM_S_XD2_t1 XD0_XDFFM_S XD2_t1 1.21e-17
* device instance cc_XD0_XDFFM_S_XD3_XDFFM_CKBB r0 *1 0,0
Ccc_XD0_XDFFM_S_XD3_XDFFM_CKBB XD0_XDFFM_S XD3_XDFFM_CKBB 1.8151e-17
* device instance cc_XD0_XDFFM_S_XD3_XDFFM_CLKB r0 *1 0,0
Ccc_XD0_XDFFM_S_XD3_XDFFM_CLKB XD0_XDFFM_S XD3_XDFFM_CLKB 2.4201e-17
* device instance cc_XD0_XDFFM_S_XD3_XDFFM_M r0 *1 0,0
Ccc_XD0_XDFFM_S_XD3_XDFFM_M XD0_XDFFM_S XD3_XDFFM_M 2.4201e-17
* device instance cc_XD0_XDFFM_S_XD3_XDFFM_MB r0 *1 0,0
Ccc_XD0_XDFFM_S_XD3_XDFFM_MB XD0_XDFFM_S XD3_XDFFM_MB 1.21e-17
* device instance cc_XD0_XDFFM_S_XD3_XDFFM_MFB r0 *1 0,0
Ccc_XD0_XDFFM_S_XD3_XDFFM_MFB XD0_XDFFM_S XD3_XDFFM_MFB 1.21e-17
* device instance cc_XD0_XDFFM_S_XD3_XDFFM_S r0 *1 0,0
Ccc_XD0_XDFFM_S_XD3_XDFFM_S XD0_XDFFM_S XD3_XDFFM_S 1.8151e-17
* device instance cc_XD0_XDFFM_S_XD3_XDFFM_SB r0 *1 0,0
Ccc_XD0_XDFFM_S_XD3_XDFFM_SB XD0_XDFFM_S XD3_XDFFM_SB 1.8151e-17
* device instance cc_XD0_XDFFM_S_XD3_XDFFM_SFB r0 *1 0,0
Ccc_XD0_XDFFM_S_XD3_XDFFM_SFB XD0_XDFFM_S XD3_XDFFM_SFB 1.21e-17
* device instance cc_XD0_XDFFM_S_XD3_XDFFQ_CKBB r0 *1 0,0
Ccc_XD0_XDFFM_S_XD3_XDFFQ_CKBB XD0_XDFFM_S XD3_XDFFQ_CKBB 1.8151e-17
* device instance cc_XD0_XDFFM_S_XD3_XDFFQ_CLKB r0 *1 0,0
Ccc_XD0_XDFFM_S_XD3_XDFFQ_CLKB XD0_XDFFM_S XD3_XDFFQ_CLKB 2.4201e-17
* device instance cc_XD0_XDFFM_S_XD3_XDFFQ_M r0 *1 0,0
Ccc_XD0_XDFFM_S_XD3_XDFFQ_M XD0_XDFFM_S XD3_XDFFQ_M 2.4201e-17
* device instance cc_XD0_XDFFM_S_XD3_XDFFQ_MB r0 *1 0,0
Ccc_XD0_XDFFM_S_XD3_XDFFQ_MB XD0_XDFFM_S XD3_XDFFQ_MB 1.21e-17
* device instance cc_XD0_XDFFM_S_XD3_XDFFQ_MFB r0 *1 0,0
Ccc_XD0_XDFFM_S_XD3_XDFFQ_MFB XD0_XDFFM_S XD3_XDFFQ_MFB 1.21e-17
* device instance cc_XD0_XDFFM_S_XD3_XDFFQ_S r0 *1 0,0
Ccc_XD0_XDFFM_S_XD3_XDFFQ_S XD0_XDFFM_S XD3_XDFFQ_S 1.8151e-17
* device instance cc_XD0_XDFFM_S_XD3_XDFFQ_SB r0 *1 0,0
Ccc_XD0_XDFFM_S_XD3_XDFFQ_SB XD0_XDFFM_S XD3_XDFFQ_SB 1.8151e-17
* device instance cc_XD0_XDFFM_S_XD3_XDFFQ_SFB r0 *1 0,0
Ccc_XD0_XDFFM_S_XD3_XDFFQ_SFB XD0_XDFFM_S XD3_XDFFQ_SFB 1.21e-17
* device instance cc_XD0_XDFFM_S_XD3_XN2_mid1 r0 *1 0,0
Ccc_XD0_XDFFM_S_XD3_XN2_mid1 XD0_XDFFM_S XD3_XN2_mid1 1.21e-17
* device instance cc_XD0_XDFFM_S_XD3_XN3_mid1 r0 *1 0,0
Ccc_XD0_XDFFM_S_XD3_XN3_mid1 XD0_XDFFM_S XD3_XN3_mid1 1.21e-17
* device instance cc_XD0_XDFFM_S_XD3_XN3_mid2 r0 *1 0,0
Ccc_XD0_XDFFM_S_XD3_XN3_mid2 XD0_XDFFM_S XD3_XN3_mid2 1.21e-17
* device instance cc_XD0_XDFFM_S_XD3_dmodout r0 *1 0,0
Ccc_XD0_XDFFM_S_XD3_dmodout XD0_XDFFM_S XD3_dmodout 1.21e-17
* device instance cc_XD0_XDFFM_S_XD3_dq r0 *1 0,0
Ccc_XD0_XDFFM_S_XD3_dq XD0_XDFFM_S XD3_dq 1.8151e-17
* device instance cc_XD0_XDFFM_S_XD3_nm r0 *1 0,0
Ccc_XD0_XDFFM_S_XD3_nm XD0_XDFFM_S XD3_nm 1.21e-17
* device instance cc_XD0_XDFFM_S_XD3_nt r0 *1 0,0
Ccc_XD0_XDFFM_S_XD3_nt XD0_XDFFM_S XD3_nt 1.21e-17
* device instance cc_XD0_XDFFM_S_XD3_t1 r0 *1 0,0
Ccc_XD0_XDFFM_S_XD3_t1 XD0_XDFFM_S XD3_t1 1.21e-17
* device instance cc_XD0_XDFFM_S_XD4_XDFFM_CKBB r0 *1 0,0
Ccc_XD0_XDFFM_S_XD4_XDFFM_CKBB XD0_XDFFM_S XD4_XDFFM_CKBB 1.8151e-17
* device instance cc_XD0_XDFFM_S_XD4_XDFFM_CLKB r0 *1 0,0
Ccc_XD0_XDFFM_S_XD4_XDFFM_CLKB XD0_XDFFM_S XD4_XDFFM_CLKB 2.4201e-17
* device instance cc_XD0_XDFFM_S_XD4_XDFFM_M r0 *1 0,0
Ccc_XD0_XDFFM_S_XD4_XDFFM_M XD0_XDFFM_S XD4_XDFFM_M 2.4201e-17
* device instance cc_XD0_XDFFM_S_XD4_XDFFM_MB r0 *1 0,0
Ccc_XD0_XDFFM_S_XD4_XDFFM_MB XD0_XDFFM_S XD4_XDFFM_MB 1.21e-17
* device instance cc_XD0_XDFFM_S_XD4_XDFFM_MFB r0 *1 0,0
Ccc_XD0_XDFFM_S_XD4_XDFFM_MFB XD0_XDFFM_S XD4_XDFFM_MFB 1.21e-17
* device instance cc_XD0_XDFFM_S_XD4_XDFFM_S r0 *1 0,0
Ccc_XD0_XDFFM_S_XD4_XDFFM_S XD0_XDFFM_S XD4_XDFFM_S 1.8151e-17
* device instance cc_XD0_XDFFM_S_XD4_XDFFM_SB r0 *1 0,0
Ccc_XD0_XDFFM_S_XD4_XDFFM_SB XD0_XDFFM_S XD4_XDFFM_SB 1.8151e-17
* device instance cc_XD0_XDFFM_S_XD4_XDFFM_SFB r0 *1 0,0
Ccc_XD0_XDFFM_S_XD4_XDFFM_SFB XD0_XDFFM_S XD4_XDFFM_SFB 1.21e-17
* device instance cc_XD0_XDFFM_S_XD4_XDFFQ_CKBB r0 *1 0,0
Ccc_XD0_XDFFM_S_XD4_XDFFQ_CKBB XD0_XDFFM_S XD4_XDFFQ_CKBB 1.8151e-17
* device instance cc_XD0_XDFFM_S_XD4_XDFFQ_CLKB r0 *1 0,0
Ccc_XD0_XDFFM_S_XD4_XDFFQ_CLKB XD0_XDFFM_S XD4_XDFFQ_CLKB 2.4201e-17
* device instance cc_XD0_XDFFM_S_XD4_XDFFQ_M r0 *1 0,0
Ccc_XD0_XDFFM_S_XD4_XDFFQ_M XD0_XDFFM_S XD4_XDFFQ_M 2.4201e-17
* device instance cc_XD0_XDFFM_S_XD4_XDFFQ_MB r0 *1 0,0
Ccc_XD0_XDFFM_S_XD4_XDFFQ_MB XD0_XDFFM_S XD4_XDFFQ_MB 1.21e-17
* device instance cc_XD0_XDFFM_S_XD4_XDFFQ_MFB r0 *1 0,0
Ccc_XD0_XDFFM_S_XD4_XDFFQ_MFB XD0_XDFFM_S XD4_XDFFQ_MFB 1.21e-17
* device instance cc_XD0_XDFFM_S_XD4_XDFFQ_S r0 *1 0,0
Ccc_XD0_XDFFM_S_XD4_XDFFQ_S XD0_XDFFM_S XD4_XDFFQ_S 1.8151e-17
* device instance cc_XD0_XDFFM_S_XD4_XDFFQ_SB r0 *1 0,0
Ccc_XD0_XDFFM_S_XD4_XDFFQ_SB XD0_XDFFM_S XD4_XDFFQ_SB 1.8151e-17
* device instance cc_XD0_XDFFM_S_XD4_XDFFQ_SFB r0 *1 0,0
Ccc_XD0_XDFFM_S_XD4_XDFFQ_SFB XD0_XDFFM_S XD4_XDFFQ_SFB 1.21e-17
* device instance cc_XD0_XDFFM_S_XD4_XN2_mid1 r0 *1 0,0
Ccc_XD0_XDFFM_S_XD4_XN2_mid1 XD0_XDFFM_S XD4_XN2_mid1 1.21e-17
* device instance cc_XD0_XDFFM_S_XD4_XN3_mid1 r0 *1 0,0
Ccc_XD0_XDFFM_S_XD4_XN3_mid1 XD0_XDFFM_S XD4_XN3_mid1 1.21e-17
* device instance cc_XD0_XDFFM_S_XD4_XN3_mid2 r0 *1 0,0
Ccc_XD0_XDFFM_S_XD4_XN3_mid2 XD0_XDFFM_S XD4_XN3_mid2 1.21e-17
* device instance cc_XD0_XDFFM_S_XD4_dmodout r0 *1 0,0
Ccc_XD0_XDFFM_S_XD4_dmodout XD0_XDFFM_S XD4_dmodout 1.21e-17
* device instance cc_XD0_XDFFM_S_XD4_dq r0 *1 0,0
Ccc_XD0_XDFFM_S_XD4_dq XD0_XDFFM_S XD4_dq 1.8151e-17
* device instance cc_XD0_XDFFM_S_XD4_nm r0 *1 0,0
Ccc_XD0_XDFFM_S_XD4_nm XD0_XDFFM_S XD4_nm 1.21e-17
* device instance cc_XD0_XDFFM_S_XD4_nt r0 *1 0,0
Ccc_XD0_XDFFM_S_XD4_nt XD0_XDFFM_S XD4_nt 1.21e-17
* device instance cc_XD0_XDFFM_S_XD4_t1 r0 *1 0,0
Ccc_XD0_XDFFM_S_XD4_t1 XD0_XDFFM_S XD4_t1 1.21e-17
* device instance cc_XD0_XDFFM_S_XD5_XDFFM_CKBB r0 *1 0,0
Ccc_XD0_XDFFM_S_XD5_XDFFM_CKBB XD0_XDFFM_S XD5_XDFFM_CKBB 1.8151e-17
* device instance cc_XD0_XDFFM_S_XD5_XDFFM_CLKB r0 *1 0,0
Ccc_XD0_XDFFM_S_XD5_XDFFM_CLKB XD0_XDFFM_S XD5_XDFFM_CLKB 2.4201e-17
* device instance cc_XD0_XDFFM_S_XD5_XDFFM_M r0 *1 0,0
Ccc_XD0_XDFFM_S_XD5_XDFFM_M XD0_XDFFM_S XD5_XDFFM_M 2.4201e-17
* device instance cc_XD0_XDFFM_S_XD5_XDFFM_MB r0 *1 0,0
Ccc_XD0_XDFFM_S_XD5_XDFFM_MB XD0_XDFFM_S XD5_XDFFM_MB 1.21e-17
* device instance cc_XD0_XDFFM_S_XD5_XDFFM_MFB r0 *1 0,0
Ccc_XD0_XDFFM_S_XD5_XDFFM_MFB XD0_XDFFM_S XD5_XDFFM_MFB 1.21e-17
* device instance cc_XD0_XDFFM_S_XD5_XDFFM_S r0 *1 0,0
Ccc_XD0_XDFFM_S_XD5_XDFFM_S XD0_XDFFM_S XD5_XDFFM_S 1.8151e-17
* device instance cc_XD0_XDFFM_S_XD5_XDFFM_SB r0 *1 0,0
Ccc_XD0_XDFFM_S_XD5_XDFFM_SB XD0_XDFFM_S XD5_XDFFM_SB 1.8151e-17
* device instance cc_XD0_XDFFM_S_XD5_XDFFM_SFB r0 *1 0,0
Ccc_XD0_XDFFM_S_XD5_XDFFM_SFB XD0_XDFFM_S XD5_XDFFM_SFB 1.21e-17
* device instance cc_XD0_XDFFM_S_XD5_XDFFQ_CKBB r0 *1 0,0
Ccc_XD0_XDFFM_S_XD5_XDFFQ_CKBB XD0_XDFFM_S XD5_XDFFQ_CKBB 1.8151e-17
* device instance cc_XD0_XDFFM_S_XD5_XDFFQ_CLKB r0 *1 0,0
Ccc_XD0_XDFFM_S_XD5_XDFFQ_CLKB XD0_XDFFM_S XD5_XDFFQ_CLKB 2.4201e-17
* device instance cc_XD0_XDFFM_S_XD5_XDFFQ_M r0 *1 0,0
Ccc_XD0_XDFFM_S_XD5_XDFFQ_M XD0_XDFFM_S XD5_XDFFQ_M 2.4201e-17
* device instance cc_XD0_XDFFM_S_XD5_XDFFQ_MB r0 *1 0,0
Ccc_XD0_XDFFM_S_XD5_XDFFQ_MB XD0_XDFFM_S XD5_XDFFQ_MB 1.21e-17
* device instance cc_XD0_XDFFM_S_XD5_XDFFQ_MFB r0 *1 0,0
Ccc_XD0_XDFFM_S_XD5_XDFFQ_MFB XD0_XDFFM_S XD5_XDFFQ_MFB 1.21e-17
* device instance cc_XD0_XDFFM_S_XD5_XDFFQ_S r0 *1 0,0
Ccc_XD0_XDFFM_S_XD5_XDFFQ_S XD0_XDFFM_S XD5_XDFFQ_S 1.8151e-17
* device instance cc_XD0_XDFFM_S_XD5_XDFFQ_SB r0 *1 0,0
Ccc_XD0_XDFFM_S_XD5_XDFFQ_SB XD0_XDFFM_S XD5_XDFFQ_SB 1.8151e-17
* device instance cc_XD0_XDFFM_S_XD5_XDFFQ_SFB r0 *1 0,0
Ccc_XD0_XDFFM_S_XD5_XDFFQ_SFB XD0_XDFFM_S XD5_XDFFQ_SFB 1.21e-17
* device instance cc_XD0_XDFFM_S_XD5_XN2_mid1 r0 *1 0,0
Ccc_XD0_XDFFM_S_XD5_XN2_mid1 XD0_XDFFM_S XD5_XN2_mid1 1.21e-17
* device instance cc_XD0_XDFFM_S_XD5_XN3_mid1 r0 *1 0,0
Ccc_XD0_XDFFM_S_XD5_XN3_mid1 XD0_XDFFM_S XD5_XN3_mid1 1.21e-17
* device instance cc_XD0_XDFFM_S_XD5_XN3_mid2 r0 *1 0,0
Ccc_XD0_XDFFM_S_XD5_XN3_mid2 XD0_XDFFM_S XD5_XN3_mid2 1.21e-17
* device instance cc_XD0_XDFFM_S_XD5_dmodout r0 *1 0,0
Ccc_XD0_XDFFM_S_XD5_dmodout XD0_XDFFM_S XD5_dmodout 1.21e-17
* device instance cc_XD0_XDFFM_S_XD5_dq r0 *1 0,0
Ccc_XD0_XDFFM_S_XD5_dq XD0_XDFFM_S XD5_dq 1.8151e-17
* device instance cc_XD0_XDFFM_S_XD5_nm r0 *1 0,0
Ccc_XD0_XDFFM_S_XD5_nm XD0_XDFFM_S XD5_nm 1.21e-17
* device instance cc_XD0_XDFFM_S_XD5_nt r0 *1 0,0
Ccc_XD0_XDFFM_S_XD5_nt XD0_XDFFM_S XD5_nt 1.21e-17
* device instance cc_XD0_XDFFM_S_XD5_t1 r0 *1 0,0
Ccc_XD0_XDFFM_S_XD5_t1 XD0_XDFFM_S XD5_t1 1.21e-17
* device instance cc_XD0_XDFFM_S_XFRT_CKBB r0 *1 0,0
Ccc_XD0_XDFFM_S_XFRT_CKBB XD0_XDFFM_S XFRT_CKBB 1.8151e-17
* device instance cc_XD0_XDFFM_S_XFRT_CLKB r0 *1 0,0
Ccc_XD0_XDFFM_S_XFRT_CLKB XD0_XDFFM_S XFRT_CLKB 2.4201e-17
* device instance cc_XD0_XDFFM_S_XFRT_M r0 *1 0,0
Ccc_XD0_XDFFM_S_XFRT_M XD0_XDFFM_S XFRT_M 2.4201e-17
* device instance cc_XD0_XDFFM_S_XFRT_MB r0 *1 0,0
Ccc_XD0_XDFFM_S_XFRT_MB XD0_XDFFM_S XFRT_MB 1.21e-17
* device instance cc_XD0_XDFFM_S_XFRT_MFB r0 *1 0,0
Ccc_XD0_XDFFM_S_XFRT_MFB XD0_XDFFM_S XFRT_MFB 1.21e-17
* device instance cc_XD0_XDFFM_S_XFRT_S r0 *1 0,0
Ccc_XD0_XDFFM_S_XFRT_S XD0_XDFFM_S XFRT_S 1.8151e-17
* device instance cc_XD0_XDFFM_S_XFRT_SB r0 *1 0,0
Ccc_XD0_XDFFM_S_XFRT_SB XD0_XDFFM_S XFRT_SB 1.8151e-17
* device instance cc_XD0_XDFFM_S_XFRT_SFB r0 *1 0,0
Ccc_XD0_XDFFM_S_XFRT_SFB XD0_XDFFM_S XFRT_SFB 1.21e-17
* device instance cc_XD0_XDFFM_S_ck1 r0 *1 0,0
Ccc_XD0_XDFFM_S_ck1 XD0_XDFFM_S ck1 3.0251e-17
* device instance cc_XD0_XDFFM_S_ck2 r0 *1 0,0
Ccc_XD0_XDFFM_S_ck2 XD0_XDFFM_S ck2 3.0251e-17
* device instance cc_XD0_XDFFM_S_ck3 r0 *1 0,0
Ccc_XD0_XDFFM_S_ck3 XD0_XDFFM_S ck3 3.0251e-17
* device instance cc_XD0_XDFFM_S_ck4 r0 *1 0,0
Ccc_XD0_XDFFM_S_ck4 XD0_XDFFM_S ck4 3.0251e-17
* device instance cc_XD0_XDFFM_S_ck5 r0 *1 0,0
Ccc_XD0_XDFFM_S_ck5 XD0_XDFFM_S ck5 3.0251e-17
* device instance cc_XD0_XDFFM_S_mod0 r0 *1 0,0
Ccc_XD0_XDFFM_S_mod0 XD0_XDFFM_S mod0 2.4201e-17
* device instance cc_XD0_XDFFM_S_mod1 r0 *1 0,0
Ccc_XD0_XDFFM_S_mod1 XD0_XDFFM_S mod1 2.4201e-17
* device instance cc_XD0_XDFFM_S_mod2 r0 *1 0,0
Ccc_XD0_XDFFM_S_mod2 XD0_XDFFM_S mod2 2.4201e-17
* device instance cc_XD0_XDFFM_S_mod3 r0 *1 0,0
Ccc_XD0_XDFFM_S_mod3 XD0_XDFFM_S mod3 2.4201e-17
* device instance cc_XD0_XDFFM_S_mod4 r0 *1 0,0
Ccc_XD0_XDFFM_S_mod4 XD0_XDFFM_S mod4 2.4201e-17
* device instance cc_XD0_XDFFM_S_net1 r0 *1 0,0
Ccc_XD0_XDFFM_S_net1 XD0_XDFFM_S net1 1.21e-17
* device instance cc_XD0_XDFFM_SB_XD0_XDFFM_SFB r0 *1 0,0
Ccc_XD0_XDFFM_SB_XD0_XDFFM_SFB XD0_XDFFM_SB XD0_XDFFM_SFB 2.4201e-17
* device instance cc_XD0_XDFFM_SB_XD0_XDFFQ_CKBB r0 *1 0,0
Ccc_XD0_XDFFM_SB_XD0_XDFFQ_CKBB XD0_XDFFM_SB XD0_XDFFQ_CKBB 1.8151e-17
* device instance cc_XD0_XDFFM_SB_XD0_XDFFQ_CLKB r0 *1 0,0
Ccc_XD0_XDFFM_SB_XD0_XDFFQ_CLKB XD0_XDFFM_SB XD0_XDFFQ_CLKB 2.4201e-17
* device instance cc_XD0_XDFFM_SB_XD0_XDFFQ_M r0 *1 0,0
Ccc_XD0_XDFFM_SB_XD0_XDFFQ_M XD0_XDFFM_SB XD0_XDFFQ_M 2.4201e-17
* device instance cc_XD0_XDFFM_SB_XD0_XDFFQ_MB r0 *1 0,0
Ccc_XD0_XDFFM_SB_XD0_XDFFQ_MB XD0_XDFFM_SB XD0_XDFFQ_MB 1.21e-17
* device instance cc_XD0_XDFFM_SB_XD0_XDFFQ_MFB r0 *1 0,0
Ccc_XD0_XDFFM_SB_XD0_XDFFQ_MFB XD0_XDFFM_SB XD0_XDFFQ_MFB 1.21e-17
* device instance cc_XD0_XDFFM_SB_XD0_XDFFQ_S r0 *1 0,0
Ccc_XD0_XDFFM_SB_XD0_XDFFQ_S XD0_XDFFM_SB XD0_XDFFQ_S 1.8151e-17
* device instance cc_XD0_XDFFM_SB_XD0_XDFFQ_SB r0 *1 0,0
Ccc_XD0_XDFFM_SB_XD0_XDFFQ_SB XD0_XDFFM_SB XD0_XDFFQ_SB 1.8151e-17
* device instance cc_XD0_XDFFM_SB_XD0_XDFFQ_SFB r0 *1 0,0
Ccc_XD0_XDFFM_SB_XD0_XDFFQ_SFB XD0_XDFFM_SB XD0_XDFFQ_SFB 1.21e-17
* device instance cc_XD0_XDFFM_SB_XD0_XNOR_midp r0 *1 0,0
Ccc_XD0_XDFFM_SB_XD0_XNOR_midp XD0_XDFFM_SB XD0_XNOR_midp 1.21e-17
* device instance cc_XD0_XDFFM_SB_XD0_dmodout r0 *1 0,0
Ccc_XD0_XDFFM_SB_XD0_dmodout XD0_XDFFM_SB XD0_dmodout 1.21e-17
* device instance cc_XD0_XDFFM_SB_XD0_dq r0 *1 0,0
Ccc_XD0_XDFFM_SB_XD0_dq XD0_XDFFM_SB XD0_dq 1.21e-17
* device instance cc_XD0_XDFFM_SB_XD0_nm r0 *1 0,0
Ccc_XD0_XDFFM_SB_XD0_nm XD0_XDFFM_SB XD0_nm 1.8151e-17
* device instance cc_XD0_XDFFM_SB_XD0_nt r0 *1 0,0
Ccc_XD0_XDFFM_SB_XD0_nt XD0_XDFFM_SB XD0_nt 2.4201e-17
* device instance cc_XD0_XDFFM_SB_XD0_t1 r0 *1 0,0
Ccc_XD0_XDFFM_SB_XD0_t1 XD0_XDFFM_SB XD0_t1 1.21e-17
* device instance cc_XD0_XDFFM_SB_XD1_XDFFM_CKBB r0 *1 0,0
Ccc_XD0_XDFFM_SB_XD1_XDFFM_CKBB XD0_XDFFM_SB XD1_XDFFM_CKBB 1.8151e-17
* device instance cc_XD0_XDFFM_SB_XD1_XDFFM_CLKB r0 *1 0,0
Ccc_XD0_XDFFM_SB_XD1_XDFFM_CLKB XD0_XDFFM_SB XD1_XDFFM_CLKB 2.4201e-17
* device instance cc_XD0_XDFFM_SB_XD1_XDFFM_M r0 *1 0,0
Ccc_XD0_XDFFM_SB_XD1_XDFFM_M XD0_XDFFM_SB XD1_XDFFM_M 2.4201e-17
* device instance cc_XD0_XDFFM_SB_XD1_XDFFM_MB r0 *1 0,0
Ccc_XD0_XDFFM_SB_XD1_XDFFM_MB XD0_XDFFM_SB XD1_XDFFM_MB 1.21e-17
* device instance cc_XD0_XDFFM_SB_XD1_XDFFM_MFB r0 *1 0,0
Ccc_XD0_XDFFM_SB_XD1_XDFFM_MFB XD0_XDFFM_SB XD1_XDFFM_MFB 1.21e-17
* device instance cc_XD0_XDFFM_SB_XD1_XDFFM_S r0 *1 0,0
Ccc_XD0_XDFFM_SB_XD1_XDFFM_S XD0_XDFFM_SB XD1_XDFFM_S 1.8151e-17
* device instance cc_XD0_XDFFM_SB_XD1_XDFFM_SB r0 *1 0,0
Ccc_XD0_XDFFM_SB_XD1_XDFFM_SB XD0_XDFFM_SB XD1_XDFFM_SB 1.8151e-17
* device instance cc_XD0_XDFFM_SB_XD1_XDFFM_SFB r0 *1 0,0
Ccc_XD0_XDFFM_SB_XD1_XDFFM_SFB XD0_XDFFM_SB XD1_XDFFM_SFB 1.21e-17
* device instance cc_XD0_XDFFM_SB_XD1_XDFFQ_CKBB r0 *1 0,0
Ccc_XD0_XDFFM_SB_XD1_XDFFQ_CKBB XD0_XDFFM_SB XD1_XDFFQ_CKBB 1.8151e-17
* device instance cc_XD0_XDFFM_SB_XD1_XDFFQ_CLKB r0 *1 0,0
Ccc_XD0_XDFFM_SB_XD1_XDFFQ_CLKB XD0_XDFFM_SB XD1_XDFFQ_CLKB 2.4201e-17
* device instance cc_XD0_XDFFM_SB_XD1_XDFFQ_M r0 *1 0,0
Ccc_XD0_XDFFM_SB_XD1_XDFFQ_M XD0_XDFFM_SB XD1_XDFFQ_M 2.4201e-17
* device instance cc_XD0_XDFFM_SB_XD1_XDFFQ_MB r0 *1 0,0
Ccc_XD0_XDFFM_SB_XD1_XDFFQ_MB XD0_XDFFM_SB XD1_XDFFQ_MB 1.21e-17
* device instance cc_XD0_XDFFM_SB_XD1_XDFFQ_MFB r0 *1 0,0
Ccc_XD0_XDFFM_SB_XD1_XDFFQ_MFB XD0_XDFFM_SB XD1_XDFFQ_MFB 1.21e-17
* device instance cc_XD0_XDFFM_SB_XD1_XDFFQ_S r0 *1 0,0
Ccc_XD0_XDFFM_SB_XD1_XDFFQ_S XD0_XDFFM_SB XD1_XDFFQ_S 1.8151e-17
* device instance cc_XD0_XDFFM_SB_XD1_XDFFQ_SB r0 *1 0,0
Ccc_XD0_XDFFM_SB_XD1_XDFFQ_SB XD0_XDFFM_SB XD1_XDFFQ_SB 1.8151e-17
* device instance cc_XD0_XDFFM_SB_XD1_XDFFQ_SFB r0 *1 0,0
Ccc_XD0_XDFFM_SB_XD1_XDFFQ_SFB XD0_XDFFM_SB XD1_XDFFQ_SFB 1.21e-17
* device instance cc_XD0_XDFFM_SB_XD1_XN2_mid1 r0 *1 0,0
Ccc_XD0_XDFFM_SB_XD1_XN2_mid1 XD0_XDFFM_SB XD1_XN2_mid1 1.21e-17
* device instance cc_XD0_XDFFM_SB_XD1_XN3_mid1 r0 *1 0,0
Ccc_XD0_XDFFM_SB_XD1_XN3_mid1 XD0_XDFFM_SB XD1_XN3_mid1 1.21e-17
* device instance cc_XD0_XDFFM_SB_XD1_XN3_mid2 r0 *1 0,0
Ccc_XD0_XDFFM_SB_XD1_XN3_mid2 XD0_XDFFM_SB XD1_XN3_mid2 1.21e-17
* device instance cc_XD0_XDFFM_SB_XD1_dmodout r0 *1 0,0
Ccc_XD0_XDFFM_SB_XD1_dmodout XD0_XDFFM_SB XD1_dmodout 1.21e-17
* device instance cc_XD0_XDFFM_SB_XD1_dq r0 *1 0,0
Ccc_XD0_XDFFM_SB_XD1_dq XD0_XDFFM_SB XD1_dq 1.8151e-17
* device instance cc_XD0_XDFFM_SB_XD1_nm r0 *1 0,0
Ccc_XD0_XDFFM_SB_XD1_nm XD0_XDFFM_SB XD1_nm 1.21e-17
* device instance cc_XD0_XDFFM_SB_XD1_nt r0 *1 0,0
Ccc_XD0_XDFFM_SB_XD1_nt XD0_XDFFM_SB XD1_nt 1.21e-17
* device instance cc_XD0_XDFFM_SB_XD1_t1 r0 *1 0,0
Ccc_XD0_XDFFM_SB_XD1_t1 XD0_XDFFM_SB XD1_t1 1.21e-17
* device instance cc_XD0_XDFFM_SB_XD2_XDFFM_CKBB r0 *1 0,0
Ccc_XD0_XDFFM_SB_XD2_XDFFM_CKBB XD0_XDFFM_SB XD2_XDFFM_CKBB 1.8151e-17
* device instance cc_XD0_XDFFM_SB_XD2_XDFFM_CLKB r0 *1 0,0
Ccc_XD0_XDFFM_SB_XD2_XDFFM_CLKB XD0_XDFFM_SB XD2_XDFFM_CLKB 2.4201e-17
* device instance cc_XD0_XDFFM_SB_XD2_XDFFM_M r0 *1 0,0
Ccc_XD0_XDFFM_SB_XD2_XDFFM_M XD0_XDFFM_SB XD2_XDFFM_M 2.4201e-17
* device instance cc_XD0_XDFFM_SB_XD2_XDFFM_MB r0 *1 0,0
Ccc_XD0_XDFFM_SB_XD2_XDFFM_MB XD0_XDFFM_SB XD2_XDFFM_MB 1.21e-17
* device instance cc_XD0_XDFFM_SB_XD2_XDFFM_MFB r0 *1 0,0
Ccc_XD0_XDFFM_SB_XD2_XDFFM_MFB XD0_XDFFM_SB XD2_XDFFM_MFB 1.21e-17
* device instance cc_XD0_XDFFM_SB_XD2_XDFFM_S r0 *1 0,0
Ccc_XD0_XDFFM_SB_XD2_XDFFM_S XD0_XDFFM_SB XD2_XDFFM_S 1.8151e-17
* device instance cc_XD0_XDFFM_SB_XD2_XDFFM_SB r0 *1 0,0
Ccc_XD0_XDFFM_SB_XD2_XDFFM_SB XD0_XDFFM_SB XD2_XDFFM_SB 1.8151e-17
* device instance cc_XD0_XDFFM_SB_XD2_XDFFM_SFB r0 *1 0,0
Ccc_XD0_XDFFM_SB_XD2_XDFFM_SFB XD0_XDFFM_SB XD2_XDFFM_SFB 1.21e-17
* device instance cc_XD0_XDFFM_SB_XD2_XDFFQ_CKBB r0 *1 0,0
Ccc_XD0_XDFFM_SB_XD2_XDFFQ_CKBB XD0_XDFFM_SB XD2_XDFFQ_CKBB 1.8151e-17
* device instance cc_XD0_XDFFM_SB_XD2_XDFFQ_CLKB r0 *1 0,0
Ccc_XD0_XDFFM_SB_XD2_XDFFQ_CLKB XD0_XDFFM_SB XD2_XDFFQ_CLKB 2.4201e-17
* device instance cc_XD0_XDFFM_SB_XD2_XDFFQ_M r0 *1 0,0
Ccc_XD0_XDFFM_SB_XD2_XDFFQ_M XD0_XDFFM_SB XD2_XDFFQ_M 2.4201e-17
* device instance cc_XD0_XDFFM_SB_XD2_XDFFQ_MB r0 *1 0,0
Ccc_XD0_XDFFM_SB_XD2_XDFFQ_MB XD0_XDFFM_SB XD2_XDFFQ_MB 1.21e-17
* device instance cc_XD0_XDFFM_SB_XD2_XDFFQ_MFB r0 *1 0,0
Ccc_XD0_XDFFM_SB_XD2_XDFFQ_MFB XD0_XDFFM_SB XD2_XDFFQ_MFB 1.21e-17
* device instance cc_XD0_XDFFM_SB_XD2_XDFFQ_S r0 *1 0,0
Ccc_XD0_XDFFM_SB_XD2_XDFFQ_S XD0_XDFFM_SB XD2_XDFFQ_S 1.8151e-17
* device instance cc_XD0_XDFFM_SB_XD2_XDFFQ_SB r0 *1 0,0
Ccc_XD0_XDFFM_SB_XD2_XDFFQ_SB XD0_XDFFM_SB XD2_XDFFQ_SB 1.8151e-17
* device instance cc_XD0_XDFFM_SB_XD2_XDFFQ_SFB r0 *1 0,0
Ccc_XD0_XDFFM_SB_XD2_XDFFQ_SFB XD0_XDFFM_SB XD2_XDFFQ_SFB 1.21e-17
* device instance cc_XD0_XDFFM_SB_XD2_XN2_mid1 r0 *1 0,0
Ccc_XD0_XDFFM_SB_XD2_XN2_mid1 XD0_XDFFM_SB XD2_XN2_mid1 1.21e-17
* device instance cc_XD0_XDFFM_SB_XD2_XN3_mid1 r0 *1 0,0
Ccc_XD0_XDFFM_SB_XD2_XN3_mid1 XD0_XDFFM_SB XD2_XN3_mid1 1.21e-17
* device instance cc_XD0_XDFFM_SB_XD2_XN3_mid2 r0 *1 0,0
Ccc_XD0_XDFFM_SB_XD2_XN3_mid2 XD0_XDFFM_SB XD2_XN3_mid2 1.21e-17
* device instance cc_XD0_XDFFM_SB_XD2_dmodout r0 *1 0,0
Ccc_XD0_XDFFM_SB_XD2_dmodout XD0_XDFFM_SB XD2_dmodout 1.21e-17
* device instance cc_XD0_XDFFM_SB_XD2_dq r0 *1 0,0
Ccc_XD0_XDFFM_SB_XD2_dq XD0_XDFFM_SB XD2_dq 1.8151e-17
* device instance cc_XD0_XDFFM_SB_XD2_nm r0 *1 0,0
Ccc_XD0_XDFFM_SB_XD2_nm XD0_XDFFM_SB XD2_nm 1.21e-17
* device instance cc_XD0_XDFFM_SB_XD2_nt r0 *1 0,0
Ccc_XD0_XDFFM_SB_XD2_nt XD0_XDFFM_SB XD2_nt 1.21e-17
* device instance cc_XD0_XDFFM_SB_XD2_t1 r0 *1 0,0
Ccc_XD0_XDFFM_SB_XD2_t1 XD0_XDFFM_SB XD2_t1 1.21e-17
* device instance cc_XD0_XDFFM_SB_XD3_XDFFM_CKBB r0 *1 0,0
Ccc_XD0_XDFFM_SB_XD3_XDFFM_CKBB XD0_XDFFM_SB XD3_XDFFM_CKBB 1.8151e-17
* device instance cc_XD0_XDFFM_SB_XD3_XDFFM_CLKB r0 *1 0,0
Ccc_XD0_XDFFM_SB_XD3_XDFFM_CLKB XD0_XDFFM_SB XD3_XDFFM_CLKB 2.4201e-17
* device instance cc_XD0_XDFFM_SB_XD3_XDFFM_M r0 *1 0,0
Ccc_XD0_XDFFM_SB_XD3_XDFFM_M XD0_XDFFM_SB XD3_XDFFM_M 2.4201e-17
* device instance cc_XD0_XDFFM_SB_XD3_XDFFM_MB r0 *1 0,0
Ccc_XD0_XDFFM_SB_XD3_XDFFM_MB XD0_XDFFM_SB XD3_XDFFM_MB 1.21e-17
* device instance cc_XD0_XDFFM_SB_XD3_XDFFM_MFB r0 *1 0,0
Ccc_XD0_XDFFM_SB_XD3_XDFFM_MFB XD0_XDFFM_SB XD3_XDFFM_MFB 1.21e-17
* device instance cc_XD0_XDFFM_SB_XD3_XDFFM_S r0 *1 0,0
Ccc_XD0_XDFFM_SB_XD3_XDFFM_S XD0_XDFFM_SB XD3_XDFFM_S 1.8151e-17
* device instance cc_XD0_XDFFM_SB_XD3_XDFFM_SB r0 *1 0,0
Ccc_XD0_XDFFM_SB_XD3_XDFFM_SB XD0_XDFFM_SB XD3_XDFFM_SB 1.8151e-17
* device instance cc_XD0_XDFFM_SB_XD3_XDFFM_SFB r0 *1 0,0
Ccc_XD0_XDFFM_SB_XD3_XDFFM_SFB XD0_XDFFM_SB XD3_XDFFM_SFB 1.21e-17
* device instance cc_XD0_XDFFM_SB_XD3_XDFFQ_CKBB r0 *1 0,0
Ccc_XD0_XDFFM_SB_XD3_XDFFQ_CKBB XD0_XDFFM_SB XD3_XDFFQ_CKBB 1.8151e-17
* device instance cc_XD0_XDFFM_SB_XD3_XDFFQ_CLKB r0 *1 0,0
Ccc_XD0_XDFFM_SB_XD3_XDFFQ_CLKB XD0_XDFFM_SB XD3_XDFFQ_CLKB 2.4201e-17
* device instance cc_XD0_XDFFM_SB_XD3_XDFFQ_M r0 *1 0,0
Ccc_XD0_XDFFM_SB_XD3_XDFFQ_M XD0_XDFFM_SB XD3_XDFFQ_M 2.4201e-17
* device instance cc_XD0_XDFFM_SB_XD3_XDFFQ_MB r0 *1 0,0
Ccc_XD0_XDFFM_SB_XD3_XDFFQ_MB XD0_XDFFM_SB XD3_XDFFQ_MB 1.21e-17
* device instance cc_XD0_XDFFM_SB_XD3_XDFFQ_MFB r0 *1 0,0
Ccc_XD0_XDFFM_SB_XD3_XDFFQ_MFB XD0_XDFFM_SB XD3_XDFFQ_MFB 1.21e-17
* device instance cc_XD0_XDFFM_SB_XD3_XDFFQ_S r0 *1 0,0
Ccc_XD0_XDFFM_SB_XD3_XDFFQ_S XD0_XDFFM_SB XD3_XDFFQ_S 1.8151e-17
* device instance cc_XD0_XDFFM_SB_XD3_XDFFQ_SB r0 *1 0,0
Ccc_XD0_XDFFM_SB_XD3_XDFFQ_SB XD0_XDFFM_SB XD3_XDFFQ_SB 1.8151e-17
* device instance cc_XD0_XDFFM_SB_XD3_XDFFQ_SFB r0 *1 0,0
Ccc_XD0_XDFFM_SB_XD3_XDFFQ_SFB XD0_XDFFM_SB XD3_XDFFQ_SFB 1.21e-17
* device instance cc_XD0_XDFFM_SB_XD3_XN2_mid1 r0 *1 0,0
Ccc_XD0_XDFFM_SB_XD3_XN2_mid1 XD0_XDFFM_SB XD3_XN2_mid1 1.21e-17
* device instance cc_XD0_XDFFM_SB_XD3_XN3_mid1 r0 *1 0,0
Ccc_XD0_XDFFM_SB_XD3_XN3_mid1 XD0_XDFFM_SB XD3_XN3_mid1 1.21e-17
* device instance cc_XD0_XDFFM_SB_XD3_XN3_mid2 r0 *1 0,0
Ccc_XD0_XDFFM_SB_XD3_XN3_mid2 XD0_XDFFM_SB XD3_XN3_mid2 1.21e-17
* device instance cc_XD0_XDFFM_SB_XD3_dmodout r0 *1 0,0
Ccc_XD0_XDFFM_SB_XD3_dmodout XD0_XDFFM_SB XD3_dmodout 1.21e-17
* device instance cc_XD0_XDFFM_SB_XD3_dq r0 *1 0,0
Ccc_XD0_XDFFM_SB_XD3_dq XD0_XDFFM_SB XD3_dq 1.8151e-17
* device instance cc_XD0_XDFFM_SB_XD3_nm r0 *1 0,0
Ccc_XD0_XDFFM_SB_XD3_nm XD0_XDFFM_SB XD3_nm 1.21e-17
* device instance cc_XD0_XDFFM_SB_XD3_nt r0 *1 0,0
Ccc_XD0_XDFFM_SB_XD3_nt XD0_XDFFM_SB XD3_nt 1.21e-17
* device instance cc_XD0_XDFFM_SB_XD3_t1 r0 *1 0,0
Ccc_XD0_XDFFM_SB_XD3_t1 XD0_XDFFM_SB XD3_t1 1.21e-17
* device instance cc_XD0_XDFFM_SB_XD4_XDFFM_CKBB r0 *1 0,0
Ccc_XD0_XDFFM_SB_XD4_XDFFM_CKBB XD0_XDFFM_SB XD4_XDFFM_CKBB 1.8151e-17
* device instance cc_XD0_XDFFM_SB_XD4_XDFFM_CLKB r0 *1 0,0
Ccc_XD0_XDFFM_SB_XD4_XDFFM_CLKB XD0_XDFFM_SB XD4_XDFFM_CLKB 2.4201e-17
* device instance cc_XD0_XDFFM_SB_XD4_XDFFM_M r0 *1 0,0
Ccc_XD0_XDFFM_SB_XD4_XDFFM_M XD0_XDFFM_SB XD4_XDFFM_M 2.4201e-17
* device instance cc_XD0_XDFFM_SB_XD4_XDFFM_MB r0 *1 0,0
Ccc_XD0_XDFFM_SB_XD4_XDFFM_MB XD0_XDFFM_SB XD4_XDFFM_MB 1.21e-17
* device instance cc_XD0_XDFFM_SB_XD4_XDFFM_MFB r0 *1 0,0
Ccc_XD0_XDFFM_SB_XD4_XDFFM_MFB XD0_XDFFM_SB XD4_XDFFM_MFB 1.21e-17
* device instance cc_XD0_XDFFM_SB_XD4_XDFFM_S r0 *1 0,0
Ccc_XD0_XDFFM_SB_XD4_XDFFM_S XD0_XDFFM_SB XD4_XDFFM_S 1.8151e-17
* device instance cc_XD0_XDFFM_SB_XD4_XDFFM_SB r0 *1 0,0
Ccc_XD0_XDFFM_SB_XD4_XDFFM_SB XD0_XDFFM_SB XD4_XDFFM_SB 1.8151e-17
* device instance cc_XD0_XDFFM_SB_XD4_XDFFM_SFB r0 *1 0,0
Ccc_XD0_XDFFM_SB_XD4_XDFFM_SFB XD0_XDFFM_SB XD4_XDFFM_SFB 1.21e-17
* device instance cc_XD0_XDFFM_SB_XD4_XDFFQ_CKBB r0 *1 0,0
Ccc_XD0_XDFFM_SB_XD4_XDFFQ_CKBB XD0_XDFFM_SB XD4_XDFFQ_CKBB 1.8151e-17
* device instance cc_XD0_XDFFM_SB_XD4_XDFFQ_CLKB r0 *1 0,0
Ccc_XD0_XDFFM_SB_XD4_XDFFQ_CLKB XD0_XDFFM_SB XD4_XDFFQ_CLKB 2.4201e-17
* device instance cc_XD0_XDFFM_SB_XD4_XDFFQ_M r0 *1 0,0
Ccc_XD0_XDFFM_SB_XD4_XDFFQ_M XD0_XDFFM_SB XD4_XDFFQ_M 2.4201e-17
* device instance cc_XD0_XDFFM_SB_XD4_XDFFQ_MB r0 *1 0,0
Ccc_XD0_XDFFM_SB_XD4_XDFFQ_MB XD0_XDFFM_SB XD4_XDFFQ_MB 1.21e-17
* device instance cc_XD0_XDFFM_SB_XD4_XDFFQ_MFB r0 *1 0,0
Ccc_XD0_XDFFM_SB_XD4_XDFFQ_MFB XD0_XDFFM_SB XD4_XDFFQ_MFB 1.21e-17
* device instance cc_XD0_XDFFM_SB_XD4_XDFFQ_S r0 *1 0,0
Ccc_XD0_XDFFM_SB_XD4_XDFFQ_S XD0_XDFFM_SB XD4_XDFFQ_S 1.8151e-17
* device instance cc_XD0_XDFFM_SB_XD4_XDFFQ_SB r0 *1 0,0
Ccc_XD0_XDFFM_SB_XD4_XDFFQ_SB XD0_XDFFM_SB XD4_XDFFQ_SB 1.8151e-17
* device instance cc_XD0_XDFFM_SB_XD4_XDFFQ_SFB r0 *1 0,0
Ccc_XD0_XDFFM_SB_XD4_XDFFQ_SFB XD0_XDFFM_SB XD4_XDFFQ_SFB 1.21e-17
* device instance cc_XD0_XDFFM_SB_XD4_XN2_mid1 r0 *1 0,0
Ccc_XD0_XDFFM_SB_XD4_XN2_mid1 XD0_XDFFM_SB XD4_XN2_mid1 1.21e-17
* device instance cc_XD0_XDFFM_SB_XD4_XN3_mid1 r0 *1 0,0
Ccc_XD0_XDFFM_SB_XD4_XN3_mid1 XD0_XDFFM_SB XD4_XN3_mid1 1.21e-17
* device instance cc_XD0_XDFFM_SB_XD4_XN3_mid2 r0 *1 0,0
Ccc_XD0_XDFFM_SB_XD4_XN3_mid2 XD0_XDFFM_SB XD4_XN3_mid2 1.21e-17
* device instance cc_XD0_XDFFM_SB_XD4_dmodout r0 *1 0,0
Ccc_XD0_XDFFM_SB_XD4_dmodout XD0_XDFFM_SB XD4_dmodout 1.21e-17
* device instance cc_XD0_XDFFM_SB_XD4_dq r0 *1 0,0
Ccc_XD0_XDFFM_SB_XD4_dq XD0_XDFFM_SB XD4_dq 1.8151e-17
* device instance cc_XD0_XDFFM_SB_XD4_nm r0 *1 0,0
Ccc_XD0_XDFFM_SB_XD4_nm XD0_XDFFM_SB XD4_nm 1.21e-17
* device instance cc_XD0_XDFFM_SB_XD4_nt r0 *1 0,0
Ccc_XD0_XDFFM_SB_XD4_nt XD0_XDFFM_SB XD4_nt 1.21e-17
* device instance cc_XD0_XDFFM_SB_XD4_t1 r0 *1 0,0
Ccc_XD0_XDFFM_SB_XD4_t1 XD0_XDFFM_SB XD4_t1 1.21e-17
* device instance cc_XD0_XDFFM_SB_XD5_XDFFM_CKBB r0 *1 0,0
Ccc_XD0_XDFFM_SB_XD5_XDFFM_CKBB XD0_XDFFM_SB XD5_XDFFM_CKBB 1.8151e-17
* device instance cc_XD0_XDFFM_SB_XD5_XDFFM_CLKB r0 *1 0,0
Ccc_XD0_XDFFM_SB_XD5_XDFFM_CLKB XD0_XDFFM_SB XD5_XDFFM_CLKB 2.4201e-17
* device instance cc_XD0_XDFFM_SB_XD5_XDFFM_M r0 *1 0,0
Ccc_XD0_XDFFM_SB_XD5_XDFFM_M XD0_XDFFM_SB XD5_XDFFM_M 2.4201e-17
* device instance cc_XD0_XDFFM_SB_XD5_XDFFM_MB r0 *1 0,0
Ccc_XD0_XDFFM_SB_XD5_XDFFM_MB XD0_XDFFM_SB XD5_XDFFM_MB 1.21e-17
* device instance cc_XD0_XDFFM_SB_XD5_XDFFM_MFB r0 *1 0,0
Ccc_XD0_XDFFM_SB_XD5_XDFFM_MFB XD0_XDFFM_SB XD5_XDFFM_MFB 1.21e-17
* device instance cc_XD0_XDFFM_SB_XD5_XDFFM_S r0 *1 0,0
Ccc_XD0_XDFFM_SB_XD5_XDFFM_S XD0_XDFFM_SB XD5_XDFFM_S 1.8151e-17
* device instance cc_XD0_XDFFM_SB_XD5_XDFFM_SB r0 *1 0,0
Ccc_XD0_XDFFM_SB_XD5_XDFFM_SB XD0_XDFFM_SB XD5_XDFFM_SB 1.8151e-17
* device instance cc_XD0_XDFFM_SB_XD5_XDFFM_SFB r0 *1 0,0
Ccc_XD0_XDFFM_SB_XD5_XDFFM_SFB XD0_XDFFM_SB XD5_XDFFM_SFB 1.21e-17
* device instance cc_XD0_XDFFM_SB_XD5_XDFFQ_CKBB r0 *1 0,0
Ccc_XD0_XDFFM_SB_XD5_XDFFQ_CKBB XD0_XDFFM_SB XD5_XDFFQ_CKBB 1.8151e-17
* device instance cc_XD0_XDFFM_SB_XD5_XDFFQ_CLKB r0 *1 0,0
Ccc_XD0_XDFFM_SB_XD5_XDFFQ_CLKB XD0_XDFFM_SB XD5_XDFFQ_CLKB 2.4201e-17
* device instance cc_XD0_XDFFM_SB_XD5_XDFFQ_M r0 *1 0,0
Ccc_XD0_XDFFM_SB_XD5_XDFFQ_M XD0_XDFFM_SB XD5_XDFFQ_M 2.4201e-17
* device instance cc_XD0_XDFFM_SB_XD5_XDFFQ_MB r0 *1 0,0
Ccc_XD0_XDFFM_SB_XD5_XDFFQ_MB XD0_XDFFM_SB XD5_XDFFQ_MB 1.21e-17
* device instance cc_XD0_XDFFM_SB_XD5_XDFFQ_MFB r0 *1 0,0
Ccc_XD0_XDFFM_SB_XD5_XDFFQ_MFB XD0_XDFFM_SB XD5_XDFFQ_MFB 1.21e-17
* device instance cc_XD0_XDFFM_SB_XD5_XDFFQ_S r0 *1 0,0
Ccc_XD0_XDFFM_SB_XD5_XDFFQ_S XD0_XDFFM_SB XD5_XDFFQ_S 1.8151e-17
* device instance cc_XD0_XDFFM_SB_XD5_XDFFQ_SB r0 *1 0,0
Ccc_XD0_XDFFM_SB_XD5_XDFFQ_SB XD0_XDFFM_SB XD5_XDFFQ_SB 1.8151e-17
* device instance cc_XD0_XDFFM_SB_XD5_XDFFQ_SFB r0 *1 0,0
Ccc_XD0_XDFFM_SB_XD5_XDFFQ_SFB XD0_XDFFM_SB XD5_XDFFQ_SFB 1.21e-17
* device instance cc_XD0_XDFFM_SB_XD5_XN2_mid1 r0 *1 0,0
Ccc_XD0_XDFFM_SB_XD5_XN2_mid1 XD0_XDFFM_SB XD5_XN2_mid1 1.21e-17
* device instance cc_XD0_XDFFM_SB_XD5_XN3_mid1 r0 *1 0,0
Ccc_XD0_XDFFM_SB_XD5_XN3_mid1 XD0_XDFFM_SB XD5_XN3_mid1 1.21e-17
* device instance cc_XD0_XDFFM_SB_XD5_XN3_mid2 r0 *1 0,0
Ccc_XD0_XDFFM_SB_XD5_XN3_mid2 XD0_XDFFM_SB XD5_XN3_mid2 1.21e-17
* device instance cc_XD0_XDFFM_SB_XD5_dmodout r0 *1 0,0
Ccc_XD0_XDFFM_SB_XD5_dmodout XD0_XDFFM_SB XD5_dmodout 1.21e-17
* device instance cc_XD0_XDFFM_SB_XD5_dq r0 *1 0,0
Ccc_XD0_XDFFM_SB_XD5_dq XD0_XDFFM_SB XD5_dq 1.8151e-17
* device instance cc_XD0_XDFFM_SB_XD5_nm r0 *1 0,0
Ccc_XD0_XDFFM_SB_XD5_nm XD0_XDFFM_SB XD5_nm 1.21e-17
* device instance cc_XD0_XDFFM_SB_XD5_nt r0 *1 0,0
Ccc_XD0_XDFFM_SB_XD5_nt XD0_XDFFM_SB XD5_nt 1.21e-17
* device instance cc_XD0_XDFFM_SB_XD5_t1 r0 *1 0,0
Ccc_XD0_XDFFM_SB_XD5_t1 XD0_XDFFM_SB XD5_t1 1.21e-17
* device instance cc_XD0_XDFFM_SB_XFRT_CKBB r0 *1 0,0
Ccc_XD0_XDFFM_SB_XFRT_CKBB XD0_XDFFM_SB XFRT_CKBB 1.8151e-17
* device instance cc_XD0_XDFFM_SB_XFRT_CLKB r0 *1 0,0
Ccc_XD0_XDFFM_SB_XFRT_CLKB XD0_XDFFM_SB XFRT_CLKB 2.4201e-17
* device instance cc_XD0_XDFFM_SB_XFRT_M r0 *1 0,0
Ccc_XD0_XDFFM_SB_XFRT_M XD0_XDFFM_SB XFRT_M 2.4201e-17
* device instance cc_XD0_XDFFM_SB_XFRT_MB r0 *1 0,0
Ccc_XD0_XDFFM_SB_XFRT_MB XD0_XDFFM_SB XFRT_MB 1.21e-17
* device instance cc_XD0_XDFFM_SB_XFRT_MFB r0 *1 0,0
Ccc_XD0_XDFFM_SB_XFRT_MFB XD0_XDFFM_SB XFRT_MFB 1.21e-17
* device instance cc_XD0_XDFFM_SB_XFRT_S r0 *1 0,0
Ccc_XD0_XDFFM_SB_XFRT_S XD0_XDFFM_SB XFRT_S 1.8151e-17
* device instance cc_XD0_XDFFM_SB_XFRT_SB r0 *1 0,0
Ccc_XD0_XDFFM_SB_XFRT_SB XD0_XDFFM_SB XFRT_SB 1.8151e-17
* device instance cc_XD0_XDFFM_SB_XFRT_SFB r0 *1 0,0
Ccc_XD0_XDFFM_SB_XFRT_SFB XD0_XDFFM_SB XFRT_SFB 1.21e-17
* device instance cc_XD0_XDFFM_SB_ck1 r0 *1 0,0
Ccc_XD0_XDFFM_SB_ck1 XD0_XDFFM_SB ck1 3.0251e-17
* device instance cc_XD0_XDFFM_SB_ck2 r0 *1 0,0
Ccc_XD0_XDFFM_SB_ck2 XD0_XDFFM_SB ck2 3.0251e-17
* device instance cc_XD0_XDFFM_SB_ck3 r0 *1 0,0
Ccc_XD0_XDFFM_SB_ck3 XD0_XDFFM_SB ck3 3.0251e-17
* device instance cc_XD0_XDFFM_SB_ck4 r0 *1 0,0
Ccc_XD0_XDFFM_SB_ck4 XD0_XDFFM_SB ck4 3.0251e-17
* device instance cc_XD0_XDFFM_SB_ck5 r0 *1 0,0
Ccc_XD0_XDFFM_SB_ck5 XD0_XDFFM_SB ck5 3.0251e-17
* device instance cc_XD0_XDFFM_SB_mod0 r0 *1 0,0
Ccc_XD0_XDFFM_SB_mod0 XD0_XDFFM_SB mod0 2.4201e-17
* device instance cc_XD0_XDFFM_SB_mod1 r0 *1 0,0
Ccc_XD0_XDFFM_SB_mod1 XD0_XDFFM_SB mod1 2.4201e-17
* device instance cc_XD0_XDFFM_SB_mod2 r0 *1 0,0
Ccc_XD0_XDFFM_SB_mod2 XD0_XDFFM_SB mod2 2.4201e-17
* device instance cc_XD0_XDFFM_SB_mod3 r0 *1 0,0
Ccc_XD0_XDFFM_SB_mod3 XD0_XDFFM_SB mod3 2.4201e-17
* device instance cc_XD0_XDFFM_SB_mod4 r0 *1 0,0
Ccc_XD0_XDFFM_SB_mod4 XD0_XDFFM_SB mod4 2.4201e-17
* device instance cc_XD0_XDFFM_SB_net1 r0 *1 0,0
Ccc_XD0_XDFFM_SB_net1 XD0_XDFFM_SB net1 1.21e-17
* device instance cc_XD0_XDFFM_SFB_XD0_XDFFQ_CKBB r0 *1 0,0
Ccc_XD0_XDFFM_SFB_XD0_XDFFQ_CKBB XD0_XDFFM_SFB XD0_XDFFQ_CKBB 1.8151e-17
* device instance cc_XD0_XDFFM_SFB_XD0_XDFFQ_CLKB r0 *1 0,0
Ccc_XD0_XDFFM_SFB_XD0_XDFFQ_CLKB XD0_XDFFM_SFB XD0_XDFFQ_CLKB 2.4201e-17
* device instance cc_XD0_XDFFM_SFB_XD0_XDFFQ_M r0 *1 0,0
Ccc_XD0_XDFFM_SFB_XD0_XDFFQ_M XD0_XDFFM_SFB XD0_XDFFQ_M 2.4201e-17
* device instance cc_XD0_XDFFM_SFB_XD0_XDFFQ_MB r0 *1 0,0
Ccc_XD0_XDFFM_SFB_XD0_XDFFQ_MB XD0_XDFFM_SFB XD0_XDFFQ_MB 1.21e-17
* device instance cc_XD0_XDFFM_SFB_XD0_XDFFQ_MFB r0 *1 0,0
Ccc_XD0_XDFFM_SFB_XD0_XDFFQ_MFB XD0_XDFFM_SFB XD0_XDFFQ_MFB 1.21e-17
* device instance cc_XD0_XDFFM_SFB_XD0_XDFFQ_S r0 *1 0,0
Ccc_XD0_XDFFM_SFB_XD0_XDFFQ_S XD0_XDFFM_SFB XD0_XDFFQ_S 1.8151e-17
* device instance cc_XD0_XDFFM_SFB_XD0_XDFFQ_SB r0 *1 0,0
Ccc_XD0_XDFFM_SFB_XD0_XDFFQ_SB XD0_XDFFM_SFB XD0_XDFFQ_SB 1.8151e-17
* device instance cc_XD0_XDFFM_SFB_XD0_XDFFQ_SFB r0 *1 0,0
Ccc_XD0_XDFFM_SFB_XD0_XDFFQ_SFB XD0_XDFFM_SFB XD0_XDFFQ_SFB 1.21e-17
* device instance cc_XD0_XDFFM_SFB_XD0_XNOR_midp r0 *1 0,0
Ccc_XD0_XDFFM_SFB_XD0_XNOR_midp XD0_XDFFM_SFB XD0_XNOR_midp 1.21e-17
* device instance cc_XD0_XDFFM_SFB_XD0_dmodout r0 *1 0,0
Ccc_XD0_XDFFM_SFB_XD0_dmodout XD0_XDFFM_SFB XD0_dmodout 1.21e-17
* device instance cc_XD0_XDFFM_SFB_XD0_dq r0 *1 0,0
Ccc_XD0_XDFFM_SFB_XD0_dq XD0_XDFFM_SFB XD0_dq 1.21e-17
* device instance cc_XD0_XDFFM_SFB_XD0_nm r0 *1 0,0
Ccc_XD0_XDFFM_SFB_XD0_nm XD0_XDFFM_SFB XD0_nm 1.8151e-17
* device instance cc_XD0_XDFFM_SFB_XD0_nt r0 *1 0,0
Ccc_XD0_XDFFM_SFB_XD0_nt XD0_XDFFM_SFB XD0_nt 2.4201e-17
* device instance cc_XD0_XDFFM_SFB_XD0_t1 r0 *1 0,0
Ccc_XD0_XDFFM_SFB_XD0_t1 XD0_XDFFM_SFB XD0_t1 1.21e-17
* device instance cc_XD0_XDFFM_SFB_XD1_XDFFM_CKBB r0 *1 0,0
Ccc_XD0_XDFFM_SFB_XD1_XDFFM_CKBB XD0_XDFFM_SFB XD1_XDFFM_CKBB 1.8151e-17
* device instance cc_XD0_XDFFM_SFB_XD1_XDFFM_CLKB r0 *1 0,0
Ccc_XD0_XDFFM_SFB_XD1_XDFFM_CLKB XD0_XDFFM_SFB XD1_XDFFM_CLKB 2.4201e-17
* device instance cc_XD0_XDFFM_SFB_XD1_XDFFM_M r0 *1 0,0
Ccc_XD0_XDFFM_SFB_XD1_XDFFM_M XD0_XDFFM_SFB XD1_XDFFM_M 2.4201e-17
* device instance cc_XD0_XDFFM_SFB_XD1_XDFFM_MB r0 *1 0,0
Ccc_XD0_XDFFM_SFB_XD1_XDFFM_MB XD0_XDFFM_SFB XD1_XDFFM_MB 1.21e-17
* device instance cc_XD0_XDFFM_SFB_XD1_XDFFM_MFB r0 *1 0,0
Ccc_XD0_XDFFM_SFB_XD1_XDFFM_MFB XD0_XDFFM_SFB XD1_XDFFM_MFB 1.21e-17
* device instance cc_XD0_XDFFM_SFB_XD1_XDFFM_S r0 *1 0,0
Ccc_XD0_XDFFM_SFB_XD1_XDFFM_S XD0_XDFFM_SFB XD1_XDFFM_S 1.8151e-17
* device instance cc_XD0_XDFFM_SFB_XD1_XDFFM_SB r0 *1 0,0
Ccc_XD0_XDFFM_SFB_XD1_XDFFM_SB XD0_XDFFM_SFB XD1_XDFFM_SB 1.8151e-17
* device instance cc_XD0_XDFFM_SFB_XD1_XDFFM_SFB r0 *1 0,0
Ccc_XD0_XDFFM_SFB_XD1_XDFFM_SFB XD0_XDFFM_SFB XD1_XDFFM_SFB 1.21e-17
* device instance cc_XD0_XDFFM_SFB_XD1_XDFFQ_CKBB r0 *1 0,0
Ccc_XD0_XDFFM_SFB_XD1_XDFFQ_CKBB XD0_XDFFM_SFB XD1_XDFFQ_CKBB 1.8151e-17
* device instance cc_XD0_XDFFM_SFB_XD1_XDFFQ_CLKB r0 *1 0,0
Ccc_XD0_XDFFM_SFB_XD1_XDFFQ_CLKB XD0_XDFFM_SFB XD1_XDFFQ_CLKB 2.4201e-17
* device instance cc_XD0_XDFFM_SFB_XD1_XDFFQ_M r0 *1 0,0
Ccc_XD0_XDFFM_SFB_XD1_XDFFQ_M XD0_XDFFM_SFB XD1_XDFFQ_M 2.4201e-17
* device instance cc_XD0_XDFFM_SFB_XD1_XDFFQ_MB r0 *1 0,0
Ccc_XD0_XDFFM_SFB_XD1_XDFFQ_MB XD0_XDFFM_SFB XD1_XDFFQ_MB 1.21e-17
* device instance cc_XD0_XDFFM_SFB_XD1_XDFFQ_MFB r0 *1 0,0
Ccc_XD0_XDFFM_SFB_XD1_XDFFQ_MFB XD0_XDFFM_SFB XD1_XDFFQ_MFB 1.21e-17
* device instance cc_XD0_XDFFM_SFB_XD1_XDFFQ_S r0 *1 0,0
Ccc_XD0_XDFFM_SFB_XD1_XDFFQ_S XD0_XDFFM_SFB XD1_XDFFQ_S 1.8151e-17
* device instance cc_XD0_XDFFM_SFB_XD1_XDFFQ_SB r0 *1 0,0
Ccc_XD0_XDFFM_SFB_XD1_XDFFQ_SB XD0_XDFFM_SFB XD1_XDFFQ_SB 1.8151e-17
* device instance cc_XD0_XDFFM_SFB_XD1_XDFFQ_SFB r0 *1 0,0
Ccc_XD0_XDFFM_SFB_XD1_XDFFQ_SFB XD0_XDFFM_SFB XD1_XDFFQ_SFB 1.21e-17
* device instance cc_XD0_XDFFM_SFB_XD1_XN2_mid1 r0 *1 0,0
Ccc_XD0_XDFFM_SFB_XD1_XN2_mid1 XD0_XDFFM_SFB XD1_XN2_mid1 1.21e-17
* device instance cc_XD0_XDFFM_SFB_XD1_XN3_mid1 r0 *1 0,0
Ccc_XD0_XDFFM_SFB_XD1_XN3_mid1 XD0_XDFFM_SFB XD1_XN3_mid1 1.21e-17
* device instance cc_XD0_XDFFM_SFB_XD1_XN3_mid2 r0 *1 0,0
Ccc_XD0_XDFFM_SFB_XD1_XN3_mid2 XD0_XDFFM_SFB XD1_XN3_mid2 1.21e-17
* device instance cc_XD0_XDFFM_SFB_XD1_dmodout r0 *1 0,0
Ccc_XD0_XDFFM_SFB_XD1_dmodout XD0_XDFFM_SFB XD1_dmodout 1.21e-17
* device instance cc_XD0_XDFFM_SFB_XD1_dq r0 *1 0,0
Ccc_XD0_XDFFM_SFB_XD1_dq XD0_XDFFM_SFB XD1_dq 1.8151e-17
* device instance cc_XD0_XDFFM_SFB_XD1_nm r0 *1 0,0
Ccc_XD0_XDFFM_SFB_XD1_nm XD0_XDFFM_SFB XD1_nm 1.21e-17
* device instance cc_XD0_XDFFM_SFB_XD1_nt r0 *1 0,0
Ccc_XD0_XDFFM_SFB_XD1_nt XD0_XDFFM_SFB XD1_nt 1.21e-17
* device instance cc_XD0_XDFFM_SFB_XD1_t1 r0 *1 0,0
Ccc_XD0_XDFFM_SFB_XD1_t1 XD0_XDFFM_SFB XD1_t1 1.21e-17
* device instance cc_XD0_XDFFM_SFB_XD2_XDFFM_CKBB r0 *1 0,0
Ccc_XD0_XDFFM_SFB_XD2_XDFFM_CKBB XD0_XDFFM_SFB XD2_XDFFM_CKBB 1.8151e-17
* device instance cc_XD0_XDFFM_SFB_XD2_XDFFM_CLKB r0 *1 0,0
Ccc_XD0_XDFFM_SFB_XD2_XDFFM_CLKB XD0_XDFFM_SFB XD2_XDFFM_CLKB 2.4201e-17
* device instance cc_XD0_XDFFM_SFB_XD2_XDFFM_M r0 *1 0,0
Ccc_XD0_XDFFM_SFB_XD2_XDFFM_M XD0_XDFFM_SFB XD2_XDFFM_M 2.4201e-17
* device instance cc_XD0_XDFFM_SFB_XD2_XDFFM_MB r0 *1 0,0
Ccc_XD0_XDFFM_SFB_XD2_XDFFM_MB XD0_XDFFM_SFB XD2_XDFFM_MB 1.21e-17
* device instance cc_XD0_XDFFM_SFB_XD2_XDFFM_MFB r0 *1 0,0
Ccc_XD0_XDFFM_SFB_XD2_XDFFM_MFB XD0_XDFFM_SFB XD2_XDFFM_MFB 1.21e-17
* device instance cc_XD0_XDFFM_SFB_XD2_XDFFM_S r0 *1 0,0
Ccc_XD0_XDFFM_SFB_XD2_XDFFM_S XD0_XDFFM_SFB XD2_XDFFM_S 1.8151e-17
* device instance cc_XD0_XDFFM_SFB_XD2_XDFFM_SB r0 *1 0,0
Ccc_XD0_XDFFM_SFB_XD2_XDFFM_SB XD0_XDFFM_SFB XD2_XDFFM_SB 1.8151e-17
* device instance cc_XD0_XDFFM_SFB_XD2_XDFFM_SFB r0 *1 0,0
Ccc_XD0_XDFFM_SFB_XD2_XDFFM_SFB XD0_XDFFM_SFB XD2_XDFFM_SFB 1.21e-17
* device instance cc_XD0_XDFFM_SFB_XD2_XDFFQ_CKBB r0 *1 0,0
Ccc_XD0_XDFFM_SFB_XD2_XDFFQ_CKBB XD0_XDFFM_SFB XD2_XDFFQ_CKBB 1.8151e-17
* device instance cc_XD0_XDFFM_SFB_XD2_XDFFQ_CLKB r0 *1 0,0
Ccc_XD0_XDFFM_SFB_XD2_XDFFQ_CLKB XD0_XDFFM_SFB XD2_XDFFQ_CLKB 2.4201e-17
* device instance cc_XD0_XDFFM_SFB_XD2_XDFFQ_M r0 *1 0,0
Ccc_XD0_XDFFM_SFB_XD2_XDFFQ_M XD0_XDFFM_SFB XD2_XDFFQ_M 2.4201e-17
* device instance cc_XD0_XDFFM_SFB_XD2_XDFFQ_MB r0 *1 0,0
Ccc_XD0_XDFFM_SFB_XD2_XDFFQ_MB XD0_XDFFM_SFB XD2_XDFFQ_MB 1.21e-17
* device instance cc_XD0_XDFFM_SFB_XD2_XDFFQ_MFB r0 *1 0,0
Ccc_XD0_XDFFM_SFB_XD2_XDFFQ_MFB XD0_XDFFM_SFB XD2_XDFFQ_MFB 1.21e-17
* device instance cc_XD0_XDFFM_SFB_XD2_XDFFQ_S r0 *1 0,0
Ccc_XD0_XDFFM_SFB_XD2_XDFFQ_S XD0_XDFFM_SFB XD2_XDFFQ_S 1.8151e-17
* device instance cc_XD0_XDFFM_SFB_XD2_XDFFQ_SB r0 *1 0,0
Ccc_XD0_XDFFM_SFB_XD2_XDFFQ_SB XD0_XDFFM_SFB XD2_XDFFQ_SB 1.8151e-17
* device instance cc_XD0_XDFFM_SFB_XD2_XDFFQ_SFB r0 *1 0,0
Ccc_XD0_XDFFM_SFB_XD2_XDFFQ_SFB XD0_XDFFM_SFB XD2_XDFFQ_SFB 1.21e-17
* device instance cc_XD0_XDFFM_SFB_XD2_XN2_mid1 r0 *1 0,0
Ccc_XD0_XDFFM_SFB_XD2_XN2_mid1 XD0_XDFFM_SFB XD2_XN2_mid1 1.21e-17
* device instance cc_XD0_XDFFM_SFB_XD2_XN3_mid1 r0 *1 0,0
Ccc_XD0_XDFFM_SFB_XD2_XN3_mid1 XD0_XDFFM_SFB XD2_XN3_mid1 1.21e-17
* device instance cc_XD0_XDFFM_SFB_XD2_XN3_mid2 r0 *1 0,0
Ccc_XD0_XDFFM_SFB_XD2_XN3_mid2 XD0_XDFFM_SFB XD2_XN3_mid2 1.21e-17
* device instance cc_XD0_XDFFM_SFB_XD2_dmodout r0 *1 0,0
Ccc_XD0_XDFFM_SFB_XD2_dmodout XD0_XDFFM_SFB XD2_dmodout 1.21e-17
* device instance cc_XD0_XDFFM_SFB_XD2_dq r0 *1 0,0
Ccc_XD0_XDFFM_SFB_XD2_dq XD0_XDFFM_SFB XD2_dq 1.8151e-17
* device instance cc_XD0_XDFFM_SFB_XD2_nm r0 *1 0,0
Ccc_XD0_XDFFM_SFB_XD2_nm XD0_XDFFM_SFB XD2_nm 1.21e-17
* device instance cc_XD0_XDFFM_SFB_XD2_nt r0 *1 0,0
Ccc_XD0_XDFFM_SFB_XD2_nt XD0_XDFFM_SFB XD2_nt 1.21e-17
* device instance cc_XD0_XDFFM_SFB_XD2_t1 r0 *1 0,0
Ccc_XD0_XDFFM_SFB_XD2_t1 XD0_XDFFM_SFB XD2_t1 1.21e-17
* device instance cc_XD0_XDFFM_SFB_XD3_XDFFM_CKBB r0 *1 0,0
Ccc_XD0_XDFFM_SFB_XD3_XDFFM_CKBB XD0_XDFFM_SFB XD3_XDFFM_CKBB 1.8151e-17
* device instance cc_XD0_XDFFM_SFB_XD3_XDFFM_CLKB r0 *1 0,0
Ccc_XD0_XDFFM_SFB_XD3_XDFFM_CLKB XD0_XDFFM_SFB XD3_XDFFM_CLKB 2.4201e-17
* device instance cc_XD0_XDFFM_SFB_XD3_XDFFM_M r0 *1 0,0
Ccc_XD0_XDFFM_SFB_XD3_XDFFM_M XD0_XDFFM_SFB XD3_XDFFM_M 2.4201e-17
* device instance cc_XD0_XDFFM_SFB_XD3_XDFFM_MB r0 *1 0,0
Ccc_XD0_XDFFM_SFB_XD3_XDFFM_MB XD0_XDFFM_SFB XD3_XDFFM_MB 1.21e-17
* device instance cc_XD0_XDFFM_SFB_XD3_XDFFM_MFB r0 *1 0,0
Ccc_XD0_XDFFM_SFB_XD3_XDFFM_MFB XD0_XDFFM_SFB XD3_XDFFM_MFB 1.21e-17
* device instance cc_XD0_XDFFM_SFB_XD3_XDFFM_S r0 *1 0,0
Ccc_XD0_XDFFM_SFB_XD3_XDFFM_S XD0_XDFFM_SFB XD3_XDFFM_S 1.8151e-17
* device instance cc_XD0_XDFFM_SFB_XD3_XDFFM_SB r0 *1 0,0
Ccc_XD0_XDFFM_SFB_XD3_XDFFM_SB XD0_XDFFM_SFB XD3_XDFFM_SB 1.8151e-17
* device instance cc_XD0_XDFFM_SFB_XD3_XDFFM_SFB r0 *1 0,0
Ccc_XD0_XDFFM_SFB_XD3_XDFFM_SFB XD0_XDFFM_SFB XD3_XDFFM_SFB 1.21e-17
* device instance cc_XD0_XDFFM_SFB_XD3_XDFFQ_CKBB r0 *1 0,0
Ccc_XD0_XDFFM_SFB_XD3_XDFFQ_CKBB XD0_XDFFM_SFB XD3_XDFFQ_CKBB 1.8151e-17
* device instance cc_XD0_XDFFM_SFB_XD3_XDFFQ_CLKB r0 *1 0,0
Ccc_XD0_XDFFM_SFB_XD3_XDFFQ_CLKB XD0_XDFFM_SFB XD3_XDFFQ_CLKB 2.4201e-17
* device instance cc_XD0_XDFFM_SFB_XD3_XDFFQ_M r0 *1 0,0
Ccc_XD0_XDFFM_SFB_XD3_XDFFQ_M XD0_XDFFM_SFB XD3_XDFFQ_M 2.4201e-17
* device instance cc_XD0_XDFFM_SFB_XD3_XDFFQ_MB r0 *1 0,0
Ccc_XD0_XDFFM_SFB_XD3_XDFFQ_MB XD0_XDFFM_SFB XD3_XDFFQ_MB 1.21e-17
* device instance cc_XD0_XDFFM_SFB_XD3_XDFFQ_MFB r0 *1 0,0
Ccc_XD0_XDFFM_SFB_XD3_XDFFQ_MFB XD0_XDFFM_SFB XD3_XDFFQ_MFB 1.21e-17
* device instance cc_XD0_XDFFM_SFB_XD3_XDFFQ_S r0 *1 0,0
Ccc_XD0_XDFFM_SFB_XD3_XDFFQ_S XD0_XDFFM_SFB XD3_XDFFQ_S 1.8151e-17
* device instance cc_XD0_XDFFM_SFB_XD3_XDFFQ_SB r0 *1 0,0
Ccc_XD0_XDFFM_SFB_XD3_XDFFQ_SB XD0_XDFFM_SFB XD3_XDFFQ_SB 1.8151e-17
* device instance cc_XD0_XDFFM_SFB_XD3_XDFFQ_SFB r0 *1 0,0
Ccc_XD0_XDFFM_SFB_XD3_XDFFQ_SFB XD0_XDFFM_SFB XD3_XDFFQ_SFB 1.21e-17
* device instance cc_XD0_XDFFM_SFB_XD3_XN2_mid1 r0 *1 0,0
Ccc_XD0_XDFFM_SFB_XD3_XN2_mid1 XD0_XDFFM_SFB XD3_XN2_mid1 1.21e-17
* device instance cc_XD0_XDFFM_SFB_XD3_XN3_mid1 r0 *1 0,0
Ccc_XD0_XDFFM_SFB_XD3_XN3_mid1 XD0_XDFFM_SFB XD3_XN3_mid1 1.21e-17
* device instance cc_XD0_XDFFM_SFB_XD3_XN3_mid2 r0 *1 0,0
Ccc_XD0_XDFFM_SFB_XD3_XN3_mid2 XD0_XDFFM_SFB XD3_XN3_mid2 1.21e-17
* device instance cc_XD0_XDFFM_SFB_XD3_dmodout r0 *1 0,0
Ccc_XD0_XDFFM_SFB_XD3_dmodout XD0_XDFFM_SFB XD3_dmodout 1.21e-17
* device instance cc_XD0_XDFFM_SFB_XD3_dq r0 *1 0,0
Ccc_XD0_XDFFM_SFB_XD3_dq XD0_XDFFM_SFB XD3_dq 1.8151e-17
* device instance cc_XD0_XDFFM_SFB_XD3_nm r0 *1 0,0
Ccc_XD0_XDFFM_SFB_XD3_nm XD0_XDFFM_SFB XD3_nm 1.21e-17
* device instance cc_XD0_XDFFM_SFB_XD3_nt r0 *1 0,0
Ccc_XD0_XDFFM_SFB_XD3_nt XD0_XDFFM_SFB XD3_nt 1.21e-17
* device instance cc_XD0_XDFFM_SFB_XD3_t1 r0 *1 0,0
Ccc_XD0_XDFFM_SFB_XD3_t1 XD0_XDFFM_SFB XD3_t1 1.21e-17
* device instance cc_XD0_XDFFM_SFB_XD4_XDFFM_CKBB r0 *1 0,0
Ccc_XD0_XDFFM_SFB_XD4_XDFFM_CKBB XD0_XDFFM_SFB XD4_XDFFM_CKBB 1.8151e-17
* device instance cc_XD0_XDFFM_SFB_XD4_XDFFM_CLKB r0 *1 0,0
Ccc_XD0_XDFFM_SFB_XD4_XDFFM_CLKB XD0_XDFFM_SFB XD4_XDFFM_CLKB 2.4201e-17
* device instance cc_XD0_XDFFM_SFB_XD4_XDFFM_M r0 *1 0,0
Ccc_XD0_XDFFM_SFB_XD4_XDFFM_M XD0_XDFFM_SFB XD4_XDFFM_M 2.4201e-17
* device instance cc_XD0_XDFFM_SFB_XD4_XDFFM_MB r0 *1 0,0
Ccc_XD0_XDFFM_SFB_XD4_XDFFM_MB XD0_XDFFM_SFB XD4_XDFFM_MB 1.21e-17
* device instance cc_XD0_XDFFM_SFB_XD4_XDFFM_MFB r0 *1 0,0
Ccc_XD0_XDFFM_SFB_XD4_XDFFM_MFB XD0_XDFFM_SFB XD4_XDFFM_MFB 1.21e-17
* device instance cc_XD0_XDFFM_SFB_XD4_XDFFM_S r0 *1 0,0
Ccc_XD0_XDFFM_SFB_XD4_XDFFM_S XD0_XDFFM_SFB XD4_XDFFM_S 1.8151e-17
* device instance cc_XD0_XDFFM_SFB_XD4_XDFFM_SB r0 *1 0,0
Ccc_XD0_XDFFM_SFB_XD4_XDFFM_SB XD0_XDFFM_SFB XD4_XDFFM_SB 1.8151e-17
* device instance cc_XD0_XDFFM_SFB_XD4_XDFFM_SFB r0 *1 0,0
Ccc_XD0_XDFFM_SFB_XD4_XDFFM_SFB XD0_XDFFM_SFB XD4_XDFFM_SFB 1.21e-17
* device instance cc_XD0_XDFFM_SFB_XD4_XDFFQ_CKBB r0 *1 0,0
Ccc_XD0_XDFFM_SFB_XD4_XDFFQ_CKBB XD0_XDFFM_SFB XD4_XDFFQ_CKBB 1.8151e-17
* device instance cc_XD0_XDFFM_SFB_XD4_XDFFQ_CLKB r0 *1 0,0
Ccc_XD0_XDFFM_SFB_XD4_XDFFQ_CLKB XD0_XDFFM_SFB XD4_XDFFQ_CLKB 2.4201e-17
* device instance cc_XD0_XDFFM_SFB_XD4_XDFFQ_M r0 *1 0,0
Ccc_XD0_XDFFM_SFB_XD4_XDFFQ_M XD0_XDFFM_SFB XD4_XDFFQ_M 2.4201e-17
* device instance cc_XD0_XDFFM_SFB_XD4_XDFFQ_MB r0 *1 0,0
Ccc_XD0_XDFFM_SFB_XD4_XDFFQ_MB XD0_XDFFM_SFB XD4_XDFFQ_MB 1.21e-17
* device instance cc_XD0_XDFFM_SFB_XD4_XDFFQ_MFB r0 *1 0,0
Ccc_XD0_XDFFM_SFB_XD4_XDFFQ_MFB XD0_XDFFM_SFB XD4_XDFFQ_MFB 1.21e-17
* device instance cc_XD0_XDFFM_SFB_XD4_XDFFQ_S r0 *1 0,0
Ccc_XD0_XDFFM_SFB_XD4_XDFFQ_S XD0_XDFFM_SFB XD4_XDFFQ_S 1.8151e-17
* device instance cc_XD0_XDFFM_SFB_XD4_XDFFQ_SB r0 *1 0,0
Ccc_XD0_XDFFM_SFB_XD4_XDFFQ_SB XD0_XDFFM_SFB XD4_XDFFQ_SB 1.8151e-17
* device instance cc_XD0_XDFFM_SFB_XD4_XDFFQ_SFB r0 *1 0,0
Ccc_XD0_XDFFM_SFB_XD4_XDFFQ_SFB XD0_XDFFM_SFB XD4_XDFFQ_SFB 1.21e-17
* device instance cc_XD0_XDFFM_SFB_XD4_XN2_mid1 r0 *1 0,0
Ccc_XD0_XDFFM_SFB_XD4_XN2_mid1 XD0_XDFFM_SFB XD4_XN2_mid1 1.21e-17
* device instance cc_XD0_XDFFM_SFB_XD4_XN3_mid1 r0 *1 0,0
Ccc_XD0_XDFFM_SFB_XD4_XN3_mid1 XD0_XDFFM_SFB XD4_XN3_mid1 1.21e-17
* device instance cc_XD0_XDFFM_SFB_XD4_XN3_mid2 r0 *1 0,0
Ccc_XD0_XDFFM_SFB_XD4_XN3_mid2 XD0_XDFFM_SFB XD4_XN3_mid2 1.21e-17
* device instance cc_XD0_XDFFM_SFB_XD4_dmodout r0 *1 0,0
Ccc_XD0_XDFFM_SFB_XD4_dmodout XD0_XDFFM_SFB XD4_dmodout 1.21e-17
* device instance cc_XD0_XDFFM_SFB_XD4_dq r0 *1 0,0
Ccc_XD0_XDFFM_SFB_XD4_dq XD0_XDFFM_SFB XD4_dq 1.8151e-17
* device instance cc_XD0_XDFFM_SFB_XD4_nm r0 *1 0,0
Ccc_XD0_XDFFM_SFB_XD4_nm XD0_XDFFM_SFB XD4_nm 1.21e-17
* device instance cc_XD0_XDFFM_SFB_XD4_nt r0 *1 0,0
Ccc_XD0_XDFFM_SFB_XD4_nt XD0_XDFFM_SFB XD4_nt 1.21e-17
* device instance cc_XD0_XDFFM_SFB_XD4_t1 r0 *1 0,0
Ccc_XD0_XDFFM_SFB_XD4_t1 XD0_XDFFM_SFB XD4_t1 1.21e-17
* device instance cc_XD0_XDFFM_SFB_XD5_XDFFM_CKBB r0 *1 0,0
Ccc_XD0_XDFFM_SFB_XD5_XDFFM_CKBB XD0_XDFFM_SFB XD5_XDFFM_CKBB 1.8151e-17
* device instance cc_XD0_XDFFM_SFB_XD5_XDFFM_CLKB r0 *1 0,0
Ccc_XD0_XDFFM_SFB_XD5_XDFFM_CLKB XD0_XDFFM_SFB XD5_XDFFM_CLKB 2.4201e-17
* device instance cc_XD0_XDFFM_SFB_XD5_XDFFM_M r0 *1 0,0
Ccc_XD0_XDFFM_SFB_XD5_XDFFM_M XD0_XDFFM_SFB XD5_XDFFM_M 2.4201e-17
* device instance cc_XD0_XDFFM_SFB_XD5_XDFFM_MB r0 *1 0,0
Ccc_XD0_XDFFM_SFB_XD5_XDFFM_MB XD0_XDFFM_SFB XD5_XDFFM_MB 1.21e-17
* device instance cc_XD0_XDFFM_SFB_XD5_XDFFM_MFB r0 *1 0,0
Ccc_XD0_XDFFM_SFB_XD5_XDFFM_MFB XD0_XDFFM_SFB XD5_XDFFM_MFB 1.21e-17
* device instance cc_XD0_XDFFM_SFB_XD5_XDFFM_S r0 *1 0,0
Ccc_XD0_XDFFM_SFB_XD5_XDFFM_S XD0_XDFFM_SFB XD5_XDFFM_S 1.8151e-17
* device instance cc_XD0_XDFFM_SFB_XD5_XDFFM_SB r0 *1 0,0
Ccc_XD0_XDFFM_SFB_XD5_XDFFM_SB XD0_XDFFM_SFB XD5_XDFFM_SB 1.8151e-17
* device instance cc_XD0_XDFFM_SFB_XD5_XDFFM_SFB r0 *1 0,0
Ccc_XD0_XDFFM_SFB_XD5_XDFFM_SFB XD0_XDFFM_SFB XD5_XDFFM_SFB 1.21e-17
* device instance cc_XD0_XDFFM_SFB_XD5_XDFFQ_CKBB r0 *1 0,0
Ccc_XD0_XDFFM_SFB_XD5_XDFFQ_CKBB XD0_XDFFM_SFB XD5_XDFFQ_CKBB 1.8151e-17
* device instance cc_XD0_XDFFM_SFB_XD5_XDFFQ_CLKB r0 *1 0,0
Ccc_XD0_XDFFM_SFB_XD5_XDFFQ_CLKB XD0_XDFFM_SFB XD5_XDFFQ_CLKB 2.4201e-17
* device instance cc_XD0_XDFFM_SFB_XD5_XDFFQ_M r0 *1 0,0
Ccc_XD0_XDFFM_SFB_XD5_XDFFQ_M XD0_XDFFM_SFB XD5_XDFFQ_M 2.4201e-17
* device instance cc_XD0_XDFFM_SFB_XD5_XDFFQ_MB r0 *1 0,0
Ccc_XD0_XDFFM_SFB_XD5_XDFFQ_MB XD0_XDFFM_SFB XD5_XDFFQ_MB 1.21e-17
* device instance cc_XD0_XDFFM_SFB_XD5_XDFFQ_MFB r0 *1 0,0
Ccc_XD0_XDFFM_SFB_XD5_XDFFQ_MFB XD0_XDFFM_SFB XD5_XDFFQ_MFB 1.21e-17
* device instance cc_XD0_XDFFM_SFB_XD5_XDFFQ_S r0 *1 0,0
Ccc_XD0_XDFFM_SFB_XD5_XDFFQ_S XD0_XDFFM_SFB XD5_XDFFQ_S 1.8151e-17
* device instance cc_XD0_XDFFM_SFB_XD5_XDFFQ_SB r0 *1 0,0
Ccc_XD0_XDFFM_SFB_XD5_XDFFQ_SB XD0_XDFFM_SFB XD5_XDFFQ_SB 1.8151e-17
* device instance cc_XD0_XDFFM_SFB_XD5_XDFFQ_SFB r0 *1 0,0
Ccc_XD0_XDFFM_SFB_XD5_XDFFQ_SFB XD0_XDFFM_SFB XD5_XDFFQ_SFB 1.21e-17
* device instance cc_XD0_XDFFM_SFB_XD5_XN2_mid1 r0 *1 0,0
Ccc_XD0_XDFFM_SFB_XD5_XN2_mid1 XD0_XDFFM_SFB XD5_XN2_mid1 1.21e-17
* device instance cc_XD0_XDFFM_SFB_XD5_XN3_mid1 r0 *1 0,0
Ccc_XD0_XDFFM_SFB_XD5_XN3_mid1 XD0_XDFFM_SFB XD5_XN3_mid1 1.21e-17
* device instance cc_XD0_XDFFM_SFB_XD5_XN3_mid2 r0 *1 0,0
Ccc_XD0_XDFFM_SFB_XD5_XN3_mid2 XD0_XDFFM_SFB XD5_XN3_mid2 1.21e-17
* device instance cc_XD0_XDFFM_SFB_XD5_dmodout r0 *1 0,0
Ccc_XD0_XDFFM_SFB_XD5_dmodout XD0_XDFFM_SFB XD5_dmodout 1.21e-17
* device instance cc_XD0_XDFFM_SFB_XD5_dq r0 *1 0,0
Ccc_XD0_XDFFM_SFB_XD5_dq XD0_XDFFM_SFB XD5_dq 1.8151e-17
* device instance cc_XD0_XDFFM_SFB_XD5_nm r0 *1 0,0
Ccc_XD0_XDFFM_SFB_XD5_nm XD0_XDFFM_SFB XD5_nm 1.21e-17
* device instance cc_XD0_XDFFM_SFB_XD5_nt r0 *1 0,0
Ccc_XD0_XDFFM_SFB_XD5_nt XD0_XDFFM_SFB XD5_nt 1.21e-17
* device instance cc_XD0_XDFFM_SFB_XD5_t1 r0 *1 0,0
Ccc_XD0_XDFFM_SFB_XD5_t1 XD0_XDFFM_SFB XD5_t1 1.21e-17
* device instance cc_XD0_XDFFM_SFB_XFRT_CKBB r0 *1 0,0
Ccc_XD0_XDFFM_SFB_XFRT_CKBB XD0_XDFFM_SFB XFRT_CKBB 1.8151e-17
* device instance cc_XD0_XDFFM_SFB_XFRT_CLKB r0 *1 0,0
Ccc_XD0_XDFFM_SFB_XFRT_CLKB XD0_XDFFM_SFB XFRT_CLKB 2.4201e-17
* device instance cc_XD0_XDFFM_SFB_XFRT_M r0 *1 0,0
Ccc_XD0_XDFFM_SFB_XFRT_M XD0_XDFFM_SFB XFRT_M 2.4201e-17
* device instance cc_XD0_XDFFM_SFB_XFRT_MB r0 *1 0,0
Ccc_XD0_XDFFM_SFB_XFRT_MB XD0_XDFFM_SFB XFRT_MB 1.21e-17
* device instance cc_XD0_XDFFM_SFB_XFRT_MFB r0 *1 0,0
Ccc_XD0_XDFFM_SFB_XFRT_MFB XD0_XDFFM_SFB XFRT_MFB 1.21e-17
* device instance cc_XD0_XDFFM_SFB_XFRT_S r0 *1 0,0
Ccc_XD0_XDFFM_SFB_XFRT_S XD0_XDFFM_SFB XFRT_S 1.8151e-17
* device instance cc_XD0_XDFFM_SFB_XFRT_SB r0 *1 0,0
Ccc_XD0_XDFFM_SFB_XFRT_SB XD0_XDFFM_SFB XFRT_SB 1.8151e-17
* device instance cc_XD0_XDFFM_SFB_XFRT_SFB r0 *1 0,0
Ccc_XD0_XDFFM_SFB_XFRT_SFB XD0_XDFFM_SFB XFRT_SFB 1.21e-17
* device instance cc_XD0_XDFFM_SFB_ck1 r0 *1 0,0
Ccc_XD0_XDFFM_SFB_ck1 XD0_XDFFM_SFB ck1 3.0251e-17
* device instance cc_XD0_XDFFM_SFB_ck2 r0 *1 0,0
Ccc_XD0_XDFFM_SFB_ck2 XD0_XDFFM_SFB ck2 3.0251e-17
* device instance cc_XD0_XDFFM_SFB_ck3 r0 *1 0,0
Ccc_XD0_XDFFM_SFB_ck3 XD0_XDFFM_SFB ck3 3.0251e-17
* device instance cc_XD0_XDFFM_SFB_ck4 r0 *1 0,0
Ccc_XD0_XDFFM_SFB_ck4 XD0_XDFFM_SFB ck4 3.0251e-17
* device instance cc_XD0_XDFFM_SFB_ck5 r0 *1 0,0
Ccc_XD0_XDFFM_SFB_ck5 XD0_XDFFM_SFB ck5 3.0251e-17
* device instance cc_XD0_XDFFM_SFB_mod0 r0 *1 0,0
Ccc_XD0_XDFFM_SFB_mod0 XD0_XDFFM_SFB mod0 2.4201e-17
* device instance cc_XD0_XDFFM_SFB_mod1 r0 *1 0,0
Ccc_XD0_XDFFM_SFB_mod1 XD0_XDFFM_SFB mod1 2.4201e-17
* device instance cc_XD0_XDFFM_SFB_mod2 r0 *1 0,0
Ccc_XD0_XDFFM_SFB_mod2 XD0_XDFFM_SFB mod2 2.4201e-17
* device instance cc_XD0_XDFFM_SFB_mod3 r0 *1 0,0
Ccc_XD0_XDFFM_SFB_mod3 XD0_XDFFM_SFB mod3 2.4201e-17
* device instance cc_XD0_XDFFM_SFB_mod4 r0 *1 0,0
Ccc_XD0_XDFFM_SFB_mod4 XD0_XDFFM_SFB mod4 2.4201e-17
* device instance cc_XD0_XDFFM_SFB_net1 r0 *1 0,0
Ccc_XD0_XDFFM_SFB_net1 XD0_XDFFM_SFB net1 1.21e-17
* device instance cc_XD0_XDFFQ_CKBB_XD0_XDFFQ_CLKB r0 *1 0,0
Ccc_XD0_XDFFQ_CKBB_XD0_XDFFQ_CLKB XD0_XDFFQ_CKBB XD0_XDFFQ_CLKB 3.6302e-17
* device instance cc_XD0_XDFFQ_CKBB_XD0_XDFFQ_M r0 *1 0,0
Ccc_XD0_XDFFQ_CKBB_XD0_XDFFQ_M XD0_XDFFQ_CKBB XD0_XDFFQ_M 4.8402e-17
* device instance cc_XD0_XDFFQ_CKBB_XD0_XDFFQ_MB r0 *1 0,0
Ccc_XD0_XDFFQ_CKBB_XD0_XDFFQ_MB XD0_XDFFQ_CKBB XD0_XDFFQ_MB 2.4201e-17
* device instance cc_XD0_XDFFQ_CKBB_XD0_XDFFQ_MFB r0 *1 0,0
Ccc_XD0_XDFFQ_CKBB_XD0_XDFFQ_MFB XD0_XDFFQ_CKBB XD0_XDFFQ_MFB 2.4201e-17
* device instance cc_XD0_XDFFQ_CKBB_XD0_XDFFQ_S r0 *1 0,0
Ccc_XD0_XDFFQ_CKBB_XD0_XDFFQ_S XD0_XDFFQ_CKBB XD0_XDFFQ_S 3.0251e-17
* device instance cc_XD0_XDFFQ_CKBB_XD0_XDFFQ_SB r0 *1 0,0
Ccc_XD0_XDFFQ_CKBB_XD0_XDFFQ_SB XD0_XDFFQ_CKBB XD0_XDFFQ_SB 3.0251e-17
* device instance cc_XD0_XDFFQ_CKBB_XD0_XDFFQ_SFB r0 *1 0,0
Ccc_XD0_XDFFQ_CKBB_XD0_XDFFQ_SFB XD0_XDFFQ_CKBB XD0_XDFFQ_SFB 1.8151e-17
* device instance cc_XD0_XDFFQ_CKBB_XD0_XN2_mid1 r0 *1 0,0
Ccc_XD0_XDFFQ_CKBB_XD0_XN2_mid1 XD0_XDFFQ_CKBB XD0_XN2_mid1 1.21e-17
* device instance cc_XD0_XDFFQ_CKBB_XD0_XNOR_midp r0 *1 0,0
Ccc_XD0_XDFFQ_CKBB_XD0_XNOR_midp XD0_XDFFQ_CKBB XD0_XNOR_midp 1.21e-17
* device instance cc_XD0_XDFFQ_CKBB_XD0_dmodout r0 *1 0,0
Ccc_XD0_XDFFQ_CKBB_XD0_dmodout XD0_XDFFQ_CKBB XD0_dmodout 1.21e-17
* device instance cc_XD0_XDFFQ_CKBB_XD0_dq r0 *1 0,0
Ccc_XD0_XDFFQ_CKBB_XD0_dq XD0_XDFFQ_CKBB XD0_dq 1.8151e-17
* device instance cc_XD0_XDFFQ_CKBB_XD0_nm r0 *1 0,0
Ccc_XD0_XDFFQ_CKBB_XD0_nm XD0_XDFFQ_CKBB XD0_nm 1.21e-17
* device instance cc_XD0_XDFFQ_CKBB_XD0_nt r0 *1 0,0
Ccc_XD0_XDFFQ_CKBB_XD0_nt XD0_XDFFQ_CKBB XD0_nt 2.4201e-17
* device instance cc_XD0_XDFFQ_CKBB_XD0_t1 r0 *1 0,0
Ccc_XD0_XDFFQ_CKBB_XD0_t1 XD0_XDFFQ_CKBB XD0_t1 1.21e-17
* device instance cc_XD0_XDFFQ_CKBB_XD1_XDFFM_CKBB r0 *1 0,0
Ccc_XD0_XDFFQ_CKBB_XD1_XDFFM_CKBB XD0_XDFFQ_CKBB XD1_XDFFM_CKBB 1.8151e-17
* device instance cc_XD0_XDFFQ_CKBB_XD1_XDFFM_CLKB r0 *1 0,0
Ccc_XD0_XDFFQ_CKBB_XD1_XDFFM_CLKB XD0_XDFFQ_CKBB XD1_XDFFM_CLKB 2.4201e-17
* device instance cc_XD0_XDFFQ_CKBB_XD1_XDFFM_M r0 *1 0,0
Ccc_XD0_XDFFQ_CKBB_XD1_XDFFM_M XD0_XDFFQ_CKBB XD1_XDFFM_M 2.4201e-17
* device instance cc_XD0_XDFFQ_CKBB_XD1_XDFFM_MB r0 *1 0,0
Ccc_XD0_XDFFQ_CKBB_XD1_XDFFM_MB XD0_XDFFQ_CKBB XD1_XDFFM_MB 1.21e-17
* device instance cc_XD0_XDFFQ_CKBB_XD1_XDFFM_MFB r0 *1 0,0
Ccc_XD0_XDFFQ_CKBB_XD1_XDFFM_MFB XD0_XDFFQ_CKBB XD1_XDFFM_MFB 1.21e-17
* device instance cc_XD0_XDFFQ_CKBB_XD1_XDFFM_S r0 *1 0,0
Ccc_XD0_XDFFQ_CKBB_XD1_XDFFM_S XD0_XDFFQ_CKBB XD1_XDFFM_S 1.8151e-17
* device instance cc_XD0_XDFFQ_CKBB_XD1_XDFFM_SB r0 *1 0,0
Ccc_XD0_XDFFQ_CKBB_XD1_XDFFM_SB XD0_XDFFQ_CKBB XD1_XDFFM_SB 1.8151e-17
* device instance cc_XD0_XDFFQ_CKBB_XD1_XDFFM_SFB r0 *1 0,0
Ccc_XD0_XDFFQ_CKBB_XD1_XDFFM_SFB XD0_XDFFQ_CKBB XD1_XDFFM_SFB 1.21e-17
* device instance cc_XD0_XDFFQ_CKBB_XD1_XDFFQ_CKBB r0 *1 0,0
Ccc_XD0_XDFFQ_CKBB_XD1_XDFFQ_CKBB XD0_XDFFQ_CKBB XD1_XDFFQ_CKBB 1.8151e-17
* device instance cc_XD0_XDFFQ_CKBB_XD1_XDFFQ_CLKB r0 *1 0,0
Ccc_XD0_XDFFQ_CKBB_XD1_XDFFQ_CLKB XD0_XDFFQ_CKBB XD1_XDFFQ_CLKB 2.4201e-17
* device instance cc_XD0_XDFFQ_CKBB_XD1_XDFFQ_M r0 *1 0,0
Ccc_XD0_XDFFQ_CKBB_XD1_XDFFQ_M XD0_XDFFQ_CKBB XD1_XDFFQ_M 2.4201e-17
* device instance cc_XD0_XDFFQ_CKBB_XD1_XDFFQ_MB r0 *1 0,0
Ccc_XD0_XDFFQ_CKBB_XD1_XDFFQ_MB XD0_XDFFQ_CKBB XD1_XDFFQ_MB 1.21e-17
* device instance cc_XD0_XDFFQ_CKBB_XD1_XDFFQ_MFB r0 *1 0,0
Ccc_XD0_XDFFQ_CKBB_XD1_XDFFQ_MFB XD0_XDFFQ_CKBB XD1_XDFFQ_MFB 1.21e-17
* device instance cc_XD0_XDFFQ_CKBB_XD1_XDFFQ_S r0 *1 0,0
Ccc_XD0_XDFFQ_CKBB_XD1_XDFFQ_S XD0_XDFFQ_CKBB XD1_XDFFQ_S 1.8151e-17
* device instance cc_XD0_XDFFQ_CKBB_XD1_XDFFQ_SB r0 *1 0,0
Ccc_XD0_XDFFQ_CKBB_XD1_XDFFQ_SB XD0_XDFFQ_CKBB XD1_XDFFQ_SB 1.8151e-17
* device instance cc_XD0_XDFFQ_CKBB_XD1_XDFFQ_SFB r0 *1 0,0
Ccc_XD0_XDFFQ_CKBB_XD1_XDFFQ_SFB XD0_XDFFQ_CKBB XD1_XDFFQ_SFB 1.21e-17
* device instance cc_XD0_XDFFQ_CKBB_XD1_XN2_mid1 r0 *1 0,0
Ccc_XD0_XDFFQ_CKBB_XD1_XN2_mid1 XD0_XDFFQ_CKBB XD1_XN2_mid1 1.21e-17
* device instance cc_XD0_XDFFQ_CKBB_XD1_XN3_mid1 r0 *1 0,0
Ccc_XD0_XDFFQ_CKBB_XD1_XN3_mid1 XD0_XDFFQ_CKBB XD1_XN3_mid1 1.21e-17
* device instance cc_XD0_XDFFQ_CKBB_XD1_XN3_mid2 r0 *1 0,0
Ccc_XD0_XDFFQ_CKBB_XD1_XN3_mid2 XD0_XDFFQ_CKBB XD1_XN3_mid2 1.21e-17
* device instance cc_XD0_XDFFQ_CKBB_XD1_dmodout r0 *1 0,0
Ccc_XD0_XDFFQ_CKBB_XD1_dmodout XD0_XDFFQ_CKBB XD1_dmodout 1.21e-17
* device instance cc_XD0_XDFFQ_CKBB_XD1_dq r0 *1 0,0
Ccc_XD0_XDFFQ_CKBB_XD1_dq XD0_XDFFQ_CKBB XD1_dq 1.8151e-17
* device instance cc_XD0_XDFFQ_CKBB_XD1_nm r0 *1 0,0
Ccc_XD0_XDFFQ_CKBB_XD1_nm XD0_XDFFQ_CKBB XD1_nm 1.21e-17
* device instance cc_XD0_XDFFQ_CKBB_XD1_nt r0 *1 0,0
Ccc_XD0_XDFFQ_CKBB_XD1_nt XD0_XDFFQ_CKBB XD1_nt 1.21e-17
* device instance cc_XD0_XDFFQ_CKBB_XD1_t1 r0 *1 0,0
Ccc_XD0_XDFFQ_CKBB_XD1_t1 XD0_XDFFQ_CKBB XD1_t1 1.21e-17
* device instance cc_XD0_XDFFQ_CKBB_XD2_XDFFM_CKBB r0 *1 0,0
Ccc_XD0_XDFFQ_CKBB_XD2_XDFFM_CKBB XD0_XDFFQ_CKBB XD2_XDFFM_CKBB 1.8151e-17
* device instance cc_XD0_XDFFQ_CKBB_XD2_XDFFM_CLKB r0 *1 0,0
Ccc_XD0_XDFFQ_CKBB_XD2_XDFFM_CLKB XD0_XDFFQ_CKBB XD2_XDFFM_CLKB 2.4201e-17
* device instance cc_XD0_XDFFQ_CKBB_XD2_XDFFM_M r0 *1 0,0
Ccc_XD0_XDFFQ_CKBB_XD2_XDFFM_M XD0_XDFFQ_CKBB XD2_XDFFM_M 2.4201e-17
* device instance cc_XD0_XDFFQ_CKBB_XD2_XDFFM_MB r0 *1 0,0
Ccc_XD0_XDFFQ_CKBB_XD2_XDFFM_MB XD0_XDFFQ_CKBB XD2_XDFFM_MB 1.21e-17
* device instance cc_XD0_XDFFQ_CKBB_XD2_XDFFM_MFB r0 *1 0,0
Ccc_XD0_XDFFQ_CKBB_XD2_XDFFM_MFB XD0_XDFFQ_CKBB XD2_XDFFM_MFB 1.21e-17
* device instance cc_XD0_XDFFQ_CKBB_XD2_XDFFM_S r0 *1 0,0
Ccc_XD0_XDFFQ_CKBB_XD2_XDFFM_S XD0_XDFFQ_CKBB XD2_XDFFM_S 1.8151e-17
* device instance cc_XD0_XDFFQ_CKBB_XD2_XDFFM_SB r0 *1 0,0
Ccc_XD0_XDFFQ_CKBB_XD2_XDFFM_SB XD0_XDFFQ_CKBB XD2_XDFFM_SB 1.8151e-17
* device instance cc_XD0_XDFFQ_CKBB_XD2_XDFFM_SFB r0 *1 0,0
Ccc_XD0_XDFFQ_CKBB_XD2_XDFFM_SFB XD0_XDFFQ_CKBB XD2_XDFFM_SFB 1.21e-17
* device instance cc_XD0_XDFFQ_CKBB_XD2_XDFFQ_CKBB r0 *1 0,0
Ccc_XD0_XDFFQ_CKBB_XD2_XDFFQ_CKBB XD0_XDFFQ_CKBB XD2_XDFFQ_CKBB 1.8151e-17
* device instance cc_XD0_XDFFQ_CKBB_XD2_XDFFQ_CLKB r0 *1 0,0
Ccc_XD0_XDFFQ_CKBB_XD2_XDFFQ_CLKB XD0_XDFFQ_CKBB XD2_XDFFQ_CLKB 2.4201e-17
* device instance cc_XD0_XDFFQ_CKBB_XD2_XDFFQ_M r0 *1 0,0
Ccc_XD0_XDFFQ_CKBB_XD2_XDFFQ_M XD0_XDFFQ_CKBB XD2_XDFFQ_M 2.4201e-17
* device instance cc_XD0_XDFFQ_CKBB_XD2_XDFFQ_MB r0 *1 0,0
Ccc_XD0_XDFFQ_CKBB_XD2_XDFFQ_MB XD0_XDFFQ_CKBB XD2_XDFFQ_MB 1.21e-17
* device instance cc_XD0_XDFFQ_CKBB_XD2_XDFFQ_MFB r0 *1 0,0
Ccc_XD0_XDFFQ_CKBB_XD2_XDFFQ_MFB XD0_XDFFQ_CKBB XD2_XDFFQ_MFB 1.21e-17
* device instance cc_XD0_XDFFQ_CKBB_XD2_XDFFQ_S r0 *1 0,0
Ccc_XD0_XDFFQ_CKBB_XD2_XDFFQ_S XD0_XDFFQ_CKBB XD2_XDFFQ_S 1.8151e-17
* device instance cc_XD0_XDFFQ_CKBB_XD2_XDFFQ_SB r0 *1 0,0
Ccc_XD0_XDFFQ_CKBB_XD2_XDFFQ_SB XD0_XDFFQ_CKBB XD2_XDFFQ_SB 1.8151e-17
* device instance cc_XD0_XDFFQ_CKBB_XD2_XDFFQ_SFB r0 *1 0,0
Ccc_XD0_XDFFQ_CKBB_XD2_XDFFQ_SFB XD0_XDFFQ_CKBB XD2_XDFFQ_SFB 1.21e-17
* device instance cc_XD0_XDFFQ_CKBB_XD2_XN2_mid1 r0 *1 0,0
Ccc_XD0_XDFFQ_CKBB_XD2_XN2_mid1 XD0_XDFFQ_CKBB XD2_XN2_mid1 1.21e-17
* device instance cc_XD0_XDFFQ_CKBB_XD2_XN3_mid1 r0 *1 0,0
Ccc_XD0_XDFFQ_CKBB_XD2_XN3_mid1 XD0_XDFFQ_CKBB XD2_XN3_mid1 1.21e-17
* device instance cc_XD0_XDFFQ_CKBB_XD2_XN3_mid2 r0 *1 0,0
Ccc_XD0_XDFFQ_CKBB_XD2_XN3_mid2 XD0_XDFFQ_CKBB XD2_XN3_mid2 1.21e-17
* device instance cc_XD0_XDFFQ_CKBB_XD2_dmodout r0 *1 0,0
Ccc_XD0_XDFFQ_CKBB_XD2_dmodout XD0_XDFFQ_CKBB XD2_dmodout 1.21e-17
* device instance cc_XD0_XDFFQ_CKBB_XD2_dq r0 *1 0,0
Ccc_XD0_XDFFQ_CKBB_XD2_dq XD0_XDFFQ_CKBB XD2_dq 1.8151e-17
* device instance cc_XD0_XDFFQ_CKBB_XD2_nm r0 *1 0,0
Ccc_XD0_XDFFQ_CKBB_XD2_nm XD0_XDFFQ_CKBB XD2_nm 1.21e-17
* device instance cc_XD0_XDFFQ_CKBB_XD2_nt r0 *1 0,0
Ccc_XD0_XDFFQ_CKBB_XD2_nt XD0_XDFFQ_CKBB XD2_nt 1.21e-17
* device instance cc_XD0_XDFFQ_CKBB_XD2_t1 r0 *1 0,0
Ccc_XD0_XDFFQ_CKBB_XD2_t1 XD0_XDFFQ_CKBB XD2_t1 1.21e-17
* device instance cc_XD0_XDFFQ_CKBB_XD3_XDFFM_CKBB r0 *1 0,0
Ccc_XD0_XDFFQ_CKBB_XD3_XDFFM_CKBB XD0_XDFFQ_CKBB XD3_XDFFM_CKBB 1.8151e-17
* device instance cc_XD0_XDFFQ_CKBB_XD3_XDFFM_CLKB r0 *1 0,0
Ccc_XD0_XDFFQ_CKBB_XD3_XDFFM_CLKB XD0_XDFFQ_CKBB XD3_XDFFM_CLKB 2.4201e-17
* device instance cc_XD0_XDFFQ_CKBB_XD3_XDFFM_M r0 *1 0,0
Ccc_XD0_XDFFQ_CKBB_XD3_XDFFM_M XD0_XDFFQ_CKBB XD3_XDFFM_M 2.4201e-17
* device instance cc_XD0_XDFFQ_CKBB_XD3_XDFFM_MB r0 *1 0,0
Ccc_XD0_XDFFQ_CKBB_XD3_XDFFM_MB XD0_XDFFQ_CKBB XD3_XDFFM_MB 1.21e-17
* device instance cc_XD0_XDFFQ_CKBB_XD3_XDFFM_MFB r0 *1 0,0
Ccc_XD0_XDFFQ_CKBB_XD3_XDFFM_MFB XD0_XDFFQ_CKBB XD3_XDFFM_MFB 1.21e-17
* device instance cc_XD0_XDFFQ_CKBB_XD3_XDFFM_S r0 *1 0,0
Ccc_XD0_XDFFQ_CKBB_XD3_XDFFM_S XD0_XDFFQ_CKBB XD3_XDFFM_S 1.8151e-17
* device instance cc_XD0_XDFFQ_CKBB_XD3_XDFFM_SB r0 *1 0,0
Ccc_XD0_XDFFQ_CKBB_XD3_XDFFM_SB XD0_XDFFQ_CKBB XD3_XDFFM_SB 1.8151e-17
* device instance cc_XD0_XDFFQ_CKBB_XD3_XDFFM_SFB r0 *1 0,0
Ccc_XD0_XDFFQ_CKBB_XD3_XDFFM_SFB XD0_XDFFQ_CKBB XD3_XDFFM_SFB 1.21e-17
* device instance cc_XD0_XDFFQ_CKBB_XD3_XDFFQ_CKBB r0 *1 0,0
Ccc_XD0_XDFFQ_CKBB_XD3_XDFFQ_CKBB XD0_XDFFQ_CKBB XD3_XDFFQ_CKBB 1.8151e-17
* device instance cc_XD0_XDFFQ_CKBB_XD3_XDFFQ_CLKB r0 *1 0,0
Ccc_XD0_XDFFQ_CKBB_XD3_XDFFQ_CLKB XD0_XDFFQ_CKBB XD3_XDFFQ_CLKB 2.4201e-17
* device instance cc_XD0_XDFFQ_CKBB_XD3_XDFFQ_M r0 *1 0,0
Ccc_XD0_XDFFQ_CKBB_XD3_XDFFQ_M XD0_XDFFQ_CKBB XD3_XDFFQ_M 2.4201e-17
* device instance cc_XD0_XDFFQ_CKBB_XD3_XDFFQ_MB r0 *1 0,0
Ccc_XD0_XDFFQ_CKBB_XD3_XDFFQ_MB XD0_XDFFQ_CKBB XD3_XDFFQ_MB 1.21e-17
* device instance cc_XD0_XDFFQ_CKBB_XD3_XDFFQ_MFB r0 *1 0,0
Ccc_XD0_XDFFQ_CKBB_XD3_XDFFQ_MFB XD0_XDFFQ_CKBB XD3_XDFFQ_MFB 1.21e-17
* device instance cc_XD0_XDFFQ_CKBB_XD3_XDFFQ_S r0 *1 0,0
Ccc_XD0_XDFFQ_CKBB_XD3_XDFFQ_S XD0_XDFFQ_CKBB XD3_XDFFQ_S 1.8151e-17
* device instance cc_XD0_XDFFQ_CKBB_XD3_XDFFQ_SB r0 *1 0,0
Ccc_XD0_XDFFQ_CKBB_XD3_XDFFQ_SB XD0_XDFFQ_CKBB XD3_XDFFQ_SB 1.8151e-17
* device instance cc_XD0_XDFFQ_CKBB_XD3_XDFFQ_SFB r0 *1 0,0
Ccc_XD0_XDFFQ_CKBB_XD3_XDFFQ_SFB XD0_XDFFQ_CKBB XD3_XDFFQ_SFB 1.21e-17
* device instance cc_XD0_XDFFQ_CKBB_XD3_XN2_mid1 r0 *1 0,0
Ccc_XD0_XDFFQ_CKBB_XD3_XN2_mid1 XD0_XDFFQ_CKBB XD3_XN2_mid1 1.21e-17
* device instance cc_XD0_XDFFQ_CKBB_XD3_XN3_mid1 r0 *1 0,0
Ccc_XD0_XDFFQ_CKBB_XD3_XN3_mid1 XD0_XDFFQ_CKBB XD3_XN3_mid1 1.21e-17
* device instance cc_XD0_XDFFQ_CKBB_XD3_XN3_mid2 r0 *1 0,0
Ccc_XD0_XDFFQ_CKBB_XD3_XN3_mid2 XD0_XDFFQ_CKBB XD3_XN3_mid2 1.21e-17
* device instance cc_XD0_XDFFQ_CKBB_XD3_dmodout r0 *1 0,0
Ccc_XD0_XDFFQ_CKBB_XD3_dmodout XD0_XDFFQ_CKBB XD3_dmodout 1.21e-17
* device instance cc_XD0_XDFFQ_CKBB_XD3_dq r0 *1 0,0
Ccc_XD0_XDFFQ_CKBB_XD3_dq XD0_XDFFQ_CKBB XD3_dq 1.8151e-17
* device instance cc_XD0_XDFFQ_CKBB_XD3_nm r0 *1 0,0
Ccc_XD0_XDFFQ_CKBB_XD3_nm XD0_XDFFQ_CKBB XD3_nm 1.21e-17
* device instance cc_XD0_XDFFQ_CKBB_XD3_nt r0 *1 0,0
Ccc_XD0_XDFFQ_CKBB_XD3_nt XD0_XDFFQ_CKBB XD3_nt 1.21e-17
* device instance cc_XD0_XDFFQ_CKBB_XD3_t1 r0 *1 0,0
Ccc_XD0_XDFFQ_CKBB_XD3_t1 XD0_XDFFQ_CKBB XD3_t1 1.21e-17
* device instance cc_XD0_XDFFQ_CKBB_XD4_XDFFM_CKBB r0 *1 0,0
Ccc_XD0_XDFFQ_CKBB_XD4_XDFFM_CKBB XD0_XDFFQ_CKBB XD4_XDFFM_CKBB 1.8151e-17
* device instance cc_XD0_XDFFQ_CKBB_XD4_XDFFM_CLKB r0 *1 0,0
Ccc_XD0_XDFFQ_CKBB_XD4_XDFFM_CLKB XD0_XDFFQ_CKBB XD4_XDFFM_CLKB 2.4201e-17
* device instance cc_XD0_XDFFQ_CKBB_XD4_XDFFM_M r0 *1 0,0
Ccc_XD0_XDFFQ_CKBB_XD4_XDFFM_M XD0_XDFFQ_CKBB XD4_XDFFM_M 2.4201e-17
* device instance cc_XD0_XDFFQ_CKBB_XD4_XDFFM_MB r0 *1 0,0
Ccc_XD0_XDFFQ_CKBB_XD4_XDFFM_MB XD0_XDFFQ_CKBB XD4_XDFFM_MB 1.21e-17
* device instance cc_XD0_XDFFQ_CKBB_XD4_XDFFM_MFB r0 *1 0,0
Ccc_XD0_XDFFQ_CKBB_XD4_XDFFM_MFB XD0_XDFFQ_CKBB XD4_XDFFM_MFB 1.21e-17
* device instance cc_XD0_XDFFQ_CKBB_XD4_XDFFM_S r0 *1 0,0
Ccc_XD0_XDFFQ_CKBB_XD4_XDFFM_S XD0_XDFFQ_CKBB XD4_XDFFM_S 1.8151e-17
* device instance cc_XD0_XDFFQ_CKBB_XD4_XDFFM_SB r0 *1 0,0
Ccc_XD0_XDFFQ_CKBB_XD4_XDFFM_SB XD0_XDFFQ_CKBB XD4_XDFFM_SB 1.8151e-17
* device instance cc_XD0_XDFFQ_CKBB_XD4_XDFFM_SFB r0 *1 0,0
Ccc_XD0_XDFFQ_CKBB_XD4_XDFFM_SFB XD0_XDFFQ_CKBB XD4_XDFFM_SFB 1.21e-17
* device instance cc_XD0_XDFFQ_CKBB_XD4_XDFFQ_CKBB r0 *1 0,0
Ccc_XD0_XDFFQ_CKBB_XD4_XDFFQ_CKBB XD0_XDFFQ_CKBB XD4_XDFFQ_CKBB 1.8151e-17
* device instance cc_XD0_XDFFQ_CKBB_XD4_XDFFQ_CLKB r0 *1 0,0
Ccc_XD0_XDFFQ_CKBB_XD4_XDFFQ_CLKB XD0_XDFFQ_CKBB XD4_XDFFQ_CLKB 2.4201e-17
* device instance cc_XD0_XDFFQ_CKBB_XD4_XDFFQ_M r0 *1 0,0
Ccc_XD0_XDFFQ_CKBB_XD4_XDFFQ_M XD0_XDFFQ_CKBB XD4_XDFFQ_M 2.4201e-17
* device instance cc_XD0_XDFFQ_CKBB_XD4_XDFFQ_MB r0 *1 0,0
Ccc_XD0_XDFFQ_CKBB_XD4_XDFFQ_MB XD0_XDFFQ_CKBB XD4_XDFFQ_MB 1.21e-17
* device instance cc_XD0_XDFFQ_CKBB_XD4_XDFFQ_MFB r0 *1 0,0
Ccc_XD0_XDFFQ_CKBB_XD4_XDFFQ_MFB XD0_XDFFQ_CKBB XD4_XDFFQ_MFB 1.21e-17
* device instance cc_XD0_XDFFQ_CKBB_XD4_XDFFQ_S r0 *1 0,0
Ccc_XD0_XDFFQ_CKBB_XD4_XDFFQ_S XD0_XDFFQ_CKBB XD4_XDFFQ_S 1.8151e-17
* device instance cc_XD0_XDFFQ_CKBB_XD4_XDFFQ_SB r0 *1 0,0
Ccc_XD0_XDFFQ_CKBB_XD4_XDFFQ_SB XD0_XDFFQ_CKBB XD4_XDFFQ_SB 1.8151e-17
* device instance cc_XD0_XDFFQ_CKBB_XD4_XDFFQ_SFB r0 *1 0,0
Ccc_XD0_XDFFQ_CKBB_XD4_XDFFQ_SFB XD0_XDFFQ_CKBB XD4_XDFFQ_SFB 1.21e-17
* device instance cc_XD0_XDFFQ_CKBB_XD4_XN2_mid1 r0 *1 0,0
Ccc_XD0_XDFFQ_CKBB_XD4_XN2_mid1 XD0_XDFFQ_CKBB XD4_XN2_mid1 1.21e-17
* device instance cc_XD0_XDFFQ_CKBB_XD4_XN3_mid1 r0 *1 0,0
Ccc_XD0_XDFFQ_CKBB_XD4_XN3_mid1 XD0_XDFFQ_CKBB XD4_XN3_mid1 1.21e-17
* device instance cc_XD0_XDFFQ_CKBB_XD4_XN3_mid2 r0 *1 0,0
Ccc_XD0_XDFFQ_CKBB_XD4_XN3_mid2 XD0_XDFFQ_CKBB XD4_XN3_mid2 1.21e-17
* device instance cc_XD0_XDFFQ_CKBB_XD4_dmodout r0 *1 0,0
Ccc_XD0_XDFFQ_CKBB_XD4_dmodout XD0_XDFFQ_CKBB XD4_dmodout 1.21e-17
* device instance cc_XD0_XDFFQ_CKBB_XD4_dq r0 *1 0,0
Ccc_XD0_XDFFQ_CKBB_XD4_dq XD0_XDFFQ_CKBB XD4_dq 1.8151e-17
* device instance cc_XD0_XDFFQ_CKBB_XD4_nm r0 *1 0,0
Ccc_XD0_XDFFQ_CKBB_XD4_nm XD0_XDFFQ_CKBB XD4_nm 1.21e-17
* device instance cc_XD0_XDFFQ_CKBB_XD4_nt r0 *1 0,0
Ccc_XD0_XDFFQ_CKBB_XD4_nt XD0_XDFFQ_CKBB XD4_nt 1.21e-17
* device instance cc_XD0_XDFFQ_CKBB_XD4_t1 r0 *1 0,0
Ccc_XD0_XDFFQ_CKBB_XD4_t1 XD0_XDFFQ_CKBB XD4_t1 1.21e-17
* device instance cc_XD0_XDFFQ_CKBB_XD5_XDFFM_CKBB r0 *1 0,0
Ccc_XD0_XDFFQ_CKBB_XD5_XDFFM_CKBB XD0_XDFFQ_CKBB XD5_XDFFM_CKBB 1.8151e-17
* device instance cc_XD0_XDFFQ_CKBB_XD5_XDFFM_CLKB r0 *1 0,0
Ccc_XD0_XDFFQ_CKBB_XD5_XDFFM_CLKB XD0_XDFFQ_CKBB XD5_XDFFM_CLKB 2.4201e-17
* device instance cc_XD0_XDFFQ_CKBB_XD5_XDFFM_M r0 *1 0,0
Ccc_XD0_XDFFQ_CKBB_XD5_XDFFM_M XD0_XDFFQ_CKBB XD5_XDFFM_M 2.4201e-17
* device instance cc_XD0_XDFFQ_CKBB_XD5_XDFFM_MB r0 *1 0,0
Ccc_XD0_XDFFQ_CKBB_XD5_XDFFM_MB XD0_XDFFQ_CKBB XD5_XDFFM_MB 1.21e-17
* device instance cc_XD0_XDFFQ_CKBB_XD5_XDFFM_MFB r0 *1 0,0
Ccc_XD0_XDFFQ_CKBB_XD5_XDFFM_MFB XD0_XDFFQ_CKBB XD5_XDFFM_MFB 1.21e-17
* device instance cc_XD0_XDFFQ_CKBB_XD5_XDFFM_S r0 *1 0,0
Ccc_XD0_XDFFQ_CKBB_XD5_XDFFM_S XD0_XDFFQ_CKBB XD5_XDFFM_S 1.8151e-17
* device instance cc_XD0_XDFFQ_CKBB_XD5_XDFFM_SB r0 *1 0,0
Ccc_XD0_XDFFQ_CKBB_XD5_XDFFM_SB XD0_XDFFQ_CKBB XD5_XDFFM_SB 1.8151e-17
* device instance cc_XD0_XDFFQ_CKBB_XD5_XDFFM_SFB r0 *1 0,0
Ccc_XD0_XDFFQ_CKBB_XD5_XDFFM_SFB XD0_XDFFQ_CKBB XD5_XDFFM_SFB 1.21e-17
* device instance cc_XD0_XDFFQ_CKBB_XD5_XDFFQ_CKBB r0 *1 0,0
Ccc_XD0_XDFFQ_CKBB_XD5_XDFFQ_CKBB XD0_XDFFQ_CKBB XD5_XDFFQ_CKBB 1.8151e-17
* device instance cc_XD0_XDFFQ_CKBB_XD5_XDFFQ_CLKB r0 *1 0,0
Ccc_XD0_XDFFQ_CKBB_XD5_XDFFQ_CLKB XD0_XDFFQ_CKBB XD5_XDFFQ_CLKB 2.4201e-17
* device instance cc_XD0_XDFFQ_CKBB_XD5_XDFFQ_M r0 *1 0,0
Ccc_XD0_XDFFQ_CKBB_XD5_XDFFQ_M XD0_XDFFQ_CKBB XD5_XDFFQ_M 2.4201e-17
* device instance cc_XD0_XDFFQ_CKBB_XD5_XDFFQ_MB r0 *1 0,0
Ccc_XD0_XDFFQ_CKBB_XD5_XDFFQ_MB XD0_XDFFQ_CKBB XD5_XDFFQ_MB 1.21e-17
* device instance cc_XD0_XDFFQ_CKBB_XD5_XDFFQ_MFB r0 *1 0,0
Ccc_XD0_XDFFQ_CKBB_XD5_XDFFQ_MFB XD0_XDFFQ_CKBB XD5_XDFFQ_MFB 1.21e-17
* device instance cc_XD0_XDFFQ_CKBB_XD5_XDFFQ_S r0 *1 0,0
Ccc_XD0_XDFFQ_CKBB_XD5_XDFFQ_S XD0_XDFFQ_CKBB XD5_XDFFQ_S 1.8151e-17
* device instance cc_XD0_XDFFQ_CKBB_XD5_XDFFQ_SB r0 *1 0,0
Ccc_XD0_XDFFQ_CKBB_XD5_XDFFQ_SB XD0_XDFFQ_CKBB XD5_XDFFQ_SB 1.8151e-17
* device instance cc_XD0_XDFFQ_CKBB_XD5_XDFFQ_SFB r0 *1 0,0
Ccc_XD0_XDFFQ_CKBB_XD5_XDFFQ_SFB XD0_XDFFQ_CKBB XD5_XDFFQ_SFB 1.21e-17
* device instance cc_XD0_XDFFQ_CKBB_XD5_XN2_mid1 r0 *1 0,0
Ccc_XD0_XDFFQ_CKBB_XD5_XN2_mid1 XD0_XDFFQ_CKBB XD5_XN2_mid1 1.21e-17
* device instance cc_XD0_XDFFQ_CKBB_XD5_XN3_mid1 r0 *1 0,0
Ccc_XD0_XDFFQ_CKBB_XD5_XN3_mid1 XD0_XDFFQ_CKBB XD5_XN3_mid1 1.21e-17
* device instance cc_XD0_XDFFQ_CKBB_XD5_XN3_mid2 r0 *1 0,0
Ccc_XD0_XDFFQ_CKBB_XD5_XN3_mid2 XD0_XDFFQ_CKBB XD5_XN3_mid2 1.21e-17
* device instance cc_XD0_XDFFQ_CKBB_XD5_dmodout r0 *1 0,0
Ccc_XD0_XDFFQ_CKBB_XD5_dmodout XD0_XDFFQ_CKBB XD5_dmodout 1.21e-17
* device instance cc_XD0_XDFFQ_CKBB_XD5_dq r0 *1 0,0
Ccc_XD0_XDFFQ_CKBB_XD5_dq XD0_XDFFQ_CKBB XD5_dq 1.8151e-17
* device instance cc_XD0_XDFFQ_CKBB_XD5_nm r0 *1 0,0
Ccc_XD0_XDFFQ_CKBB_XD5_nm XD0_XDFFQ_CKBB XD5_nm 1.21e-17
* device instance cc_XD0_XDFFQ_CKBB_XD5_nt r0 *1 0,0
Ccc_XD0_XDFFQ_CKBB_XD5_nt XD0_XDFFQ_CKBB XD5_nt 1.21e-17
* device instance cc_XD0_XDFFQ_CKBB_XD5_t1 r0 *1 0,0
Ccc_XD0_XDFFQ_CKBB_XD5_t1 XD0_XDFFQ_CKBB XD5_t1 1.21e-17
* device instance cc_XD0_XDFFQ_CKBB_XFRT_CKBB r0 *1 0,0
Ccc_XD0_XDFFQ_CKBB_XFRT_CKBB XD0_XDFFQ_CKBB XFRT_CKBB 1.8151e-17
* device instance cc_XD0_XDFFQ_CKBB_XFRT_CLKB r0 *1 0,0
Ccc_XD0_XDFFQ_CKBB_XFRT_CLKB XD0_XDFFQ_CKBB XFRT_CLKB 2.4201e-17
* device instance cc_XD0_XDFFQ_CKBB_XFRT_M r0 *1 0,0
Ccc_XD0_XDFFQ_CKBB_XFRT_M XD0_XDFFQ_CKBB XFRT_M 2.4201e-17
* device instance cc_XD0_XDFFQ_CKBB_XFRT_MB r0 *1 0,0
Ccc_XD0_XDFFQ_CKBB_XFRT_MB XD0_XDFFQ_CKBB XFRT_MB 1.21e-17
* device instance cc_XD0_XDFFQ_CKBB_XFRT_MFB r0 *1 0,0
Ccc_XD0_XDFFQ_CKBB_XFRT_MFB XD0_XDFFQ_CKBB XFRT_MFB 1.21e-17
* device instance cc_XD0_XDFFQ_CKBB_XFRT_S r0 *1 0,0
Ccc_XD0_XDFFQ_CKBB_XFRT_S XD0_XDFFQ_CKBB XFRT_S 1.8151e-17
* device instance cc_XD0_XDFFQ_CKBB_XFRT_SB r0 *1 0,0
Ccc_XD0_XDFFQ_CKBB_XFRT_SB XD0_XDFFQ_CKBB XFRT_SB 1.8151e-17
* device instance cc_XD0_XDFFQ_CKBB_XFRT_SFB r0 *1 0,0
Ccc_XD0_XDFFQ_CKBB_XFRT_SFB XD0_XDFFQ_CKBB XFRT_SFB 1.21e-17
* device instance cc_XD0_XDFFQ_CKBB_ck1 r0 *1 0,0
Ccc_XD0_XDFFQ_CKBB_ck1 XD0_XDFFQ_CKBB ck1 3.0251e-17
* device instance cc_XD0_XDFFQ_CKBB_ck2 r0 *1 0,0
Ccc_XD0_XDFFQ_CKBB_ck2 XD0_XDFFQ_CKBB ck2 3.0251e-17
* device instance cc_XD0_XDFFQ_CKBB_ck3 r0 *1 0,0
Ccc_XD0_XDFFQ_CKBB_ck3 XD0_XDFFQ_CKBB ck3 3.0251e-17
* device instance cc_XD0_XDFFQ_CKBB_ck4 r0 *1 0,0
Ccc_XD0_XDFFQ_CKBB_ck4 XD0_XDFFQ_CKBB ck4 3.0251e-17
* device instance cc_XD0_XDFFQ_CKBB_ck5 r0 *1 0,0
Ccc_XD0_XDFFQ_CKBB_ck5 XD0_XDFFQ_CKBB ck5 3.0251e-17
* device instance cc_XD0_XDFFQ_CKBB_mod0 r0 *1 0,0
Ccc_XD0_XDFFQ_CKBB_mod0 XD0_XDFFQ_CKBB mod0 2.4201e-17
* device instance cc_XD0_XDFFQ_CKBB_mod1 r0 *1 0,0
Ccc_XD0_XDFFQ_CKBB_mod1 XD0_XDFFQ_CKBB mod1 2.4201e-17
* device instance cc_XD0_XDFFQ_CKBB_mod2 r0 *1 0,0
Ccc_XD0_XDFFQ_CKBB_mod2 XD0_XDFFQ_CKBB mod2 2.4201e-17
* device instance cc_XD0_XDFFQ_CKBB_mod3 r0 *1 0,0
Ccc_XD0_XDFFQ_CKBB_mod3 XD0_XDFFQ_CKBB mod3 2.4201e-17
* device instance cc_XD0_XDFFQ_CKBB_mod4 r0 *1 0,0
Ccc_XD0_XDFFQ_CKBB_mod4 XD0_XDFFQ_CKBB mod4 2.4201e-17
* device instance cc_XD0_XDFFQ_CKBB_net1 r0 *1 0,0
Ccc_XD0_XDFFQ_CKBB_net1 XD0_XDFFQ_CKBB net1 1.21e-17
* device instance cc_XD0_XDFFQ_CLKB_XD0_XDFFQ_M r0 *1 0,0
Ccc_XD0_XDFFQ_CLKB_XD0_XDFFQ_M XD0_XDFFQ_CLKB XD0_XDFFQ_M 4.2352e-17
* device instance cc_XD0_XDFFQ_CLKB_XD0_XDFFQ_MB r0 *1 0,0
Ccc_XD0_XDFFQ_CLKB_XD0_XDFFQ_MB XD0_XDFFQ_CLKB XD0_XDFFQ_MB 2.4201e-17
* device instance cc_XD0_XDFFQ_CLKB_XD0_XDFFQ_MFB r0 *1 0,0
Ccc_XD0_XDFFQ_CLKB_XD0_XDFFQ_MFB XD0_XDFFQ_CLKB XD0_XDFFQ_MFB 2.4201e-17
* device instance cc_XD0_XDFFQ_CLKB_XD0_XDFFQ_S r0 *1 0,0
Ccc_XD0_XDFFQ_CLKB_XD0_XDFFQ_S XD0_XDFFQ_CLKB XD0_XDFFQ_S 1.8151e-17
* device instance cc_XD0_XDFFQ_CLKB_XD0_XDFFQ_SB r0 *1 0,0
Ccc_XD0_XDFFQ_CLKB_XD0_XDFFQ_SB XD0_XDFFQ_CLKB XD0_XDFFQ_SB 1.8151e-17
* device instance cc_XD0_XDFFQ_CLKB_XD0_XDFFQ_SFB r0 *1 0,0
Ccc_XD0_XDFFQ_CLKB_XD0_XDFFQ_SFB XD0_XDFFQ_CLKB XD0_XDFFQ_SFB 1.21e-17
* device instance cc_XD0_XDFFQ_CLKB_XD0_XN2_mid1 r0 *1 0,0
Ccc_XD0_XDFFQ_CLKB_XD0_XN2_mid1 XD0_XDFFQ_CLKB XD0_XN2_mid1 1.21e-17
* device instance cc_XD0_XDFFQ_CLKB_XD0_XNOR_midp r0 *1 0,0
Ccc_XD0_XDFFQ_CLKB_XD0_XNOR_midp XD0_XDFFQ_CLKB XD0_XNOR_midp 1.21e-17
* device instance cc_XD0_XDFFQ_CLKB_XD0_dmodout r0 *1 0,0
Ccc_XD0_XDFFQ_CLKB_XD0_dmodout XD0_XDFFQ_CLKB XD0_dmodout 1.21e-17
* device instance cc_XD0_XDFFQ_CLKB_XD0_dq r0 *1 0,0
Ccc_XD0_XDFFQ_CLKB_XD0_dq XD0_XDFFQ_CLKB XD0_dq 1.8151e-17
* device instance cc_XD0_XDFFQ_CLKB_XD0_nm r0 *1 0,0
Ccc_XD0_XDFFQ_CLKB_XD0_nm XD0_XDFFQ_CLKB XD0_nm 1.21e-17
* device instance cc_XD0_XDFFQ_CLKB_XD0_nt r0 *1 0,0
Ccc_XD0_XDFFQ_CLKB_XD0_nt XD0_XDFFQ_CLKB XD0_nt 2.4201e-17
* device instance cc_XD0_XDFFQ_CLKB_XD0_t1 r0 *1 0,0
Ccc_XD0_XDFFQ_CLKB_XD0_t1 XD0_XDFFQ_CLKB XD0_t1 1.21e-17
* device instance cc_XD0_XDFFQ_CLKB_XD1_XDFFM_CKBB r0 *1 0,0
Ccc_XD0_XDFFQ_CLKB_XD1_XDFFM_CKBB XD0_XDFFQ_CLKB XD1_XDFFM_CKBB 1.8151e-17
* device instance cc_XD0_XDFFQ_CLKB_XD1_XDFFM_CLKB r0 *1 0,0
Ccc_XD0_XDFFQ_CLKB_XD1_XDFFM_CLKB XD0_XDFFQ_CLKB XD1_XDFFM_CLKB 2.4201e-17
* device instance cc_XD0_XDFFQ_CLKB_XD1_XDFFM_M r0 *1 0,0
Ccc_XD0_XDFFQ_CLKB_XD1_XDFFM_M XD0_XDFFQ_CLKB XD1_XDFFM_M 2.4201e-17
* device instance cc_XD0_XDFFQ_CLKB_XD1_XDFFM_MB r0 *1 0,0
Ccc_XD0_XDFFQ_CLKB_XD1_XDFFM_MB XD0_XDFFQ_CLKB XD1_XDFFM_MB 1.21e-17
* device instance cc_XD0_XDFFQ_CLKB_XD1_XDFFM_MFB r0 *1 0,0
Ccc_XD0_XDFFQ_CLKB_XD1_XDFFM_MFB XD0_XDFFQ_CLKB XD1_XDFFM_MFB 1.21e-17
* device instance cc_XD0_XDFFQ_CLKB_XD1_XDFFM_S r0 *1 0,0
Ccc_XD0_XDFFQ_CLKB_XD1_XDFFM_S XD0_XDFFQ_CLKB XD1_XDFFM_S 1.8151e-17
* device instance cc_XD0_XDFFQ_CLKB_XD1_XDFFM_SB r0 *1 0,0
Ccc_XD0_XDFFQ_CLKB_XD1_XDFFM_SB XD0_XDFFQ_CLKB XD1_XDFFM_SB 1.8151e-17
* device instance cc_XD0_XDFFQ_CLKB_XD1_XDFFM_SFB r0 *1 0,0
Ccc_XD0_XDFFQ_CLKB_XD1_XDFFM_SFB XD0_XDFFQ_CLKB XD1_XDFFM_SFB 1.21e-17
* device instance cc_XD0_XDFFQ_CLKB_XD1_XDFFQ_CKBB r0 *1 0,0
Ccc_XD0_XDFFQ_CLKB_XD1_XDFFQ_CKBB XD0_XDFFQ_CLKB XD1_XDFFQ_CKBB 1.8151e-17
* device instance cc_XD0_XDFFQ_CLKB_XD1_XDFFQ_CLKB r0 *1 0,0
Ccc_XD0_XDFFQ_CLKB_XD1_XDFFQ_CLKB XD0_XDFFQ_CLKB XD1_XDFFQ_CLKB 2.4201e-17
* device instance cc_XD0_XDFFQ_CLKB_XD1_XDFFQ_M r0 *1 0,0
Ccc_XD0_XDFFQ_CLKB_XD1_XDFFQ_M XD0_XDFFQ_CLKB XD1_XDFFQ_M 2.4201e-17
* device instance cc_XD0_XDFFQ_CLKB_XD1_XDFFQ_MB r0 *1 0,0
Ccc_XD0_XDFFQ_CLKB_XD1_XDFFQ_MB XD0_XDFFQ_CLKB XD1_XDFFQ_MB 1.21e-17
* device instance cc_XD0_XDFFQ_CLKB_XD1_XDFFQ_MFB r0 *1 0,0
Ccc_XD0_XDFFQ_CLKB_XD1_XDFFQ_MFB XD0_XDFFQ_CLKB XD1_XDFFQ_MFB 1.21e-17
* device instance cc_XD0_XDFFQ_CLKB_XD1_XDFFQ_S r0 *1 0,0
Ccc_XD0_XDFFQ_CLKB_XD1_XDFFQ_S XD0_XDFFQ_CLKB XD1_XDFFQ_S 1.8151e-17
* device instance cc_XD0_XDFFQ_CLKB_XD1_XDFFQ_SB r0 *1 0,0
Ccc_XD0_XDFFQ_CLKB_XD1_XDFFQ_SB XD0_XDFFQ_CLKB XD1_XDFFQ_SB 1.8151e-17
* device instance cc_XD0_XDFFQ_CLKB_XD1_XDFFQ_SFB r0 *1 0,0
Ccc_XD0_XDFFQ_CLKB_XD1_XDFFQ_SFB XD0_XDFFQ_CLKB XD1_XDFFQ_SFB 1.21e-17
* device instance cc_XD0_XDFFQ_CLKB_XD1_XN2_mid1 r0 *1 0,0
Ccc_XD0_XDFFQ_CLKB_XD1_XN2_mid1 XD0_XDFFQ_CLKB XD1_XN2_mid1 1.21e-17
* device instance cc_XD0_XDFFQ_CLKB_XD1_XN3_mid1 r0 *1 0,0
Ccc_XD0_XDFFQ_CLKB_XD1_XN3_mid1 XD0_XDFFQ_CLKB XD1_XN3_mid1 1.21e-17
* device instance cc_XD0_XDFFQ_CLKB_XD1_XN3_mid2 r0 *1 0,0
Ccc_XD0_XDFFQ_CLKB_XD1_XN3_mid2 XD0_XDFFQ_CLKB XD1_XN3_mid2 1.21e-17
* device instance cc_XD0_XDFFQ_CLKB_XD1_dmodout r0 *1 0,0
Ccc_XD0_XDFFQ_CLKB_XD1_dmodout XD0_XDFFQ_CLKB XD1_dmodout 1.21e-17
* device instance cc_XD0_XDFFQ_CLKB_XD1_dq r0 *1 0,0
Ccc_XD0_XDFFQ_CLKB_XD1_dq XD0_XDFFQ_CLKB XD1_dq 1.8151e-17
* device instance cc_XD0_XDFFQ_CLKB_XD1_nm r0 *1 0,0
Ccc_XD0_XDFFQ_CLKB_XD1_nm XD0_XDFFQ_CLKB XD1_nm 1.21e-17
* device instance cc_XD0_XDFFQ_CLKB_XD1_nt r0 *1 0,0
Ccc_XD0_XDFFQ_CLKB_XD1_nt XD0_XDFFQ_CLKB XD1_nt 1.21e-17
* device instance cc_XD0_XDFFQ_CLKB_XD1_t1 r0 *1 0,0
Ccc_XD0_XDFFQ_CLKB_XD1_t1 XD0_XDFFQ_CLKB XD1_t1 1.21e-17
* device instance cc_XD0_XDFFQ_CLKB_XD2_XDFFM_CKBB r0 *1 0,0
Ccc_XD0_XDFFQ_CLKB_XD2_XDFFM_CKBB XD0_XDFFQ_CLKB XD2_XDFFM_CKBB 1.8151e-17
* device instance cc_XD0_XDFFQ_CLKB_XD2_XDFFM_CLKB r0 *1 0,0
Ccc_XD0_XDFFQ_CLKB_XD2_XDFFM_CLKB XD0_XDFFQ_CLKB XD2_XDFFM_CLKB 2.4201e-17
* device instance cc_XD0_XDFFQ_CLKB_XD2_XDFFM_M r0 *1 0,0
Ccc_XD0_XDFFQ_CLKB_XD2_XDFFM_M XD0_XDFFQ_CLKB XD2_XDFFM_M 2.4201e-17
* device instance cc_XD0_XDFFQ_CLKB_XD2_XDFFM_MB r0 *1 0,0
Ccc_XD0_XDFFQ_CLKB_XD2_XDFFM_MB XD0_XDFFQ_CLKB XD2_XDFFM_MB 1.21e-17
* device instance cc_XD0_XDFFQ_CLKB_XD2_XDFFM_MFB r0 *1 0,0
Ccc_XD0_XDFFQ_CLKB_XD2_XDFFM_MFB XD0_XDFFQ_CLKB XD2_XDFFM_MFB 1.21e-17
* device instance cc_XD0_XDFFQ_CLKB_XD2_XDFFM_S r0 *1 0,0
Ccc_XD0_XDFFQ_CLKB_XD2_XDFFM_S XD0_XDFFQ_CLKB XD2_XDFFM_S 1.8151e-17
* device instance cc_XD0_XDFFQ_CLKB_XD2_XDFFM_SB r0 *1 0,0
Ccc_XD0_XDFFQ_CLKB_XD2_XDFFM_SB XD0_XDFFQ_CLKB XD2_XDFFM_SB 1.8151e-17
* device instance cc_XD0_XDFFQ_CLKB_XD2_XDFFM_SFB r0 *1 0,0
Ccc_XD0_XDFFQ_CLKB_XD2_XDFFM_SFB XD0_XDFFQ_CLKB XD2_XDFFM_SFB 1.21e-17
* device instance cc_XD0_XDFFQ_CLKB_XD2_XDFFQ_CKBB r0 *1 0,0
Ccc_XD0_XDFFQ_CLKB_XD2_XDFFQ_CKBB XD0_XDFFQ_CLKB XD2_XDFFQ_CKBB 1.8151e-17
* device instance cc_XD0_XDFFQ_CLKB_XD2_XDFFQ_CLKB r0 *1 0,0
Ccc_XD0_XDFFQ_CLKB_XD2_XDFFQ_CLKB XD0_XDFFQ_CLKB XD2_XDFFQ_CLKB 2.4201e-17
* device instance cc_XD0_XDFFQ_CLKB_XD2_XDFFQ_M r0 *1 0,0
Ccc_XD0_XDFFQ_CLKB_XD2_XDFFQ_M XD0_XDFFQ_CLKB XD2_XDFFQ_M 2.4201e-17
* device instance cc_XD0_XDFFQ_CLKB_XD2_XDFFQ_MB r0 *1 0,0
Ccc_XD0_XDFFQ_CLKB_XD2_XDFFQ_MB XD0_XDFFQ_CLKB XD2_XDFFQ_MB 1.21e-17
* device instance cc_XD0_XDFFQ_CLKB_XD2_XDFFQ_MFB r0 *1 0,0
Ccc_XD0_XDFFQ_CLKB_XD2_XDFFQ_MFB XD0_XDFFQ_CLKB XD2_XDFFQ_MFB 1.21e-17
* device instance cc_XD0_XDFFQ_CLKB_XD2_XDFFQ_S r0 *1 0,0
Ccc_XD0_XDFFQ_CLKB_XD2_XDFFQ_S XD0_XDFFQ_CLKB XD2_XDFFQ_S 1.8151e-17
* device instance cc_XD0_XDFFQ_CLKB_XD2_XDFFQ_SB r0 *1 0,0
Ccc_XD0_XDFFQ_CLKB_XD2_XDFFQ_SB XD0_XDFFQ_CLKB XD2_XDFFQ_SB 1.8151e-17
* device instance cc_XD0_XDFFQ_CLKB_XD2_XDFFQ_SFB r0 *1 0,0
Ccc_XD0_XDFFQ_CLKB_XD2_XDFFQ_SFB XD0_XDFFQ_CLKB XD2_XDFFQ_SFB 1.21e-17
* device instance cc_XD0_XDFFQ_CLKB_XD2_XN2_mid1 r0 *1 0,0
Ccc_XD0_XDFFQ_CLKB_XD2_XN2_mid1 XD0_XDFFQ_CLKB XD2_XN2_mid1 1.21e-17
* device instance cc_XD0_XDFFQ_CLKB_XD2_XN3_mid1 r0 *1 0,0
Ccc_XD0_XDFFQ_CLKB_XD2_XN3_mid1 XD0_XDFFQ_CLKB XD2_XN3_mid1 1.21e-17
* device instance cc_XD0_XDFFQ_CLKB_XD2_XN3_mid2 r0 *1 0,0
Ccc_XD0_XDFFQ_CLKB_XD2_XN3_mid2 XD0_XDFFQ_CLKB XD2_XN3_mid2 1.21e-17
* device instance cc_XD0_XDFFQ_CLKB_XD2_dmodout r0 *1 0,0
Ccc_XD0_XDFFQ_CLKB_XD2_dmodout XD0_XDFFQ_CLKB XD2_dmodout 1.21e-17
* device instance cc_XD0_XDFFQ_CLKB_XD2_dq r0 *1 0,0
Ccc_XD0_XDFFQ_CLKB_XD2_dq XD0_XDFFQ_CLKB XD2_dq 1.8151e-17
* device instance cc_XD0_XDFFQ_CLKB_XD2_nm r0 *1 0,0
Ccc_XD0_XDFFQ_CLKB_XD2_nm XD0_XDFFQ_CLKB XD2_nm 1.21e-17
* device instance cc_XD0_XDFFQ_CLKB_XD2_nt r0 *1 0,0
Ccc_XD0_XDFFQ_CLKB_XD2_nt XD0_XDFFQ_CLKB XD2_nt 1.21e-17
* device instance cc_XD0_XDFFQ_CLKB_XD2_t1 r0 *1 0,0
Ccc_XD0_XDFFQ_CLKB_XD2_t1 XD0_XDFFQ_CLKB XD2_t1 1.21e-17
* device instance cc_XD0_XDFFQ_CLKB_XD3_XDFFM_CKBB r0 *1 0,0
Ccc_XD0_XDFFQ_CLKB_XD3_XDFFM_CKBB XD0_XDFFQ_CLKB XD3_XDFFM_CKBB 1.8151e-17
* device instance cc_XD0_XDFFQ_CLKB_XD3_XDFFM_CLKB r0 *1 0,0
Ccc_XD0_XDFFQ_CLKB_XD3_XDFFM_CLKB XD0_XDFFQ_CLKB XD3_XDFFM_CLKB 2.4201e-17
* device instance cc_XD0_XDFFQ_CLKB_XD3_XDFFM_M r0 *1 0,0
Ccc_XD0_XDFFQ_CLKB_XD3_XDFFM_M XD0_XDFFQ_CLKB XD3_XDFFM_M 2.4201e-17
* device instance cc_XD0_XDFFQ_CLKB_XD3_XDFFM_MB r0 *1 0,0
Ccc_XD0_XDFFQ_CLKB_XD3_XDFFM_MB XD0_XDFFQ_CLKB XD3_XDFFM_MB 1.21e-17
* device instance cc_XD0_XDFFQ_CLKB_XD3_XDFFM_MFB r0 *1 0,0
Ccc_XD0_XDFFQ_CLKB_XD3_XDFFM_MFB XD0_XDFFQ_CLKB XD3_XDFFM_MFB 1.21e-17
* device instance cc_XD0_XDFFQ_CLKB_XD3_XDFFM_S r0 *1 0,0
Ccc_XD0_XDFFQ_CLKB_XD3_XDFFM_S XD0_XDFFQ_CLKB XD3_XDFFM_S 1.8151e-17
* device instance cc_XD0_XDFFQ_CLKB_XD3_XDFFM_SB r0 *1 0,0
Ccc_XD0_XDFFQ_CLKB_XD3_XDFFM_SB XD0_XDFFQ_CLKB XD3_XDFFM_SB 1.8151e-17
* device instance cc_XD0_XDFFQ_CLKB_XD3_XDFFM_SFB r0 *1 0,0
Ccc_XD0_XDFFQ_CLKB_XD3_XDFFM_SFB XD0_XDFFQ_CLKB XD3_XDFFM_SFB 1.21e-17
* device instance cc_XD0_XDFFQ_CLKB_XD3_XDFFQ_CKBB r0 *1 0,0
Ccc_XD0_XDFFQ_CLKB_XD3_XDFFQ_CKBB XD0_XDFFQ_CLKB XD3_XDFFQ_CKBB 1.8151e-17
* device instance cc_XD0_XDFFQ_CLKB_XD3_XDFFQ_CLKB r0 *1 0,0
Ccc_XD0_XDFFQ_CLKB_XD3_XDFFQ_CLKB XD0_XDFFQ_CLKB XD3_XDFFQ_CLKB 2.4201e-17
* device instance cc_XD0_XDFFQ_CLKB_XD3_XDFFQ_M r0 *1 0,0
Ccc_XD0_XDFFQ_CLKB_XD3_XDFFQ_M XD0_XDFFQ_CLKB XD3_XDFFQ_M 2.4201e-17
* device instance cc_XD0_XDFFQ_CLKB_XD3_XDFFQ_MB r0 *1 0,0
Ccc_XD0_XDFFQ_CLKB_XD3_XDFFQ_MB XD0_XDFFQ_CLKB XD3_XDFFQ_MB 1.21e-17
* device instance cc_XD0_XDFFQ_CLKB_XD3_XDFFQ_MFB r0 *1 0,0
Ccc_XD0_XDFFQ_CLKB_XD3_XDFFQ_MFB XD0_XDFFQ_CLKB XD3_XDFFQ_MFB 1.21e-17
* device instance cc_XD0_XDFFQ_CLKB_XD3_XDFFQ_S r0 *1 0,0
Ccc_XD0_XDFFQ_CLKB_XD3_XDFFQ_S XD0_XDFFQ_CLKB XD3_XDFFQ_S 1.8151e-17
* device instance cc_XD0_XDFFQ_CLKB_XD3_XDFFQ_SB r0 *1 0,0
Ccc_XD0_XDFFQ_CLKB_XD3_XDFFQ_SB XD0_XDFFQ_CLKB XD3_XDFFQ_SB 1.8151e-17
* device instance cc_XD0_XDFFQ_CLKB_XD3_XDFFQ_SFB r0 *1 0,0
Ccc_XD0_XDFFQ_CLKB_XD3_XDFFQ_SFB XD0_XDFFQ_CLKB XD3_XDFFQ_SFB 1.21e-17
* device instance cc_XD0_XDFFQ_CLKB_XD3_XN2_mid1 r0 *1 0,0
Ccc_XD0_XDFFQ_CLKB_XD3_XN2_mid1 XD0_XDFFQ_CLKB XD3_XN2_mid1 1.21e-17
* device instance cc_XD0_XDFFQ_CLKB_XD3_XN3_mid1 r0 *1 0,0
Ccc_XD0_XDFFQ_CLKB_XD3_XN3_mid1 XD0_XDFFQ_CLKB XD3_XN3_mid1 1.21e-17
* device instance cc_XD0_XDFFQ_CLKB_XD3_XN3_mid2 r0 *1 0,0
Ccc_XD0_XDFFQ_CLKB_XD3_XN3_mid2 XD0_XDFFQ_CLKB XD3_XN3_mid2 1.21e-17
* device instance cc_XD0_XDFFQ_CLKB_XD3_dmodout r0 *1 0,0
Ccc_XD0_XDFFQ_CLKB_XD3_dmodout XD0_XDFFQ_CLKB XD3_dmodout 1.21e-17
* device instance cc_XD0_XDFFQ_CLKB_XD3_dq r0 *1 0,0
Ccc_XD0_XDFFQ_CLKB_XD3_dq XD0_XDFFQ_CLKB XD3_dq 1.8151e-17
* device instance cc_XD0_XDFFQ_CLKB_XD3_nm r0 *1 0,0
Ccc_XD0_XDFFQ_CLKB_XD3_nm XD0_XDFFQ_CLKB XD3_nm 1.21e-17
* device instance cc_XD0_XDFFQ_CLKB_XD3_nt r0 *1 0,0
Ccc_XD0_XDFFQ_CLKB_XD3_nt XD0_XDFFQ_CLKB XD3_nt 1.21e-17
* device instance cc_XD0_XDFFQ_CLKB_XD3_t1 r0 *1 0,0
Ccc_XD0_XDFFQ_CLKB_XD3_t1 XD0_XDFFQ_CLKB XD3_t1 1.21e-17
* device instance cc_XD0_XDFFQ_CLKB_XD4_XDFFM_CKBB r0 *1 0,0
Ccc_XD0_XDFFQ_CLKB_XD4_XDFFM_CKBB XD0_XDFFQ_CLKB XD4_XDFFM_CKBB 1.8151e-17
* device instance cc_XD0_XDFFQ_CLKB_XD4_XDFFM_CLKB r0 *1 0,0
Ccc_XD0_XDFFQ_CLKB_XD4_XDFFM_CLKB XD0_XDFFQ_CLKB XD4_XDFFM_CLKB 2.4201e-17
* device instance cc_XD0_XDFFQ_CLKB_XD4_XDFFM_M r0 *1 0,0
Ccc_XD0_XDFFQ_CLKB_XD4_XDFFM_M XD0_XDFFQ_CLKB XD4_XDFFM_M 2.4201e-17
* device instance cc_XD0_XDFFQ_CLKB_XD4_XDFFM_MB r0 *1 0,0
Ccc_XD0_XDFFQ_CLKB_XD4_XDFFM_MB XD0_XDFFQ_CLKB XD4_XDFFM_MB 1.21e-17
* device instance cc_XD0_XDFFQ_CLKB_XD4_XDFFM_MFB r0 *1 0,0
Ccc_XD0_XDFFQ_CLKB_XD4_XDFFM_MFB XD0_XDFFQ_CLKB XD4_XDFFM_MFB 1.21e-17
* device instance cc_XD0_XDFFQ_CLKB_XD4_XDFFM_S r0 *1 0,0
Ccc_XD0_XDFFQ_CLKB_XD4_XDFFM_S XD0_XDFFQ_CLKB XD4_XDFFM_S 1.8151e-17
* device instance cc_XD0_XDFFQ_CLKB_XD4_XDFFM_SB r0 *1 0,0
Ccc_XD0_XDFFQ_CLKB_XD4_XDFFM_SB XD0_XDFFQ_CLKB XD4_XDFFM_SB 1.8151e-17
* device instance cc_XD0_XDFFQ_CLKB_XD4_XDFFM_SFB r0 *1 0,0
Ccc_XD0_XDFFQ_CLKB_XD4_XDFFM_SFB XD0_XDFFQ_CLKB XD4_XDFFM_SFB 1.21e-17
* device instance cc_XD0_XDFFQ_CLKB_XD4_XDFFQ_CKBB r0 *1 0,0
Ccc_XD0_XDFFQ_CLKB_XD4_XDFFQ_CKBB XD0_XDFFQ_CLKB XD4_XDFFQ_CKBB 1.8151e-17
* device instance cc_XD0_XDFFQ_CLKB_XD4_XDFFQ_CLKB r0 *1 0,0
Ccc_XD0_XDFFQ_CLKB_XD4_XDFFQ_CLKB XD0_XDFFQ_CLKB XD4_XDFFQ_CLKB 2.4201e-17
* device instance cc_XD0_XDFFQ_CLKB_XD4_XDFFQ_M r0 *1 0,0
Ccc_XD0_XDFFQ_CLKB_XD4_XDFFQ_M XD0_XDFFQ_CLKB XD4_XDFFQ_M 2.4201e-17
* device instance cc_XD0_XDFFQ_CLKB_XD4_XDFFQ_MB r0 *1 0,0
Ccc_XD0_XDFFQ_CLKB_XD4_XDFFQ_MB XD0_XDFFQ_CLKB XD4_XDFFQ_MB 1.21e-17
* device instance cc_XD0_XDFFQ_CLKB_XD4_XDFFQ_MFB r0 *1 0,0
Ccc_XD0_XDFFQ_CLKB_XD4_XDFFQ_MFB XD0_XDFFQ_CLKB XD4_XDFFQ_MFB 1.21e-17
* device instance cc_XD0_XDFFQ_CLKB_XD4_XDFFQ_S r0 *1 0,0
Ccc_XD0_XDFFQ_CLKB_XD4_XDFFQ_S XD0_XDFFQ_CLKB XD4_XDFFQ_S 1.8151e-17
* device instance cc_XD0_XDFFQ_CLKB_XD4_XDFFQ_SB r0 *1 0,0
Ccc_XD0_XDFFQ_CLKB_XD4_XDFFQ_SB XD0_XDFFQ_CLKB XD4_XDFFQ_SB 1.8151e-17
* device instance cc_XD0_XDFFQ_CLKB_XD4_XDFFQ_SFB r0 *1 0,0
Ccc_XD0_XDFFQ_CLKB_XD4_XDFFQ_SFB XD0_XDFFQ_CLKB XD4_XDFFQ_SFB 1.21e-17
* device instance cc_XD0_XDFFQ_CLKB_XD4_XN2_mid1 r0 *1 0,0
Ccc_XD0_XDFFQ_CLKB_XD4_XN2_mid1 XD0_XDFFQ_CLKB XD4_XN2_mid1 1.21e-17
* device instance cc_XD0_XDFFQ_CLKB_XD4_XN3_mid1 r0 *1 0,0
Ccc_XD0_XDFFQ_CLKB_XD4_XN3_mid1 XD0_XDFFQ_CLKB XD4_XN3_mid1 1.21e-17
* device instance cc_XD0_XDFFQ_CLKB_XD4_XN3_mid2 r0 *1 0,0
Ccc_XD0_XDFFQ_CLKB_XD4_XN3_mid2 XD0_XDFFQ_CLKB XD4_XN3_mid2 1.21e-17
* device instance cc_XD0_XDFFQ_CLKB_XD4_dmodout r0 *1 0,0
Ccc_XD0_XDFFQ_CLKB_XD4_dmodout XD0_XDFFQ_CLKB XD4_dmodout 1.21e-17
* device instance cc_XD0_XDFFQ_CLKB_XD4_dq r0 *1 0,0
Ccc_XD0_XDFFQ_CLKB_XD4_dq XD0_XDFFQ_CLKB XD4_dq 1.8151e-17
* device instance cc_XD0_XDFFQ_CLKB_XD4_nm r0 *1 0,0
Ccc_XD0_XDFFQ_CLKB_XD4_nm XD0_XDFFQ_CLKB XD4_nm 1.21e-17
* device instance cc_XD0_XDFFQ_CLKB_XD4_nt r0 *1 0,0
Ccc_XD0_XDFFQ_CLKB_XD4_nt XD0_XDFFQ_CLKB XD4_nt 1.21e-17
* device instance cc_XD0_XDFFQ_CLKB_XD4_t1 r0 *1 0,0
Ccc_XD0_XDFFQ_CLKB_XD4_t1 XD0_XDFFQ_CLKB XD4_t1 1.21e-17
* device instance cc_XD0_XDFFQ_CLKB_XD5_XDFFM_CKBB r0 *1 0,0
Ccc_XD0_XDFFQ_CLKB_XD5_XDFFM_CKBB XD0_XDFFQ_CLKB XD5_XDFFM_CKBB 1.8151e-17
* device instance cc_XD0_XDFFQ_CLKB_XD5_XDFFM_CLKB r0 *1 0,0
Ccc_XD0_XDFFQ_CLKB_XD5_XDFFM_CLKB XD0_XDFFQ_CLKB XD5_XDFFM_CLKB 2.4201e-17
* device instance cc_XD0_XDFFQ_CLKB_XD5_XDFFM_M r0 *1 0,0
Ccc_XD0_XDFFQ_CLKB_XD5_XDFFM_M XD0_XDFFQ_CLKB XD5_XDFFM_M 2.4201e-17
* device instance cc_XD0_XDFFQ_CLKB_XD5_XDFFM_MB r0 *1 0,0
Ccc_XD0_XDFFQ_CLKB_XD5_XDFFM_MB XD0_XDFFQ_CLKB XD5_XDFFM_MB 1.21e-17
* device instance cc_XD0_XDFFQ_CLKB_XD5_XDFFM_MFB r0 *1 0,0
Ccc_XD0_XDFFQ_CLKB_XD5_XDFFM_MFB XD0_XDFFQ_CLKB XD5_XDFFM_MFB 1.21e-17
* device instance cc_XD0_XDFFQ_CLKB_XD5_XDFFM_S r0 *1 0,0
Ccc_XD0_XDFFQ_CLKB_XD5_XDFFM_S XD0_XDFFQ_CLKB XD5_XDFFM_S 1.8151e-17
* device instance cc_XD0_XDFFQ_CLKB_XD5_XDFFM_SB r0 *1 0,0
Ccc_XD0_XDFFQ_CLKB_XD5_XDFFM_SB XD0_XDFFQ_CLKB XD5_XDFFM_SB 1.8151e-17
* device instance cc_XD0_XDFFQ_CLKB_XD5_XDFFM_SFB r0 *1 0,0
Ccc_XD0_XDFFQ_CLKB_XD5_XDFFM_SFB XD0_XDFFQ_CLKB XD5_XDFFM_SFB 1.21e-17
* device instance cc_XD0_XDFFQ_CLKB_XD5_XDFFQ_CKBB r0 *1 0,0
Ccc_XD0_XDFFQ_CLKB_XD5_XDFFQ_CKBB XD0_XDFFQ_CLKB XD5_XDFFQ_CKBB 1.8151e-17
* device instance cc_XD0_XDFFQ_CLKB_XD5_XDFFQ_CLKB r0 *1 0,0
Ccc_XD0_XDFFQ_CLKB_XD5_XDFFQ_CLKB XD0_XDFFQ_CLKB XD5_XDFFQ_CLKB 2.4201e-17
* device instance cc_XD0_XDFFQ_CLKB_XD5_XDFFQ_M r0 *1 0,0
Ccc_XD0_XDFFQ_CLKB_XD5_XDFFQ_M XD0_XDFFQ_CLKB XD5_XDFFQ_M 2.4201e-17
* device instance cc_XD0_XDFFQ_CLKB_XD5_XDFFQ_MB r0 *1 0,0
Ccc_XD0_XDFFQ_CLKB_XD5_XDFFQ_MB XD0_XDFFQ_CLKB XD5_XDFFQ_MB 1.21e-17
* device instance cc_XD0_XDFFQ_CLKB_XD5_XDFFQ_MFB r0 *1 0,0
Ccc_XD0_XDFFQ_CLKB_XD5_XDFFQ_MFB XD0_XDFFQ_CLKB XD5_XDFFQ_MFB 1.21e-17
* device instance cc_XD0_XDFFQ_CLKB_XD5_XDFFQ_S r0 *1 0,0
Ccc_XD0_XDFFQ_CLKB_XD5_XDFFQ_S XD0_XDFFQ_CLKB XD5_XDFFQ_S 1.8151e-17
* device instance cc_XD0_XDFFQ_CLKB_XD5_XDFFQ_SB r0 *1 0,0
Ccc_XD0_XDFFQ_CLKB_XD5_XDFFQ_SB XD0_XDFFQ_CLKB XD5_XDFFQ_SB 1.8151e-17
* device instance cc_XD0_XDFFQ_CLKB_XD5_XDFFQ_SFB r0 *1 0,0
Ccc_XD0_XDFFQ_CLKB_XD5_XDFFQ_SFB XD0_XDFFQ_CLKB XD5_XDFFQ_SFB 1.21e-17
* device instance cc_XD0_XDFFQ_CLKB_XD5_XN2_mid1 r0 *1 0,0
Ccc_XD0_XDFFQ_CLKB_XD5_XN2_mid1 XD0_XDFFQ_CLKB XD5_XN2_mid1 1.21e-17
* device instance cc_XD0_XDFFQ_CLKB_XD5_XN3_mid1 r0 *1 0,0
Ccc_XD0_XDFFQ_CLKB_XD5_XN3_mid1 XD0_XDFFQ_CLKB XD5_XN3_mid1 1.21e-17
* device instance cc_XD0_XDFFQ_CLKB_XD5_XN3_mid2 r0 *1 0,0
Ccc_XD0_XDFFQ_CLKB_XD5_XN3_mid2 XD0_XDFFQ_CLKB XD5_XN3_mid2 1.21e-17
* device instance cc_XD0_XDFFQ_CLKB_XD5_dmodout r0 *1 0,0
Ccc_XD0_XDFFQ_CLKB_XD5_dmodout XD0_XDFFQ_CLKB XD5_dmodout 1.21e-17
* device instance cc_XD0_XDFFQ_CLKB_XD5_dq r0 *1 0,0
Ccc_XD0_XDFFQ_CLKB_XD5_dq XD0_XDFFQ_CLKB XD5_dq 1.8151e-17
* device instance cc_XD0_XDFFQ_CLKB_XD5_nm r0 *1 0,0
Ccc_XD0_XDFFQ_CLKB_XD5_nm XD0_XDFFQ_CLKB XD5_nm 1.21e-17
* device instance cc_XD0_XDFFQ_CLKB_XD5_nt r0 *1 0,0
Ccc_XD0_XDFFQ_CLKB_XD5_nt XD0_XDFFQ_CLKB XD5_nt 1.21e-17
* device instance cc_XD0_XDFFQ_CLKB_XD5_t1 r0 *1 0,0
Ccc_XD0_XDFFQ_CLKB_XD5_t1 XD0_XDFFQ_CLKB XD5_t1 1.21e-17
* device instance cc_XD0_XDFFQ_CLKB_XFRT_CKBB r0 *1 0,0
Ccc_XD0_XDFFQ_CLKB_XFRT_CKBB XD0_XDFFQ_CLKB XFRT_CKBB 1.8151e-17
* device instance cc_XD0_XDFFQ_CLKB_XFRT_CLKB r0 *1 0,0
Ccc_XD0_XDFFQ_CLKB_XFRT_CLKB XD0_XDFFQ_CLKB XFRT_CLKB 2.4201e-17
* device instance cc_XD0_XDFFQ_CLKB_XFRT_M r0 *1 0,0
Ccc_XD0_XDFFQ_CLKB_XFRT_M XD0_XDFFQ_CLKB XFRT_M 2.4201e-17
* device instance cc_XD0_XDFFQ_CLKB_XFRT_MB r0 *1 0,0
Ccc_XD0_XDFFQ_CLKB_XFRT_MB XD0_XDFFQ_CLKB XFRT_MB 1.21e-17
* device instance cc_XD0_XDFFQ_CLKB_XFRT_MFB r0 *1 0,0
Ccc_XD0_XDFFQ_CLKB_XFRT_MFB XD0_XDFFQ_CLKB XFRT_MFB 1.21e-17
* device instance cc_XD0_XDFFQ_CLKB_XFRT_S r0 *1 0,0
Ccc_XD0_XDFFQ_CLKB_XFRT_S XD0_XDFFQ_CLKB XFRT_S 1.8151e-17
* device instance cc_XD0_XDFFQ_CLKB_XFRT_SB r0 *1 0,0
Ccc_XD0_XDFFQ_CLKB_XFRT_SB XD0_XDFFQ_CLKB XFRT_SB 1.8151e-17
* device instance cc_XD0_XDFFQ_CLKB_XFRT_SFB r0 *1 0,0
Ccc_XD0_XDFFQ_CLKB_XFRT_SFB XD0_XDFFQ_CLKB XFRT_SFB 1.21e-17
* device instance cc_XD0_XDFFQ_CLKB_ck1 r0 *1 0,0
Ccc_XD0_XDFFQ_CLKB_ck1 XD0_XDFFQ_CLKB ck1 3.0251e-17
* device instance cc_XD0_XDFFQ_CLKB_ck2 r0 *1 0,0
Ccc_XD0_XDFFQ_CLKB_ck2 XD0_XDFFQ_CLKB ck2 3.0251e-17
* device instance cc_XD0_XDFFQ_CLKB_ck3 r0 *1 0,0
Ccc_XD0_XDFFQ_CLKB_ck3 XD0_XDFFQ_CLKB ck3 3.0251e-17
* device instance cc_XD0_XDFFQ_CLKB_ck4 r0 *1 0,0
Ccc_XD0_XDFFQ_CLKB_ck4 XD0_XDFFQ_CLKB ck4 3.0251e-17
* device instance cc_XD0_XDFFQ_CLKB_ck5 r0 *1 0,0
Ccc_XD0_XDFFQ_CLKB_ck5 XD0_XDFFQ_CLKB ck5 3.0251e-17
* device instance cc_XD0_XDFFQ_CLKB_mod0 r0 *1 0,0
Ccc_XD0_XDFFQ_CLKB_mod0 XD0_XDFFQ_CLKB mod0 2.4201e-17
* device instance cc_XD0_XDFFQ_CLKB_mod1 r0 *1 0,0
Ccc_XD0_XDFFQ_CLKB_mod1 XD0_XDFFQ_CLKB mod1 2.4201e-17
* device instance cc_XD0_XDFFQ_CLKB_mod2 r0 *1 0,0
Ccc_XD0_XDFFQ_CLKB_mod2 XD0_XDFFQ_CLKB mod2 2.4201e-17
* device instance cc_XD0_XDFFQ_CLKB_mod3 r0 *1 0,0
Ccc_XD0_XDFFQ_CLKB_mod3 XD0_XDFFQ_CLKB mod3 2.4201e-17
* device instance cc_XD0_XDFFQ_CLKB_mod4 r0 *1 0,0
Ccc_XD0_XDFFQ_CLKB_mod4 XD0_XDFFQ_CLKB mod4 2.4201e-17
* device instance cc_XD0_XDFFQ_CLKB_net1 r0 *1 0,0
Ccc_XD0_XDFFQ_CLKB_net1 XD0_XDFFQ_CLKB net1 1.21e-17
* device instance cc_XD0_XDFFQ_M_XD0_XDFFQ_MB r0 *1 0,0
Ccc_XD0_XDFFQ_M_XD0_XDFFQ_MB XD0_XDFFQ_M XD0_XDFFQ_MB 2.4201e-17
* device instance cc_XD0_XDFFQ_M_XD0_XDFFQ_MFB r0 *1 0,0
Ccc_XD0_XDFFQ_M_XD0_XDFFQ_MFB XD0_XDFFQ_M XD0_XDFFQ_MFB 3.4688e-17
* device instance cc_XD0_XDFFQ_M_XD0_XDFFQ_S r0 *1 0,0
Ccc_XD0_XDFFQ_M_XD0_XDFFQ_S XD0_XDFFQ_M XD0_XDFFQ_S 2.8638e-17
* device instance cc_XD0_XDFFQ_M_XD0_XDFFQ_SB r0 *1 0,0
Ccc_XD0_XDFFQ_M_XD0_XDFFQ_SB XD0_XDFFQ_M XD0_XDFFQ_SB 1.8151e-17
* device instance cc_XD0_XDFFQ_M_XD0_XDFFQ_SFB r0 *1 0,0
Ccc_XD0_XDFFQ_M_XD0_XDFFQ_SFB XD0_XDFFQ_M XD0_XDFFQ_SFB 1.21e-17
* device instance cc_XD0_XDFFQ_M_XD0_XN2_mid1 r0 *1 0,0
Ccc_XD0_XDFFQ_M_XD0_XN2_mid1 XD0_XDFFQ_M XD0_XN2_mid1 1.21e-17
* device instance cc_XD0_XDFFQ_M_XD0_XNOR_midp r0 *1 0,0
Ccc_XD0_XDFFQ_M_XD0_XNOR_midp XD0_XDFFQ_M XD0_XNOR_midp 1.21e-17
* device instance cc_XD0_XDFFQ_M_XD0_dmodout r0 *1 0,0
Ccc_XD0_XDFFQ_M_XD0_dmodout XD0_XDFFQ_M XD0_dmodout 1.21e-17
* device instance cc_XD0_XDFFQ_M_XD0_dq r0 *1 0,0
Ccc_XD0_XDFFQ_M_XD0_dq XD0_XDFFQ_M XD0_dq 2.8638e-17
* device instance cc_XD0_XDFFQ_M_XD0_nm r0 *1 0,0
Ccc_XD0_XDFFQ_M_XD0_nm XD0_XDFFQ_M XD0_nm 1.21e-17
* device instance cc_XD0_XDFFQ_M_XD0_nt r0 *1 0,0
Ccc_XD0_XDFFQ_M_XD0_nt XD0_XDFFQ_M XD0_nt 2.4201e-17
* device instance cc_XD0_XDFFQ_M_XD0_t1 r0 *1 0,0
Ccc_XD0_XDFFQ_M_XD0_t1 XD0_XDFFQ_M XD0_t1 1.21e-17
* device instance cc_XD0_XDFFQ_M_XD1_XDFFM_CKBB r0 *1 0,0
Ccc_XD0_XDFFQ_M_XD1_XDFFM_CKBB XD0_XDFFQ_M XD1_XDFFM_CKBB 1.8151e-17
* device instance cc_XD0_XDFFQ_M_XD1_XDFFM_CLKB r0 *1 0,0
Ccc_XD0_XDFFQ_M_XD1_XDFFM_CLKB XD0_XDFFQ_M XD1_XDFFM_CLKB 2.4201e-17
* device instance cc_XD0_XDFFQ_M_XD1_XDFFM_M r0 *1 0,0
Ccc_XD0_XDFFQ_M_XD1_XDFFM_M XD0_XDFFQ_M XD1_XDFFM_M 2.4201e-17
* device instance cc_XD0_XDFFQ_M_XD1_XDFFM_MB r0 *1 0,0
Ccc_XD0_XDFFQ_M_XD1_XDFFM_MB XD0_XDFFQ_M XD1_XDFFM_MB 1.21e-17
* device instance cc_XD0_XDFFQ_M_XD1_XDFFM_MFB r0 *1 0,0
Ccc_XD0_XDFFQ_M_XD1_XDFFM_MFB XD0_XDFFQ_M XD1_XDFFM_MFB 1.21e-17
* device instance cc_XD0_XDFFQ_M_XD1_XDFFM_S r0 *1 0,0
Ccc_XD0_XDFFQ_M_XD1_XDFFM_S XD0_XDFFQ_M XD1_XDFFM_S 1.8151e-17
* device instance cc_XD0_XDFFQ_M_XD1_XDFFM_SB r0 *1 0,0
Ccc_XD0_XDFFQ_M_XD1_XDFFM_SB XD0_XDFFQ_M XD1_XDFFM_SB 1.8151e-17
* device instance cc_XD0_XDFFQ_M_XD1_XDFFM_SFB r0 *1 0,0
Ccc_XD0_XDFFQ_M_XD1_XDFFM_SFB XD0_XDFFQ_M XD1_XDFFM_SFB 1.21e-17
* device instance cc_XD0_XDFFQ_M_XD1_XDFFQ_CKBB r0 *1 0,0
Ccc_XD0_XDFFQ_M_XD1_XDFFQ_CKBB XD0_XDFFQ_M XD1_XDFFQ_CKBB 1.8151e-17
* device instance cc_XD0_XDFFQ_M_XD1_XDFFQ_CLKB r0 *1 0,0
Ccc_XD0_XDFFQ_M_XD1_XDFFQ_CLKB XD0_XDFFQ_M XD1_XDFFQ_CLKB 2.4201e-17
* device instance cc_XD0_XDFFQ_M_XD1_XDFFQ_M r0 *1 0,0
Ccc_XD0_XDFFQ_M_XD1_XDFFQ_M XD0_XDFFQ_M XD1_XDFFQ_M 2.4201e-17
* device instance cc_XD0_XDFFQ_M_XD1_XDFFQ_MB r0 *1 0,0
Ccc_XD0_XDFFQ_M_XD1_XDFFQ_MB XD0_XDFFQ_M XD1_XDFFQ_MB 1.21e-17
* device instance cc_XD0_XDFFQ_M_XD1_XDFFQ_MFB r0 *1 0,0
Ccc_XD0_XDFFQ_M_XD1_XDFFQ_MFB XD0_XDFFQ_M XD1_XDFFQ_MFB 1.21e-17
* device instance cc_XD0_XDFFQ_M_XD1_XDFFQ_S r0 *1 0,0
Ccc_XD0_XDFFQ_M_XD1_XDFFQ_S XD0_XDFFQ_M XD1_XDFFQ_S 1.8151e-17
* device instance cc_XD0_XDFFQ_M_XD1_XDFFQ_SB r0 *1 0,0
Ccc_XD0_XDFFQ_M_XD1_XDFFQ_SB XD0_XDFFQ_M XD1_XDFFQ_SB 1.8151e-17
* device instance cc_XD0_XDFFQ_M_XD1_XDFFQ_SFB r0 *1 0,0
Ccc_XD0_XDFFQ_M_XD1_XDFFQ_SFB XD0_XDFFQ_M XD1_XDFFQ_SFB 1.21e-17
* device instance cc_XD0_XDFFQ_M_XD1_XN2_mid1 r0 *1 0,0
Ccc_XD0_XDFFQ_M_XD1_XN2_mid1 XD0_XDFFQ_M XD1_XN2_mid1 1.21e-17
* device instance cc_XD0_XDFFQ_M_XD1_XN3_mid1 r0 *1 0,0
Ccc_XD0_XDFFQ_M_XD1_XN3_mid1 XD0_XDFFQ_M XD1_XN3_mid1 1.21e-17
* device instance cc_XD0_XDFFQ_M_XD1_XN3_mid2 r0 *1 0,0
Ccc_XD0_XDFFQ_M_XD1_XN3_mid2 XD0_XDFFQ_M XD1_XN3_mid2 1.21e-17
* device instance cc_XD0_XDFFQ_M_XD1_dmodout r0 *1 0,0
Ccc_XD0_XDFFQ_M_XD1_dmodout XD0_XDFFQ_M XD1_dmodout 1.21e-17
* device instance cc_XD0_XDFFQ_M_XD1_dq r0 *1 0,0
Ccc_XD0_XDFFQ_M_XD1_dq XD0_XDFFQ_M XD1_dq 1.8151e-17
* device instance cc_XD0_XDFFQ_M_XD1_nm r0 *1 0,0
Ccc_XD0_XDFFQ_M_XD1_nm XD0_XDFFQ_M XD1_nm 1.21e-17
* device instance cc_XD0_XDFFQ_M_XD1_nt r0 *1 0,0
Ccc_XD0_XDFFQ_M_XD1_nt XD0_XDFFQ_M XD1_nt 1.21e-17
* device instance cc_XD0_XDFFQ_M_XD1_t1 r0 *1 0,0
Ccc_XD0_XDFFQ_M_XD1_t1 XD0_XDFFQ_M XD1_t1 1.21e-17
* device instance cc_XD0_XDFFQ_M_XD2_XDFFM_CKBB r0 *1 0,0
Ccc_XD0_XDFFQ_M_XD2_XDFFM_CKBB XD0_XDFFQ_M XD2_XDFFM_CKBB 1.8151e-17
* device instance cc_XD0_XDFFQ_M_XD2_XDFFM_CLKB r0 *1 0,0
Ccc_XD0_XDFFQ_M_XD2_XDFFM_CLKB XD0_XDFFQ_M XD2_XDFFM_CLKB 2.4201e-17
* device instance cc_XD0_XDFFQ_M_XD2_XDFFM_M r0 *1 0,0
Ccc_XD0_XDFFQ_M_XD2_XDFFM_M XD0_XDFFQ_M XD2_XDFFM_M 2.4201e-17
* device instance cc_XD0_XDFFQ_M_XD2_XDFFM_MB r0 *1 0,0
Ccc_XD0_XDFFQ_M_XD2_XDFFM_MB XD0_XDFFQ_M XD2_XDFFM_MB 1.21e-17
* device instance cc_XD0_XDFFQ_M_XD2_XDFFM_MFB r0 *1 0,0
Ccc_XD0_XDFFQ_M_XD2_XDFFM_MFB XD0_XDFFQ_M XD2_XDFFM_MFB 1.21e-17
* device instance cc_XD0_XDFFQ_M_XD2_XDFFM_S r0 *1 0,0
Ccc_XD0_XDFFQ_M_XD2_XDFFM_S XD0_XDFFQ_M XD2_XDFFM_S 1.8151e-17
* device instance cc_XD0_XDFFQ_M_XD2_XDFFM_SB r0 *1 0,0
Ccc_XD0_XDFFQ_M_XD2_XDFFM_SB XD0_XDFFQ_M XD2_XDFFM_SB 1.8151e-17
* device instance cc_XD0_XDFFQ_M_XD2_XDFFM_SFB r0 *1 0,0
Ccc_XD0_XDFFQ_M_XD2_XDFFM_SFB XD0_XDFFQ_M XD2_XDFFM_SFB 1.21e-17
* device instance cc_XD0_XDFFQ_M_XD2_XDFFQ_CKBB r0 *1 0,0
Ccc_XD0_XDFFQ_M_XD2_XDFFQ_CKBB XD0_XDFFQ_M XD2_XDFFQ_CKBB 1.8151e-17
* device instance cc_XD0_XDFFQ_M_XD2_XDFFQ_CLKB r0 *1 0,0
Ccc_XD0_XDFFQ_M_XD2_XDFFQ_CLKB XD0_XDFFQ_M XD2_XDFFQ_CLKB 2.4201e-17
* device instance cc_XD0_XDFFQ_M_XD2_XDFFQ_M r0 *1 0,0
Ccc_XD0_XDFFQ_M_XD2_XDFFQ_M XD0_XDFFQ_M XD2_XDFFQ_M 2.4201e-17
* device instance cc_XD0_XDFFQ_M_XD2_XDFFQ_MB r0 *1 0,0
Ccc_XD0_XDFFQ_M_XD2_XDFFQ_MB XD0_XDFFQ_M XD2_XDFFQ_MB 1.21e-17
* device instance cc_XD0_XDFFQ_M_XD2_XDFFQ_MFB r0 *1 0,0
Ccc_XD0_XDFFQ_M_XD2_XDFFQ_MFB XD0_XDFFQ_M XD2_XDFFQ_MFB 1.21e-17
* device instance cc_XD0_XDFFQ_M_XD2_XDFFQ_S r0 *1 0,0
Ccc_XD0_XDFFQ_M_XD2_XDFFQ_S XD0_XDFFQ_M XD2_XDFFQ_S 1.8151e-17
* device instance cc_XD0_XDFFQ_M_XD2_XDFFQ_SB r0 *1 0,0
Ccc_XD0_XDFFQ_M_XD2_XDFFQ_SB XD0_XDFFQ_M XD2_XDFFQ_SB 1.8151e-17
* device instance cc_XD0_XDFFQ_M_XD2_XDFFQ_SFB r0 *1 0,0
Ccc_XD0_XDFFQ_M_XD2_XDFFQ_SFB XD0_XDFFQ_M XD2_XDFFQ_SFB 1.21e-17
* device instance cc_XD0_XDFFQ_M_XD2_XN2_mid1 r0 *1 0,0
Ccc_XD0_XDFFQ_M_XD2_XN2_mid1 XD0_XDFFQ_M XD2_XN2_mid1 1.21e-17
* device instance cc_XD0_XDFFQ_M_XD2_XN3_mid1 r0 *1 0,0
Ccc_XD0_XDFFQ_M_XD2_XN3_mid1 XD0_XDFFQ_M XD2_XN3_mid1 1.21e-17
* device instance cc_XD0_XDFFQ_M_XD2_XN3_mid2 r0 *1 0,0
Ccc_XD0_XDFFQ_M_XD2_XN3_mid2 XD0_XDFFQ_M XD2_XN3_mid2 1.21e-17
* device instance cc_XD0_XDFFQ_M_XD2_dmodout r0 *1 0,0
Ccc_XD0_XDFFQ_M_XD2_dmodout XD0_XDFFQ_M XD2_dmodout 1.21e-17
* device instance cc_XD0_XDFFQ_M_XD2_dq r0 *1 0,0
Ccc_XD0_XDFFQ_M_XD2_dq XD0_XDFFQ_M XD2_dq 1.8151e-17
* device instance cc_XD0_XDFFQ_M_XD2_nm r0 *1 0,0
Ccc_XD0_XDFFQ_M_XD2_nm XD0_XDFFQ_M XD2_nm 1.21e-17
* device instance cc_XD0_XDFFQ_M_XD2_nt r0 *1 0,0
Ccc_XD0_XDFFQ_M_XD2_nt XD0_XDFFQ_M XD2_nt 1.21e-17
* device instance cc_XD0_XDFFQ_M_XD2_t1 r0 *1 0,0
Ccc_XD0_XDFFQ_M_XD2_t1 XD0_XDFFQ_M XD2_t1 1.21e-17
* device instance cc_XD0_XDFFQ_M_XD3_XDFFM_CKBB r0 *1 0,0
Ccc_XD0_XDFFQ_M_XD3_XDFFM_CKBB XD0_XDFFQ_M XD3_XDFFM_CKBB 1.8151e-17
* device instance cc_XD0_XDFFQ_M_XD3_XDFFM_CLKB r0 *1 0,0
Ccc_XD0_XDFFQ_M_XD3_XDFFM_CLKB XD0_XDFFQ_M XD3_XDFFM_CLKB 2.4201e-17
* device instance cc_XD0_XDFFQ_M_XD3_XDFFM_M r0 *1 0,0
Ccc_XD0_XDFFQ_M_XD3_XDFFM_M XD0_XDFFQ_M XD3_XDFFM_M 2.4201e-17
* device instance cc_XD0_XDFFQ_M_XD3_XDFFM_MB r0 *1 0,0
Ccc_XD0_XDFFQ_M_XD3_XDFFM_MB XD0_XDFFQ_M XD3_XDFFM_MB 1.21e-17
* device instance cc_XD0_XDFFQ_M_XD3_XDFFM_MFB r0 *1 0,0
Ccc_XD0_XDFFQ_M_XD3_XDFFM_MFB XD0_XDFFQ_M XD3_XDFFM_MFB 1.21e-17
* device instance cc_XD0_XDFFQ_M_XD3_XDFFM_S r0 *1 0,0
Ccc_XD0_XDFFQ_M_XD3_XDFFM_S XD0_XDFFQ_M XD3_XDFFM_S 1.8151e-17
* device instance cc_XD0_XDFFQ_M_XD3_XDFFM_SB r0 *1 0,0
Ccc_XD0_XDFFQ_M_XD3_XDFFM_SB XD0_XDFFQ_M XD3_XDFFM_SB 1.8151e-17
* device instance cc_XD0_XDFFQ_M_XD3_XDFFM_SFB r0 *1 0,0
Ccc_XD0_XDFFQ_M_XD3_XDFFM_SFB XD0_XDFFQ_M XD3_XDFFM_SFB 1.21e-17
* device instance cc_XD0_XDFFQ_M_XD3_XDFFQ_CKBB r0 *1 0,0
Ccc_XD0_XDFFQ_M_XD3_XDFFQ_CKBB XD0_XDFFQ_M XD3_XDFFQ_CKBB 1.8151e-17
* device instance cc_XD0_XDFFQ_M_XD3_XDFFQ_CLKB r0 *1 0,0
Ccc_XD0_XDFFQ_M_XD3_XDFFQ_CLKB XD0_XDFFQ_M XD3_XDFFQ_CLKB 2.4201e-17
* device instance cc_XD0_XDFFQ_M_XD3_XDFFQ_M r0 *1 0,0
Ccc_XD0_XDFFQ_M_XD3_XDFFQ_M XD0_XDFFQ_M XD3_XDFFQ_M 2.4201e-17
* device instance cc_XD0_XDFFQ_M_XD3_XDFFQ_MB r0 *1 0,0
Ccc_XD0_XDFFQ_M_XD3_XDFFQ_MB XD0_XDFFQ_M XD3_XDFFQ_MB 1.21e-17
* device instance cc_XD0_XDFFQ_M_XD3_XDFFQ_MFB r0 *1 0,0
Ccc_XD0_XDFFQ_M_XD3_XDFFQ_MFB XD0_XDFFQ_M XD3_XDFFQ_MFB 1.21e-17
* device instance cc_XD0_XDFFQ_M_XD3_XDFFQ_S r0 *1 0,0
Ccc_XD0_XDFFQ_M_XD3_XDFFQ_S XD0_XDFFQ_M XD3_XDFFQ_S 1.8151e-17
* device instance cc_XD0_XDFFQ_M_XD3_XDFFQ_SB r0 *1 0,0
Ccc_XD0_XDFFQ_M_XD3_XDFFQ_SB XD0_XDFFQ_M XD3_XDFFQ_SB 1.8151e-17
* device instance cc_XD0_XDFFQ_M_XD3_XDFFQ_SFB r0 *1 0,0
Ccc_XD0_XDFFQ_M_XD3_XDFFQ_SFB XD0_XDFFQ_M XD3_XDFFQ_SFB 1.21e-17
* device instance cc_XD0_XDFFQ_M_XD3_XN2_mid1 r0 *1 0,0
Ccc_XD0_XDFFQ_M_XD3_XN2_mid1 XD0_XDFFQ_M XD3_XN2_mid1 1.21e-17
* device instance cc_XD0_XDFFQ_M_XD3_XN3_mid1 r0 *1 0,0
Ccc_XD0_XDFFQ_M_XD3_XN3_mid1 XD0_XDFFQ_M XD3_XN3_mid1 1.21e-17
* device instance cc_XD0_XDFFQ_M_XD3_XN3_mid2 r0 *1 0,0
Ccc_XD0_XDFFQ_M_XD3_XN3_mid2 XD0_XDFFQ_M XD3_XN3_mid2 1.21e-17
* device instance cc_XD0_XDFFQ_M_XD3_dmodout r0 *1 0,0
Ccc_XD0_XDFFQ_M_XD3_dmodout XD0_XDFFQ_M XD3_dmodout 1.21e-17
* device instance cc_XD0_XDFFQ_M_XD3_dq r0 *1 0,0
Ccc_XD0_XDFFQ_M_XD3_dq XD0_XDFFQ_M XD3_dq 1.8151e-17
* device instance cc_XD0_XDFFQ_M_XD3_nm r0 *1 0,0
Ccc_XD0_XDFFQ_M_XD3_nm XD0_XDFFQ_M XD3_nm 1.21e-17
* device instance cc_XD0_XDFFQ_M_XD3_nt r0 *1 0,0
Ccc_XD0_XDFFQ_M_XD3_nt XD0_XDFFQ_M XD3_nt 1.21e-17
* device instance cc_XD0_XDFFQ_M_XD3_t1 r0 *1 0,0
Ccc_XD0_XDFFQ_M_XD3_t1 XD0_XDFFQ_M XD3_t1 1.21e-17
* device instance cc_XD0_XDFFQ_M_XD4_XDFFM_CKBB r0 *1 0,0
Ccc_XD0_XDFFQ_M_XD4_XDFFM_CKBB XD0_XDFFQ_M XD4_XDFFM_CKBB 1.8151e-17
* device instance cc_XD0_XDFFQ_M_XD4_XDFFM_CLKB r0 *1 0,0
Ccc_XD0_XDFFQ_M_XD4_XDFFM_CLKB XD0_XDFFQ_M XD4_XDFFM_CLKB 2.4201e-17
* device instance cc_XD0_XDFFQ_M_XD4_XDFFM_M r0 *1 0,0
Ccc_XD0_XDFFQ_M_XD4_XDFFM_M XD0_XDFFQ_M XD4_XDFFM_M 2.4201e-17
* device instance cc_XD0_XDFFQ_M_XD4_XDFFM_MB r0 *1 0,0
Ccc_XD0_XDFFQ_M_XD4_XDFFM_MB XD0_XDFFQ_M XD4_XDFFM_MB 1.21e-17
* device instance cc_XD0_XDFFQ_M_XD4_XDFFM_MFB r0 *1 0,0
Ccc_XD0_XDFFQ_M_XD4_XDFFM_MFB XD0_XDFFQ_M XD4_XDFFM_MFB 1.21e-17
* device instance cc_XD0_XDFFQ_M_XD4_XDFFM_S r0 *1 0,0
Ccc_XD0_XDFFQ_M_XD4_XDFFM_S XD0_XDFFQ_M XD4_XDFFM_S 1.8151e-17
* device instance cc_XD0_XDFFQ_M_XD4_XDFFM_SB r0 *1 0,0
Ccc_XD0_XDFFQ_M_XD4_XDFFM_SB XD0_XDFFQ_M XD4_XDFFM_SB 1.8151e-17
* device instance cc_XD0_XDFFQ_M_XD4_XDFFM_SFB r0 *1 0,0
Ccc_XD0_XDFFQ_M_XD4_XDFFM_SFB XD0_XDFFQ_M XD4_XDFFM_SFB 1.21e-17
* device instance cc_XD0_XDFFQ_M_XD4_XDFFQ_CKBB r0 *1 0,0
Ccc_XD0_XDFFQ_M_XD4_XDFFQ_CKBB XD0_XDFFQ_M XD4_XDFFQ_CKBB 1.8151e-17
* device instance cc_XD0_XDFFQ_M_XD4_XDFFQ_CLKB r0 *1 0,0
Ccc_XD0_XDFFQ_M_XD4_XDFFQ_CLKB XD0_XDFFQ_M XD4_XDFFQ_CLKB 2.4201e-17
* device instance cc_XD0_XDFFQ_M_XD4_XDFFQ_M r0 *1 0,0
Ccc_XD0_XDFFQ_M_XD4_XDFFQ_M XD0_XDFFQ_M XD4_XDFFQ_M 2.4201e-17
* device instance cc_XD0_XDFFQ_M_XD4_XDFFQ_MB r0 *1 0,0
Ccc_XD0_XDFFQ_M_XD4_XDFFQ_MB XD0_XDFFQ_M XD4_XDFFQ_MB 1.21e-17
* device instance cc_XD0_XDFFQ_M_XD4_XDFFQ_MFB r0 *1 0,0
Ccc_XD0_XDFFQ_M_XD4_XDFFQ_MFB XD0_XDFFQ_M XD4_XDFFQ_MFB 1.21e-17
* device instance cc_XD0_XDFFQ_M_XD4_XDFFQ_S r0 *1 0,0
Ccc_XD0_XDFFQ_M_XD4_XDFFQ_S XD0_XDFFQ_M XD4_XDFFQ_S 1.8151e-17
* device instance cc_XD0_XDFFQ_M_XD4_XDFFQ_SB r0 *1 0,0
Ccc_XD0_XDFFQ_M_XD4_XDFFQ_SB XD0_XDFFQ_M XD4_XDFFQ_SB 1.8151e-17
* device instance cc_XD0_XDFFQ_M_XD4_XDFFQ_SFB r0 *1 0,0
Ccc_XD0_XDFFQ_M_XD4_XDFFQ_SFB XD0_XDFFQ_M XD4_XDFFQ_SFB 1.21e-17
* device instance cc_XD0_XDFFQ_M_XD4_XN2_mid1 r0 *1 0,0
Ccc_XD0_XDFFQ_M_XD4_XN2_mid1 XD0_XDFFQ_M XD4_XN2_mid1 1.21e-17
* device instance cc_XD0_XDFFQ_M_XD4_XN3_mid1 r0 *1 0,0
Ccc_XD0_XDFFQ_M_XD4_XN3_mid1 XD0_XDFFQ_M XD4_XN3_mid1 1.21e-17
* device instance cc_XD0_XDFFQ_M_XD4_XN3_mid2 r0 *1 0,0
Ccc_XD0_XDFFQ_M_XD4_XN3_mid2 XD0_XDFFQ_M XD4_XN3_mid2 1.21e-17
* device instance cc_XD0_XDFFQ_M_XD4_dmodout r0 *1 0,0
Ccc_XD0_XDFFQ_M_XD4_dmodout XD0_XDFFQ_M XD4_dmodout 1.21e-17
* device instance cc_XD0_XDFFQ_M_XD4_dq r0 *1 0,0
Ccc_XD0_XDFFQ_M_XD4_dq XD0_XDFFQ_M XD4_dq 1.8151e-17
* device instance cc_XD0_XDFFQ_M_XD4_nm r0 *1 0,0
Ccc_XD0_XDFFQ_M_XD4_nm XD0_XDFFQ_M XD4_nm 1.21e-17
* device instance cc_XD0_XDFFQ_M_XD4_nt r0 *1 0,0
Ccc_XD0_XDFFQ_M_XD4_nt XD0_XDFFQ_M XD4_nt 1.21e-17
* device instance cc_XD0_XDFFQ_M_XD4_t1 r0 *1 0,0
Ccc_XD0_XDFFQ_M_XD4_t1 XD0_XDFFQ_M XD4_t1 1.21e-17
* device instance cc_XD0_XDFFQ_M_XD5_XDFFM_CKBB r0 *1 0,0
Ccc_XD0_XDFFQ_M_XD5_XDFFM_CKBB XD0_XDFFQ_M XD5_XDFFM_CKBB 1.8151e-17
* device instance cc_XD0_XDFFQ_M_XD5_XDFFM_CLKB r0 *1 0,0
Ccc_XD0_XDFFQ_M_XD5_XDFFM_CLKB XD0_XDFFQ_M XD5_XDFFM_CLKB 2.4201e-17
* device instance cc_XD0_XDFFQ_M_XD5_XDFFM_M r0 *1 0,0
Ccc_XD0_XDFFQ_M_XD5_XDFFM_M XD0_XDFFQ_M XD5_XDFFM_M 2.4201e-17
* device instance cc_XD0_XDFFQ_M_XD5_XDFFM_MB r0 *1 0,0
Ccc_XD0_XDFFQ_M_XD5_XDFFM_MB XD0_XDFFQ_M XD5_XDFFM_MB 1.21e-17
* device instance cc_XD0_XDFFQ_M_XD5_XDFFM_MFB r0 *1 0,0
Ccc_XD0_XDFFQ_M_XD5_XDFFM_MFB XD0_XDFFQ_M XD5_XDFFM_MFB 1.21e-17
* device instance cc_XD0_XDFFQ_M_XD5_XDFFM_S r0 *1 0,0
Ccc_XD0_XDFFQ_M_XD5_XDFFM_S XD0_XDFFQ_M XD5_XDFFM_S 1.8151e-17
* device instance cc_XD0_XDFFQ_M_XD5_XDFFM_SB r0 *1 0,0
Ccc_XD0_XDFFQ_M_XD5_XDFFM_SB XD0_XDFFQ_M XD5_XDFFM_SB 1.8151e-17
* device instance cc_XD0_XDFFQ_M_XD5_XDFFM_SFB r0 *1 0,0
Ccc_XD0_XDFFQ_M_XD5_XDFFM_SFB XD0_XDFFQ_M XD5_XDFFM_SFB 1.21e-17
* device instance cc_XD0_XDFFQ_M_XD5_XDFFQ_CKBB r0 *1 0,0
Ccc_XD0_XDFFQ_M_XD5_XDFFQ_CKBB XD0_XDFFQ_M XD5_XDFFQ_CKBB 1.8151e-17
* device instance cc_XD0_XDFFQ_M_XD5_XDFFQ_CLKB r0 *1 0,0
Ccc_XD0_XDFFQ_M_XD5_XDFFQ_CLKB XD0_XDFFQ_M XD5_XDFFQ_CLKB 2.4201e-17
* device instance cc_XD0_XDFFQ_M_XD5_XDFFQ_M r0 *1 0,0
Ccc_XD0_XDFFQ_M_XD5_XDFFQ_M XD0_XDFFQ_M XD5_XDFFQ_M 2.4201e-17
* device instance cc_XD0_XDFFQ_M_XD5_XDFFQ_MB r0 *1 0,0
Ccc_XD0_XDFFQ_M_XD5_XDFFQ_MB XD0_XDFFQ_M XD5_XDFFQ_MB 1.21e-17
* device instance cc_XD0_XDFFQ_M_XD5_XDFFQ_MFB r0 *1 0,0
Ccc_XD0_XDFFQ_M_XD5_XDFFQ_MFB XD0_XDFFQ_M XD5_XDFFQ_MFB 1.21e-17
* device instance cc_XD0_XDFFQ_M_XD5_XDFFQ_S r0 *1 0,0
Ccc_XD0_XDFFQ_M_XD5_XDFFQ_S XD0_XDFFQ_M XD5_XDFFQ_S 1.8151e-17
* device instance cc_XD0_XDFFQ_M_XD5_XDFFQ_SB r0 *1 0,0
Ccc_XD0_XDFFQ_M_XD5_XDFFQ_SB XD0_XDFFQ_M XD5_XDFFQ_SB 1.8151e-17
* device instance cc_XD0_XDFFQ_M_XD5_XDFFQ_SFB r0 *1 0,0
Ccc_XD0_XDFFQ_M_XD5_XDFFQ_SFB XD0_XDFFQ_M XD5_XDFFQ_SFB 1.21e-17
* device instance cc_XD0_XDFFQ_M_XD5_XN2_mid1 r0 *1 0,0
Ccc_XD0_XDFFQ_M_XD5_XN2_mid1 XD0_XDFFQ_M XD5_XN2_mid1 1.21e-17
* device instance cc_XD0_XDFFQ_M_XD5_XN3_mid1 r0 *1 0,0
Ccc_XD0_XDFFQ_M_XD5_XN3_mid1 XD0_XDFFQ_M XD5_XN3_mid1 1.21e-17
* device instance cc_XD0_XDFFQ_M_XD5_XN3_mid2 r0 *1 0,0
Ccc_XD0_XDFFQ_M_XD5_XN3_mid2 XD0_XDFFQ_M XD5_XN3_mid2 1.21e-17
* device instance cc_XD0_XDFFQ_M_XD5_dmodout r0 *1 0,0
Ccc_XD0_XDFFQ_M_XD5_dmodout XD0_XDFFQ_M XD5_dmodout 1.21e-17
* device instance cc_XD0_XDFFQ_M_XD5_dq r0 *1 0,0
Ccc_XD0_XDFFQ_M_XD5_dq XD0_XDFFQ_M XD5_dq 1.8151e-17
* device instance cc_XD0_XDFFQ_M_XD5_nm r0 *1 0,0
Ccc_XD0_XDFFQ_M_XD5_nm XD0_XDFFQ_M XD5_nm 1.21e-17
* device instance cc_XD0_XDFFQ_M_XD5_nt r0 *1 0,0
Ccc_XD0_XDFFQ_M_XD5_nt XD0_XDFFQ_M XD5_nt 1.21e-17
* device instance cc_XD0_XDFFQ_M_XD5_t1 r0 *1 0,0
Ccc_XD0_XDFFQ_M_XD5_t1 XD0_XDFFQ_M XD5_t1 1.21e-17
* device instance cc_XD0_XDFFQ_M_XFRT_CKBB r0 *1 0,0
Ccc_XD0_XDFFQ_M_XFRT_CKBB XD0_XDFFQ_M XFRT_CKBB 1.8151e-17
* device instance cc_XD0_XDFFQ_M_XFRT_CLKB r0 *1 0,0
Ccc_XD0_XDFFQ_M_XFRT_CLKB XD0_XDFFQ_M XFRT_CLKB 2.4201e-17
* device instance cc_XD0_XDFFQ_M_XFRT_M r0 *1 0,0
Ccc_XD0_XDFFQ_M_XFRT_M XD0_XDFFQ_M XFRT_M 2.4201e-17
* device instance cc_XD0_XDFFQ_M_XFRT_MB r0 *1 0,0
Ccc_XD0_XDFFQ_M_XFRT_MB XD0_XDFFQ_M XFRT_MB 1.21e-17
* device instance cc_XD0_XDFFQ_M_XFRT_MFB r0 *1 0,0
Ccc_XD0_XDFFQ_M_XFRT_MFB XD0_XDFFQ_M XFRT_MFB 1.21e-17
* device instance cc_XD0_XDFFQ_M_XFRT_S r0 *1 0,0
Ccc_XD0_XDFFQ_M_XFRT_S XD0_XDFFQ_M XFRT_S 1.8151e-17
* device instance cc_XD0_XDFFQ_M_XFRT_SB r0 *1 0,0
Ccc_XD0_XDFFQ_M_XFRT_SB XD0_XDFFQ_M XFRT_SB 1.8151e-17
* device instance cc_XD0_XDFFQ_M_XFRT_SFB r0 *1 0,0
Ccc_XD0_XDFFQ_M_XFRT_SFB XD0_XDFFQ_M XFRT_SFB 1.21e-17
* device instance cc_XD0_XDFFQ_M_ck1 r0 *1 0,0
Ccc_XD0_XDFFQ_M_ck1 XD0_XDFFQ_M ck1 3.0251e-17
* device instance cc_XD0_XDFFQ_M_ck2 r0 *1 0,0
Ccc_XD0_XDFFQ_M_ck2 XD0_XDFFQ_M ck2 3.0251e-17
* device instance cc_XD0_XDFFQ_M_ck3 r0 *1 0,0
Ccc_XD0_XDFFQ_M_ck3 XD0_XDFFQ_M ck3 3.0251e-17
* device instance cc_XD0_XDFFQ_M_ck4 r0 *1 0,0
Ccc_XD0_XDFFQ_M_ck4 XD0_XDFFQ_M ck4 3.0251e-17
* device instance cc_XD0_XDFFQ_M_ck5 r0 *1 0,0
Ccc_XD0_XDFFQ_M_ck5 XD0_XDFFQ_M ck5 3.0251e-17
* device instance cc_XD0_XDFFQ_M_mod0 r0 *1 0,0
Ccc_XD0_XDFFQ_M_mod0 XD0_XDFFQ_M mod0 2.4201e-17
* device instance cc_XD0_XDFFQ_M_mod1 r0 *1 0,0
Ccc_XD0_XDFFQ_M_mod1 XD0_XDFFQ_M mod1 2.4201e-17
* device instance cc_XD0_XDFFQ_M_mod2 r0 *1 0,0
Ccc_XD0_XDFFQ_M_mod2 XD0_XDFFQ_M mod2 2.4201e-17
* device instance cc_XD0_XDFFQ_M_mod3 r0 *1 0,0
Ccc_XD0_XDFFQ_M_mod3 XD0_XDFFQ_M mod3 2.4201e-17
* device instance cc_XD0_XDFFQ_M_mod4 r0 *1 0,0
Ccc_XD0_XDFFQ_M_mod4 XD0_XDFFQ_M mod4 2.4201e-17
* device instance cc_XD0_XDFFQ_M_net1 r0 *1 0,0
Ccc_XD0_XDFFQ_M_net1 XD0_XDFFQ_M net1 1.21e-17
* device instance cc_XD0_XDFFQ_MB_XD0_XDFFQ_MFB r0 *1 0,0
Ccc_XD0_XDFFQ_MB_XD0_XDFFQ_MFB XD0_XDFFQ_MB XD0_XDFFQ_MFB 1.21e-17
* device instance cc_XD0_XDFFQ_MB_XD0_XDFFQ_S r0 *1 0,0
Ccc_XD0_XDFFQ_MB_XD0_XDFFQ_S XD0_XDFFQ_MB XD0_XDFFQ_S 1.8151e-17
* device instance cc_XD0_XDFFQ_MB_XD0_XDFFQ_SB r0 *1 0,0
Ccc_XD0_XDFFQ_MB_XD0_XDFFQ_SB XD0_XDFFQ_MB XD0_XDFFQ_SB 1.8151e-17
* device instance cc_XD0_XDFFQ_MB_XD0_XDFFQ_SFB r0 *1 0,0
Ccc_XD0_XDFFQ_MB_XD0_XDFFQ_SFB XD0_XDFFQ_MB XD0_XDFFQ_SFB 1.21e-17
* device instance cc_XD0_XDFFQ_MB_XD0_XN2_mid1 r0 *1 0,0
Ccc_XD0_XDFFQ_MB_XD0_XN2_mid1 XD0_XDFFQ_MB XD0_XN2_mid1 1.21e-17
* device instance cc_XD0_XDFFQ_MB_XD0_XNOR_midp r0 *1 0,0
Ccc_XD0_XDFFQ_MB_XD0_XNOR_midp XD0_XDFFQ_MB XD0_XNOR_midp 1.21e-17
* device instance cc_XD0_XDFFQ_MB_XD0_dmodout r0 *1 0,0
Ccc_XD0_XDFFQ_MB_XD0_dmodout XD0_XDFFQ_MB XD0_dmodout 1.21e-17
* device instance cc_XD0_XDFFQ_MB_XD0_dq r0 *1 0,0
Ccc_XD0_XDFFQ_MB_XD0_dq XD0_XDFFQ_MB XD0_dq 1.21e-17
* device instance cc_XD0_XDFFQ_MB_XD0_nm r0 *1 0,0
Ccc_XD0_XDFFQ_MB_XD0_nm XD0_XDFFQ_MB XD0_nm 1.21e-17
* device instance cc_XD0_XDFFQ_MB_XD0_nt r0 *1 0,0
Ccc_XD0_XDFFQ_MB_XD0_nt XD0_XDFFQ_MB XD0_nt 2.4201e-17
* device instance cc_XD0_XDFFQ_MB_XD0_t1 r0 *1 0,0
Ccc_XD0_XDFFQ_MB_XD0_t1 XD0_XDFFQ_MB XD0_t1 1.21e-17
* device instance cc_XD0_XDFFQ_MB_XD1_XDFFM_CKBB r0 *1 0,0
Ccc_XD0_XDFFQ_MB_XD1_XDFFM_CKBB XD0_XDFFQ_MB XD1_XDFFM_CKBB 1.8151e-17
* device instance cc_XD0_XDFFQ_MB_XD1_XDFFM_CLKB r0 *1 0,0
Ccc_XD0_XDFFQ_MB_XD1_XDFFM_CLKB XD0_XDFFQ_MB XD1_XDFFM_CLKB 2.4201e-17
* device instance cc_XD0_XDFFQ_MB_XD1_XDFFM_M r0 *1 0,0
Ccc_XD0_XDFFQ_MB_XD1_XDFFM_M XD0_XDFFQ_MB XD1_XDFFM_M 2.4201e-17
* device instance cc_XD0_XDFFQ_MB_XD1_XDFFM_MB r0 *1 0,0
Ccc_XD0_XDFFQ_MB_XD1_XDFFM_MB XD0_XDFFQ_MB XD1_XDFFM_MB 1.21e-17
* device instance cc_XD0_XDFFQ_MB_XD1_XDFFM_MFB r0 *1 0,0
Ccc_XD0_XDFFQ_MB_XD1_XDFFM_MFB XD0_XDFFQ_MB XD1_XDFFM_MFB 1.21e-17
* device instance cc_XD0_XDFFQ_MB_XD1_XDFFM_S r0 *1 0,0
Ccc_XD0_XDFFQ_MB_XD1_XDFFM_S XD0_XDFFQ_MB XD1_XDFFM_S 1.8151e-17
* device instance cc_XD0_XDFFQ_MB_XD1_XDFFM_SB r0 *1 0,0
Ccc_XD0_XDFFQ_MB_XD1_XDFFM_SB XD0_XDFFQ_MB XD1_XDFFM_SB 1.8151e-17
* device instance cc_XD0_XDFFQ_MB_XD1_XDFFM_SFB r0 *1 0,0
Ccc_XD0_XDFFQ_MB_XD1_XDFFM_SFB XD0_XDFFQ_MB XD1_XDFFM_SFB 1.21e-17
* device instance cc_XD0_XDFFQ_MB_XD1_XDFFQ_CKBB r0 *1 0,0
Ccc_XD0_XDFFQ_MB_XD1_XDFFQ_CKBB XD0_XDFFQ_MB XD1_XDFFQ_CKBB 1.8151e-17
* device instance cc_XD0_XDFFQ_MB_XD1_XDFFQ_CLKB r0 *1 0,0
Ccc_XD0_XDFFQ_MB_XD1_XDFFQ_CLKB XD0_XDFFQ_MB XD1_XDFFQ_CLKB 2.4201e-17
* device instance cc_XD0_XDFFQ_MB_XD1_XDFFQ_M r0 *1 0,0
Ccc_XD0_XDFFQ_MB_XD1_XDFFQ_M XD0_XDFFQ_MB XD1_XDFFQ_M 2.4201e-17
* device instance cc_XD0_XDFFQ_MB_XD1_XDFFQ_MB r0 *1 0,0
Ccc_XD0_XDFFQ_MB_XD1_XDFFQ_MB XD0_XDFFQ_MB XD1_XDFFQ_MB 1.21e-17
* device instance cc_XD0_XDFFQ_MB_XD1_XDFFQ_MFB r0 *1 0,0
Ccc_XD0_XDFFQ_MB_XD1_XDFFQ_MFB XD0_XDFFQ_MB XD1_XDFFQ_MFB 1.21e-17
* device instance cc_XD0_XDFFQ_MB_XD1_XDFFQ_S r0 *1 0,0
Ccc_XD0_XDFFQ_MB_XD1_XDFFQ_S XD0_XDFFQ_MB XD1_XDFFQ_S 1.8151e-17
* device instance cc_XD0_XDFFQ_MB_XD1_XDFFQ_SB r0 *1 0,0
Ccc_XD0_XDFFQ_MB_XD1_XDFFQ_SB XD0_XDFFQ_MB XD1_XDFFQ_SB 1.8151e-17
* device instance cc_XD0_XDFFQ_MB_XD1_XDFFQ_SFB r0 *1 0,0
Ccc_XD0_XDFFQ_MB_XD1_XDFFQ_SFB XD0_XDFFQ_MB XD1_XDFFQ_SFB 1.21e-17
* device instance cc_XD0_XDFFQ_MB_XD1_XN2_mid1 r0 *1 0,0
Ccc_XD0_XDFFQ_MB_XD1_XN2_mid1 XD0_XDFFQ_MB XD1_XN2_mid1 1.21e-17
* device instance cc_XD0_XDFFQ_MB_XD1_XN3_mid1 r0 *1 0,0
Ccc_XD0_XDFFQ_MB_XD1_XN3_mid1 XD0_XDFFQ_MB XD1_XN3_mid1 1.21e-17
* device instance cc_XD0_XDFFQ_MB_XD1_XN3_mid2 r0 *1 0,0
Ccc_XD0_XDFFQ_MB_XD1_XN3_mid2 XD0_XDFFQ_MB XD1_XN3_mid2 1.21e-17
* device instance cc_XD0_XDFFQ_MB_XD1_dmodout r0 *1 0,0
Ccc_XD0_XDFFQ_MB_XD1_dmodout XD0_XDFFQ_MB XD1_dmodout 1.21e-17
* device instance cc_XD0_XDFFQ_MB_XD1_dq r0 *1 0,0
Ccc_XD0_XDFFQ_MB_XD1_dq XD0_XDFFQ_MB XD1_dq 1.8151e-17
* device instance cc_XD0_XDFFQ_MB_XD1_nm r0 *1 0,0
Ccc_XD0_XDFFQ_MB_XD1_nm XD0_XDFFQ_MB XD1_nm 1.21e-17
* device instance cc_XD0_XDFFQ_MB_XD1_nt r0 *1 0,0
Ccc_XD0_XDFFQ_MB_XD1_nt XD0_XDFFQ_MB XD1_nt 1.21e-17
* device instance cc_XD0_XDFFQ_MB_XD1_t1 r0 *1 0,0
Ccc_XD0_XDFFQ_MB_XD1_t1 XD0_XDFFQ_MB XD1_t1 1.21e-17
* device instance cc_XD0_XDFFQ_MB_XD2_XDFFM_CKBB r0 *1 0,0
Ccc_XD0_XDFFQ_MB_XD2_XDFFM_CKBB XD0_XDFFQ_MB XD2_XDFFM_CKBB 1.8151e-17
* device instance cc_XD0_XDFFQ_MB_XD2_XDFFM_CLKB r0 *1 0,0
Ccc_XD0_XDFFQ_MB_XD2_XDFFM_CLKB XD0_XDFFQ_MB XD2_XDFFM_CLKB 2.4201e-17
* device instance cc_XD0_XDFFQ_MB_XD2_XDFFM_M r0 *1 0,0
Ccc_XD0_XDFFQ_MB_XD2_XDFFM_M XD0_XDFFQ_MB XD2_XDFFM_M 2.4201e-17
* device instance cc_XD0_XDFFQ_MB_XD2_XDFFM_MB r0 *1 0,0
Ccc_XD0_XDFFQ_MB_XD2_XDFFM_MB XD0_XDFFQ_MB XD2_XDFFM_MB 1.21e-17
* device instance cc_XD0_XDFFQ_MB_XD2_XDFFM_MFB r0 *1 0,0
Ccc_XD0_XDFFQ_MB_XD2_XDFFM_MFB XD0_XDFFQ_MB XD2_XDFFM_MFB 1.21e-17
* device instance cc_XD0_XDFFQ_MB_XD2_XDFFM_S r0 *1 0,0
Ccc_XD0_XDFFQ_MB_XD2_XDFFM_S XD0_XDFFQ_MB XD2_XDFFM_S 1.8151e-17
* device instance cc_XD0_XDFFQ_MB_XD2_XDFFM_SB r0 *1 0,0
Ccc_XD0_XDFFQ_MB_XD2_XDFFM_SB XD0_XDFFQ_MB XD2_XDFFM_SB 1.8151e-17
* device instance cc_XD0_XDFFQ_MB_XD2_XDFFM_SFB r0 *1 0,0
Ccc_XD0_XDFFQ_MB_XD2_XDFFM_SFB XD0_XDFFQ_MB XD2_XDFFM_SFB 1.21e-17
* device instance cc_XD0_XDFFQ_MB_XD2_XDFFQ_CKBB r0 *1 0,0
Ccc_XD0_XDFFQ_MB_XD2_XDFFQ_CKBB XD0_XDFFQ_MB XD2_XDFFQ_CKBB 1.8151e-17
* device instance cc_XD0_XDFFQ_MB_XD2_XDFFQ_CLKB r0 *1 0,0
Ccc_XD0_XDFFQ_MB_XD2_XDFFQ_CLKB XD0_XDFFQ_MB XD2_XDFFQ_CLKB 2.4201e-17
* device instance cc_XD0_XDFFQ_MB_XD2_XDFFQ_M r0 *1 0,0
Ccc_XD0_XDFFQ_MB_XD2_XDFFQ_M XD0_XDFFQ_MB XD2_XDFFQ_M 2.4201e-17
* device instance cc_XD0_XDFFQ_MB_XD2_XDFFQ_MB r0 *1 0,0
Ccc_XD0_XDFFQ_MB_XD2_XDFFQ_MB XD0_XDFFQ_MB XD2_XDFFQ_MB 1.21e-17
* device instance cc_XD0_XDFFQ_MB_XD2_XDFFQ_MFB r0 *1 0,0
Ccc_XD0_XDFFQ_MB_XD2_XDFFQ_MFB XD0_XDFFQ_MB XD2_XDFFQ_MFB 1.21e-17
* device instance cc_XD0_XDFFQ_MB_XD2_XDFFQ_S r0 *1 0,0
Ccc_XD0_XDFFQ_MB_XD2_XDFFQ_S XD0_XDFFQ_MB XD2_XDFFQ_S 1.8151e-17
* device instance cc_XD0_XDFFQ_MB_XD2_XDFFQ_SB r0 *1 0,0
Ccc_XD0_XDFFQ_MB_XD2_XDFFQ_SB XD0_XDFFQ_MB XD2_XDFFQ_SB 1.8151e-17
* device instance cc_XD0_XDFFQ_MB_XD2_XDFFQ_SFB r0 *1 0,0
Ccc_XD0_XDFFQ_MB_XD2_XDFFQ_SFB XD0_XDFFQ_MB XD2_XDFFQ_SFB 1.21e-17
* device instance cc_XD0_XDFFQ_MB_XD2_XN2_mid1 r0 *1 0,0
Ccc_XD0_XDFFQ_MB_XD2_XN2_mid1 XD0_XDFFQ_MB XD2_XN2_mid1 1.21e-17
* device instance cc_XD0_XDFFQ_MB_XD2_XN3_mid1 r0 *1 0,0
Ccc_XD0_XDFFQ_MB_XD2_XN3_mid1 XD0_XDFFQ_MB XD2_XN3_mid1 1.21e-17
* device instance cc_XD0_XDFFQ_MB_XD2_XN3_mid2 r0 *1 0,0
Ccc_XD0_XDFFQ_MB_XD2_XN3_mid2 XD0_XDFFQ_MB XD2_XN3_mid2 1.21e-17
* device instance cc_XD0_XDFFQ_MB_XD2_dmodout r0 *1 0,0
Ccc_XD0_XDFFQ_MB_XD2_dmodout XD0_XDFFQ_MB XD2_dmodout 1.21e-17
* device instance cc_XD0_XDFFQ_MB_XD2_dq r0 *1 0,0
Ccc_XD0_XDFFQ_MB_XD2_dq XD0_XDFFQ_MB XD2_dq 1.8151e-17
* device instance cc_XD0_XDFFQ_MB_XD2_nm r0 *1 0,0
Ccc_XD0_XDFFQ_MB_XD2_nm XD0_XDFFQ_MB XD2_nm 1.21e-17
* device instance cc_XD0_XDFFQ_MB_XD2_nt r0 *1 0,0
Ccc_XD0_XDFFQ_MB_XD2_nt XD0_XDFFQ_MB XD2_nt 1.21e-17
* device instance cc_XD0_XDFFQ_MB_XD2_t1 r0 *1 0,0
Ccc_XD0_XDFFQ_MB_XD2_t1 XD0_XDFFQ_MB XD2_t1 1.21e-17
* device instance cc_XD0_XDFFQ_MB_XD3_XDFFM_CKBB r0 *1 0,0
Ccc_XD0_XDFFQ_MB_XD3_XDFFM_CKBB XD0_XDFFQ_MB XD3_XDFFM_CKBB 1.8151e-17
* device instance cc_XD0_XDFFQ_MB_XD3_XDFFM_CLKB r0 *1 0,0
Ccc_XD0_XDFFQ_MB_XD3_XDFFM_CLKB XD0_XDFFQ_MB XD3_XDFFM_CLKB 2.4201e-17
* device instance cc_XD0_XDFFQ_MB_XD3_XDFFM_M r0 *1 0,0
Ccc_XD0_XDFFQ_MB_XD3_XDFFM_M XD0_XDFFQ_MB XD3_XDFFM_M 2.4201e-17
* device instance cc_XD0_XDFFQ_MB_XD3_XDFFM_MB r0 *1 0,0
Ccc_XD0_XDFFQ_MB_XD3_XDFFM_MB XD0_XDFFQ_MB XD3_XDFFM_MB 1.21e-17
* device instance cc_XD0_XDFFQ_MB_XD3_XDFFM_MFB r0 *1 0,0
Ccc_XD0_XDFFQ_MB_XD3_XDFFM_MFB XD0_XDFFQ_MB XD3_XDFFM_MFB 1.21e-17
* device instance cc_XD0_XDFFQ_MB_XD3_XDFFM_S r0 *1 0,0
Ccc_XD0_XDFFQ_MB_XD3_XDFFM_S XD0_XDFFQ_MB XD3_XDFFM_S 1.8151e-17
* device instance cc_XD0_XDFFQ_MB_XD3_XDFFM_SB r0 *1 0,0
Ccc_XD0_XDFFQ_MB_XD3_XDFFM_SB XD0_XDFFQ_MB XD3_XDFFM_SB 1.8151e-17
* device instance cc_XD0_XDFFQ_MB_XD3_XDFFM_SFB r0 *1 0,0
Ccc_XD0_XDFFQ_MB_XD3_XDFFM_SFB XD0_XDFFQ_MB XD3_XDFFM_SFB 1.21e-17
* device instance cc_XD0_XDFFQ_MB_XD3_XDFFQ_CKBB r0 *1 0,0
Ccc_XD0_XDFFQ_MB_XD3_XDFFQ_CKBB XD0_XDFFQ_MB XD3_XDFFQ_CKBB 1.8151e-17
* device instance cc_XD0_XDFFQ_MB_XD3_XDFFQ_CLKB r0 *1 0,0
Ccc_XD0_XDFFQ_MB_XD3_XDFFQ_CLKB XD0_XDFFQ_MB XD3_XDFFQ_CLKB 2.4201e-17
* device instance cc_XD0_XDFFQ_MB_XD3_XDFFQ_M r0 *1 0,0
Ccc_XD0_XDFFQ_MB_XD3_XDFFQ_M XD0_XDFFQ_MB XD3_XDFFQ_M 2.4201e-17
* device instance cc_XD0_XDFFQ_MB_XD3_XDFFQ_MB r0 *1 0,0
Ccc_XD0_XDFFQ_MB_XD3_XDFFQ_MB XD0_XDFFQ_MB XD3_XDFFQ_MB 1.21e-17
* device instance cc_XD0_XDFFQ_MB_XD3_XDFFQ_MFB r0 *1 0,0
Ccc_XD0_XDFFQ_MB_XD3_XDFFQ_MFB XD0_XDFFQ_MB XD3_XDFFQ_MFB 1.21e-17
* device instance cc_XD0_XDFFQ_MB_XD3_XDFFQ_S r0 *1 0,0
Ccc_XD0_XDFFQ_MB_XD3_XDFFQ_S XD0_XDFFQ_MB XD3_XDFFQ_S 1.8151e-17
* device instance cc_XD0_XDFFQ_MB_XD3_XDFFQ_SB r0 *1 0,0
Ccc_XD0_XDFFQ_MB_XD3_XDFFQ_SB XD0_XDFFQ_MB XD3_XDFFQ_SB 1.8151e-17
* device instance cc_XD0_XDFFQ_MB_XD3_XDFFQ_SFB r0 *1 0,0
Ccc_XD0_XDFFQ_MB_XD3_XDFFQ_SFB XD0_XDFFQ_MB XD3_XDFFQ_SFB 1.21e-17
* device instance cc_XD0_XDFFQ_MB_XD3_XN2_mid1 r0 *1 0,0
Ccc_XD0_XDFFQ_MB_XD3_XN2_mid1 XD0_XDFFQ_MB XD3_XN2_mid1 1.21e-17
* device instance cc_XD0_XDFFQ_MB_XD3_XN3_mid1 r0 *1 0,0
Ccc_XD0_XDFFQ_MB_XD3_XN3_mid1 XD0_XDFFQ_MB XD3_XN3_mid1 1.21e-17
* device instance cc_XD0_XDFFQ_MB_XD3_XN3_mid2 r0 *1 0,0
Ccc_XD0_XDFFQ_MB_XD3_XN3_mid2 XD0_XDFFQ_MB XD3_XN3_mid2 1.21e-17
* device instance cc_XD0_XDFFQ_MB_XD3_dmodout r0 *1 0,0
Ccc_XD0_XDFFQ_MB_XD3_dmodout XD0_XDFFQ_MB XD3_dmodout 1.21e-17
* device instance cc_XD0_XDFFQ_MB_XD3_dq r0 *1 0,0
Ccc_XD0_XDFFQ_MB_XD3_dq XD0_XDFFQ_MB XD3_dq 1.8151e-17
* device instance cc_XD0_XDFFQ_MB_XD3_nm r0 *1 0,0
Ccc_XD0_XDFFQ_MB_XD3_nm XD0_XDFFQ_MB XD3_nm 1.21e-17
* device instance cc_XD0_XDFFQ_MB_XD3_nt r0 *1 0,0
Ccc_XD0_XDFFQ_MB_XD3_nt XD0_XDFFQ_MB XD3_nt 1.21e-17
* device instance cc_XD0_XDFFQ_MB_XD3_t1 r0 *1 0,0
Ccc_XD0_XDFFQ_MB_XD3_t1 XD0_XDFFQ_MB XD3_t1 1.21e-17
* device instance cc_XD0_XDFFQ_MB_XD4_XDFFM_CKBB r0 *1 0,0
Ccc_XD0_XDFFQ_MB_XD4_XDFFM_CKBB XD0_XDFFQ_MB XD4_XDFFM_CKBB 1.8151e-17
* device instance cc_XD0_XDFFQ_MB_XD4_XDFFM_CLKB r0 *1 0,0
Ccc_XD0_XDFFQ_MB_XD4_XDFFM_CLKB XD0_XDFFQ_MB XD4_XDFFM_CLKB 2.4201e-17
* device instance cc_XD0_XDFFQ_MB_XD4_XDFFM_M r0 *1 0,0
Ccc_XD0_XDFFQ_MB_XD4_XDFFM_M XD0_XDFFQ_MB XD4_XDFFM_M 2.4201e-17
* device instance cc_XD0_XDFFQ_MB_XD4_XDFFM_MB r0 *1 0,0
Ccc_XD0_XDFFQ_MB_XD4_XDFFM_MB XD0_XDFFQ_MB XD4_XDFFM_MB 1.21e-17
* device instance cc_XD0_XDFFQ_MB_XD4_XDFFM_MFB r0 *1 0,0
Ccc_XD0_XDFFQ_MB_XD4_XDFFM_MFB XD0_XDFFQ_MB XD4_XDFFM_MFB 1.21e-17
* device instance cc_XD0_XDFFQ_MB_XD4_XDFFM_S r0 *1 0,0
Ccc_XD0_XDFFQ_MB_XD4_XDFFM_S XD0_XDFFQ_MB XD4_XDFFM_S 1.8151e-17
* device instance cc_XD0_XDFFQ_MB_XD4_XDFFM_SB r0 *1 0,0
Ccc_XD0_XDFFQ_MB_XD4_XDFFM_SB XD0_XDFFQ_MB XD4_XDFFM_SB 1.8151e-17
* device instance cc_XD0_XDFFQ_MB_XD4_XDFFM_SFB r0 *1 0,0
Ccc_XD0_XDFFQ_MB_XD4_XDFFM_SFB XD0_XDFFQ_MB XD4_XDFFM_SFB 1.21e-17
* device instance cc_XD0_XDFFQ_MB_XD4_XDFFQ_CKBB r0 *1 0,0
Ccc_XD0_XDFFQ_MB_XD4_XDFFQ_CKBB XD0_XDFFQ_MB XD4_XDFFQ_CKBB 1.8151e-17
* device instance cc_XD0_XDFFQ_MB_XD4_XDFFQ_CLKB r0 *1 0,0
Ccc_XD0_XDFFQ_MB_XD4_XDFFQ_CLKB XD0_XDFFQ_MB XD4_XDFFQ_CLKB 2.4201e-17
* device instance cc_XD0_XDFFQ_MB_XD4_XDFFQ_M r0 *1 0,0
Ccc_XD0_XDFFQ_MB_XD4_XDFFQ_M XD0_XDFFQ_MB XD4_XDFFQ_M 2.4201e-17
* device instance cc_XD0_XDFFQ_MB_XD4_XDFFQ_MB r0 *1 0,0
Ccc_XD0_XDFFQ_MB_XD4_XDFFQ_MB XD0_XDFFQ_MB XD4_XDFFQ_MB 1.21e-17
* device instance cc_XD0_XDFFQ_MB_XD4_XDFFQ_MFB r0 *1 0,0
Ccc_XD0_XDFFQ_MB_XD4_XDFFQ_MFB XD0_XDFFQ_MB XD4_XDFFQ_MFB 1.21e-17
* device instance cc_XD0_XDFFQ_MB_XD4_XDFFQ_S r0 *1 0,0
Ccc_XD0_XDFFQ_MB_XD4_XDFFQ_S XD0_XDFFQ_MB XD4_XDFFQ_S 1.8151e-17
* device instance cc_XD0_XDFFQ_MB_XD4_XDFFQ_SB r0 *1 0,0
Ccc_XD0_XDFFQ_MB_XD4_XDFFQ_SB XD0_XDFFQ_MB XD4_XDFFQ_SB 1.8151e-17
* device instance cc_XD0_XDFFQ_MB_XD4_XDFFQ_SFB r0 *1 0,0
Ccc_XD0_XDFFQ_MB_XD4_XDFFQ_SFB XD0_XDFFQ_MB XD4_XDFFQ_SFB 1.21e-17
* device instance cc_XD0_XDFFQ_MB_XD4_XN2_mid1 r0 *1 0,0
Ccc_XD0_XDFFQ_MB_XD4_XN2_mid1 XD0_XDFFQ_MB XD4_XN2_mid1 1.21e-17
* device instance cc_XD0_XDFFQ_MB_XD4_XN3_mid1 r0 *1 0,0
Ccc_XD0_XDFFQ_MB_XD4_XN3_mid1 XD0_XDFFQ_MB XD4_XN3_mid1 1.21e-17
* device instance cc_XD0_XDFFQ_MB_XD4_XN3_mid2 r0 *1 0,0
Ccc_XD0_XDFFQ_MB_XD4_XN3_mid2 XD0_XDFFQ_MB XD4_XN3_mid2 1.21e-17
* device instance cc_XD0_XDFFQ_MB_XD4_dmodout r0 *1 0,0
Ccc_XD0_XDFFQ_MB_XD4_dmodout XD0_XDFFQ_MB XD4_dmodout 1.21e-17
* device instance cc_XD0_XDFFQ_MB_XD4_dq r0 *1 0,0
Ccc_XD0_XDFFQ_MB_XD4_dq XD0_XDFFQ_MB XD4_dq 1.8151e-17
* device instance cc_XD0_XDFFQ_MB_XD4_nm r0 *1 0,0
Ccc_XD0_XDFFQ_MB_XD4_nm XD0_XDFFQ_MB XD4_nm 1.21e-17
* device instance cc_XD0_XDFFQ_MB_XD4_nt r0 *1 0,0
Ccc_XD0_XDFFQ_MB_XD4_nt XD0_XDFFQ_MB XD4_nt 1.21e-17
* device instance cc_XD0_XDFFQ_MB_XD4_t1 r0 *1 0,0
Ccc_XD0_XDFFQ_MB_XD4_t1 XD0_XDFFQ_MB XD4_t1 1.21e-17
* device instance cc_XD0_XDFFQ_MB_XD5_XDFFM_CKBB r0 *1 0,0
Ccc_XD0_XDFFQ_MB_XD5_XDFFM_CKBB XD0_XDFFQ_MB XD5_XDFFM_CKBB 1.8151e-17
* device instance cc_XD0_XDFFQ_MB_XD5_XDFFM_CLKB r0 *1 0,0
Ccc_XD0_XDFFQ_MB_XD5_XDFFM_CLKB XD0_XDFFQ_MB XD5_XDFFM_CLKB 2.4201e-17
* device instance cc_XD0_XDFFQ_MB_XD5_XDFFM_M r0 *1 0,0
Ccc_XD0_XDFFQ_MB_XD5_XDFFM_M XD0_XDFFQ_MB XD5_XDFFM_M 2.4201e-17
* device instance cc_XD0_XDFFQ_MB_XD5_XDFFM_MB r0 *1 0,0
Ccc_XD0_XDFFQ_MB_XD5_XDFFM_MB XD0_XDFFQ_MB XD5_XDFFM_MB 1.21e-17
* device instance cc_XD0_XDFFQ_MB_XD5_XDFFM_MFB r0 *1 0,0
Ccc_XD0_XDFFQ_MB_XD5_XDFFM_MFB XD0_XDFFQ_MB XD5_XDFFM_MFB 1.21e-17
* device instance cc_XD0_XDFFQ_MB_XD5_XDFFM_S r0 *1 0,0
Ccc_XD0_XDFFQ_MB_XD5_XDFFM_S XD0_XDFFQ_MB XD5_XDFFM_S 1.8151e-17
* device instance cc_XD0_XDFFQ_MB_XD5_XDFFM_SB r0 *1 0,0
Ccc_XD0_XDFFQ_MB_XD5_XDFFM_SB XD0_XDFFQ_MB XD5_XDFFM_SB 1.8151e-17
* device instance cc_XD0_XDFFQ_MB_XD5_XDFFM_SFB r0 *1 0,0
Ccc_XD0_XDFFQ_MB_XD5_XDFFM_SFB XD0_XDFFQ_MB XD5_XDFFM_SFB 1.21e-17
* device instance cc_XD0_XDFFQ_MB_XD5_XDFFQ_CKBB r0 *1 0,0
Ccc_XD0_XDFFQ_MB_XD5_XDFFQ_CKBB XD0_XDFFQ_MB XD5_XDFFQ_CKBB 1.8151e-17
* device instance cc_XD0_XDFFQ_MB_XD5_XDFFQ_CLKB r0 *1 0,0
Ccc_XD0_XDFFQ_MB_XD5_XDFFQ_CLKB XD0_XDFFQ_MB XD5_XDFFQ_CLKB 2.4201e-17
* device instance cc_XD0_XDFFQ_MB_XD5_XDFFQ_M r0 *1 0,0
Ccc_XD0_XDFFQ_MB_XD5_XDFFQ_M XD0_XDFFQ_MB XD5_XDFFQ_M 2.4201e-17
* device instance cc_XD0_XDFFQ_MB_XD5_XDFFQ_MB r0 *1 0,0
Ccc_XD0_XDFFQ_MB_XD5_XDFFQ_MB XD0_XDFFQ_MB XD5_XDFFQ_MB 1.21e-17
* device instance cc_XD0_XDFFQ_MB_XD5_XDFFQ_MFB r0 *1 0,0
Ccc_XD0_XDFFQ_MB_XD5_XDFFQ_MFB XD0_XDFFQ_MB XD5_XDFFQ_MFB 1.21e-17
* device instance cc_XD0_XDFFQ_MB_XD5_XDFFQ_S r0 *1 0,0
Ccc_XD0_XDFFQ_MB_XD5_XDFFQ_S XD0_XDFFQ_MB XD5_XDFFQ_S 1.8151e-17
* device instance cc_XD0_XDFFQ_MB_XD5_XDFFQ_SB r0 *1 0,0
Ccc_XD0_XDFFQ_MB_XD5_XDFFQ_SB XD0_XDFFQ_MB XD5_XDFFQ_SB 1.8151e-17
* device instance cc_XD0_XDFFQ_MB_XD5_XDFFQ_SFB r0 *1 0,0
Ccc_XD0_XDFFQ_MB_XD5_XDFFQ_SFB XD0_XDFFQ_MB XD5_XDFFQ_SFB 1.21e-17
* device instance cc_XD0_XDFFQ_MB_XD5_XN2_mid1 r0 *1 0,0
Ccc_XD0_XDFFQ_MB_XD5_XN2_mid1 XD0_XDFFQ_MB XD5_XN2_mid1 1.21e-17
* device instance cc_XD0_XDFFQ_MB_XD5_XN3_mid1 r0 *1 0,0
Ccc_XD0_XDFFQ_MB_XD5_XN3_mid1 XD0_XDFFQ_MB XD5_XN3_mid1 1.21e-17
* device instance cc_XD0_XDFFQ_MB_XD5_XN3_mid2 r0 *1 0,0
Ccc_XD0_XDFFQ_MB_XD5_XN3_mid2 XD0_XDFFQ_MB XD5_XN3_mid2 1.21e-17
* device instance cc_XD0_XDFFQ_MB_XD5_dmodout r0 *1 0,0
Ccc_XD0_XDFFQ_MB_XD5_dmodout XD0_XDFFQ_MB XD5_dmodout 1.21e-17
* device instance cc_XD0_XDFFQ_MB_XD5_dq r0 *1 0,0
Ccc_XD0_XDFFQ_MB_XD5_dq XD0_XDFFQ_MB XD5_dq 1.8151e-17
* device instance cc_XD0_XDFFQ_MB_XD5_nm r0 *1 0,0
Ccc_XD0_XDFFQ_MB_XD5_nm XD0_XDFFQ_MB XD5_nm 1.21e-17
* device instance cc_XD0_XDFFQ_MB_XD5_nt r0 *1 0,0
Ccc_XD0_XDFFQ_MB_XD5_nt XD0_XDFFQ_MB XD5_nt 1.21e-17
* device instance cc_XD0_XDFFQ_MB_XD5_t1 r0 *1 0,0
Ccc_XD0_XDFFQ_MB_XD5_t1 XD0_XDFFQ_MB XD5_t1 1.21e-17
* device instance cc_XD0_XDFFQ_MB_XFRT_CKBB r0 *1 0,0
Ccc_XD0_XDFFQ_MB_XFRT_CKBB XD0_XDFFQ_MB XFRT_CKBB 1.8151e-17
* device instance cc_XD0_XDFFQ_MB_XFRT_CLKB r0 *1 0,0
Ccc_XD0_XDFFQ_MB_XFRT_CLKB XD0_XDFFQ_MB XFRT_CLKB 2.4201e-17
* device instance cc_XD0_XDFFQ_MB_XFRT_M r0 *1 0,0
Ccc_XD0_XDFFQ_MB_XFRT_M XD0_XDFFQ_MB XFRT_M 2.4201e-17
* device instance cc_XD0_XDFFQ_MB_XFRT_MB r0 *1 0,0
Ccc_XD0_XDFFQ_MB_XFRT_MB XD0_XDFFQ_MB XFRT_MB 1.21e-17
* device instance cc_XD0_XDFFQ_MB_XFRT_MFB r0 *1 0,0
Ccc_XD0_XDFFQ_MB_XFRT_MFB XD0_XDFFQ_MB XFRT_MFB 1.21e-17
* device instance cc_XD0_XDFFQ_MB_XFRT_S r0 *1 0,0
Ccc_XD0_XDFFQ_MB_XFRT_S XD0_XDFFQ_MB XFRT_S 1.8151e-17
* device instance cc_XD0_XDFFQ_MB_XFRT_SB r0 *1 0,0
Ccc_XD0_XDFFQ_MB_XFRT_SB XD0_XDFFQ_MB XFRT_SB 1.8151e-17
* device instance cc_XD0_XDFFQ_MB_XFRT_SFB r0 *1 0,0
Ccc_XD0_XDFFQ_MB_XFRT_SFB XD0_XDFFQ_MB XFRT_SFB 1.21e-17
* device instance cc_XD0_XDFFQ_MB_ck1 r0 *1 0,0
Ccc_XD0_XDFFQ_MB_ck1 XD0_XDFFQ_MB ck1 3.0251e-17
* device instance cc_XD0_XDFFQ_MB_ck2 r0 *1 0,0
Ccc_XD0_XDFFQ_MB_ck2 XD0_XDFFQ_MB ck2 3.0251e-17
* device instance cc_XD0_XDFFQ_MB_ck3 r0 *1 0,0
Ccc_XD0_XDFFQ_MB_ck3 XD0_XDFFQ_MB ck3 3.0251e-17
* device instance cc_XD0_XDFFQ_MB_ck4 r0 *1 0,0
Ccc_XD0_XDFFQ_MB_ck4 XD0_XDFFQ_MB ck4 3.0251e-17
* device instance cc_XD0_XDFFQ_MB_ck5 r0 *1 0,0
Ccc_XD0_XDFFQ_MB_ck5 XD0_XDFFQ_MB ck5 3.0251e-17
* device instance cc_XD0_XDFFQ_MB_mod0 r0 *1 0,0
Ccc_XD0_XDFFQ_MB_mod0 XD0_XDFFQ_MB mod0 2.4201e-17
* device instance cc_XD0_XDFFQ_MB_mod1 r0 *1 0,0
Ccc_XD0_XDFFQ_MB_mod1 XD0_XDFFQ_MB mod1 2.4201e-17
* device instance cc_XD0_XDFFQ_MB_mod2 r0 *1 0,0
Ccc_XD0_XDFFQ_MB_mod2 XD0_XDFFQ_MB mod2 2.4201e-17
* device instance cc_XD0_XDFFQ_MB_mod3 r0 *1 0,0
Ccc_XD0_XDFFQ_MB_mod3 XD0_XDFFQ_MB mod3 2.4201e-17
* device instance cc_XD0_XDFFQ_MB_mod4 r0 *1 0,0
Ccc_XD0_XDFFQ_MB_mod4 XD0_XDFFQ_MB mod4 2.4201e-17
* device instance cc_XD0_XDFFQ_MB_net1 r0 *1 0,0
Ccc_XD0_XDFFQ_MB_net1 XD0_XDFFQ_MB net1 1.21e-17
* device instance cc_XD0_XDFFQ_MFB_XD0_XDFFQ_S r0 *1 0,0
Ccc_XD0_XDFFQ_MFB_XD0_XDFFQ_S XD0_XDFFQ_MFB XD0_XDFFQ_S 1.8151e-17
* device instance cc_XD0_XDFFQ_MFB_XD0_XDFFQ_SB r0 *1 0,0
Ccc_XD0_XDFFQ_MFB_XD0_XDFFQ_SB XD0_XDFFQ_MFB XD0_XDFFQ_SB 1.8151e-17
* device instance cc_XD0_XDFFQ_MFB_XD0_XDFFQ_SFB r0 *1 0,0
Ccc_XD0_XDFFQ_MFB_XD0_XDFFQ_SFB XD0_XDFFQ_MFB XD0_XDFFQ_SFB 1.21e-17
* device instance cc_XD0_XDFFQ_MFB_XD0_XN2_mid1 r0 *1 0,0
Ccc_XD0_XDFFQ_MFB_XD0_XN2_mid1 XD0_XDFFQ_MFB XD0_XN2_mid1 1.21e-17
* device instance cc_XD0_XDFFQ_MFB_XD0_XNOR_midp r0 *1 0,0
Ccc_XD0_XDFFQ_MFB_XD0_XNOR_midp XD0_XDFFQ_MFB XD0_XNOR_midp 1.21e-17
* device instance cc_XD0_XDFFQ_MFB_XD0_dmodout r0 *1 0,0
Ccc_XD0_XDFFQ_MFB_XD0_dmodout XD0_XDFFQ_MFB XD0_dmodout 1.21e-17
* device instance cc_XD0_XDFFQ_MFB_XD0_dq r0 *1 0,0
Ccc_XD0_XDFFQ_MFB_XD0_dq XD0_XDFFQ_MFB XD0_dq 1.21e-17
* device instance cc_XD0_XDFFQ_MFB_XD0_nm r0 *1 0,0
Ccc_XD0_XDFFQ_MFB_XD0_nm XD0_XDFFQ_MFB XD0_nm 1.21e-17
* device instance cc_XD0_XDFFQ_MFB_XD0_nt r0 *1 0,0
Ccc_XD0_XDFFQ_MFB_XD0_nt XD0_XDFFQ_MFB XD0_nt 2.4201e-17
* device instance cc_XD0_XDFFQ_MFB_XD0_t1 r0 *1 0,0
Ccc_XD0_XDFFQ_MFB_XD0_t1 XD0_XDFFQ_MFB XD0_t1 1.21e-17
* device instance cc_XD0_XDFFQ_MFB_XD1_XDFFM_CKBB r0 *1 0,0
Ccc_XD0_XDFFQ_MFB_XD1_XDFFM_CKBB XD0_XDFFQ_MFB XD1_XDFFM_CKBB 1.8151e-17
* device instance cc_XD0_XDFFQ_MFB_XD1_XDFFM_CLKB r0 *1 0,0
Ccc_XD0_XDFFQ_MFB_XD1_XDFFM_CLKB XD0_XDFFQ_MFB XD1_XDFFM_CLKB 2.4201e-17
* device instance cc_XD0_XDFFQ_MFB_XD1_XDFFM_M r0 *1 0,0
Ccc_XD0_XDFFQ_MFB_XD1_XDFFM_M XD0_XDFFQ_MFB XD1_XDFFM_M 2.4201e-17
* device instance cc_XD0_XDFFQ_MFB_XD1_XDFFM_MB r0 *1 0,0
Ccc_XD0_XDFFQ_MFB_XD1_XDFFM_MB XD0_XDFFQ_MFB XD1_XDFFM_MB 1.21e-17
* device instance cc_XD0_XDFFQ_MFB_XD1_XDFFM_MFB r0 *1 0,0
Ccc_XD0_XDFFQ_MFB_XD1_XDFFM_MFB XD0_XDFFQ_MFB XD1_XDFFM_MFB 1.21e-17
* device instance cc_XD0_XDFFQ_MFB_XD1_XDFFM_S r0 *1 0,0
Ccc_XD0_XDFFQ_MFB_XD1_XDFFM_S XD0_XDFFQ_MFB XD1_XDFFM_S 1.8151e-17
* device instance cc_XD0_XDFFQ_MFB_XD1_XDFFM_SB r0 *1 0,0
Ccc_XD0_XDFFQ_MFB_XD1_XDFFM_SB XD0_XDFFQ_MFB XD1_XDFFM_SB 1.8151e-17
* device instance cc_XD0_XDFFQ_MFB_XD1_XDFFM_SFB r0 *1 0,0
Ccc_XD0_XDFFQ_MFB_XD1_XDFFM_SFB XD0_XDFFQ_MFB XD1_XDFFM_SFB 1.21e-17
* device instance cc_XD0_XDFFQ_MFB_XD1_XDFFQ_CKBB r0 *1 0,0
Ccc_XD0_XDFFQ_MFB_XD1_XDFFQ_CKBB XD0_XDFFQ_MFB XD1_XDFFQ_CKBB 1.8151e-17
* device instance cc_XD0_XDFFQ_MFB_XD1_XDFFQ_CLKB r0 *1 0,0
Ccc_XD0_XDFFQ_MFB_XD1_XDFFQ_CLKB XD0_XDFFQ_MFB XD1_XDFFQ_CLKB 2.4201e-17
* device instance cc_XD0_XDFFQ_MFB_XD1_XDFFQ_M r0 *1 0,0
Ccc_XD0_XDFFQ_MFB_XD1_XDFFQ_M XD0_XDFFQ_MFB XD1_XDFFQ_M 2.4201e-17
* device instance cc_XD0_XDFFQ_MFB_XD1_XDFFQ_MB r0 *1 0,0
Ccc_XD0_XDFFQ_MFB_XD1_XDFFQ_MB XD0_XDFFQ_MFB XD1_XDFFQ_MB 1.21e-17
* device instance cc_XD0_XDFFQ_MFB_XD1_XDFFQ_MFB r0 *1 0,0
Ccc_XD0_XDFFQ_MFB_XD1_XDFFQ_MFB XD0_XDFFQ_MFB XD1_XDFFQ_MFB 1.21e-17
* device instance cc_XD0_XDFFQ_MFB_XD1_XDFFQ_S r0 *1 0,0
Ccc_XD0_XDFFQ_MFB_XD1_XDFFQ_S XD0_XDFFQ_MFB XD1_XDFFQ_S 1.8151e-17
* device instance cc_XD0_XDFFQ_MFB_XD1_XDFFQ_SB r0 *1 0,0
Ccc_XD0_XDFFQ_MFB_XD1_XDFFQ_SB XD0_XDFFQ_MFB XD1_XDFFQ_SB 1.8151e-17
* device instance cc_XD0_XDFFQ_MFB_XD1_XDFFQ_SFB r0 *1 0,0
Ccc_XD0_XDFFQ_MFB_XD1_XDFFQ_SFB XD0_XDFFQ_MFB XD1_XDFFQ_SFB 1.21e-17
* device instance cc_XD0_XDFFQ_MFB_XD1_XN2_mid1 r0 *1 0,0
Ccc_XD0_XDFFQ_MFB_XD1_XN2_mid1 XD0_XDFFQ_MFB XD1_XN2_mid1 1.21e-17
* device instance cc_XD0_XDFFQ_MFB_XD1_XN3_mid1 r0 *1 0,0
Ccc_XD0_XDFFQ_MFB_XD1_XN3_mid1 XD0_XDFFQ_MFB XD1_XN3_mid1 1.21e-17
* device instance cc_XD0_XDFFQ_MFB_XD1_XN3_mid2 r0 *1 0,0
Ccc_XD0_XDFFQ_MFB_XD1_XN3_mid2 XD0_XDFFQ_MFB XD1_XN3_mid2 1.21e-17
* device instance cc_XD0_XDFFQ_MFB_XD1_dmodout r0 *1 0,0
Ccc_XD0_XDFFQ_MFB_XD1_dmodout XD0_XDFFQ_MFB XD1_dmodout 1.21e-17
* device instance cc_XD0_XDFFQ_MFB_XD1_dq r0 *1 0,0
Ccc_XD0_XDFFQ_MFB_XD1_dq XD0_XDFFQ_MFB XD1_dq 1.8151e-17
* device instance cc_XD0_XDFFQ_MFB_XD1_nm r0 *1 0,0
Ccc_XD0_XDFFQ_MFB_XD1_nm XD0_XDFFQ_MFB XD1_nm 1.21e-17
* device instance cc_XD0_XDFFQ_MFB_XD1_nt r0 *1 0,0
Ccc_XD0_XDFFQ_MFB_XD1_nt XD0_XDFFQ_MFB XD1_nt 1.21e-17
* device instance cc_XD0_XDFFQ_MFB_XD1_t1 r0 *1 0,0
Ccc_XD0_XDFFQ_MFB_XD1_t1 XD0_XDFFQ_MFB XD1_t1 1.21e-17
* device instance cc_XD0_XDFFQ_MFB_XD2_XDFFM_CKBB r0 *1 0,0
Ccc_XD0_XDFFQ_MFB_XD2_XDFFM_CKBB XD0_XDFFQ_MFB XD2_XDFFM_CKBB 1.8151e-17
* device instance cc_XD0_XDFFQ_MFB_XD2_XDFFM_CLKB r0 *1 0,0
Ccc_XD0_XDFFQ_MFB_XD2_XDFFM_CLKB XD0_XDFFQ_MFB XD2_XDFFM_CLKB 2.4201e-17
* device instance cc_XD0_XDFFQ_MFB_XD2_XDFFM_M r0 *1 0,0
Ccc_XD0_XDFFQ_MFB_XD2_XDFFM_M XD0_XDFFQ_MFB XD2_XDFFM_M 2.4201e-17
* device instance cc_XD0_XDFFQ_MFB_XD2_XDFFM_MB r0 *1 0,0
Ccc_XD0_XDFFQ_MFB_XD2_XDFFM_MB XD0_XDFFQ_MFB XD2_XDFFM_MB 1.21e-17
* device instance cc_XD0_XDFFQ_MFB_XD2_XDFFM_MFB r0 *1 0,0
Ccc_XD0_XDFFQ_MFB_XD2_XDFFM_MFB XD0_XDFFQ_MFB XD2_XDFFM_MFB 1.21e-17
* device instance cc_XD0_XDFFQ_MFB_XD2_XDFFM_S r0 *1 0,0
Ccc_XD0_XDFFQ_MFB_XD2_XDFFM_S XD0_XDFFQ_MFB XD2_XDFFM_S 1.8151e-17
* device instance cc_XD0_XDFFQ_MFB_XD2_XDFFM_SB r0 *1 0,0
Ccc_XD0_XDFFQ_MFB_XD2_XDFFM_SB XD0_XDFFQ_MFB XD2_XDFFM_SB 1.8151e-17
* device instance cc_XD0_XDFFQ_MFB_XD2_XDFFM_SFB r0 *1 0,0
Ccc_XD0_XDFFQ_MFB_XD2_XDFFM_SFB XD0_XDFFQ_MFB XD2_XDFFM_SFB 1.21e-17
* device instance cc_XD0_XDFFQ_MFB_XD2_XDFFQ_CKBB r0 *1 0,0
Ccc_XD0_XDFFQ_MFB_XD2_XDFFQ_CKBB XD0_XDFFQ_MFB XD2_XDFFQ_CKBB 1.8151e-17
* device instance cc_XD0_XDFFQ_MFB_XD2_XDFFQ_CLKB r0 *1 0,0
Ccc_XD0_XDFFQ_MFB_XD2_XDFFQ_CLKB XD0_XDFFQ_MFB XD2_XDFFQ_CLKB 2.4201e-17
* device instance cc_XD0_XDFFQ_MFB_XD2_XDFFQ_M r0 *1 0,0
Ccc_XD0_XDFFQ_MFB_XD2_XDFFQ_M XD0_XDFFQ_MFB XD2_XDFFQ_M 2.4201e-17
* device instance cc_XD0_XDFFQ_MFB_XD2_XDFFQ_MB r0 *1 0,0
Ccc_XD0_XDFFQ_MFB_XD2_XDFFQ_MB XD0_XDFFQ_MFB XD2_XDFFQ_MB 1.21e-17
* device instance cc_XD0_XDFFQ_MFB_XD2_XDFFQ_MFB r0 *1 0,0
Ccc_XD0_XDFFQ_MFB_XD2_XDFFQ_MFB XD0_XDFFQ_MFB XD2_XDFFQ_MFB 1.21e-17
* device instance cc_XD0_XDFFQ_MFB_XD2_XDFFQ_S r0 *1 0,0
Ccc_XD0_XDFFQ_MFB_XD2_XDFFQ_S XD0_XDFFQ_MFB XD2_XDFFQ_S 1.8151e-17
* device instance cc_XD0_XDFFQ_MFB_XD2_XDFFQ_SB r0 *1 0,0
Ccc_XD0_XDFFQ_MFB_XD2_XDFFQ_SB XD0_XDFFQ_MFB XD2_XDFFQ_SB 1.8151e-17
* device instance cc_XD0_XDFFQ_MFB_XD2_XDFFQ_SFB r0 *1 0,0
Ccc_XD0_XDFFQ_MFB_XD2_XDFFQ_SFB XD0_XDFFQ_MFB XD2_XDFFQ_SFB 1.21e-17
* device instance cc_XD0_XDFFQ_MFB_XD2_XN2_mid1 r0 *1 0,0
Ccc_XD0_XDFFQ_MFB_XD2_XN2_mid1 XD0_XDFFQ_MFB XD2_XN2_mid1 1.21e-17
* device instance cc_XD0_XDFFQ_MFB_XD2_XN3_mid1 r0 *1 0,0
Ccc_XD0_XDFFQ_MFB_XD2_XN3_mid1 XD0_XDFFQ_MFB XD2_XN3_mid1 1.21e-17
* device instance cc_XD0_XDFFQ_MFB_XD2_XN3_mid2 r0 *1 0,0
Ccc_XD0_XDFFQ_MFB_XD2_XN3_mid2 XD0_XDFFQ_MFB XD2_XN3_mid2 1.21e-17
* device instance cc_XD0_XDFFQ_MFB_XD2_dmodout r0 *1 0,0
Ccc_XD0_XDFFQ_MFB_XD2_dmodout XD0_XDFFQ_MFB XD2_dmodout 1.21e-17
* device instance cc_XD0_XDFFQ_MFB_XD2_dq r0 *1 0,0
Ccc_XD0_XDFFQ_MFB_XD2_dq XD0_XDFFQ_MFB XD2_dq 1.8151e-17
* device instance cc_XD0_XDFFQ_MFB_XD2_nm r0 *1 0,0
Ccc_XD0_XDFFQ_MFB_XD2_nm XD0_XDFFQ_MFB XD2_nm 1.21e-17
* device instance cc_XD0_XDFFQ_MFB_XD2_nt r0 *1 0,0
Ccc_XD0_XDFFQ_MFB_XD2_nt XD0_XDFFQ_MFB XD2_nt 1.21e-17
* device instance cc_XD0_XDFFQ_MFB_XD2_t1 r0 *1 0,0
Ccc_XD0_XDFFQ_MFB_XD2_t1 XD0_XDFFQ_MFB XD2_t1 1.21e-17
* device instance cc_XD0_XDFFQ_MFB_XD3_XDFFM_CKBB r0 *1 0,0
Ccc_XD0_XDFFQ_MFB_XD3_XDFFM_CKBB XD0_XDFFQ_MFB XD3_XDFFM_CKBB 1.8151e-17
* device instance cc_XD0_XDFFQ_MFB_XD3_XDFFM_CLKB r0 *1 0,0
Ccc_XD0_XDFFQ_MFB_XD3_XDFFM_CLKB XD0_XDFFQ_MFB XD3_XDFFM_CLKB 2.4201e-17
* device instance cc_XD0_XDFFQ_MFB_XD3_XDFFM_M r0 *1 0,0
Ccc_XD0_XDFFQ_MFB_XD3_XDFFM_M XD0_XDFFQ_MFB XD3_XDFFM_M 2.4201e-17
* device instance cc_XD0_XDFFQ_MFB_XD3_XDFFM_MB r0 *1 0,0
Ccc_XD0_XDFFQ_MFB_XD3_XDFFM_MB XD0_XDFFQ_MFB XD3_XDFFM_MB 1.21e-17
* device instance cc_XD0_XDFFQ_MFB_XD3_XDFFM_MFB r0 *1 0,0
Ccc_XD0_XDFFQ_MFB_XD3_XDFFM_MFB XD0_XDFFQ_MFB XD3_XDFFM_MFB 1.21e-17
* device instance cc_XD0_XDFFQ_MFB_XD3_XDFFM_S r0 *1 0,0
Ccc_XD0_XDFFQ_MFB_XD3_XDFFM_S XD0_XDFFQ_MFB XD3_XDFFM_S 1.8151e-17
* device instance cc_XD0_XDFFQ_MFB_XD3_XDFFM_SB r0 *1 0,0
Ccc_XD0_XDFFQ_MFB_XD3_XDFFM_SB XD0_XDFFQ_MFB XD3_XDFFM_SB 1.8151e-17
* device instance cc_XD0_XDFFQ_MFB_XD3_XDFFM_SFB r0 *1 0,0
Ccc_XD0_XDFFQ_MFB_XD3_XDFFM_SFB XD0_XDFFQ_MFB XD3_XDFFM_SFB 1.21e-17
* device instance cc_XD0_XDFFQ_MFB_XD3_XDFFQ_CKBB r0 *1 0,0
Ccc_XD0_XDFFQ_MFB_XD3_XDFFQ_CKBB XD0_XDFFQ_MFB XD3_XDFFQ_CKBB 1.8151e-17
* device instance cc_XD0_XDFFQ_MFB_XD3_XDFFQ_CLKB r0 *1 0,0
Ccc_XD0_XDFFQ_MFB_XD3_XDFFQ_CLKB XD0_XDFFQ_MFB XD3_XDFFQ_CLKB 2.4201e-17
* device instance cc_XD0_XDFFQ_MFB_XD3_XDFFQ_M r0 *1 0,0
Ccc_XD0_XDFFQ_MFB_XD3_XDFFQ_M XD0_XDFFQ_MFB XD3_XDFFQ_M 2.4201e-17
* device instance cc_XD0_XDFFQ_MFB_XD3_XDFFQ_MB r0 *1 0,0
Ccc_XD0_XDFFQ_MFB_XD3_XDFFQ_MB XD0_XDFFQ_MFB XD3_XDFFQ_MB 1.21e-17
* device instance cc_XD0_XDFFQ_MFB_XD3_XDFFQ_MFB r0 *1 0,0
Ccc_XD0_XDFFQ_MFB_XD3_XDFFQ_MFB XD0_XDFFQ_MFB XD3_XDFFQ_MFB 1.21e-17
* device instance cc_XD0_XDFFQ_MFB_XD3_XDFFQ_S r0 *1 0,0
Ccc_XD0_XDFFQ_MFB_XD3_XDFFQ_S XD0_XDFFQ_MFB XD3_XDFFQ_S 1.8151e-17
* device instance cc_XD0_XDFFQ_MFB_XD3_XDFFQ_SB r0 *1 0,0
Ccc_XD0_XDFFQ_MFB_XD3_XDFFQ_SB XD0_XDFFQ_MFB XD3_XDFFQ_SB 1.8151e-17
* device instance cc_XD0_XDFFQ_MFB_XD3_XDFFQ_SFB r0 *1 0,0
Ccc_XD0_XDFFQ_MFB_XD3_XDFFQ_SFB XD0_XDFFQ_MFB XD3_XDFFQ_SFB 1.21e-17
* device instance cc_XD0_XDFFQ_MFB_XD3_XN2_mid1 r0 *1 0,0
Ccc_XD0_XDFFQ_MFB_XD3_XN2_mid1 XD0_XDFFQ_MFB XD3_XN2_mid1 1.21e-17
* device instance cc_XD0_XDFFQ_MFB_XD3_XN3_mid1 r0 *1 0,0
Ccc_XD0_XDFFQ_MFB_XD3_XN3_mid1 XD0_XDFFQ_MFB XD3_XN3_mid1 1.21e-17
* device instance cc_XD0_XDFFQ_MFB_XD3_XN3_mid2 r0 *1 0,0
Ccc_XD0_XDFFQ_MFB_XD3_XN3_mid2 XD0_XDFFQ_MFB XD3_XN3_mid2 1.21e-17
* device instance cc_XD0_XDFFQ_MFB_XD3_dmodout r0 *1 0,0
Ccc_XD0_XDFFQ_MFB_XD3_dmodout XD0_XDFFQ_MFB XD3_dmodout 1.21e-17
* device instance cc_XD0_XDFFQ_MFB_XD3_dq r0 *1 0,0
Ccc_XD0_XDFFQ_MFB_XD3_dq XD0_XDFFQ_MFB XD3_dq 1.8151e-17
* device instance cc_XD0_XDFFQ_MFB_XD3_nm r0 *1 0,0
Ccc_XD0_XDFFQ_MFB_XD3_nm XD0_XDFFQ_MFB XD3_nm 1.21e-17
* device instance cc_XD0_XDFFQ_MFB_XD3_nt r0 *1 0,0
Ccc_XD0_XDFFQ_MFB_XD3_nt XD0_XDFFQ_MFB XD3_nt 1.21e-17
* device instance cc_XD0_XDFFQ_MFB_XD3_t1 r0 *1 0,0
Ccc_XD0_XDFFQ_MFB_XD3_t1 XD0_XDFFQ_MFB XD3_t1 1.21e-17
* device instance cc_XD0_XDFFQ_MFB_XD4_XDFFM_CKBB r0 *1 0,0
Ccc_XD0_XDFFQ_MFB_XD4_XDFFM_CKBB XD0_XDFFQ_MFB XD4_XDFFM_CKBB 1.8151e-17
* device instance cc_XD0_XDFFQ_MFB_XD4_XDFFM_CLKB r0 *1 0,0
Ccc_XD0_XDFFQ_MFB_XD4_XDFFM_CLKB XD0_XDFFQ_MFB XD4_XDFFM_CLKB 2.4201e-17
* device instance cc_XD0_XDFFQ_MFB_XD4_XDFFM_M r0 *1 0,0
Ccc_XD0_XDFFQ_MFB_XD4_XDFFM_M XD0_XDFFQ_MFB XD4_XDFFM_M 2.4201e-17
* device instance cc_XD0_XDFFQ_MFB_XD4_XDFFM_MB r0 *1 0,0
Ccc_XD0_XDFFQ_MFB_XD4_XDFFM_MB XD0_XDFFQ_MFB XD4_XDFFM_MB 1.21e-17
* device instance cc_XD0_XDFFQ_MFB_XD4_XDFFM_MFB r0 *1 0,0
Ccc_XD0_XDFFQ_MFB_XD4_XDFFM_MFB XD0_XDFFQ_MFB XD4_XDFFM_MFB 1.21e-17
* device instance cc_XD0_XDFFQ_MFB_XD4_XDFFM_S r0 *1 0,0
Ccc_XD0_XDFFQ_MFB_XD4_XDFFM_S XD0_XDFFQ_MFB XD4_XDFFM_S 1.8151e-17
* device instance cc_XD0_XDFFQ_MFB_XD4_XDFFM_SB r0 *1 0,0
Ccc_XD0_XDFFQ_MFB_XD4_XDFFM_SB XD0_XDFFQ_MFB XD4_XDFFM_SB 1.8151e-17
* device instance cc_XD0_XDFFQ_MFB_XD4_XDFFM_SFB r0 *1 0,0
Ccc_XD0_XDFFQ_MFB_XD4_XDFFM_SFB XD0_XDFFQ_MFB XD4_XDFFM_SFB 1.21e-17
* device instance cc_XD0_XDFFQ_MFB_XD4_XDFFQ_CKBB r0 *1 0,0
Ccc_XD0_XDFFQ_MFB_XD4_XDFFQ_CKBB XD0_XDFFQ_MFB XD4_XDFFQ_CKBB 1.8151e-17
* device instance cc_XD0_XDFFQ_MFB_XD4_XDFFQ_CLKB r0 *1 0,0
Ccc_XD0_XDFFQ_MFB_XD4_XDFFQ_CLKB XD0_XDFFQ_MFB XD4_XDFFQ_CLKB 2.4201e-17
* device instance cc_XD0_XDFFQ_MFB_XD4_XDFFQ_M r0 *1 0,0
Ccc_XD0_XDFFQ_MFB_XD4_XDFFQ_M XD0_XDFFQ_MFB XD4_XDFFQ_M 2.4201e-17
* device instance cc_XD0_XDFFQ_MFB_XD4_XDFFQ_MB r0 *1 0,0
Ccc_XD0_XDFFQ_MFB_XD4_XDFFQ_MB XD0_XDFFQ_MFB XD4_XDFFQ_MB 1.21e-17
* device instance cc_XD0_XDFFQ_MFB_XD4_XDFFQ_MFB r0 *1 0,0
Ccc_XD0_XDFFQ_MFB_XD4_XDFFQ_MFB XD0_XDFFQ_MFB XD4_XDFFQ_MFB 1.21e-17
* device instance cc_XD0_XDFFQ_MFB_XD4_XDFFQ_S r0 *1 0,0
Ccc_XD0_XDFFQ_MFB_XD4_XDFFQ_S XD0_XDFFQ_MFB XD4_XDFFQ_S 1.8151e-17
* device instance cc_XD0_XDFFQ_MFB_XD4_XDFFQ_SB r0 *1 0,0
Ccc_XD0_XDFFQ_MFB_XD4_XDFFQ_SB XD0_XDFFQ_MFB XD4_XDFFQ_SB 1.8151e-17
* device instance cc_XD0_XDFFQ_MFB_XD4_XDFFQ_SFB r0 *1 0,0
Ccc_XD0_XDFFQ_MFB_XD4_XDFFQ_SFB XD0_XDFFQ_MFB XD4_XDFFQ_SFB 1.21e-17
* device instance cc_XD0_XDFFQ_MFB_XD4_XN2_mid1 r0 *1 0,0
Ccc_XD0_XDFFQ_MFB_XD4_XN2_mid1 XD0_XDFFQ_MFB XD4_XN2_mid1 1.21e-17
* device instance cc_XD0_XDFFQ_MFB_XD4_XN3_mid1 r0 *1 0,0
Ccc_XD0_XDFFQ_MFB_XD4_XN3_mid1 XD0_XDFFQ_MFB XD4_XN3_mid1 1.21e-17
* device instance cc_XD0_XDFFQ_MFB_XD4_XN3_mid2 r0 *1 0,0
Ccc_XD0_XDFFQ_MFB_XD4_XN3_mid2 XD0_XDFFQ_MFB XD4_XN3_mid2 1.21e-17
* device instance cc_XD0_XDFFQ_MFB_XD4_dmodout r0 *1 0,0
Ccc_XD0_XDFFQ_MFB_XD4_dmodout XD0_XDFFQ_MFB XD4_dmodout 1.21e-17
* device instance cc_XD0_XDFFQ_MFB_XD4_dq r0 *1 0,0
Ccc_XD0_XDFFQ_MFB_XD4_dq XD0_XDFFQ_MFB XD4_dq 1.8151e-17
* device instance cc_XD0_XDFFQ_MFB_XD4_nm r0 *1 0,0
Ccc_XD0_XDFFQ_MFB_XD4_nm XD0_XDFFQ_MFB XD4_nm 1.21e-17
* device instance cc_XD0_XDFFQ_MFB_XD4_nt r0 *1 0,0
Ccc_XD0_XDFFQ_MFB_XD4_nt XD0_XDFFQ_MFB XD4_nt 1.21e-17
* device instance cc_XD0_XDFFQ_MFB_XD4_t1 r0 *1 0,0
Ccc_XD0_XDFFQ_MFB_XD4_t1 XD0_XDFFQ_MFB XD4_t1 1.21e-17
* device instance cc_XD0_XDFFQ_MFB_XD5_XDFFM_CKBB r0 *1 0,0
Ccc_XD0_XDFFQ_MFB_XD5_XDFFM_CKBB XD0_XDFFQ_MFB XD5_XDFFM_CKBB 1.8151e-17
* device instance cc_XD0_XDFFQ_MFB_XD5_XDFFM_CLKB r0 *1 0,0
Ccc_XD0_XDFFQ_MFB_XD5_XDFFM_CLKB XD0_XDFFQ_MFB XD5_XDFFM_CLKB 2.4201e-17
* device instance cc_XD0_XDFFQ_MFB_XD5_XDFFM_M r0 *1 0,0
Ccc_XD0_XDFFQ_MFB_XD5_XDFFM_M XD0_XDFFQ_MFB XD5_XDFFM_M 2.4201e-17
* device instance cc_XD0_XDFFQ_MFB_XD5_XDFFM_MB r0 *1 0,0
Ccc_XD0_XDFFQ_MFB_XD5_XDFFM_MB XD0_XDFFQ_MFB XD5_XDFFM_MB 1.21e-17
* device instance cc_XD0_XDFFQ_MFB_XD5_XDFFM_MFB r0 *1 0,0
Ccc_XD0_XDFFQ_MFB_XD5_XDFFM_MFB XD0_XDFFQ_MFB XD5_XDFFM_MFB 1.21e-17
* device instance cc_XD0_XDFFQ_MFB_XD5_XDFFM_S r0 *1 0,0
Ccc_XD0_XDFFQ_MFB_XD5_XDFFM_S XD0_XDFFQ_MFB XD5_XDFFM_S 1.8151e-17
* device instance cc_XD0_XDFFQ_MFB_XD5_XDFFM_SB r0 *1 0,0
Ccc_XD0_XDFFQ_MFB_XD5_XDFFM_SB XD0_XDFFQ_MFB XD5_XDFFM_SB 1.8151e-17
* device instance cc_XD0_XDFFQ_MFB_XD5_XDFFM_SFB r0 *1 0,0
Ccc_XD0_XDFFQ_MFB_XD5_XDFFM_SFB XD0_XDFFQ_MFB XD5_XDFFM_SFB 1.21e-17
* device instance cc_XD0_XDFFQ_MFB_XD5_XDFFQ_CKBB r0 *1 0,0
Ccc_XD0_XDFFQ_MFB_XD5_XDFFQ_CKBB XD0_XDFFQ_MFB XD5_XDFFQ_CKBB 1.8151e-17
* device instance cc_XD0_XDFFQ_MFB_XD5_XDFFQ_CLKB r0 *1 0,0
Ccc_XD0_XDFFQ_MFB_XD5_XDFFQ_CLKB XD0_XDFFQ_MFB XD5_XDFFQ_CLKB 2.4201e-17
* device instance cc_XD0_XDFFQ_MFB_XD5_XDFFQ_M r0 *1 0,0
Ccc_XD0_XDFFQ_MFB_XD5_XDFFQ_M XD0_XDFFQ_MFB XD5_XDFFQ_M 2.4201e-17
* device instance cc_XD0_XDFFQ_MFB_XD5_XDFFQ_MB r0 *1 0,0
Ccc_XD0_XDFFQ_MFB_XD5_XDFFQ_MB XD0_XDFFQ_MFB XD5_XDFFQ_MB 1.21e-17
* device instance cc_XD0_XDFFQ_MFB_XD5_XDFFQ_MFB r0 *1 0,0
Ccc_XD0_XDFFQ_MFB_XD5_XDFFQ_MFB XD0_XDFFQ_MFB XD5_XDFFQ_MFB 1.21e-17
* device instance cc_XD0_XDFFQ_MFB_XD5_XDFFQ_S r0 *1 0,0
Ccc_XD0_XDFFQ_MFB_XD5_XDFFQ_S XD0_XDFFQ_MFB XD5_XDFFQ_S 1.8151e-17
* device instance cc_XD0_XDFFQ_MFB_XD5_XDFFQ_SB r0 *1 0,0
Ccc_XD0_XDFFQ_MFB_XD5_XDFFQ_SB XD0_XDFFQ_MFB XD5_XDFFQ_SB 1.8151e-17
* device instance cc_XD0_XDFFQ_MFB_XD5_XDFFQ_SFB r0 *1 0,0
Ccc_XD0_XDFFQ_MFB_XD5_XDFFQ_SFB XD0_XDFFQ_MFB XD5_XDFFQ_SFB 1.21e-17
* device instance cc_XD0_XDFFQ_MFB_XD5_XN2_mid1 r0 *1 0,0
Ccc_XD0_XDFFQ_MFB_XD5_XN2_mid1 XD0_XDFFQ_MFB XD5_XN2_mid1 1.21e-17
* device instance cc_XD0_XDFFQ_MFB_XD5_XN3_mid1 r0 *1 0,0
Ccc_XD0_XDFFQ_MFB_XD5_XN3_mid1 XD0_XDFFQ_MFB XD5_XN3_mid1 1.21e-17
* device instance cc_XD0_XDFFQ_MFB_XD5_XN3_mid2 r0 *1 0,0
Ccc_XD0_XDFFQ_MFB_XD5_XN3_mid2 XD0_XDFFQ_MFB XD5_XN3_mid2 1.21e-17
* device instance cc_XD0_XDFFQ_MFB_XD5_dmodout r0 *1 0,0
Ccc_XD0_XDFFQ_MFB_XD5_dmodout XD0_XDFFQ_MFB XD5_dmodout 1.21e-17
* device instance cc_XD0_XDFFQ_MFB_XD5_dq r0 *1 0,0
Ccc_XD0_XDFFQ_MFB_XD5_dq XD0_XDFFQ_MFB XD5_dq 1.8151e-17
* device instance cc_XD0_XDFFQ_MFB_XD5_nm r0 *1 0,0
Ccc_XD0_XDFFQ_MFB_XD5_nm XD0_XDFFQ_MFB XD5_nm 1.21e-17
* device instance cc_XD0_XDFFQ_MFB_XD5_nt r0 *1 0,0
Ccc_XD0_XDFFQ_MFB_XD5_nt XD0_XDFFQ_MFB XD5_nt 1.21e-17
* device instance cc_XD0_XDFFQ_MFB_XD5_t1 r0 *1 0,0
Ccc_XD0_XDFFQ_MFB_XD5_t1 XD0_XDFFQ_MFB XD5_t1 1.21e-17
* device instance cc_XD0_XDFFQ_MFB_XFRT_CKBB r0 *1 0,0
Ccc_XD0_XDFFQ_MFB_XFRT_CKBB XD0_XDFFQ_MFB XFRT_CKBB 1.8151e-17
* device instance cc_XD0_XDFFQ_MFB_XFRT_CLKB r0 *1 0,0
Ccc_XD0_XDFFQ_MFB_XFRT_CLKB XD0_XDFFQ_MFB XFRT_CLKB 2.4201e-17
* device instance cc_XD0_XDFFQ_MFB_XFRT_M r0 *1 0,0
Ccc_XD0_XDFFQ_MFB_XFRT_M XD0_XDFFQ_MFB XFRT_M 2.4201e-17
* device instance cc_XD0_XDFFQ_MFB_XFRT_MB r0 *1 0,0
Ccc_XD0_XDFFQ_MFB_XFRT_MB XD0_XDFFQ_MFB XFRT_MB 1.21e-17
* device instance cc_XD0_XDFFQ_MFB_XFRT_MFB r0 *1 0,0
Ccc_XD0_XDFFQ_MFB_XFRT_MFB XD0_XDFFQ_MFB XFRT_MFB 1.21e-17
* device instance cc_XD0_XDFFQ_MFB_XFRT_S r0 *1 0,0
Ccc_XD0_XDFFQ_MFB_XFRT_S XD0_XDFFQ_MFB XFRT_S 1.8151e-17
* device instance cc_XD0_XDFFQ_MFB_XFRT_SB r0 *1 0,0
Ccc_XD0_XDFFQ_MFB_XFRT_SB XD0_XDFFQ_MFB XFRT_SB 1.8151e-17
* device instance cc_XD0_XDFFQ_MFB_XFRT_SFB r0 *1 0,0
Ccc_XD0_XDFFQ_MFB_XFRT_SFB XD0_XDFFQ_MFB XFRT_SFB 1.21e-17
* device instance cc_XD0_XDFFQ_MFB_ck1 r0 *1 0,0
Ccc_XD0_XDFFQ_MFB_ck1 XD0_XDFFQ_MFB ck1 3.0251e-17
* device instance cc_XD0_XDFFQ_MFB_ck2 r0 *1 0,0
Ccc_XD0_XDFFQ_MFB_ck2 XD0_XDFFQ_MFB ck2 3.0251e-17
* device instance cc_XD0_XDFFQ_MFB_ck3 r0 *1 0,0
Ccc_XD0_XDFFQ_MFB_ck3 XD0_XDFFQ_MFB ck3 3.0251e-17
* device instance cc_XD0_XDFFQ_MFB_ck4 r0 *1 0,0
Ccc_XD0_XDFFQ_MFB_ck4 XD0_XDFFQ_MFB ck4 3.0251e-17
* device instance cc_XD0_XDFFQ_MFB_ck5 r0 *1 0,0
Ccc_XD0_XDFFQ_MFB_ck5 XD0_XDFFQ_MFB ck5 3.0251e-17
* device instance cc_XD0_XDFFQ_MFB_mod0 r0 *1 0,0
Ccc_XD0_XDFFQ_MFB_mod0 XD0_XDFFQ_MFB mod0 2.4201e-17
* device instance cc_XD0_XDFFQ_MFB_mod1 r0 *1 0,0
Ccc_XD0_XDFFQ_MFB_mod1 XD0_XDFFQ_MFB mod1 2.4201e-17
* device instance cc_XD0_XDFFQ_MFB_mod2 r0 *1 0,0
Ccc_XD0_XDFFQ_MFB_mod2 XD0_XDFFQ_MFB mod2 2.4201e-17
* device instance cc_XD0_XDFFQ_MFB_mod3 r0 *1 0,0
Ccc_XD0_XDFFQ_MFB_mod3 XD0_XDFFQ_MFB mod3 2.4201e-17
* device instance cc_XD0_XDFFQ_MFB_mod4 r0 *1 0,0
Ccc_XD0_XDFFQ_MFB_mod4 XD0_XDFFQ_MFB mod4 2.4201e-17
* device instance cc_XD0_XDFFQ_MFB_net1 r0 *1 0,0
Ccc_XD0_XDFFQ_MFB_net1 XD0_XDFFQ_MFB net1 1.21e-17
* device instance cc_XD0_XDFFQ_S_XD0_XDFFQ_SB r0 *1 0,0
Ccc_XD0_XDFFQ_S_XD0_XDFFQ_SB XD0_XDFFQ_S XD0_XDFFQ_SB 3.0251e-17
* device instance cc_XD0_XDFFQ_S_XD0_XDFFQ_SFB r0 *1 0,0
Ccc_XD0_XDFFQ_S_XD0_XDFFQ_SFB XD0_XDFFQ_S XD0_XDFFQ_SFB 3.4688e-17
* device instance cc_XD0_XDFFQ_S_XD0_XN2_mid1 r0 *1 0,0
Ccc_XD0_XDFFQ_S_XD0_XN2_mid1 XD0_XDFFQ_S XD0_XN2_mid1 1.21e-17
* device instance cc_XD0_XDFFQ_S_XD0_XNOR_midp r0 *1 0,0
Ccc_XD0_XDFFQ_S_XD0_XNOR_midp XD0_XDFFQ_S XD0_XNOR_midp 1.21e-17
* device instance cc_XD0_XDFFQ_S_XD0_dmodout r0 *1 0,0
Ccc_XD0_XDFFQ_S_XD0_dmodout XD0_XDFFQ_S XD0_dmodout 1.21e-17
* device instance cc_XD0_XDFFQ_S_XD0_dq r0 *1 0,0
Ccc_XD0_XDFFQ_S_XD0_dq XD0_XDFFQ_S XD0_dq 1.21e-17
* device instance cc_XD0_XDFFQ_S_XD0_nm r0 *1 0,0
Ccc_XD0_XDFFQ_S_XD0_nm XD0_XDFFQ_S XD0_nm 1.21e-17
* device instance cc_XD0_XDFFQ_S_XD0_nt r0 *1 0,0
Ccc_XD0_XDFFQ_S_XD0_nt XD0_XDFFQ_S XD0_nt 2.4201e-17
* device instance cc_XD0_XDFFQ_S_XD0_t1 r0 *1 0,0
Ccc_XD0_XDFFQ_S_XD0_t1 XD0_XDFFQ_S XD0_t1 1.21e-17
* device instance cc_XD0_XDFFQ_S_XD1_XDFFM_CKBB r0 *1 0,0
Ccc_XD0_XDFFQ_S_XD1_XDFFM_CKBB XD0_XDFFQ_S XD1_XDFFM_CKBB 1.8151e-17
* device instance cc_XD0_XDFFQ_S_XD1_XDFFM_CLKB r0 *1 0,0
Ccc_XD0_XDFFQ_S_XD1_XDFFM_CLKB XD0_XDFFQ_S XD1_XDFFM_CLKB 2.4201e-17
* device instance cc_XD0_XDFFQ_S_XD1_XDFFM_M r0 *1 0,0
Ccc_XD0_XDFFQ_S_XD1_XDFFM_M XD0_XDFFQ_S XD1_XDFFM_M 2.4201e-17
* device instance cc_XD0_XDFFQ_S_XD1_XDFFM_MB r0 *1 0,0
Ccc_XD0_XDFFQ_S_XD1_XDFFM_MB XD0_XDFFQ_S XD1_XDFFM_MB 1.21e-17
* device instance cc_XD0_XDFFQ_S_XD1_XDFFM_MFB r0 *1 0,0
Ccc_XD0_XDFFQ_S_XD1_XDFFM_MFB XD0_XDFFQ_S XD1_XDFFM_MFB 1.21e-17
* device instance cc_XD0_XDFFQ_S_XD1_XDFFM_S r0 *1 0,0
Ccc_XD0_XDFFQ_S_XD1_XDFFM_S XD0_XDFFQ_S XD1_XDFFM_S 1.8151e-17
* device instance cc_XD0_XDFFQ_S_XD1_XDFFM_SB r0 *1 0,0
Ccc_XD0_XDFFQ_S_XD1_XDFFM_SB XD0_XDFFQ_S XD1_XDFFM_SB 1.8151e-17
* device instance cc_XD0_XDFFQ_S_XD1_XDFFM_SFB r0 *1 0,0
Ccc_XD0_XDFFQ_S_XD1_XDFFM_SFB XD0_XDFFQ_S XD1_XDFFM_SFB 1.21e-17
* device instance cc_XD0_XDFFQ_S_XD1_XDFFQ_CKBB r0 *1 0,0
Ccc_XD0_XDFFQ_S_XD1_XDFFQ_CKBB XD0_XDFFQ_S XD1_XDFFQ_CKBB 1.8151e-17
* device instance cc_XD0_XDFFQ_S_XD1_XDFFQ_CLKB r0 *1 0,0
Ccc_XD0_XDFFQ_S_XD1_XDFFQ_CLKB XD0_XDFFQ_S XD1_XDFFQ_CLKB 2.4201e-17
* device instance cc_XD0_XDFFQ_S_XD1_XDFFQ_M r0 *1 0,0
Ccc_XD0_XDFFQ_S_XD1_XDFFQ_M XD0_XDFFQ_S XD1_XDFFQ_M 2.4201e-17
* device instance cc_XD0_XDFFQ_S_XD1_XDFFQ_MB r0 *1 0,0
Ccc_XD0_XDFFQ_S_XD1_XDFFQ_MB XD0_XDFFQ_S XD1_XDFFQ_MB 1.21e-17
* device instance cc_XD0_XDFFQ_S_XD1_XDFFQ_MFB r0 *1 0,0
Ccc_XD0_XDFFQ_S_XD1_XDFFQ_MFB XD0_XDFFQ_S XD1_XDFFQ_MFB 1.21e-17
* device instance cc_XD0_XDFFQ_S_XD1_XDFFQ_S r0 *1 0,0
Ccc_XD0_XDFFQ_S_XD1_XDFFQ_S XD0_XDFFQ_S XD1_XDFFQ_S 1.8151e-17
* device instance cc_XD0_XDFFQ_S_XD1_XDFFQ_SB r0 *1 0,0
Ccc_XD0_XDFFQ_S_XD1_XDFFQ_SB XD0_XDFFQ_S XD1_XDFFQ_SB 1.8151e-17
* device instance cc_XD0_XDFFQ_S_XD1_XDFFQ_SFB r0 *1 0,0
Ccc_XD0_XDFFQ_S_XD1_XDFFQ_SFB XD0_XDFFQ_S XD1_XDFFQ_SFB 1.21e-17
* device instance cc_XD0_XDFFQ_S_XD1_XN2_mid1 r0 *1 0,0
Ccc_XD0_XDFFQ_S_XD1_XN2_mid1 XD0_XDFFQ_S XD1_XN2_mid1 1.21e-17
* device instance cc_XD0_XDFFQ_S_XD1_XN3_mid1 r0 *1 0,0
Ccc_XD0_XDFFQ_S_XD1_XN3_mid1 XD0_XDFFQ_S XD1_XN3_mid1 1.21e-17
* device instance cc_XD0_XDFFQ_S_XD1_XN3_mid2 r0 *1 0,0
Ccc_XD0_XDFFQ_S_XD1_XN3_mid2 XD0_XDFFQ_S XD1_XN3_mid2 1.21e-17
* device instance cc_XD0_XDFFQ_S_XD1_dmodout r0 *1 0,0
Ccc_XD0_XDFFQ_S_XD1_dmodout XD0_XDFFQ_S XD1_dmodout 1.21e-17
* device instance cc_XD0_XDFFQ_S_XD1_dq r0 *1 0,0
Ccc_XD0_XDFFQ_S_XD1_dq XD0_XDFFQ_S XD1_dq 1.8151e-17
* device instance cc_XD0_XDFFQ_S_XD1_nm r0 *1 0,0
Ccc_XD0_XDFFQ_S_XD1_nm XD0_XDFFQ_S XD1_nm 1.21e-17
* device instance cc_XD0_XDFFQ_S_XD1_nt r0 *1 0,0
Ccc_XD0_XDFFQ_S_XD1_nt XD0_XDFFQ_S XD1_nt 1.21e-17
* device instance cc_XD0_XDFFQ_S_XD1_t1 r0 *1 0,0
Ccc_XD0_XDFFQ_S_XD1_t1 XD0_XDFFQ_S XD1_t1 1.21e-17
* device instance cc_XD0_XDFFQ_S_XD2_XDFFM_CKBB r0 *1 0,0
Ccc_XD0_XDFFQ_S_XD2_XDFFM_CKBB XD0_XDFFQ_S XD2_XDFFM_CKBB 1.8151e-17
* device instance cc_XD0_XDFFQ_S_XD2_XDFFM_CLKB r0 *1 0,0
Ccc_XD0_XDFFQ_S_XD2_XDFFM_CLKB XD0_XDFFQ_S XD2_XDFFM_CLKB 2.4201e-17
* device instance cc_XD0_XDFFQ_S_XD2_XDFFM_M r0 *1 0,0
Ccc_XD0_XDFFQ_S_XD2_XDFFM_M XD0_XDFFQ_S XD2_XDFFM_M 2.4201e-17
* device instance cc_XD0_XDFFQ_S_XD2_XDFFM_MB r0 *1 0,0
Ccc_XD0_XDFFQ_S_XD2_XDFFM_MB XD0_XDFFQ_S XD2_XDFFM_MB 1.21e-17
* device instance cc_XD0_XDFFQ_S_XD2_XDFFM_MFB r0 *1 0,0
Ccc_XD0_XDFFQ_S_XD2_XDFFM_MFB XD0_XDFFQ_S XD2_XDFFM_MFB 1.21e-17
* device instance cc_XD0_XDFFQ_S_XD2_XDFFM_S r0 *1 0,0
Ccc_XD0_XDFFQ_S_XD2_XDFFM_S XD0_XDFFQ_S XD2_XDFFM_S 1.8151e-17
* device instance cc_XD0_XDFFQ_S_XD2_XDFFM_SB r0 *1 0,0
Ccc_XD0_XDFFQ_S_XD2_XDFFM_SB XD0_XDFFQ_S XD2_XDFFM_SB 1.8151e-17
* device instance cc_XD0_XDFFQ_S_XD2_XDFFM_SFB r0 *1 0,0
Ccc_XD0_XDFFQ_S_XD2_XDFFM_SFB XD0_XDFFQ_S XD2_XDFFM_SFB 1.21e-17
* device instance cc_XD0_XDFFQ_S_XD2_XDFFQ_CKBB r0 *1 0,0
Ccc_XD0_XDFFQ_S_XD2_XDFFQ_CKBB XD0_XDFFQ_S XD2_XDFFQ_CKBB 1.8151e-17
* device instance cc_XD0_XDFFQ_S_XD2_XDFFQ_CLKB r0 *1 0,0
Ccc_XD0_XDFFQ_S_XD2_XDFFQ_CLKB XD0_XDFFQ_S XD2_XDFFQ_CLKB 2.4201e-17
* device instance cc_XD0_XDFFQ_S_XD2_XDFFQ_M r0 *1 0,0
Ccc_XD0_XDFFQ_S_XD2_XDFFQ_M XD0_XDFFQ_S XD2_XDFFQ_M 2.4201e-17
* device instance cc_XD0_XDFFQ_S_XD2_XDFFQ_MB r0 *1 0,0
Ccc_XD0_XDFFQ_S_XD2_XDFFQ_MB XD0_XDFFQ_S XD2_XDFFQ_MB 1.21e-17
* device instance cc_XD0_XDFFQ_S_XD2_XDFFQ_MFB r0 *1 0,0
Ccc_XD0_XDFFQ_S_XD2_XDFFQ_MFB XD0_XDFFQ_S XD2_XDFFQ_MFB 1.21e-17
* device instance cc_XD0_XDFFQ_S_XD2_XDFFQ_S r0 *1 0,0
Ccc_XD0_XDFFQ_S_XD2_XDFFQ_S XD0_XDFFQ_S XD2_XDFFQ_S 1.8151e-17
* device instance cc_XD0_XDFFQ_S_XD2_XDFFQ_SB r0 *1 0,0
Ccc_XD0_XDFFQ_S_XD2_XDFFQ_SB XD0_XDFFQ_S XD2_XDFFQ_SB 1.8151e-17
* device instance cc_XD0_XDFFQ_S_XD2_XDFFQ_SFB r0 *1 0,0
Ccc_XD0_XDFFQ_S_XD2_XDFFQ_SFB XD0_XDFFQ_S XD2_XDFFQ_SFB 1.21e-17
* device instance cc_XD0_XDFFQ_S_XD2_XN2_mid1 r0 *1 0,0
Ccc_XD0_XDFFQ_S_XD2_XN2_mid1 XD0_XDFFQ_S XD2_XN2_mid1 1.21e-17
* device instance cc_XD0_XDFFQ_S_XD2_XN3_mid1 r0 *1 0,0
Ccc_XD0_XDFFQ_S_XD2_XN3_mid1 XD0_XDFFQ_S XD2_XN3_mid1 1.21e-17
* device instance cc_XD0_XDFFQ_S_XD2_XN3_mid2 r0 *1 0,0
Ccc_XD0_XDFFQ_S_XD2_XN3_mid2 XD0_XDFFQ_S XD2_XN3_mid2 1.21e-17
* device instance cc_XD0_XDFFQ_S_XD2_dmodout r0 *1 0,0
Ccc_XD0_XDFFQ_S_XD2_dmodout XD0_XDFFQ_S XD2_dmodout 1.21e-17
* device instance cc_XD0_XDFFQ_S_XD2_dq r0 *1 0,0
Ccc_XD0_XDFFQ_S_XD2_dq XD0_XDFFQ_S XD2_dq 1.8151e-17
* device instance cc_XD0_XDFFQ_S_XD2_nm r0 *1 0,0
Ccc_XD0_XDFFQ_S_XD2_nm XD0_XDFFQ_S XD2_nm 1.21e-17
* device instance cc_XD0_XDFFQ_S_XD2_nt r0 *1 0,0
Ccc_XD0_XDFFQ_S_XD2_nt XD0_XDFFQ_S XD2_nt 1.21e-17
* device instance cc_XD0_XDFFQ_S_XD2_t1 r0 *1 0,0
Ccc_XD0_XDFFQ_S_XD2_t1 XD0_XDFFQ_S XD2_t1 1.21e-17
* device instance cc_XD0_XDFFQ_S_XD3_XDFFM_CKBB r0 *1 0,0
Ccc_XD0_XDFFQ_S_XD3_XDFFM_CKBB XD0_XDFFQ_S XD3_XDFFM_CKBB 1.8151e-17
* device instance cc_XD0_XDFFQ_S_XD3_XDFFM_CLKB r0 *1 0,0
Ccc_XD0_XDFFQ_S_XD3_XDFFM_CLKB XD0_XDFFQ_S XD3_XDFFM_CLKB 2.4201e-17
* device instance cc_XD0_XDFFQ_S_XD3_XDFFM_M r0 *1 0,0
Ccc_XD0_XDFFQ_S_XD3_XDFFM_M XD0_XDFFQ_S XD3_XDFFM_M 2.4201e-17
* device instance cc_XD0_XDFFQ_S_XD3_XDFFM_MB r0 *1 0,0
Ccc_XD0_XDFFQ_S_XD3_XDFFM_MB XD0_XDFFQ_S XD3_XDFFM_MB 1.21e-17
* device instance cc_XD0_XDFFQ_S_XD3_XDFFM_MFB r0 *1 0,0
Ccc_XD0_XDFFQ_S_XD3_XDFFM_MFB XD0_XDFFQ_S XD3_XDFFM_MFB 1.21e-17
* device instance cc_XD0_XDFFQ_S_XD3_XDFFM_S r0 *1 0,0
Ccc_XD0_XDFFQ_S_XD3_XDFFM_S XD0_XDFFQ_S XD3_XDFFM_S 1.8151e-17
* device instance cc_XD0_XDFFQ_S_XD3_XDFFM_SB r0 *1 0,0
Ccc_XD0_XDFFQ_S_XD3_XDFFM_SB XD0_XDFFQ_S XD3_XDFFM_SB 1.8151e-17
* device instance cc_XD0_XDFFQ_S_XD3_XDFFM_SFB r0 *1 0,0
Ccc_XD0_XDFFQ_S_XD3_XDFFM_SFB XD0_XDFFQ_S XD3_XDFFM_SFB 1.21e-17
* device instance cc_XD0_XDFFQ_S_XD3_XDFFQ_CKBB r0 *1 0,0
Ccc_XD0_XDFFQ_S_XD3_XDFFQ_CKBB XD0_XDFFQ_S XD3_XDFFQ_CKBB 1.8151e-17
* device instance cc_XD0_XDFFQ_S_XD3_XDFFQ_CLKB r0 *1 0,0
Ccc_XD0_XDFFQ_S_XD3_XDFFQ_CLKB XD0_XDFFQ_S XD3_XDFFQ_CLKB 2.4201e-17
* device instance cc_XD0_XDFFQ_S_XD3_XDFFQ_M r0 *1 0,0
Ccc_XD0_XDFFQ_S_XD3_XDFFQ_M XD0_XDFFQ_S XD3_XDFFQ_M 2.4201e-17
* device instance cc_XD0_XDFFQ_S_XD3_XDFFQ_MB r0 *1 0,0
Ccc_XD0_XDFFQ_S_XD3_XDFFQ_MB XD0_XDFFQ_S XD3_XDFFQ_MB 1.21e-17
* device instance cc_XD0_XDFFQ_S_XD3_XDFFQ_MFB r0 *1 0,0
Ccc_XD0_XDFFQ_S_XD3_XDFFQ_MFB XD0_XDFFQ_S XD3_XDFFQ_MFB 1.21e-17
* device instance cc_XD0_XDFFQ_S_XD3_XDFFQ_S r0 *1 0,0
Ccc_XD0_XDFFQ_S_XD3_XDFFQ_S XD0_XDFFQ_S XD3_XDFFQ_S 1.8151e-17
* device instance cc_XD0_XDFFQ_S_XD3_XDFFQ_SB r0 *1 0,0
Ccc_XD0_XDFFQ_S_XD3_XDFFQ_SB XD0_XDFFQ_S XD3_XDFFQ_SB 1.8151e-17
* device instance cc_XD0_XDFFQ_S_XD3_XDFFQ_SFB r0 *1 0,0
Ccc_XD0_XDFFQ_S_XD3_XDFFQ_SFB XD0_XDFFQ_S XD3_XDFFQ_SFB 1.21e-17
* device instance cc_XD0_XDFFQ_S_XD3_XN2_mid1 r0 *1 0,0
Ccc_XD0_XDFFQ_S_XD3_XN2_mid1 XD0_XDFFQ_S XD3_XN2_mid1 1.21e-17
* device instance cc_XD0_XDFFQ_S_XD3_XN3_mid1 r0 *1 0,0
Ccc_XD0_XDFFQ_S_XD3_XN3_mid1 XD0_XDFFQ_S XD3_XN3_mid1 1.21e-17
* device instance cc_XD0_XDFFQ_S_XD3_XN3_mid2 r0 *1 0,0
Ccc_XD0_XDFFQ_S_XD3_XN3_mid2 XD0_XDFFQ_S XD3_XN3_mid2 1.21e-17
* device instance cc_XD0_XDFFQ_S_XD3_dmodout r0 *1 0,0
Ccc_XD0_XDFFQ_S_XD3_dmodout XD0_XDFFQ_S XD3_dmodout 1.21e-17
* device instance cc_XD0_XDFFQ_S_XD3_dq r0 *1 0,0
Ccc_XD0_XDFFQ_S_XD3_dq XD0_XDFFQ_S XD3_dq 1.8151e-17
* device instance cc_XD0_XDFFQ_S_XD3_nm r0 *1 0,0
Ccc_XD0_XDFFQ_S_XD3_nm XD0_XDFFQ_S XD3_nm 1.21e-17
* device instance cc_XD0_XDFFQ_S_XD3_nt r0 *1 0,0
Ccc_XD0_XDFFQ_S_XD3_nt XD0_XDFFQ_S XD3_nt 1.21e-17
* device instance cc_XD0_XDFFQ_S_XD3_t1 r0 *1 0,0
Ccc_XD0_XDFFQ_S_XD3_t1 XD0_XDFFQ_S XD3_t1 1.21e-17
* device instance cc_XD0_XDFFQ_S_XD4_XDFFM_CKBB r0 *1 0,0
Ccc_XD0_XDFFQ_S_XD4_XDFFM_CKBB XD0_XDFFQ_S XD4_XDFFM_CKBB 1.8151e-17
* device instance cc_XD0_XDFFQ_S_XD4_XDFFM_CLKB r0 *1 0,0
Ccc_XD0_XDFFQ_S_XD4_XDFFM_CLKB XD0_XDFFQ_S XD4_XDFFM_CLKB 2.4201e-17
* device instance cc_XD0_XDFFQ_S_XD4_XDFFM_M r0 *1 0,0
Ccc_XD0_XDFFQ_S_XD4_XDFFM_M XD0_XDFFQ_S XD4_XDFFM_M 2.4201e-17
* device instance cc_XD0_XDFFQ_S_XD4_XDFFM_MB r0 *1 0,0
Ccc_XD0_XDFFQ_S_XD4_XDFFM_MB XD0_XDFFQ_S XD4_XDFFM_MB 1.21e-17
* device instance cc_XD0_XDFFQ_S_XD4_XDFFM_MFB r0 *1 0,0
Ccc_XD0_XDFFQ_S_XD4_XDFFM_MFB XD0_XDFFQ_S XD4_XDFFM_MFB 1.21e-17
* device instance cc_XD0_XDFFQ_S_XD4_XDFFM_S r0 *1 0,0
Ccc_XD0_XDFFQ_S_XD4_XDFFM_S XD0_XDFFQ_S XD4_XDFFM_S 1.8151e-17
* device instance cc_XD0_XDFFQ_S_XD4_XDFFM_SB r0 *1 0,0
Ccc_XD0_XDFFQ_S_XD4_XDFFM_SB XD0_XDFFQ_S XD4_XDFFM_SB 1.8151e-17
* device instance cc_XD0_XDFFQ_S_XD4_XDFFM_SFB r0 *1 0,0
Ccc_XD0_XDFFQ_S_XD4_XDFFM_SFB XD0_XDFFQ_S XD4_XDFFM_SFB 1.21e-17
* device instance cc_XD0_XDFFQ_S_XD4_XDFFQ_CKBB r0 *1 0,0
Ccc_XD0_XDFFQ_S_XD4_XDFFQ_CKBB XD0_XDFFQ_S XD4_XDFFQ_CKBB 1.8151e-17
* device instance cc_XD0_XDFFQ_S_XD4_XDFFQ_CLKB r0 *1 0,0
Ccc_XD0_XDFFQ_S_XD4_XDFFQ_CLKB XD0_XDFFQ_S XD4_XDFFQ_CLKB 2.4201e-17
* device instance cc_XD0_XDFFQ_S_XD4_XDFFQ_M r0 *1 0,0
Ccc_XD0_XDFFQ_S_XD4_XDFFQ_M XD0_XDFFQ_S XD4_XDFFQ_M 2.4201e-17
* device instance cc_XD0_XDFFQ_S_XD4_XDFFQ_MB r0 *1 0,0
Ccc_XD0_XDFFQ_S_XD4_XDFFQ_MB XD0_XDFFQ_S XD4_XDFFQ_MB 1.21e-17
* device instance cc_XD0_XDFFQ_S_XD4_XDFFQ_MFB r0 *1 0,0
Ccc_XD0_XDFFQ_S_XD4_XDFFQ_MFB XD0_XDFFQ_S XD4_XDFFQ_MFB 1.21e-17
* device instance cc_XD0_XDFFQ_S_XD4_XDFFQ_S r0 *1 0,0
Ccc_XD0_XDFFQ_S_XD4_XDFFQ_S XD0_XDFFQ_S XD4_XDFFQ_S 1.8151e-17
* device instance cc_XD0_XDFFQ_S_XD4_XDFFQ_SB r0 *1 0,0
Ccc_XD0_XDFFQ_S_XD4_XDFFQ_SB XD0_XDFFQ_S XD4_XDFFQ_SB 1.8151e-17
* device instance cc_XD0_XDFFQ_S_XD4_XDFFQ_SFB r0 *1 0,0
Ccc_XD0_XDFFQ_S_XD4_XDFFQ_SFB XD0_XDFFQ_S XD4_XDFFQ_SFB 1.21e-17
* device instance cc_XD0_XDFFQ_S_XD4_XN2_mid1 r0 *1 0,0
Ccc_XD0_XDFFQ_S_XD4_XN2_mid1 XD0_XDFFQ_S XD4_XN2_mid1 1.21e-17
* device instance cc_XD0_XDFFQ_S_XD4_XN3_mid1 r0 *1 0,0
Ccc_XD0_XDFFQ_S_XD4_XN3_mid1 XD0_XDFFQ_S XD4_XN3_mid1 1.21e-17
* device instance cc_XD0_XDFFQ_S_XD4_XN3_mid2 r0 *1 0,0
Ccc_XD0_XDFFQ_S_XD4_XN3_mid2 XD0_XDFFQ_S XD4_XN3_mid2 1.21e-17
* device instance cc_XD0_XDFFQ_S_XD4_dmodout r0 *1 0,0
Ccc_XD0_XDFFQ_S_XD4_dmodout XD0_XDFFQ_S XD4_dmodout 1.21e-17
* device instance cc_XD0_XDFFQ_S_XD4_dq r0 *1 0,0
Ccc_XD0_XDFFQ_S_XD4_dq XD0_XDFFQ_S XD4_dq 1.8151e-17
* device instance cc_XD0_XDFFQ_S_XD4_nm r0 *1 0,0
Ccc_XD0_XDFFQ_S_XD4_nm XD0_XDFFQ_S XD4_nm 1.21e-17
* device instance cc_XD0_XDFFQ_S_XD4_nt r0 *1 0,0
Ccc_XD0_XDFFQ_S_XD4_nt XD0_XDFFQ_S XD4_nt 1.21e-17
* device instance cc_XD0_XDFFQ_S_XD4_t1 r0 *1 0,0
Ccc_XD0_XDFFQ_S_XD4_t1 XD0_XDFFQ_S XD4_t1 1.21e-17
* device instance cc_XD0_XDFFQ_S_XD5_XDFFM_CKBB r0 *1 0,0
Ccc_XD0_XDFFQ_S_XD5_XDFFM_CKBB XD0_XDFFQ_S XD5_XDFFM_CKBB 1.8151e-17
* device instance cc_XD0_XDFFQ_S_XD5_XDFFM_CLKB r0 *1 0,0
Ccc_XD0_XDFFQ_S_XD5_XDFFM_CLKB XD0_XDFFQ_S XD5_XDFFM_CLKB 2.4201e-17
* device instance cc_XD0_XDFFQ_S_XD5_XDFFM_M r0 *1 0,0
Ccc_XD0_XDFFQ_S_XD5_XDFFM_M XD0_XDFFQ_S XD5_XDFFM_M 2.4201e-17
* device instance cc_XD0_XDFFQ_S_XD5_XDFFM_MB r0 *1 0,0
Ccc_XD0_XDFFQ_S_XD5_XDFFM_MB XD0_XDFFQ_S XD5_XDFFM_MB 1.21e-17
* device instance cc_XD0_XDFFQ_S_XD5_XDFFM_MFB r0 *1 0,0
Ccc_XD0_XDFFQ_S_XD5_XDFFM_MFB XD0_XDFFQ_S XD5_XDFFM_MFB 1.21e-17
* device instance cc_XD0_XDFFQ_S_XD5_XDFFM_S r0 *1 0,0
Ccc_XD0_XDFFQ_S_XD5_XDFFM_S XD0_XDFFQ_S XD5_XDFFM_S 1.8151e-17
* device instance cc_XD0_XDFFQ_S_XD5_XDFFM_SB r0 *1 0,0
Ccc_XD0_XDFFQ_S_XD5_XDFFM_SB XD0_XDFFQ_S XD5_XDFFM_SB 1.8151e-17
* device instance cc_XD0_XDFFQ_S_XD5_XDFFM_SFB r0 *1 0,0
Ccc_XD0_XDFFQ_S_XD5_XDFFM_SFB XD0_XDFFQ_S XD5_XDFFM_SFB 1.21e-17
* device instance cc_XD0_XDFFQ_S_XD5_XDFFQ_CKBB r0 *1 0,0
Ccc_XD0_XDFFQ_S_XD5_XDFFQ_CKBB XD0_XDFFQ_S XD5_XDFFQ_CKBB 1.8151e-17
* device instance cc_XD0_XDFFQ_S_XD5_XDFFQ_CLKB r0 *1 0,0
Ccc_XD0_XDFFQ_S_XD5_XDFFQ_CLKB XD0_XDFFQ_S XD5_XDFFQ_CLKB 2.4201e-17
* device instance cc_XD0_XDFFQ_S_XD5_XDFFQ_M r0 *1 0,0
Ccc_XD0_XDFFQ_S_XD5_XDFFQ_M XD0_XDFFQ_S XD5_XDFFQ_M 2.4201e-17
* device instance cc_XD0_XDFFQ_S_XD5_XDFFQ_MB r0 *1 0,0
Ccc_XD0_XDFFQ_S_XD5_XDFFQ_MB XD0_XDFFQ_S XD5_XDFFQ_MB 1.21e-17
* device instance cc_XD0_XDFFQ_S_XD5_XDFFQ_MFB r0 *1 0,0
Ccc_XD0_XDFFQ_S_XD5_XDFFQ_MFB XD0_XDFFQ_S XD5_XDFFQ_MFB 1.21e-17
* device instance cc_XD0_XDFFQ_S_XD5_XDFFQ_S r0 *1 0,0
Ccc_XD0_XDFFQ_S_XD5_XDFFQ_S XD0_XDFFQ_S XD5_XDFFQ_S 1.8151e-17
* device instance cc_XD0_XDFFQ_S_XD5_XDFFQ_SB r0 *1 0,0
Ccc_XD0_XDFFQ_S_XD5_XDFFQ_SB XD0_XDFFQ_S XD5_XDFFQ_SB 1.8151e-17
* device instance cc_XD0_XDFFQ_S_XD5_XDFFQ_SFB r0 *1 0,0
Ccc_XD0_XDFFQ_S_XD5_XDFFQ_SFB XD0_XDFFQ_S XD5_XDFFQ_SFB 1.21e-17
* device instance cc_XD0_XDFFQ_S_XD5_XN2_mid1 r0 *1 0,0
Ccc_XD0_XDFFQ_S_XD5_XN2_mid1 XD0_XDFFQ_S XD5_XN2_mid1 1.21e-17
* device instance cc_XD0_XDFFQ_S_XD5_XN3_mid1 r0 *1 0,0
Ccc_XD0_XDFFQ_S_XD5_XN3_mid1 XD0_XDFFQ_S XD5_XN3_mid1 1.21e-17
* device instance cc_XD0_XDFFQ_S_XD5_XN3_mid2 r0 *1 0,0
Ccc_XD0_XDFFQ_S_XD5_XN3_mid2 XD0_XDFFQ_S XD5_XN3_mid2 1.21e-17
* device instance cc_XD0_XDFFQ_S_XD5_dmodout r0 *1 0,0
Ccc_XD0_XDFFQ_S_XD5_dmodout XD0_XDFFQ_S XD5_dmodout 1.21e-17
* device instance cc_XD0_XDFFQ_S_XD5_dq r0 *1 0,0
Ccc_XD0_XDFFQ_S_XD5_dq XD0_XDFFQ_S XD5_dq 1.8151e-17
* device instance cc_XD0_XDFFQ_S_XD5_nm r0 *1 0,0
Ccc_XD0_XDFFQ_S_XD5_nm XD0_XDFFQ_S XD5_nm 1.21e-17
* device instance cc_XD0_XDFFQ_S_XD5_nt r0 *1 0,0
Ccc_XD0_XDFFQ_S_XD5_nt XD0_XDFFQ_S XD5_nt 1.21e-17
* device instance cc_XD0_XDFFQ_S_XD5_t1 r0 *1 0,0
Ccc_XD0_XDFFQ_S_XD5_t1 XD0_XDFFQ_S XD5_t1 1.21e-17
* device instance cc_XD0_XDFFQ_S_XFRT_CKBB r0 *1 0,0
Ccc_XD0_XDFFQ_S_XFRT_CKBB XD0_XDFFQ_S XFRT_CKBB 1.8151e-17
* device instance cc_XD0_XDFFQ_S_XFRT_CLKB r0 *1 0,0
Ccc_XD0_XDFFQ_S_XFRT_CLKB XD0_XDFFQ_S XFRT_CLKB 2.4201e-17
* device instance cc_XD0_XDFFQ_S_XFRT_M r0 *1 0,0
Ccc_XD0_XDFFQ_S_XFRT_M XD0_XDFFQ_S XFRT_M 2.4201e-17
* device instance cc_XD0_XDFFQ_S_XFRT_MB r0 *1 0,0
Ccc_XD0_XDFFQ_S_XFRT_MB XD0_XDFFQ_S XFRT_MB 1.21e-17
* device instance cc_XD0_XDFFQ_S_XFRT_MFB r0 *1 0,0
Ccc_XD0_XDFFQ_S_XFRT_MFB XD0_XDFFQ_S XFRT_MFB 1.21e-17
* device instance cc_XD0_XDFFQ_S_XFRT_S r0 *1 0,0
Ccc_XD0_XDFFQ_S_XFRT_S XD0_XDFFQ_S XFRT_S 1.8151e-17
* device instance cc_XD0_XDFFQ_S_XFRT_SB r0 *1 0,0
Ccc_XD0_XDFFQ_S_XFRT_SB XD0_XDFFQ_S XFRT_SB 1.8151e-17
* device instance cc_XD0_XDFFQ_S_XFRT_SFB r0 *1 0,0
Ccc_XD0_XDFFQ_S_XFRT_SFB XD0_XDFFQ_S XFRT_SFB 1.21e-17
* device instance cc_XD0_XDFFQ_S_ck1 r0 *1 0,0
Ccc_XD0_XDFFQ_S_ck1 XD0_XDFFQ_S ck1 3.0251e-17
* device instance cc_XD0_XDFFQ_S_ck2 r0 *1 0,0
Ccc_XD0_XDFFQ_S_ck2 XD0_XDFFQ_S ck2 3.0251e-17
* device instance cc_XD0_XDFFQ_S_ck3 r0 *1 0,0
Ccc_XD0_XDFFQ_S_ck3 XD0_XDFFQ_S ck3 3.0251e-17
* device instance cc_XD0_XDFFQ_S_ck4 r0 *1 0,0
Ccc_XD0_XDFFQ_S_ck4 XD0_XDFFQ_S ck4 3.0251e-17
* device instance cc_XD0_XDFFQ_S_ck5 r0 *1 0,0
Ccc_XD0_XDFFQ_S_ck5 XD0_XDFFQ_S ck5 3.0251e-17
* device instance cc_XD0_XDFFQ_S_mod0 r0 *1 0,0
Ccc_XD0_XDFFQ_S_mod0 XD0_XDFFQ_S mod0 2.4201e-17
* device instance cc_XD0_XDFFQ_S_mod1 r0 *1 0,0
Ccc_XD0_XDFFQ_S_mod1 XD0_XDFFQ_S mod1 2.4201e-17
* device instance cc_XD0_XDFFQ_S_mod2 r0 *1 0,0
Ccc_XD0_XDFFQ_S_mod2 XD0_XDFFQ_S mod2 2.4201e-17
* device instance cc_XD0_XDFFQ_S_mod3 r0 *1 0,0
Ccc_XD0_XDFFQ_S_mod3 XD0_XDFFQ_S mod3 2.4201e-17
* device instance cc_XD0_XDFFQ_S_mod4 r0 *1 0,0
Ccc_XD0_XDFFQ_S_mod4 XD0_XDFFQ_S mod4 2.4201e-17
* device instance cc_XD0_XDFFQ_S_net1 r0 *1 0,0
Ccc_XD0_XDFFQ_S_net1 XD0_XDFFQ_S net1 1.21e-17
* device instance cc_XD0_XDFFQ_SB_XD0_XDFFQ_SFB r0 *1 0,0
Ccc_XD0_XDFFQ_SB_XD0_XDFFQ_SFB XD0_XDFFQ_SB XD0_XDFFQ_SFB 2.4201e-17
* device instance cc_XD0_XDFFQ_SB_XD0_XN2_mid1 r0 *1 0,0
Ccc_XD0_XDFFQ_SB_XD0_XN2_mid1 XD0_XDFFQ_SB XD0_XN2_mid1 1.21e-17
* device instance cc_XD0_XDFFQ_SB_XD0_XNOR_midp r0 *1 0,0
Ccc_XD0_XDFFQ_SB_XD0_XNOR_midp XD0_XDFFQ_SB XD0_XNOR_midp 1.21e-17
* device instance cc_XD0_XDFFQ_SB_XD0_dmodout r0 *1 0,0
Ccc_XD0_XDFFQ_SB_XD0_dmodout XD0_XDFFQ_SB XD0_dmodout 1.21e-17
* device instance cc_XD0_XDFFQ_SB_XD0_dq r0 *1 0,0
Ccc_XD0_XDFFQ_SB_XD0_dq XD0_XDFFQ_SB XD0_dq 1.21e-17
* device instance cc_XD0_XDFFQ_SB_XD0_nm r0 *1 0,0
Ccc_XD0_XDFFQ_SB_XD0_nm XD0_XDFFQ_SB XD0_nm 1.21e-17
* device instance cc_XD0_XDFFQ_SB_XD0_nt r0 *1 0,0
Ccc_XD0_XDFFQ_SB_XD0_nt XD0_XDFFQ_SB XD0_nt 2.4201e-17
* device instance cc_XD0_XDFFQ_SB_XD0_t1 r0 *1 0,0
Ccc_XD0_XDFFQ_SB_XD0_t1 XD0_XDFFQ_SB XD0_t1 1.21e-17
* device instance cc_XD0_XDFFQ_SB_XD1_XDFFM_CKBB r0 *1 0,0
Ccc_XD0_XDFFQ_SB_XD1_XDFFM_CKBB XD0_XDFFQ_SB XD1_XDFFM_CKBB 1.8151e-17
* device instance cc_XD0_XDFFQ_SB_XD1_XDFFM_CLKB r0 *1 0,0
Ccc_XD0_XDFFQ_SB_XD1_XDFFM_CLKB XD0_XDFFQ_SB XD1_XDFFM_CLKB 2.4201e-17
* device instance cc_XD0_XDFFQ_SB_XD1_XDFFM_M r0 *1 0,0
Ccc_XD0_XDFFQ_SB_XD1_XDFFM_M XD0_XDFFQ_SB XD1_XDFFM_M 2.4201e-17
* device instance cc_XD0_XDFFQ_SB_XD1_XDFFM_MB r0 *1 0,0
Ccc_XD0_XDFFQ_SB_XD1_XDFFM_MB XD0_XDFFQ_SB XD1_XDFFM_MB 1.21e-17
* device instance cc_XD0_XDFFQ_SB_XD1_XDFFM_MFB r0 *1 0,0
Ccc_XD0_XDFFQ_SB_XD1_XDFFM_MFB XD0_XDFFQ_SB XD1_XDFFM_MFB 1.21e-17
* device instance cc_XD0_XDFFQ_SB_XD1_XDFFM_S r0 *1 0,0
Ccc_XD0_XDFFQ_SB_XD1_XDFFM_S XD0_XDFFQ_SB XD1_XDFFM_S 1.8151e-17
* device instance cc_XD0_XDFFQ_SB_XD1_XDFFM_SB r0 *1 0,0
Ccc_XD0_XDFFQ_SB_XD1_XDFFM_SB XD0_XDFFQ_SB XD1_XDFFM_SB 1.8151e-17
* device instance cc_XD0_XDFFQ_SB_XD1_XDFFM_SFB r0 *1 0,0
Ccc_XD0_XDFFQ_SB_XD1_XDFFM_SFB XD0_XDFFQ_SB XD1_XDFFM_SFB 1.21e-17
* device instance cc_XD0_XDFFQ_SB_XD1_XDFFQ_CKBB r0 *1 0,0
Ccc_XD0_XDFFQ_SB_XD1_XDFFQ_CKBB XD0_XDFFQ_SB XD1_XDFFQ_CKBB 1.8151e-17
* device instance cc_XD0_XDFFQ_SB_XD1_XDFFQ_CLKB r0 *1 0,0
Ccc_XD0_XDFFQ_SB_XD1_XDFFQ_CLKB XD0_XDFFQ_SB XD1_XDFFQ_CLKB 2.4201e-17
* device instance cc_XD0_XDFFQ_SB_XD1_XDFFQ_M r0 *1 0,0
Ccc_XD0_XDFFQ_SB_XD1_XDFFQ_M XD0_XDFFQ_SB XD1_XDFFQ_M 2.4201e-17
* device instance cc_XD0_XDFFQ_SB_XD1_XDFFQ_MB r0 *1 0,0
Ccc_XD0_XDFFQ_SB_XD1_XDFFQ_MB XD0_XDFFQ_SB XD1_XDFFQ_MB 1.21e-17
* device instance cc_XD0_XDFFQ_SB_XD1_XDFFQ_MFB r0 *1 0,0
Ccc_XD0_XDFFQ_SB_XD1_XDFFQ_MFB XD0_XDFFQ_SB XD1_XDFFQ_MFB 1.21e-17
* device instance cc_XD0_XDFFQ_SB_XD1_XDFFQ_S r0 *1 0,0
Ccc_XD0_XDFFQ_SB_XD1_XDFFQ_S XD0_XDFFQ_SB XD1_XDFFQ_S 1.8151e-17
* device instance cc_XD0_XDFFQ_SB_XD1_XDFFQ_SB r0 *1 0,0
Ccc_XD0_XDFFQ_SB_XD1_XDFFQ_SB XD0_XDFFQ_SB XD1_XDFFQ_SB 1.8151e-17
* device instance cc_XD0_XDFFQ_SB_XD1_XDFFQ_SFB r0 *1 0,0
Ccc_XD0_XDFFQ_SB_XD1_XDFFQ_SFB XD0_XDFFQ_SB XD1_XDFFQ_SFB 1.21e-17
* device instance cc_XD0_XDFFQ_SB_XD1_XN2_mid1 r0 *1 0,0
Ccc_XD0_XDFFQ_SB_XD1_XN2_mid1 XD0_XDFFQ_SB XD1_XN2_mid1 1.21e-17
* device instance cc_XD0_XDFFQ_SB_XD1_XN3_mid1 r0 *1 0,0
Ccc_XD0_XDFFQ_SB_XD1_XN3_mid1 XD0_XDFFQ_SB XD1_XN3_mid1 1.21e-17
* device instance cc_XD0_XDFFQ_SB_XD1_XN3_mid2 r0 *1 0,0
Ccc_XD0_XDFFQ_SB_XD1_XN3_mid2 XD0_XDFFQ_SB XD1_XN3_mid2 1.21e-17
* device instance cc_XD0_XDFFQ_SB_XD1_dmodout r0 *1 0,0
Ccc_XD0_XDFFQ_SB_XD1_dmodout XD0_XDFFQ_SB XD1_dmodout 1.21e-17
* device instance cc_XD0_XDFFQ_SB_XD1_dq r0 *1 0,0
Ccc_XD0_XDFFQ_SB_XD1_dq XD0_XDFFQ_SB XD1_dq 1.8151e-17
* device instance cc_XD0_XDFFQ_SB_XD1_nm r0 *1 0,0
Ccc_XD0_XDFFQ_SB_XD1_nm XD0_XDFFQ_SB XD1_nm 1.21e-17
* device instance cc_XD0_XDFFQ_SB_XD1_nt r0 *1 0,0
Ccc_XD0_XDFFQ_SB_XD1_nt XD0_XDFFQ_SB XD1_nt 1.21e-17
* device instance cc_XD0_XDFFQ_SB_XD1_t1 r0 *1 0,0
Ccc_XD0_XDFFQ_SB_XD1_t1 XD0_XDFFQ_SB XD1_t1 1.21e-17
* device instance cc_XD0_XDFFQ_SB_XD2_XDFFM_CKBB r0 *1 0,0
Ccc_XD0_XDFFQ_SB_XD2_XDFFM_CKBB XD0_XDFFQ_SB XD2_XDFFM_CKBB 1.8151e-17
* device instance cc_XD0_XDFFQ_SB_XD2_XDFFM_CLKB r0 *1 0,0
Ccc_XD0_XDFFQ_SB_XD2_XDFFM_CLKB XD0_XDFFQ_SB XD2_XDFFM_CLKB 2.4201e-17
* device instance cc_XD0_XDFFQ_SB_XD2_XDFFM_M r0 *1 0,0
Ccc_XD0_XDFFQ_SB_XD2_XDFFM_M XD0_XDFFQ_SB XD2_XDFFM_M 2.4201e-17
* device instance cc_XD0_XDFFQ_SB_XD2_XDFFM_MB r0 *1 0,0
Ccc_XD0_XDFFQ_SB_XD2_XDFFM_MB XD0_XDFFQ_SB XD2_XDFFM_MB 1.21e-17
* device instance cc_XD0_XDFFQ_SB_XD2_XDFFM_MFB r0 *1 0,0
Ccc_XD0_XDFFQ_SB_XD2_XDFFM_MFB XD0_XDFFQ_SB XD2_XDFFM_MFB 1.21e-17
* device instance cc_XD0_XDFFQ_SB_XD2_XDFFM_S r0 *1 0,0
Ccc_XD0_XDFFQ_SB_XD2_XDFFM_S XD0_XDFFQ_SB XD2_XDFFM_S 1.8151e-17
* device instance cc_XD0_XDFFQ_SB_XD2_XDFFM_SB r0 *1 0,0
Ccc_XD0_XDFFQ_SB_XD2_XDFFM_SB XD0_XDFFQ_SB XD2_XDFFM_SB 1.8151e-17
* device instance cc_XD0_XDFFQ_SB_XD2_XDFFM_SFB r0 *1 0,0
Ccc_XD0_XDFFQ_SB_XD2_XDFFM_SFB XD0_XDFFQ_SB XD2_XDFFM_SFB 1.21e-17
* device instance cc_XD0_XDFFQ_SB_XD2_XDFFQ_CKBB r0 *1 0,0
Ccc_XD0_XDFFQ_SB_XD2_XDFFQ_CKBB XD0_XDFFQ_SB XD2_XDFFQ_CKBB 1.8151e-17
* device instance cc_XD0_XDFFQ_SB_XD2_XDFFQ_CLKB r0 *1 0,0
Ccc_XD0_XDFFQ_SB_XD2_XDFFQ_CLKB XD0_XDFFQ_SB XD2_XDFFQ_CLKB 2.4201e-17
* device instance cc_XD0_XDFFQ_SB_XD2_XDFFQ_M r0 *1 0,0
Ccc_XD0_XDFFQ_SB_XD2_XDFFQ_M XD0_XDFFQ_SB XD2_XDFFQ_M 2.4201e-17
* device instance cc_XD0_XDFFQ_SB_XD2_XDFFQ_MB r0 *1 0,0
Ccc_XD0_XDFFQ_SB_XD2_XDFFQ_MB XD0_XDFFQ_SB XD2_XDFFQ_MB 1.21e-17
* device instance cc_XD0_XDFFQ_SB_XD2_XDFFQ_MFB r0 *1 0,0
Ccc_XD0_XDFFQ_SB_XD2_XDFFQ_MFB XD0_XDFFQ_SB XD2_XDFFQ_MFB 1.21e-17
* device instance cc_XD0_XDFFQ_SB_XD2_XDFFQ_S r0 *1 0,0
Ccc_XD0_XDFFQ_SB_XD2_XDFFQ_S XD0_XDFFQ_SB XD2_XDFFQ_S 1.8151e-17
* device instance cc_XD0_XDFFQ_SB_XD2_XDFFQ_SB r0 *1 0,0
Ccc_XD0_XDFFQ_SB_XD2_XDFFQ_SB XD0_XDFFQ_SB XD2_XDFFQ_SB 1.8151e-17
* device instance cc_XD0_XDFFQ_SB_XD2_XDFFQ_SFB r0 *1 0,0
Ccc_XD0_XDFFQ_SB_XD2_XDFFQ_SFB XD0_XDFFQ_SB XD2_XDFFQ_SFB 1.21e-17
* device instance cc_XD0_XDFFQ_SB_XD2_XN2_mid1 r0 *1 0,0
Ccc_XD0_XDFFQ_SB_XD2_XN2_mid1 XD0_XDFFQ_SB XD2_XN2_mid1 1.21e-17
* device instance cc_XD0_XDFFQ_SB_XD2_XN3_mid1 r0 *1 0,0
Ccc_XD0_XDFFQ_SB_XD2_XN3_mid1 XD0_XDFFQ_SB XD2_XN3_mid1 1.21e-17
* device instance cc_XD0_XDFFQ_SB_XD2_XN3_mid2 r0 *1 0,0
Ccc_XD0_XDFFQ_SB_XD2_XN3_mid2 XD0_XDFFQ_SB XD2_XN3_mid2 1.21e-17
* device instance cc_XD0_XDFFQ_SB_XD2_dmodout r0 *1 0,0
Ccc_XD0_XDFFQ_SB_XD2_dmodout XD0_XDFFQ_SB XD2_dmodout 1.21e-17
* device instance cc_XD0_XDFFQ_SB_XD2_dq r0 *1 0,0
Ccc_XD0_XDFFQ_SB_XD2_dq XD0_XDFFQ_SB XD2_dq 1.8151e-17
* device instance cc_XD0_XDFFQ_SB_XD2_nm r0 *1 0,0
Ccc_XD0_XDFFQ_SB_XD2_nm XD0_XDFFQ_SB XD2_nm 1.21e-17
* device instance cc_XD0_XDFFQ_SB_XD2_nt r0 *1 0,0
Ccc_XD0_XDFFQ_SB_XD2_nt XD0_XDFFQ_SB XD2_nt 1.21e-17
* device instance cc_XD0_XDFFQ_SB_XD2_t1 r0 *1 0,0
Ccc_XD0_XDFFQ_SB_XD2_t1 XD0_XDFFQ_SB XD2_t1 1.21e-17
* device instance cc_XD0_XDFFQ_SB_XD3_XDFFM_CKBB r0 *1 0,0
Ccc_XD0_XDFFQ_SB_XD3_XDFFM_CKBB XD0_XDFFQ_SB XD3_XDFFM_CKBB 1.8151e-17
* device instance cc_XD0_XDFFQ_SB_XD3_XDFFM_CLKB r0 *1 0,0
Ccc_XD0_XDFFQ_SB_XD3_XDFFM_CLKB XD0_XDFFQ_SB XD3_XDFFM_CLKB 2.4201e-17
* device instance cc_XD0_XDFFQ_SB_XD3_XDFFM_M r0 *1 0,0
Ccc_XD0_XDFFQ_SB_XD3_XDFFM_M XD0_XDFFQ_SB XD3_XDFFM_M 2.4201e-17
* device instance cc_XD0_XDFFQ_SB_XD3_XDFFM_MB r0 *1 0,0
Ccc_XD0_XDFFQ_SB_XD3_XDFFM_MB XD0_XDFFQ_SB XD3_XDFFM_MB 1.21e-17
* device instance cc_XD0_XDFFQ_SB_XD3_XDFFM_MFB r0 *1 0,0
Ccc_XD0_XDFFQ_SB_XD3_XDFFM_MFB XD0_XDFFQ_SB XD3_XDFFM_MFB 1.21e-17
* device instance cc_XD0_XDFFQ_SB_XD3_XDFFM_S r0 *1 0,0
Ccc_XD0_XDFFQ_SB_XD3_XDFFM_S XD0_XDFFQ_SB XD3_XDFFM_S 1.8151e-17
* device instance cc_XD0_XDFFQ_SB_XD3_XDFFM_SB r0 *1 0,0
Ccc_XD0_XDFFQ_SB_XD3_XDFFM_SB XD0_XDFFQ_SB XD3_XDFFM_SB 1.8151e-17
* device instance cc_XD0_XDFFQ_SB_XD3_XDFFM_SFB r0 *1 0,0
Ccc_XD0_XDFFQ_SB_XD3_XDFFM_SFB XD0_XDFFQ_SB XD3_XDFFM_SFB 1.21e-17
* device instance cc_XD0_XDFFQ_SB_XD3_XDFFQ_CKBB r0 *1 0,0
Ccc_XD0_XDFFQ_SB_XD3_XDFFQ_CKBB XD0_XDFFQ_SB XD3_XDFFQ_CKBB 1.8151e-17
* device instance cc_XD0_XDFFQ_SB_XD3_XDFFQ_CLKB r0 *1 0,0
Ccc_XD0_XDFFQ_SB_XD3_XDFFQ_CLKB XD0_XDFFQ_SB XD3_XDFFQ_CLKB 2.4201e-17
* device instance cc_XD0_XDFFQ_SB_XD3_XDFFQ_M r0 *1 0,0
Ccc_XD0_XDFFQ_SB_XD3_XDFFQ_M XD0_XDFFQ_SB XD3_XDFFQ_M 2.4201e-17
* device instance cc_XD0_XDFFQ_SB_XD3_XDFFQ_MB r0 *1 0,0
Ccc_XD0_XDFFQ_SB_XD3_XDFFQ_MB XD0_XDFFQ_SB XD3_XDFFQ_MB 1.21e-17
* device instance cc_XD0_XDFFQ_SB_XD3_XDFFQ_MFB r0 *1 0,0
Ccc_XD0_XDFFQ_SB_XD3_XDFFQ_MFB XD0_XDFFQ_SB XD3_XDFFQ_MFB 1.21e-17
* device instance cc_XD0_XDFFQ_SB_XD3_XDFFQ_S r0 *1 0,0
Ccc_XD0_XDFFQ_SB_XD3_XDFFQ_S XD0_XDFFQ_SB XD3_XDFFQ_S 1.8151e-17
* device instance cc_XD0_XDFFQ_SB_XD3_XDFFQ_SB r0 *1 0,0
Ccc_XD0_XDFFQ_SB_XD3_XDFFQ_SB XD0_XDFFQ_SB XD3_XDFFQ_SB 1.8151e-17
* device instance cc_XD0_XDFFQ_SB_XD3_XDFFQ_SFB r0 *1 0,0
Ccc_XD0_XDFFQ_SB_XD3_XDFFQ_SFB XD0_XDFFQ_SB XD3_XDFFQ_SFB 1.21e-17
* device instance cc_XD0_XDFFQ_SB_XD3_XN2_mid1 r0 *1 0,0
Ccc_XD0_XDFFQ_SB_XD3_XN2_mid1 XD0_XDFFQ_SB XD3_XN2_mid1 1.21e-17
* device instance cc_XD0_XDFFQ_SB_XD3_XN3_mid1 r0 *1 0,0
Ccc_XD0_XDFFQ_SB_XD3_XN3_mid1 XD0_XDFFQ_SB XD3_XN3_mid1 1.21e-17
* device instance cc_XD0_XDFFQ_SB_XD3_XN3_mid2 r0 *1 0,0
Ccc_XD0_XDFFQ_SB_XD3_XN3_mid2 XD0_XDFFQ_SB XD3_XN3_mid2 1.21e-17
* device instance cc_XD0_XDFFQ_SB_XD3_dmodout r0 *1 0,0
Ccc_XD0_XDFFQ_SB_XD3_dmodout XD0_XDFFQ_SB XD3_dmodout 1.21e-17
* device instance cc_XD0_XDFFQ_SB_XD3_dq r0 *1 0,0
Ccc_XD0_XDFFQ_SB_XD3_dq XD0_XDFFQ_SB XD3_dq 1.8151e-17
* device instance cc_XD0_XDFFQ_SB_XD3_nm r0 *1 0,0
Ccc_XD0_XDFFQ_SB_XD3_nm XD0_XDFFQ_SB XD3_nm 1.21e-17
* device instance cc_XD0_XDFFQ_SB_XD3_nt r0 *1 0,0
Ccc_XD0_XDFFQ_SB_XD3_nt XD0_XDFFQ_SB XD3_nt 1.21e-17
* device instance cc_XD0_XDFFQ_SB_XD3_t1 r0 *1 0,0
Ccc_XD0_XDFFQ_SB_XD3_t1 XD0_XDFFQ_SB XD3_t1 1.21e-17
* device instance cc_XD0_XDFFQ_SB_XD4_XDFFM_CKBB r0 *1 0,0
Ccc_XD0_XDFFQ_SB_XD4_XDFFM_CKBB XD0_XDFFQ_SB XD4_XDFFM_CKBB 1.8151e-17
* device instance cc_XD0_XDFFQ_SB_XD4_XDFFM_CLKB r0 *1 0,0
Ccc_XD0_XDFFQ_SB_XD4_XDFFM_CLKB XD0_XDFFQ_SB XD4_XDFFM_CLKB 2.4201e-17
* device instance cc_XD0_XDFFQ_SB_XD4_XDFFM_M r0 *1 0,0
Ccc_XD0_XDFFQ_SB_XD4_XDFFM_M XD0_XDFFQ_SB XD4_XDFFM_M 2.4201e-17
* device instance cc_XD0_XDFFQ_SB_XD4_XDFFM_MB r0 *1 0,0
Ccc_XD0_XDFFQ_SB_XD4_XDFFM_MB XD0_XDFFQ_SB XD4_XDFFM_MB 1.21e-17
* device instance cc_XD0_XDFFQ_SB_XD4_XDFFM_MFB r0 *1 0,0
Ccc_XD0_XDFFQ_SB_XD4_XDFFM_MFB XD0_XDFFQ_SB XD4_XDFFM_MFB 1.21e-17
* device instance cc_XD0_XDFFQ_SB_XD4_XDFFM_S r0 *1 0,0
Ccc_XD0_XDFFQ_SB_XD4_XDFFM_S XD0_XDFFQ_SB XD4_XDFFM_S 1.8151e-17
* device instance cc_XD0_XDFFQ_SB_XD4_XDFFM_SB r0 *1 0,0
Ccc_XD0_XDFFQ_SB_XD4_XDFFM_SB XD0_XDFFQ_SB XD4_XDFFM_SB 1.8151e-17
* device instance cc_XD0_XDFFQ_SB_XD4_XDFFM_SFB r0 *1 0,0
Ccc_XD0_XDFFQ_SB_XD4_XDFFM_SFB XD0_XDFFQ_SB XD4_XDFFM_SFB 1.21e-17
* device instance cc_XD0_XDFFQ_SB_XD4_XDFFQ_CKBB r0 *1 0,0
Ccc_XD0_XDFFQ_SB_XD4_XDFFQ_CKBB XD0_XDFFQ_SB XD4_XDFFQ_CKBB 1.8151e-17
* device instance cc_XD0_XDFFQ_SB_XD4_XDFFQ_CLKB r0 *1 0,0
Ccc_XD0_XDFFQ_SB_XD4_XDFFQ_CLKB XD0_XDFFQ_SB XD4_XDFFQ_CLKB 2.4201e-17
* device instance cc_XD0_XDFFQ_SB_XD4_XDFFQ_M r0 *1 0,0
Ccc_XD0_XDFFQ_SB_XD4_XDFFQ_M XD0_XDFFQ_SB XD4_XDFFQ_M 2.4201e-17
* device instance cc_XD0_XDFFQ_SB_XD4_XDFFQ_MB r0 *1 0,0
Ccc_XD0_XDFFQ_SB_XD4_XDFFQ_MB XD0_XDFFQ_SB XD4_XDFFQ_MB 1.21e-17
* device instance cc_XD0_XDFFQ_SB_XD4_XDFFQ_MFB r0 *1 0,0
Ccc_XD0_XDFFQ_SB_XD4_XDFFQ_MFB XD0_XDFFQ_SB XD4_XDFFQ_MFB 1.21e-17
* device instance cc_XD0_XDFFQ_SB_XD4_XDFFQ_S r0 *1 0,0
Ccc_XD0_XDFFQ_SB_XD4_XDFFQ_S XD0_XDFFQ_SB XD4_XDFFQ_S 1.8151e-17
* device instance cc_XD0_XDFFQ_SB_XD4_XDFFQ_SB r0 *1 0,0
Ccc_XD0_XDFFQ_SB_XD4_XDFFQ_SB XD0_XDFFQ_SB XD4_XDFFQ_SB 1.8151e-17
* device instance cc_XD0_XDFFQ_SB_XD4_XDFFQ_SFB r0 *1 0,0
Ccc_XD0_XDFFQ_SB_XD4_XDFFQ_SFB XD0_XDFFQ_SB XD4_XDFFQ_SFB 1.21e-17
* device instance cc_XD0_XDFFQ_SB_XD4_XN2_mid1 r0 *1 0,0
Ccc_XD0_XDFFQ_SB_XD4_XN2_mid1 XD0_XDFFQ_SB XD4_XN2_mid1 1.21e-17
* device instance cc_XD0_XDFFQ_SB_XD4_XN3_mid1 r0 *1 0,0
Ccc_XD0_XDFFQ_SB_XD4_XN3_mid1 XD0_XDFFQ_SB XD4_XN3_mid1 1.21e-17
* device instance cc_XD0_XDFFQ_SB_XD4_XN3_mid2 r0 *1 0,0
Ccc_XD0_XDFFQ_SB_XD4_XN3_mid2 XD0_XDFFQ_SB XD4_XN3_mid2 1.21e-17
* device instance cc_XD0_XDFFQ_SB_XD4_dmodout r0 *1 0,0
Ccc_XD0_XDFFQ_SB_XD4_dmodout XD0_XDFFQ_SB XD4_dmodout 1.21e-17
* device instance cc_XD0_XDFFQ_SB_XD4_dq r0 *1 0,0
Ccc_XD0_XDFFQ_SB_XD4_dq XD0_XDFFQ_SB XD4_dq 1.8151e-17
* device instance cc_XD0_XDFFQ_SB_XD4_nm r0 *1 0,0
Ccc_XD0_XDFFQ_SB_XD4_nm XD0_XDFFQ_SB XD4_nm 1.21e-17
* device instance cc_XD0_XDFFQ_SB_XD4_nt r0 *1 0,0
Ccc_XD0_XDFFQ_SB_XD4_nt XD0_XDFFQ_SB XD4_nt 1.21e-17
* device instance cc_XD0_XDFFQ_SB_XD4_t1 r0 *1 0,0
Ccc_XD0_XDFFQ_SB_XD4_t1 XD0_XDFFQ_SB XD4_t1 1.21e-17
* device instance cc_XD0_XDFFQ_SB_XD5_XDFFM_CKBB r0 *1 0,0
Ccc_XD0_XDFFQ_SB_XD5_XDFFM_CKBB XD0_XDFFQ_SB XD5_XDFFM_CKBB 1.8151e-17
* device instance cc_XD0_XDFFQ_SB_XD5_XDFFM_CLKB r0 *1 0,0
Ccc_XD0_XDFFQ_SB_XD5_XDFFM_CLKB XD0_XDFFQ_SB XD5_XDFFM_CLKB 2.4201e-17
* device instance cc_XD0_XDFFQ_SB_XD5_XDFFM_M r0 *1 0,0
Ccc_XD0_XDFFQ_SB_XD5_XDFFM_M XD0_XDFFQ_SB XD5_XDFFM_M 2.4201e-17
* device instance cc_XD0_XDFFQ_SB_XD5_XDFFM_MB r0 *1 0,0
Ccc_XD0_XDFFQ_SB_XD5_XDFFM_MB XD0_XDFFQ_SB XD5_XDFFM_MB 1.21e-17
* device instance cc_XD0_XDFFQ_SB_XD5_XDFFM_MFB r0 *1 0,0
Ccc_XD0_XDFFQ_SB_XD5_XDFFM_MFB XD0_XDFFQ_SB XD5_XDFFM_MFB 1.21e-17
* device instance cc_XD0_XDFFQ_SB_XD5_XDFFM_S r0 *1 0,0
Ccc_XD0_XDFFQ_SB_XD5_XDFFM_S XD0_XDFFQ_SB XD5_XDFFM_S 1.8151e-17
* device instance cc_XD0_XDFFQ_SB_XD5_XDFFM_SB r0 *1 0,0
Ccc_XD0_XDFFQ_SB_XD5_XDFFM_SB XD0_XDFFQ_SB XD5_XDFFM_SB 1.8151e-17
* device instance cc_XD0_XDFFQ_SB_XD5_XDFFM_SFB r0 *1 0,0
Ccc_XD0_XDFFQ_SB_XD5_XDFFM_SFB XD0_XDFFQ_SB XD5_XDFFM_SFB 1.21e-17
* device instance cc_XD0_XDFFQ_SB_XD5_XDFFQ_CKBB r0 *1 0,0
Ccc_XD0_XDFFQ_SB_XD5_XDFFQ_CKBB XD0_XDFFQ_SB XD5_XDFFQ_CKBB 1.8151e-17
* device instance cc_XD0_XDFFQ_SB_XD5_XDFFQ_CLKB r0 *1 0,0
Ccc_XD0_XDFFQ_SB_XD5_XDFFQ_CLKB XD0_XDFFQ_SB XD5_XDFFQ_CLKB 2.4201e-17
* device instance cc_XD0_XDFFQ_SB_XD5_XDFFQ_M r0 *1 0,0
Ccc_XD0_XDFFQ_SB_XD5_XDFFQ_M XD0_XDFFQ_SB XD5_XDFFQ_M 2.4201e-17
* device instance cc_XD0_XDFFQ_SB_XD5_XDFFQ_MB r0 *1 0,0
Ccc_XD0_XDFFQ_SB_XD5_XDFFQ_MB XD0_XDFFQ_SB XD5_XDFFQ_MB 1.21e-17
* device instance cc_XD0_XDFFQ_SB_XD5_XDFFQ_MFB r0 *1 0,0
Ccc_XD0_XDFFQ_SB_XD5_XDFFQ_MFB XD0_XDFFQ_SB XD5_XDFFQ_MFB 1.21e-17
* device instance cc_XD0_XDFFQ_SB_XD5_XDFFQ_S r0 *1 0,0
Ccc_XD0_XDFFQ_SB_XD5_XDFFQ_S XD0_XDFFQ_SB XD5_XDFFQ_S 1.8151e-17
* device instance cc_XD0_XDFFQ_SB_XD5_XDFFQ_SB r0 *1 0,0
Ccc_XD0_XDFFQ_SB_XD5_XDFFQ_SB XD0_XDFFQ_SB XD5_XDFFQ_SB 1.8151e-17
* device instance cc_XD0_XDFFQ_SB_XD5_XDFFQ_SFB r0 *1 0,0
Ccc_XD0_XDFFQ_SB_XD5_XDFFQ_SFB XD0_XDFFQ_SB XD5_XDFFQ_SFB 1.21e-17
* device instance cc_XD0_XDFFQ_SB_XD5_XN2_mid1 r0 *1 0,0
Ccc_XD0_XDFFQ_SB_XD5_XN2_mid1 XD0_XDFFQ_SB XD5_XN2_mid1 1.21e-17
* device instance cc_XD0_XDFFQ_SB_XD5_XN3_mid1 r0 *1 0,0
Ccc_XD0_XDFFQ_SB_XD5_XN3_mid1 XD0_XDFFQ_SB XD5_XN3_mid1 1.21e-17
* device instance cc_XD0_XDFFQ_SB_XD5_XN3_mid2 r0 *1 0,0
Ccc_XD0_XDFFQ_SB_XD5_XN3_mid2 XD0_XDFFQ_SB XD5_XN3_mid2 1.21e-17
* device instance cc_XD0_XDFFQ_SB_XD5_dmodout r0 *1 0,0
Ccc_XD0_XDFFQ_SB_XD5_dmodout XD0_XDFFQ_SB XD5_dmodout 1.21e-17
* device instance cc_XD0_XDFFQ_SB_XD5_dq r0 *1 0,0
Ccc_XD0_XDFFQ_SB_XD5_dq XD0_XDFFQ_SB XD5_dq 1.8151e-17
* device instance cc_XD0_XDFFQ_SB_XD5_nm r0 *1 0,0
Ccc_XD0_XDFFQ_SB_XD5_nm XD0_XDFFQ_SB XD5_nm 1.21e-17
* device instance cc_XD0_XDFFQ_SB_XD5_nt r0 *1 0,0
Ccc_XD0_XDFFQ_SB_XD5_nt XD0_XDFFQ_SB XD5_nt 1.21e-17
* device instance cc_XD0_XDFFQ_SB_XD5_t1 r0 *1 0,0
Ccc_XD0_XDFFQ_SB_XD5_t1 XD0_XDFFQ_SB XD5_t1 1.21e-17
* device instance cc_XD0_XDFFQ_SB_XFRT_CKBB r0 *1 0,0
Ccc_XD0_XDFFQ_SB_XFRT_CKBB XD0_XDFFQ_SB XFRT_CKBB 1.8151e-17
* device instance cc_XD0_XDFFQ_SB_XFRT_CLKB r0 *1 0,0
Ccc_XD0_XDFFQ_SB_XFRT_CLKB XD0_XDFFQ_SB XFRT_CLKB 2.4201e-17
* device instance cc_XD0_XDFFQ_SB_XFRT_M r0 *1 0,0
Ccc_XD0_XDFFQ_SB_XFRT_M XD0_XDFFQ_SB XFRT_M 2.4201e-17
* device instance cc_XD0_XDFFQ_SB_XFRT_MB r0 *1 0,0
Ccc_XD0_XDFFQ_SB_XFRT_MB XD0_XDFFQ_SB XFRT_MB 1.21e-17
* device instance cc_XD0_XDFFQ_SB_XFRT_MFB r0 *1 0,0
Ccc_XD0_XDFFQ_SB_XFRT_MFB XD0_XDFFQ_SB XFRT_MFB 1.21e-17
* device instance cc_XD0_XDFFQ_SB_XFRT_S r0 *1 0,0
Ccc_XD0_XDFFQ_SB_XFRT_S XD0_XDFFQ_SB XFRT_S 1.8151e-17
* device instance cc_XD0_XDFFQ_SB_XFRT_SB r0 *1 0,0
Ccc_XD0_XDFFQ_SB_XFRT_SB XD0_XDFFQ_SB XFRT_SB 1.8151e-17
* device instance cc_XD0_XDFFQ_SB_XFRT_SFB r0 *1 0,0
Ccc_XD0_XDFFQ_SB_XFRT_SFB XD0_XDFFQ_SB XFRT_SFB 1.21e-17
* device instance cc_XD0_XDFFQ_SB_ck1 r0 *1 0,0
Ccc_XD0_XDFFQ_SB_ck1 XD0_XDFFQ_SB ck1 3.0251e-17
* device instance cc_XD0_XDFFQ_SB_ck2 r0 *1 0,0
Ccc_XD0_XDFFQ_SB_ck2 XD0_XDFFQ_SB ck2 3.0251e-17
* device instance cc_XD0_XDFFQ_SB_ck3 r0 *1 0,0
Ccc_XD0_XDFFQ_SB_ck3 XD0_XDFFQ_SB ck3 3.0251e-17
* device instance cc_XD0_XDFFQ_SB_ck4 r0 *1 0,0
Ccc_XD0_XDFFQ_SB_ck4 XD0_XDFFQ_SB ck4 3.0251e-17
* device instance cc_XD0_XDFFQ_SB_ck5 r0 *1 0,0
Ccc_XD0_XDFFQ_SB_ck5 XD0_XDFFQ_SB ck5 3.0251e-17
* device instance cc_XD0_XDFFQ_SB_mod0 r0 *1 0,0
Ccc_XD0_XDFFQ_SB_mod0 XD0_XDFFQ_SB mod0 2.4201e-17
* device instance cc_XD0_XDFFQ_SB_mod1 r0 *1 0,0
Ccc_XD0_XDFFQ_SB_mod1 XD0_XDFFQ_SB mod1 2.4201e-17
* device instance cc_XD0_XDFFQ_SB_mod2 r0 *1 0,0
Ccc_XD0_XDFFQ_SB_mod2 XD0_XDFFQ_SB mod2 2.4201e-17
* device instance cc_XD0_XDFFQ_SB_mod3 r0 *1 0,0
Ccc_XD0_XDFFQ_SB_mod3 XD0_XDFFQ_SB mod3 2.4201e-17
* device instance cc_XD0_XDFFQ_SB_mod4 r0 *1 0,0
Ccc_XD0_XDFFQ_SB_mod4 XD0_XDFFQ_SB mod4 2.4201e-17
* device instance cc_XD0_XDFFQ_SB_net1 r0 *1 0,0
Ccc_XD0_XDFFQ_SB_net1 XD0_XDFFQ_SB net1 1.21e-17
* device instance cc_XD0_XDFFQ_SFB_XD0_XN2_mid1 r0 *1 0,0
Ccc_XD0_XDFFQ_SFB_XD0_XN2_mid1 XD0_XDFFQ_SFB XD0_XN2_mid1 1.21e-17
* device instance cc_XD0_XDFFQ_SFB_XD0_XNOR_midp r0 *1 0,0
Ccc_XD0_XDFFQ_SFB_XD0_XNOR_midp XD0_XDFFQ_SFB XD0_XNOR_midp 1.21e-17
* device instance cc_XD0_XDFFQ_SFB_XD0_dmodout r0 *1 0,0
Ccc_XD0_XDFFQ_SFB_XD0_dmodout XD0_XDFFQ_SFB XD0_dmodout 1.21e-17
* device instance cc_XD0_XDFFQ_SFB_XD0_dq r0 *1 0,0
Ccc_XD0_XDFFQ_SFB_XD0_dq XD0_XDFFQ_SFB XD0_dq 1.21e-17
* device instance cc_XD0_XDFFQ_SFB_XD0_nm r0 *1 0,0
Ccc_XD0_XDFFQ_SFB_XD0_nm XD0_XDFFQ_SFB XD0_nm 1.21e-17
* device instance cc_XD0_XDFFQ_SFB_XD0_nt r0 *1 0,0
Ccc_XD0_XDFFQ_SFB_XD0_nt XD0_XDFFQ_SFB XD0_nt 2.4201e-17
* device instance cc_XD0_XDFFQ_SFB_XD0_t1 r0 *1 0,0
Ccc_XD0_XDFFQ_SFB_XD0_t1 XD0_XDFFQ_SFB XD0_t1 1.21e-17
* device instance cc_XD0_XDFFQ_SFB_XD1_XDFFM_CKBB r0 *1 0,0
Ccc_XD0_XDFFQ_SFB_XD1_XDFFM_CKBB XD0_XDFFQ_SFB XD1_XDFFM_CKBB 1.8151e-17
* device instance cc_XD0_XDFFQ_SFB_XD1_XDFFM_CLKB r0 *1 0,0
Ccc_XD0_XDFFQ_SFB_XD1_XDFFM_CLKB XD0_XDFFQ_SFB XD1_XDFFM_CLKB 2.4201e-17
* device instance cc_XD0_XDFFQ_SFB_XD1_XDFFM_M r0 *1 0,0
Ccc_XD0_XDFFQ_SFB_XD1_XDFFM_M XD0_XDFFQ_SFB XD1_XDFFM_M 2.4201e-17
* device instance cc_XD0_XDFFQ_SFB_XD1_XDFFM_MB r0 *1 0,0
Ccc_XD0_XDFFQ_SFB_XD1_XDFFM_MB XD0_XDFFQ_SFB XD1_XDFFM_MB 1.21e-17
* device instance cc_XD0_XDFFQ_SFB_XD1_XDFFM_MFB r0 *1 0,0
Ccc_XD0_XDFFQ_SFB_XD1_XDFFM_MFB XD0_XDFFQ_SFB XD1_XDFFM_MFB 1.21e-17
* device instance cc_XD0_XDFFQ_SFB_XD1_XDFFM_S r0 *1 0,0
Ccc_XD0_XDFFQ_SFB_XD1_XDFFM_S XD0_XDFFQ_SFB XD1_XDFFM_S 1.8151e-17
* device instance cc_XD0_XDFFQ_SFB_XD1_XDFFM_SB r0 *1 0,0
Ccc_XD0_XDFFQ_SFB_XD1_XDFFM_SB XD0_XDFFQ_SFB XD1_XDFFM_SB 1.8151e-17
* device instance cc_XD0_XDFFQ_SFB_XD1_XDFFM_SFB r0 *1 0,0
Ccc_XD0_XDFFQ_SFB_XD1_XDFFM_SFB XD0_XDFFQ_SFB XD1_XDFFM_SFB 1.21e-17
* device instance cc_XD0_XDFFQ_SFB_XD1_XDFFQ_CKBB r0 *1 0,0
Ccc_XD0_XDFFQ_SFB_XD1_XDFFQ_CKBB XD0_XDFFQ_SFB XD1_XDFFQ_CKBB 1.8151e-17
* device instance cc_XD0_XDFFQ_SFB_XD1_XDFFQ_CLKB r0 *1 0,0
Ccc_XD0_XDFFQ_SFB_XD1_XDFFQ_CLKB XD0_XDFFQ_SFB XD1_XDFFQ_CLKB 2.4201e-17
* device instance cc_XD0_XDFFQ_SFB_XD1_XDFFQ_M r0 *1 0,0
Ccc_XD0_XDFFQ_SFB_XD1_XDFFQ_M XD0_XDFFQ_SFB XD1_XDFFQ_M 2.4201e-17
* device instance cc_XD0_XDFFQ_SFB_XD1_XDFFQ_MB r0 *1 0,0
Ccc_XD0_XDFFQ_SFB_XD1_XDFFQ_MB XD0_XDFFQ_SFB XD1_XDFFQ_MB 1.21e-17
* device instance cc_XD0_XDFFQ_SFB_XD1_XDFFQ_MFB r0 *1 0,0
Ccc_XD0_XDFFQ_SFB_XD1_XDFFQ_MFB XD0_XDFFQ_SFB XD1_XDFFQ_MFB 1.21e-17
* device instance cc_XD0_XDFFQ_SFB_XD1_XDFFQ_S r0 *1 0,0
Ccc_XD0_XDFFQ_SFB_XD1_XDFFQ_S XD0_XDFFQ_SFB XD1_XDFFQ_S 1.8151e-17
* device instance cc_XD0_XDFFQ_SFB_XD1_XDFFQ_SB r0 *1 0,0
Ccc_XD0_XDFFQ_SFB_XD1_XDFFQ_SB XD0_XDFFQ_SFB XD1_XDFFQ_SB 1.8151e-17
* device instance cc_XD0_XDFFQ_SFB_XD1_XDFFQ_SFB r0 *1 0,0
Ccc_XD0_XDFFQ_SFB_XD1_XDFFQ_SFB XD0_XDFFQ_SFB XD1_XDFFQ_SFB 1.21e-17
* device instance cc_XD0_XDFFQ_SFB_XD1_XN2_mid1 r0 *1 0,0
Ccc_XD0_XDFFQ_SFB_XD1_XN2_mid1 XD0_XDFFQ_SFB XD1_XN2_mid1 1.21e-17
* device instance cc_XD0_XDFFQ_SFB_XD1_XN3_mid1 r0 *1 0,0
Ccc_XD0_XDFFQ_SFB_XD1_XN3_mid1 XD0_XDFFQ_SFB XD1_XN3_mid1 1.21e-17
* device instance cc_XD0_XDFFQ_SFB_XD1_XN3_mid2 r0 *1 0,0
Ccc_XD0_XDFFQ_SFB_XD1_XN3_mid2 XD0_XDFFQ_SFB XD1_XN3_mid2 1.21e-17
* device instance cc_XD0_XDFFQ_SFB_XD1_dmodout r0 *1 0,0
Ccc_XD0_XDFFQ_SFB_XD1_dmodout XD0_XDFFQ_SFB XD1_dmodout 1.21e-17
* device instance cc_XD0_XDFFQ_SFB_XD1_dq r0 *1 0,0
Ccc_XD0_XDFFQ_SFB_XD1_dq XD0_XDFFQ_SFB XD1_dq 1.8151e-17
* device instance cc_XD0_XDFFQ_SFB_XD1_nm r0 *1 0,0
Ccc_XD0_XDFFQ_SFB_XD1_nm XD0_XDFFQ_SFB XD1_nm 1.21e-17
* device instance cc_XD0_XDFFQ_SFB_XD1_nt r0 *1 0,0
Ccc_XD0_XDFFQ_SFB_XD1_nt XD0_XDFFQ_SFB XD1_nt 1.21e-17
* device instance cc_XD0_XDFFQ_SFB_XD1_t1 r0 *1 0,0
Ccc_XD0_XDFFQ_SFB_XD1_t1 XD0_XDFFQ_SFB XD1_t1 1.21e-17
* device instance cc_XD0_XDFFQ_SFB_XD2_XDFFM_CKBB r0 *1 0,0
Ccc_XD0_XDFFQ_SFB_XD2_XDFFM_CKBB XD0_XDFFQ_SFB XD2_XDFFM_CKBB 1.8151e-17
* device instance cc_XD0_XDFFQ_SFB_XD2_XDFFM_CLKB r0 *1 0,0
Ccc_XD0_XDFFQ_SFB_XD2_XDFFM_CLKB XD0_XDFFQ_SFB XD2_XDFFM_CLKB 2.4201e-17
* device instance cc_XD0_XDFFQ_SFB_XD2_XDFFM_M r0 *1 0,0
Ccc_XD0_XDFFQ_SFB_XD2_XDFFM_M XD0_XDFFQ_SFB XD2_XDFFM_M 2.4201e-17
* device instance cc_XD0_XDFFQ_SFB_XD2_XDFFM_MB r0 *1 0,0
Ccc_XD0_XDFFQ_SFB_XD2_XDFFM_MB XD0_XDFFQ_SFB XD2_XDFFM_MB 1.21e-17
* device instance cc_XD0_XDFFQ_SFB_XD2_XDFFM_MFB r0 *1 0,0
Ccc_XD0_XDFFQ_SFB_XD2_XDFFM_MFB XD0_XDFFQ_SFB XD2_XDFFM_MFB 1.21e-17
* device instance cc_XD0_XDFFQ_SFB_XD2_XDFFM_S r0 *1 0,0
Ccc_XD0_XDFFQ_SFB_XD2_XDFFM_S XD0_XDFFQ_SFB XD2_XDFFM_S 1.8151e-17
* device instance cc_XD0_XDFFQ_SFB_XD2_XDFFM_SB r0 *1 0,0
Ccc_XD0_XDFFQ_SFB_XD2_XDFFM_SB XD0_XDFFQ_SFB XD2_XDFFM_SB 1.8151e-17
* device instance cc_XD0_XDFFQ_SFB_XD2_XDFFM_SFB r0 *1 0,0
Ccc_XD0_XDFFQ_SFB_XD2_XDFFM_SFB XD0_XDFFQ_SFB XD2_XDFFM_SFB 1.21e-17
* device instance cc_XD0_XDFFQ_SFB_XD2_XDFFQ_CKBB r0 *1 0,0
Ccc_XD0_XDFFQ_SFB_XD2_XDFFQ_CKBB XD0_XDFFQ_SFB XD2_XDFFQ_CKBB 1.8151e-17
* device instance cc_XD0_XDFFQ_SFB_XD2_XDFFQ_CLKB r0 *1 0,0
Ccc_XD0_XDFFQ_SFB_XD2_XDFFQ_CLKB XD0_XDFFQ_SFB XD2_XDFFQ_CLKB 2.4201e-17
* device instance cc_XD0_XDFFQ_SFB_XD2_XDFFQ_M r0 *1 0,0
Ccc_XD0_XDFFQ_SFB_XD2_XDFFQ_M XD0_XDFFQ_SFB XD2_XDFFQ_M 2.4201e-17
* device instance cc_XD0_XDFFQ_SFB_XD2_XDFFQ_MB r0 *1 0,0
Ccc_XD0_XDFFQ_SFB_XD2_XDFFQ_MB XD0_XDFFQ_SFB XD2_XDFFQ_MB 1.21e-17
* device instance cc_XD0_XDFFQ_SFB_XD2_XDFFQ_MFB r0 *1 0,0
Ccc_XD0_XDFFQ_SFB_XD2_XDFFQ_MFB XD0_XDFFQ_SFB XD2_XDFFQ_MFB 1.21e-17
* device instance cc_XD0_XDFFQ_SFB_XD2_XDFFQ_S r0 *1 0,0
Ccc_XD0_XDFFQ_SFB_XD2_XDFFQ_S XD0_XDFFQ_SFB XD2_XDFFQ_S 1.8151e-17
* device instance cc_XD0_XDFFQ_SFB_XD2_XDFFQ_SB r0 *1 0,0
Ccc_XD0_XDFFQ_SFB_XD2_XDFFQ_SB XD0_XDFFQ_SFB XD2_XDFFQ_SB 1.8151e-17
* device instance cc_XD0_XDFFQ_SFB_XD2_XDFFQ_SFB r0 *1 0,0
Ccc_XD0_XDFFQ_SFB_XD2_XDFFQ_SFB XD0_XDFFQ_SFB XD2_XDFFQ_SFB 1.21e-17
* device instance cc_XD0_XDFFQ_SFB_XD2_XN2_mid1 r0 *1 0,0
Ccc_XD0_XDFFQ_SFB_XD2_XN2_mid1 XD0_XDFFQ_SFB XD2_XN2_mid1 1.21e-17
* device instance cc_XD0_XDFFQ_SFB_XD2_XN3_mid1 r0 *1 0,0
Ccc_XD0_XDFFQ_SFB_XD2_XN3_mid1 XD0_XDFFQ_SFB XD2_XN3_mid1 1.21e-17
* device instance cc_XD0_XDFFQ_SFB_XD2_XN3_mid2 r0 *1 0,0
Ccc_XD0_XDFFQ_SFB_XD2_XN3_mid2 XD0_XDFFQ_SFB XD2_XN3_mid2 1.21e-17
* device instance cc_XD0_XDFFQ_SFB_XD2_dmodout r0 *1 0,0
Ccc_XD0_XDFFQ_SFB_XD2_dmodout XD0_XDFFQ_SFB XD2_dmodout 1.21e-17
* device instance cc_XD0_XDFFQ_SFB_XD2_dq r0 *1 0,0
Ccc_XD0_XDFFQ_SFB_XD2_dq XD0_XDFFQ_SFB XD2_dq 1.8151e-17
* device instance cc_XD0_XDFFQ_SFB_XD2_nm r0 *1 0,0
Ccc_XD0_XDFFQ_SFB_XD2_nm XD0_XDFFQ_SFB XD2_nm 1.21e-17
* device instance cc_XD0_XDFFQ_SFB_XD2_nt r0 *1 0,0
Ccc_XD0_XDFFQ_SFB_XD2_nt XD0_XDFFQ_SFB XD2_nt 1.21e-17
* device instance cc_XD0_XDFFQ_SFB_XD2_t1 r0 *1 0,0
Ccc_XD0_XDFFQ_SFB_XD2_t1 XD0_XDFFQ_SFB XD2_t1 1.21e-17
* device instance cc_XD0_XDFFQ_SFB_XD3_XDFFM_CKBB r0 *1 0,0
Ccc_XD0_XDFFQ_SFB_XD3_XDFFM_CKBB XD0_XDFFQ_SFB XD3_XDFFM_CKBB 1.8151e-17
* device instance cc_XD0_XDFFQ_SFB_XD3_XDFFM_CLKB r0 *1 0,0
Ccc_XD0_XDFFQ_SFB_XD3_XDFFM_CLKB XD0_XDFFQ_SFB XD3_XDFFM_CLKB 2.4201e-17
* device instance cc_XD0_XDFFQ_SFB_XD3_XDFFM_M r0 *1 0,0
Ccc_XD0_XDFFQ_SFB_XD3_XDFFM_M XD0_XDFFQ_SFB XD3_XDFFM_M 2.4201e-17
* device instance cc_XD0_XDFFQ_SFB_XD3_XDFFM_MB r0 *1 0,0
Ccc_XD0_XDFFQ_SFB_XD3_XDFFM_MB XD0_XDFFQ_SFB XD3_XDFFM_MB 1.21e-17
* device instance cc_XD0_XDFFQ_SFB_XD3_XDFFM_MFB r0 *1 0,0
Ccc_XD0_XDFFQ_SFB_XD3_XDFFM_MFB XD0_XDFFQ_SFB XD3_XDFFM_MFB 1.21e-17
* device instance cc_XD0_XDFFQ_SFB_XD3_XDFFM_S r0 *1 0,0
Ccc_XD0_XDFFQ_SFB_XD3_XDFFM_S XD0_XDFFQ_SFB XD3_XDFFM_S 1.8151e-17
* device instance cc_XD0_XDFFQ_SFB_XD3_XDFFM_SB r0 *1 0,0
Ccc_XD0_XDFFQ_SFB_XD3_XDFFM_SB XD0_XDFFQ_SFB XD3_XDFFM_SB 1.8151e-17
* device instance cc_XD0_XDFFQ_SFB_XD3_XDFFM_SFB r0 *1 0,0
Ccc_XD0_XDFFQ_SFB_XD3_XDFFM_SFB XD0_XDFFQ_SFB XD3_XDFFM_SFB 1.21e-17
* device instance cc_XD0_XDFFQ_SFB_XD3_XDFFQ_CKBB r0 *1 0,0
Ccc_XD0_XDFFQ_SFB_XD3_XDFFQ_CKBB XD0_XDFFQ_SFB XD3_XDFFQ_CKBB 1.8151e-17
* device instance cc_XD0_XDFFQ_SFB_XD3_XDFFQ_CLKB r0 *1 0,0
Ccc_XD0_XDFFQ_SFB_XD3_XDFFQ_CLKB XD0_XDFFQ_SFB XD3_XDFFQ_CLKB 2.4201e-17
* device instance cc_XD0_XDFFQ_SFB_XD3_XDFFQ_M r0 *1 0,0
Ccc_XD0_XDFFQ_SFB_XD3_XDFFQ_M XD0_XDFFQ_SFB XD3_XDFFQ_M 2.4201e-17
* device instance cc_XD0_XDFFQ_SFB_XD3_XDFFQ_MB r0 *1 0,0
Ccc_XD0_XDFFQ_SFB_XD3_XDFFQ_MB XD0_XDFFQ_SFB XD3_XDFFQ_MB 1.21e-17
* device instance cc_XD0_XDFFQ_SFB_XD3_XDFFQ_MFB r0 *1 0,0
Ccc_XD0_XDFFQ_SFB_XD3_XDFFQ_MFB XD0_XDFFQ_SFB XD3_XDFFQ_MFB 1.21e-17
* device instance cc_XD0_XDFFQ_SFB_XD3_XDFFQ_S r0 *1 0,0
Ccc_XD0_XDFFQ_SFB_XD3_XDFFQ_S XD0_XDFFQ_SFB XD3_XDFFQ_S 1.8151e-17
* device instance cc_XD0_XDFFQ_SFB_XD3_XDFFQ_SB r0 *1 0,0
Ccc_XD0_XDFFQ_SFB_XD3_XDFFQ_SB XD0_XDFFQ_SFB XD3_XDFFQ_SB 1.8151e-17
* device instance cc_XD0_XDFFQ_SFB_XD3_XDFFQ_SFB r0 *1 0,0
Ccc_XD0_XDFFQ_SFB_XD3_XDFFQ_SFB XD0_XDFFQ_SFB XD3_XDFFQ_SFB 1.21e-17
* device instance cc_XD0_XDFFQ_SFB_XD3_XN2_mid1 r0 *1 0,0
Ccc_XD0_XDFFQ_SFB_XD3_XN2_mid1 XD0_XDFFQ_SFB XD3_XN2_mid1 1.21e-17
* device instance cc_XD0_XDFFQ_SFB_XD3_XN3_mid1 r0 *1 0,0
Ccc_XD0_XDFFQ_SFB_XD3_XN3_mid1 XD0_XDFFQ_SFB XD3_XN3_mid1 1.21e-17
* device instance cc_XD0_XDFFQ_SFB_XD3_XN3_mid2 r0 *1 0,0
Ccc_XD0_XDFFQ_SFB_XD3_XN3_mid2 XD0_XDFFQ_SFB XD3_XN3_mid2 1.21e-17
* device instance cc_XD0_XDFFQ_SFB_XD3_dmodout r0 *1 0,0
Ccc_XD0_XDFFQ_SFB_XD3_dmodout XD0_XDFFQ_SFB XD3_dmodout 1.21e-17
* device instance cc_XD0_XDFFQ_SFB_XD3_dq r0 *1 0,0
Ccc_XD0_XDFFQ_SFB_XD3_dq XD0_XDFFQ_SFB XD3_dq 1.8151e-17
* device instance cc_XD0_XDFFQ_SFB_XD3_nm r0 *1 0,0
Ccc_XD0_XDFFQ_SFB_XD3_nm XD0_XDFFQ_SFB XD3_nm 1.21e-17
* device instance cc_XD0_XDFFQ_SFB_XD3_nt r0 *1 0,0
Ccc_XD0_XDFFQ_SFB_XD3_nt XD0_XDFFQ_SFB XD3_nt 1.21e-17
* device instance cc_XD0_XDFFQ_SFB_XD3_t1 r0 *1 0,0
Ccc_XD0_XDFFQ_SFB_XD3_t1 XD0_XDFFQ_SFB XD3_t1 1.21e-17
* device instance cc_XD0_XDFFQ_SFB_XD4_XDFFM_CKBB r0 *1 0,0
Ccc_XD0_XDFFQ_SFB_XD4_XDFFM_CKBB XD0_XDFFQ_SFB XD4_XDFFM_CKBB 1.8151e-17
* device instance cc_XD0_XDFFQ_SFB_XD4_XDFFM_CLKB r0 *1 0,0
Ccc_XD0_XDFFQ_SFB_XD4_XDFFM_CLKB XD0_XDFFQ_SFB XD4_XDFFM_CLKB 2.4201e-17
* device instance cc_XD0_XDFFQ_SFB_XD4_XDFFM_M r0 *1 0,0
Ccc_XD0_XDFFQ_SFB_XD4_XDFFM_M XD0_XDFFQ_SFB XD4_XDFFM_M 2.4201e-17
* device instance cc_XD0_XDFFQ_SFB_XD4_XDFFM_MB r0 *1 0,0
Ccc_XD0_XDFFQ_SFB_XD4_XDFFM_MB XD0_XDFFQ_SFB XD4_XDFFM_MB 1.21e-17
* device instance cc_XD0_XDFFQ_SFB_XD4_XDFFM_MFB r0 *1 0,0
Ccc_XD0_XDFFQ_SFB_XD4_XDFFM_MFB XD0_XDFFQ_SFB XD4_XDFFM_MFB 1.21e-17
* device instance cc_XD0_XDFFQ_SFB_XD4_XDFFM_S r0 *1 0,0
Ccc_XD0_XDFFQ_SFB_XD4_XDFFM_S XD0_XDFFQ_SFB XD4_XDFFM_S 1.8151e-17
* device instance cc_XD0_XDFFQ_SFB_XD4_XDFFM_SB r0 *1 0,0
Ccc_XD0_XDFFQ_SFB_XD4_XDFFM_SB XD0_XDFFQ_SFB XD4_XDFFM_SB 1.8151e-17
* device instance cc_XD0_XDFFQ_SFB_XD4_XDFFM_SFB r0 *1 0,0
Ccc_XD0_XDFFQ_SFB_XD4_XDFFM_SFB XD0_XDFFQ_SFB XD4_XDFFM_SFB 1.21e-17
* device instance cc_XD0_XDFFQ_SFB_XD4_XDFFQ_CKBB r0 *1 0,0
Ccc_XD0_XDFFQ_SFB_XD4_XDFFQ_CKBB XD0_XDFFQ_SFB XD4_XDFFQ_CKBB 1.8151e-17
* device instance cc_XD0_XDFFQ_SFB_XD4_XDFFQ_CLKB r0 *1 0,0
Ccc_XD0_XDFFQ_SFB_XD4_XDFFQ_CLKB XD0_XDFFQ_SFB XD4_XDFFQ_CLKB 2.4201e-17
* device instance cc_XD0_XDFFQ_SFB_XD4_XDFFQ_M r0 *1 0,0
Ccc_XD0_XDFFQ_SFB_XD4_XDFFQ_M XD0_XDFFQ_SFB XD4_XDFFQ_M 2.4201e-17
* device instance cc_XD0_XDFFQ_SFB_XD4_XDFFQ_MB r0 *1 0,0
Ccc_XD0_XDFFQ_SFB_XD4_XDFFQ_MB XD0_XDFFQ_SFB XD4_XDFFQ_MB 1.21e-17
* device instance cc_XD0_XDFFQ_SFB_XD4_XDFFQ_MFB r0 *1 0,0
Ccc_XD0_XDFFQ_SFB_XD4_XDFFQ_MFB XD0_XDFFQ_SFB XD4_XDFFQ_MFB 1.21e-17
* device instance cc_XD0_XDFFQ_SFB_XD4_XDFFQ_S r0 *1 0,0
Ccc_XD0_XDFFQ_SFB_XD4_XDFFQ_S XD0_XDFFQ_SFB XD4_XDFFQ_S 1.8151e-17
* device instance cc_XD0_XDFFQ_SFB_XD4_XDFFQ_SB r0 *1 0,0
Ccc_XD0_XDFFQ_SFB_XD4_XDFFQ_SB XD0_XDFFQ_SFB XD4_XDFFQ_SB 1.8151e-17
* device instance cc_XD0_XDFFQ_SFB_XD4_XDFFQ_SFB r0 *1 0,0
Ccc_XD0_XDFFQ_SFB_XD4_XDFFQ_SFB XD0_XDFFQ_SFB XD4_XDFFQ_SFB 1.21e-17
* device instance cc_XD0_XDFFQ_SFB_XD4_XN2_mid1 r0 *1 0,0
Ccc_XD0_XDFFQ_SFB_XD4_XN2_mid1 XD0_XDFFQ_SFB XD4_XN2_mid1 1.21e-17
* device instance cc_XD0_XDFFQ_SFB_XD4_XN3_mid1 r0 *1 0,0
Ccc_XD0_XDFFQ_SFB_XD4_XN3_mid1 XD0_XDFFQ_SFB XD4_XN3_mid1 1.21e-17
* device instance cc_XD0_XDFFQ_SFB_XD4_XN3_mid2 r0 *1 0,0
Ccc_XD0_XDFFQ_SFB_XD4_XN3_mid2 XD0_XDFFQ_SFB XD4_XN3_mid2 1.21e-17
* device instance cc_XD0_XDFFQ_SFB_XD4_dmodout r0 *1 0,0
Ccc_XD0_XDFFQ_SFB_XD4_dmodout XD0_XDFFQ_SFB XD4_dmodout 1.21e-17
* device instance cc_XD0_XDFFQ_SFB_XD4_dq r0 *1 0,0
Ccc_XD0_XDFFQ_SFB_XD4_dq XD0_XDFFQ_SFB XD4_dq 1.8151e-17
* device instance cc_XD0_XDFFQ_SFB_XD4_nm r0 *1 0,0
Ccc_XD0_XDFFQ_SFB_XD4_nm XD0_XDFFQ_SFB XD4_nm 1.21e-17
* device instance cc_XD0_XDFFQ_SFB_XD4_nt r0 *1 0,0
Ccc_XD0_XDFFQ_SFB_XD4_nt XD0_XDFFQ_SFB XD4_nt 1.21e-17
* device instance cc_XD0_XDFFQ_SFB_XD4_t1 r0 *1 0,0
Ccc_XD0_XDFFQ_SFB_XD4_t1 XD0_XDFFQ_SFB XD4_t1 1.21e-17
* device instance cc_XD0_XDFFQ_SFB_XD5_XDFFM_CKBB r0 *1 0,0
Ccc_XD0_XDFFQ_SFB_XD5_XDFFM_CKBB XD0_XDFFQ_SFB XD5_XDFFM_CKBB 1.8151e-17
* device instance cc_XD0_XDFFQ_SFB_XD5_XDFFM_CLKB r0 *1 0,0
Ccc_XD0_XDFFQ_SFB_XD5_XDFFM_CLKB XD0_XDFFQ_SFB XD5_XDFFM_CLKB 2.4201e-17
* device instance cc_XD0_XDFFQ_SFB_XD5_XDFFM_M r0 *1 0,0
Ccc_XD0_XDFFQ_SFB_XD5_XDFFM_M XD0_XDFFQ_SFB XD5_XDFFM_M 2.4201e-17
* device instance cc_XD0_XDFFQ_SFB_XD5_XDFFM_MB r0 *1 0,0
Ccc_XD0_XDFFQ_SFB_XD5_XDFFM_MB XD0_XDFFQ_SFB XD5_XDFFM_MB 1.21e-17
* device instance cc_XD0_XDFFQ_SFB_XD5_XDFFM_MFB r0 *1 0,0
Ccc_XD0_XDFFQ_SFB_XD5_XDFFM_MFB XD0_XDFFQ_SFB XD5_XDFFM_MFB 1.21e-17
* device instance cc_XD0_XDFFQ_SFB_XD5_XDFFM_S r0 *1 0,0
Ccc_XD0_XDFFQ_SFB_XD5_XDFFM_S XD0_XDFFQ_SFB XD5_XDFFM_S 1.8151e-17
* device instance cc_XD0_XDFFQ_SFB_XD5_XDFFM_SB r0 *1 0,0
Ccc_XD0_XDFFQ_SFB_XD5_XDFFM_SB XD0_XDFFQ_SFB XD5_XDFFM_SB 1.8151e-17
* device instance cc_XD0_XDFFQ_SFB_XD5_XDFFM_SFB r0 *1 0,0
Ccc_XD0_XDFFQ_SFB_XD5_XDFFM_SFB XD0_XDFFQ_SFB XD5_XDFFM_SFB 1.21e-17
* device instance cc_XD0_XDFFQ_SFB_XD5_XDFFQ_CKBB r0 *1 0,0
Ccc_XD0_XDFFQ_SFB_XD5_XDFFQ_CKBB XD0_XDFFQ_SFB XD5_XDFFQ_CKBB 1.8151e-17
* device instance cc_XD0_XDFFQ_SFB_XD5_XDFFQ_CLKB r0 *1 0,0
Ccc_XD0_XDFFQ_SFB_XD5_XDFFQ_CLKB XD0_XDFFQ_SFB XD5_XDFFQ_CLKB 2.4201e-17
* device instance cc_XD0_XDFFQ_SFB_XD5_XDFFQ_M r0 *1 0,0
Ccc_XD0_XDFFQ_SFB_XD5_XDFFQ_M XD0_XDFFQ_SFB XD5_XDFFQ_M 2.4201e-17
* device instance cc_XD0_XDFFQ_SFB_XD5_XDFFQ_MB r0 *1 0,0
Ccc_XD0_XDFFQ_SFB_XD5_XDFFQ_MB XD0_XDFFQ_SFB XD5_XDFFQ_MB 1.21e-17
* device instance cc_XD0_XDFFQ_SFB_XD5_XDFFQ_MFB r0 *1 0,0
Ccc_XD0_XDFFQ_SFB_XD5_XDFFQ_MFB XD0_XDFFQ_SFB XD5_XDFFQ_MFB 1.21e-17
* device instance cc_XD0_XDFFQ_SFB_XD5_XDFFQ_S r0 *1 0,0
Ccc_XD0_XDFFQ_SFB_XD5_XDFFQ_S XD0_XDFFQ_SFB XD5_XDFFQ_S 1.8151e-17
* device instance cc_XD0_XDFFQ_SFB_XD5_XDFFQ_SB r0 *1 0,0
Ccc_XD0_XDFFQ_SFB_XD5_XDFFQ_SB XD0_XDFFQ_SFB XD5_XDFFQ_SB 1.8151e-17
* device instance cc_XD0_XDFFQ_SFB_XD5_XDFFQ_SFB r0 *1 0,0
Ccc_XD0_XDFFQ_SFB_XD5_XDFFQ_SFB XD0_XDFFQ_SFB XD5_XDFFQ_SFB 1.21e-17
* device instance cc_XD0_XDFFQ_SFB_XD5_XN2_mid1 r0 *1 0,0
Ccc_XD0_XDFFQ_SFB_XD5_XN2_mid1 XD0_XDFFQ_SFB XD5_XN2_mid1 1.21e-17
* device instance cc_XD0_XDFFQ_SFB_XD5_XN3_mid1 r0 *1 0,0
Ccc_XD0_XDFFQ_SFB_XD5_XN3_mid1 XD0_XDFFQ_SFB XD5_XN3_mid1 1.21e-17
* device instance cc_XD0_XDFFQ_SFB_XD5_XN3_mid2 r0 *1 0,0
Ccc_XD0_XDFFQ_SFB_XD5_XN3_mid2 XD0_XDFFQ_SFB XD5_XN3_mid2 1.21e-17
* device instance cc_XD0_XDFFQ_SFB_XD5_dmodout r0 *1 0,0
Ccc_XD0_XDFFQ_SFB_XD5_dmodout XD0_XDFFQ_SFB XD5_dmodout 1.21e-17
* device instance cc_XD0_XDFFQ_SFB_XD5_dq r0 *1 0,0
Ccc_XD0_XDFFQ_SFB_XD5_dq XD0_XDFFQ_SFB XD5_dq 1.8151e-17
* device instance cc_XD0_XDFFQ_SFB_XD5_nm r0 *1 0,0
Ccc_XD0_XDFFQ_SFB_XD5_nm XD0_XDFFQ_SFB XD5_nm 1.21e-17
* device instance cc_XD0_XDFFQ_SFB_XD5_nt r0 *1 0,0
Ccc_XD0_XDFFQ_SFB_XD5_nt XD0_XDFFQ_SFB XD5_nt 1.21e-17
* device instance cc_XD0_XDFFQ_SFB_XD5_t1 r0 *1 0,0
Ccc_XD0_XDFFQ_SFB_XD5_t1 XD0_XDFFQ_SFB XD5_t1 1.21e-17
* device instance cc_XD0_XDFFQ_SFB_XFRT_CKBB r0 *1 0,0
Ccc_XD0_XDFFQ_SFB_XFRT_CKBB XD0_XDFFQ_SFB XFRT_CKBB 1.8151e-17
* device instance cc_XD0_XDFFQ_SFB_XFRT_CLKB r0 *1 0,0
Ccc_XD0_XDFFQ_SFB_XFRT_CLKB XD0_XDFFQ_SFB XFRT_CLKB 2.4201e-17
* device instance cc_XD0_XDFFQ_SFB_XFRT_M r0 *1 0,0
Ccc_XD0_XDFFQ_SFB_XFRT_M XD0_XDFFQ_SFB XFRT_M 2.4201e-17
* device instance cc_XD0_XDFFQ_SFB_XFRT_MB r0 *1 0,0
Ccc_XD0_XDFFQ_SFB_XFRT_MB XD0_XDFFQ_SFB XFRT_MB 1.21e-17
* device instance cc_XD0_XDFFQ_SFB_XFRT_MFB r0 *1 0,0
Ccc_XD0_XDFFQ_SFB_XFRT_MFB XD0_XDFFQ_SFB XFRT_MFB 1.21e-17
* device instance cc_XD0_XDFFQ_SFB_XFRT_S r0 *1 0,0
Ccc_XD0_XDFFQ_SFB_XFRT_S XD0_XDFFQ_SFB XFRT_S 1.8151e-17
* device instance cc_XD0_XDFFQ_SFB_XFRT_SB r0 *1 0,0
Ccc_XD0_XDFFQ_SFB_XFRT_SB XD0_XDFFQ_SFB XFRT_SB 1.8151e-17
* device instance cc_XD0_XDFFQ_SFB_XFRT_SFB r0 *1 0,0
Ccc_XD0_XDFFQ_SFB_XFRT_SFB XD0_XDFFQ_SFB XFRT_SFB 1.21e-17
* device instance cc_XD0_XDFFQ_SFB_ck1 r0 *1 0,0
Ccc_XD0_XDFFQ_SFB_ck1 XD0_XDFFQ_SFB ck1 3.0251e-17
* device instance cc_XD0_XDFFQ_SFB_ck2 r0 *1 0,0
Ccc_XD0_XDFFQ_SFB_ck2 XD0_XDFFQ_SFB ck2 3.0251e-17
* device instance cc_XD0_XDFFQ_SFB_ck3 r0 *1 0,0
Ccc_XD0_XDFFQ_SFB_ck3 XD0_XDFFQ_SFB ck3 3.0251e-17
* device instance cc_XD0_XDFFQ_SFB_ck4 r0 *1 0,0
Ccc_XD0_XDFFQ_SFB_ck4 XD0_XDFFQ_SFB ck4 3.0251e-17
* device instance cc_XD0_XDFFQ_SFB_ck5 r0 *1 0,0
Ccc_XD0_XDFFQ_SFB_ck5 XD0_XDFFQ_SFB ck5 3.0251e-17
* device instance cc_XD0_XDFFQ_SFB_mod0 r0 *1 0,0
Ccc_XD0_XDFFQ_SFB_mod0 XD0_XDFFQ_SFB mod0 2.4201e-17
* device instance cc_XD0_XDFFQ_SFB_mod1 r0 *1 0,0
Ccc_XD0_XDFFQ_SFB_mod1 XD0_XDFFQ_SFB mod1 2.4201e-17
* device instance cc_XD0_XDFFQ_SFB_mod2 r0 *1 0,0
Ccc_XD0_XDFFQ_SFB_mod2 XD0_XDFFQ_SFB mod2 2.4201e-17
* device instance cc_XD0_XDFFQ_SFB_mod3 r0 *1 0,0
Ccc_XD0_XDFFQ_SFB_mod3 XD0_XDFFQ_SFB mod3 2.4201e-17
* device instance cc_XD0_XDFFQ_SFB_mod4 r0 *1 0,0
Ccc_XD0_XDFFQ_SFB_mod4 XD0_XDFFQ_SFB mod4 2.4201e-17
* device instance cc_XD0_XDFFQ_SFB_net1 r0 *1 0,0
Ccc_XD0_XDFFQ_SFB_net1 XD0_XDFFQ_SFB net1 1.21e-17
* device instance cc_XD0_XN2_mid1_XD0_nm r0 *1 0,0
Ccc_XD0_XN2_mid1_XD0_nm XD0_XN2_mid1 XD0_nm 1.1294e-17
* device instance cc_XD0_XN2_mid1_ck1 r0 *1 0,0
Ccc_XD0_XN2_mid1_ck1 XD0_XN2_mid1 ck1 6.05e-18
* device instance cc_XD0_XN3_mid1_XD0_XN3_mid2 r0 *1 0,0
Ccc_XD0_XN3_mid1_XD0_XN3_mid2 XD0_XN3_mid1 XD0_XN3_mid2 1.1294e-17
* device instance cc_XD0_XN3_mid1_XD0_nt r0 *1 0,0
Ccc_XD0_XN3_mid1_XD0_nt XD0_XN3_mid1 XD0_nt 1.1294e-17
* device instance cc_XD0_XN3_mid2_net1 r0 *1 0,0
Ccc_XD0_XN3_mid2_net1 XD0_XN3_mid2 net1 6.05e-18
* device instance cc_XD0_XNOR_midp_XD0_dq r0 *1 0,0
Ccc_XD0_XNOR_midp_XD0_dq XD0_XNOR_midp XD0_dq 5.244e-18
* device instance cc_XD0_XNOR_midp_XD0_t1 r0 *1 0,0
Ccc_XD0_XNOR_midp_XD0_t1 XD0_XNOR_midp XD0_t1 6.05e-18
* device instance cc_XD0_dmodout_XD0_dq r0 *1 0,0
Ccc_XD0_dmodout_XD0_dq XD0_dmodout XD0_dq 1.21e-17
* device instance cc_XD0_dmodout_XD0_nm r0 *1 0,0
Ccc_XD0_dmodout_XD0_nm XD0_dmodout XD0_nm 1.8151e-17
* device instance cc_XD0_dmodout_XD0_nt r0 *1 0,0
Ccc_XD0_dmodout_XD0_nt XD0_dmodout XD0_nt 2.4201e-17
* device instance cc_XD0_dmodout_XD0_t1 r0 *1 0,0
Ccc_XD0_dmodout_XD0_t1 XD0_dmodout XD0_t1 1.21e-17
* device instance cc_XD0_dmodout_XD1_XDFFM_CKBB r0 *1 0,0
Ccc_XD0_dmodout_XD1_XDFFM_CKBB XD0_dmodout XD1_XDFFM_CKBB 1.8151e-17
* device instance cc_XD0_dmodout_XD1_XDFFM_CLKB r0 *1 0,0
Ccc_XD0_dmodout_XD1_XDFFM_CLKB XD0_dmodout XD1_XDFFM_CLKB 2.4201e-17
* device instance cc_XD0_dmodout_XD1_XDFFM_M r0 *1 0,0
Ccc_XD0_dmodout_XD1_XDFFM_M XD0_dmodout XD1_XDFFM_M 2.4201e-17
* device instance cc_XD0_dmodout_XD1_XDFFM_MB r0 *1 0,0
Ccc_XD0_dmodout_XD1_XDFFM_MB XD0_dmodout XD1_XDFFM_MB 1.21e-17
* device instance cc_XD0_dmodout_XD1_XDFFM_MFB r0 *1 0,0
Ccc_XD0_dmodout_XD1_XDFFM_MFB XD0_dmodout XD1_XDFFM_MFB 1.21e-17
* device instance cc_XD0_dmodout_XD1_XDFFM_S r0 *1 0,0
Ccc_XD0_dmodout_XD1_XDFFM_S XD0_dmodout XD1_XDFFM_S 1.8151e-17
* device instance cc_XD0_dmodout_XD1_XDFFM_SB r0 *1 0,0
Ccc_XD0_dmodout_XD1_XDFFM_SB XD0_dmodout XD1_XDFFM_SB 1.8151e-17
* device instance cc_XD0_dmodout_XD1_XDFFM_SFB r0 *1 0,0
Ccc_XD0_dmodout_XD1_XDFFM_SFB XD0_dmodout XD1_XDFFM_SFB 1.21e-17
* device instance cc_XD0_dmodout_XD1_XDFFQ_CKBB r0 *1 0,0
Ccc_XD0_dmodout_XD1_XDFFQ_CKBB XD0_dmodout XD1_XDFFQ_CKBB 1.8151e-17
* device instance cc_XD0_dmodout_XD1_XDFFQ_CLKB r0 *1 0,0
Ccc_XD0_dmodout_XD1_XDFFQ_CLKB XD0_dmodout XD1_XDFFQ_CLKB 2.4201e-17
* device instance cc_XD0_dmodout_XD1_XDFFQ_M r0 *1 0,0
Ccc_XD0_dmodout_XD1_XDFFQ_M XD0_dmodout XD1_XDFFQ_M 2.4201e-17
* device instance cc_XD0_dmodout_XD1_XDFFQ_MB r0 *1 0,0
Ccc_XD0_dmodout_XD1_XDFFQ_MB XD0_dmodout XD1_XDFFQ_MB 1.21e-17
* device instance cc_XD0_dmodout_XD1_XDFFQ_MFB r0 *1 0,0
Ccc_XD0_dmodout_XD1_XDFFQ_MFB XD0_dmodout XD1_XDFFQ_MFB 1.21e-17
* device instance cc_XD0_dmodout_XD1_XDFFQ_S r0 *1 0,0
Ccc_XD0_dmodout_XD1_XDFFQ_S XD0_dmodout XD1_XDFFQ_S 1.8151e-17
* device instance cc_XD0_dmodout_XD1_XDFFQ_SB r0 *1 0,0
Ccc_XD0_dmodout_XD1_XDFFQ_SB XD0_dmodout XD1_XDFFQ_SB 1.8151e-17
* device instance cc_XD0_dmodout_XD1_XDFFQ_SFB r0 *1 0,0
Ccc_XD0_dmodout_XD1_XDFFQ_SFB XD0_dmodout XD1_XDFFQ_SFB 1.21e-17
* device instance cc_XD0_dmodout_XD1_XN2_mid1 r0 *1 0,0
Ccc_XD0_dmodout_XD1_XN2_mid1 XD0_dmodout XD1_XN2_mid1 1.21e-17
* device instance cc_XD0_dmodout_XD1_XN3_mid1 r0 *1 0,0
Ccc_XD0_dmodout_XD1_XN3_mid1 XD0_dmodout XD1_XN3_mid1 1.21e-17
* device instance cc_XD0_dmodout_XD1_XN3_mid2 r0 *1 0,0
Ccc_XD0_dmodout_XD1_XN3_mid2 XD0_dmodout XD1_XN3_mid2 1.21e-17
* device instance cc_XD0_dmodout_XD1_dmodout r0 *1 0,0
Ccc_XD0_dmodout_XD1_dmodout XD0_dmodout XD1_dmodout 1.21e-17
* device instance cc_XD0_dmodout_XD1_dq r0 *1 0,0
Ccc_XD0_dmodout_XD1_dq XD0_dmodout XD1_dq 1.8151e-17
* device instance cc_XD0_dmodout_XD1_nm r0 *1 0,0
Ccc_XD0_dmodout_XD1_nm XD0_dmodout XD1_nm 1.21e-17
* device instance cc_XD0_dmodout_XD1_nt r0 *1 0,0
Ccc_XD0_dmodout_XD1_nt XD0_dmodout XD1_nt 1.21e-17
* device instance cc_XD0_dmodout_XD1_t1 r0 *1 0,0
Ccc_XD0_dmodout_XD1_t1 XD0_dmodout XD1_t1 1.21e-17
* device instance cc_XD0_dmodout_XD2_XDFFM_CKBB r0 *1 0,0
Ccc_XD0_dmodout_XD2_XDFFM_CKBB XD0_dmodout XD2_XDFFM_CKBB 1.8151e-17
* device instance cc_XD0_dmodout_XD2_XDFFM_CLKB r0 *1 0,0
Ccc_XD0_dmodout_XD2_XDFFM_CLKB XD0_dmodout XD2_XDFFM_CLKB 2.4201e-17
* device instance cc_XD0_dmodout_XD2_XDFFM_M r0 *1 0,0
Ccc_XD0_dmodout_XD2_XDFFM_M XD0_dmodout XD2_XDFFM_M 2.4201e-17
* device instance cc_XD0_dmodout_XD2_XDFFM_MB r0 *1 0,0
Ccc_XD0_dmodout_XD2_XDFFM_MB XD0_dmodout XD2_XDFFM_MB 1.21e-17
* device instance cc_XD0_dmodout_XD2_XDFFM_MFB r0 *1 0,0
Ccc_XD0_dmodout_XD2_XDFFM_MFB XD0_dmodout XD2_XDFFM_MFB 1.21e-17
* device instance cc_XD0_dmodout_XD2_XDFFM_S r0 *1 0,0
Ccc_XD0_dmodout_XD2_XDFFM_S XD0_dmodout XD2_XDFFM_S 1.8151e-17
* device instance cc_XD0_dmodout_XD2_XDFFM_SB r0 *1 0,0
Ccc_XD0_dmodout_XD2_XDFFM_SB XD0_dmodout XD2_XDFFM_SB 1.8151e-17
* device instance cc_XD0_dmodout_XD2_XDFFM_SFB r0 *1 0,0
Ccc_XD0_dmodout_XD2_XDFFM_SFB XD0_dmodout XD2_XDFFM_SFB 1.21e-17
* device instance cc_XD0_dmodout_XD2_XDFFQ_CKBB r0 *1 0,0
Ccc_XD0_dmodout_XD2_XDFFQ_CKBB XD0_dmodout XD2_XDFFQ_CKBB 1.8151e-17
* device instance cc_XD0_dmodout_XD2_XDFFQ_CLKB r0 *1 0,0
Ccc_XD0_dmodout_XD2_XDFFQ_CLKB XD0_dmodout XD2_XDFFQ_CLKB 2.4201e-17
* device instance cc_XD0_dmodout_XD2_XDFFQ_M r0 *1 0,0
Ccc_XD0_dmodout_XD2_XDFFQ_M XD0_dmodout XD2_XDFFQ_M 2.4201e-17
* device instance cc_XD0_dmodout_XD2_XDFFQ_MB r0 *1 0,0
Ccc_XD0_dmodout_XD2_XDFFQ_MB XD0_dmodout XD2_XDFFQ_MB 1.21e-17
* device instance cc_XD0_dmodout_XD2_XDFFQ_MFB r0 *1 0,0
Ccc_XD0_dmodout_XD2_XDFFQ_MFB XD0_dmodout XD2_XDFFQ_MFB 1.21e-17
* device instance cc_XD0_dmodout_XD2_XDFFQ_S r0 *1 0,0
Ccc_XD0_dmodout_XD2_XDFFQ_S XD0_dmodout XD2_XDFFQ_S 1.8151e-17
* device instance cc_XD0_dmodout_XD2_XDFFQ_SB r0 *1 0,0
Ccc_XD0_dmodout_XD2_XDFFQ_SB XD0_dmodout XD2_XDFFQ_SB 1.8151e-17
* device instance cc_XD0_dmodout_XD2_XDFFQ_SFB r0 *1 0,0
Ccc_XD0_dmodout_XD2_XDFFQ_SFB XD0_dmodout XD2_XDFFQ_SFB 1.21e-17
* device instance cc_XD0_dmodout_XD2_XN2_mid1 r0 *1 0,0
Ccc_XD0_dmodout_XD2_XN2_mid1 XD0_dmodout XD2_XN2_mid1 1.21e-17
* device instance cc_XD0_dmodout_XD2_XN3_mid1 r0 *1 0,0
Ccc_XD0_dmodout_XD2_XN3_mid1 XD0_dmodout XD2_XN3_mid1 1.21e-17
* device instance cc_XD0_dmodout_XD2_XN3_mid2 r0 *1 0,0
Ccc_XD0_dmodout_XD2_XN3_mid2 XD0_dmodout XD2_XN3_mid2 1.21e-17
* device instance cc_XD0_dmodout_XD2_dmodout r0 *1 0,0
Ccc_XD0_dmodout_XD2_dmodout XD0_dmodout XD2_dmodout 1.21e-17
* device instance cc_XD0_dmodout_XD2_dq r0 *1 0,0
Ccc_XD0_dmodout_XD2_dq XD0_dmodout XD2_dq 1.8151e-17
* device instance cc_XD0_dmodout_XD2_nm r0 *1 0,0
Ccc_XD0_dmodout_XD2_nm XD0_dmodout XD2_nm 1.21e-17
* device instance cc_XD0_dmodout_XD2_nt r0 *1 0,0
Ccc_XD0_dmodout_XD2_nt XD0_dmodout XD2_nt 1.21e-17
* device instance cc_XD0_dmodout_XD2_t1 r0 *1 0,0
Ccc_XD0_dmodout_XD2_t1 XD0_dmodout XD2_t1 1.21e-17
* device instance cc_XD0_dmodout_XD3_XDFFM_CKBB r0 *1 0,0
Ccc_XD0_dmodout_XD3_XDFFM_CKBB XD0_dmodout XD3_XDFFM_CKBB 1.8151e-17
* device instance cc_XD0_dmodout_XD3_XDFFM_CLKB r0 *1 0,0
Ccc_XD0_dmodout_XD3_XDFFM_CLKB XD0_dmodout XD3_XDFFM_CLKB 2.4201e-17
* device instance cc_XD0_dmodout_XD3_XDFFM_M r0 *1 0,0
Ccc_XD0_dmodout_XD3_XDFFM_M XD0_dmodout XD3_XDFFM_M 2.4201e-17
* device instance cc_XD0_dmodout_XD3_XDFFM_MB r0 *1 0,0
Ccc_XD0_dmodout_XD3_XDFFM_MB XD0_dmodout XD3_XDFFM_MB 1.21e-17
* device instance cc_XD0_dmodout_XD3_XDFFM_MFB r0 *1 0,0
Ccc_XD0_dmodout_XD3_XDFFM_MFB XD0_dmodout XD3_XDFFM_MFB 1.21e-17
* device instance cc_XD0_dmodout_XD3_XDFFM_S r0 *1 0,0
Ccc_XD0_dmodout_XD3_XDFFM_S XD0_dmodout XD3_XDFFM_S 1.8151e-17
* device instance cc_XD0_dmodout_XD3_XDFFM_SB r0 *1 0,0
Ccc_XD0_dmodout_XD3_XDFFM_SB XD0_dmodout XD3_XDFFM_SB 1.8151e-17
* device instance cc_XD0_dmodout_XD3_XDFFM_SFB r0 *1 0,0
Ccc_XD0_dmodout_XD3_XDFFM_SFB XD0_dmodout XD3_XDFFM_SFB 1.21e-17
* device instance cc_XD0_dmodout_XD3_XDFFQ_CKBB r0 *1 0,0
Ccc_XD0_dmodout_XD3_XDFFQ_CKBB XD0_dmodout XD3_XDFFQ_CKBB 1.8151e-17
* device instance cc_XD0_dmodout_XD3_XDFFQ_CLKB r0 *1 0,0
Ccc_XD0_dmodout_XD3_XDFFQ_CLKB XD0_dmodout XD3_XDFFQ_CLKB 2.4201e-17
* device instance cc_XD0_dmodout_XD3_XDFFQ_M r0 *1 0,0
Ccc_XD0_dmodout_XD3_XDFFQ_M XD0_dmodout XD3_XDFFQ_M 2.4201e-17
* device instance cc_XD0_dmodout_XD3_XDFFQ_MB r0 *1 0,0
Ccc_XD0_dmodout_XD3_XDFFQ_MB XD0_dmodout XD3_XDFFQ_MB 1.21e-17
* device instance cc_XD0_dmodout_XD3_XDFFQ_MFB r0 *1 0,0
Ccc_XD0_dmodout_XD3_XDFFQ_MFB XD0_dmodout XD3_XDFFQ_MFB 1.21e-17
* device instance cc_XD0_dmodout_XD3_XDFFQ_S r0 *1 0,0
Ccc_XD0_dmodout_XD3_XDFFQ_S XD0_dmodout XD3_XDFFQ_S 1.8151e-17
* device instance cc_XD0_dmodout_XD3_XDFFQ_SB r0 *1 0,0
Ccc_XD0_dmodout_XD3_XDFFQ_SB XD0_dmodout XD3_XDFFQ_SB 1.8151e-17
* device instance cc_XD0_dmodout_XD3_XDFFQ_SFB r0 *1 0,0
Ccc_XD0_dmodout_XD3_XDFFQ_SFB XD0_dmodout XD3_XDFFQ_SFB 1.21e-17
* device instance cc_XD0_dmodout_XD3_XN2_mid1 r0 *1 0,0
Ccc_XD0_dmodout_XD3_XN2_mid1 XD0_dmodout XD3_XN2_mid1 1.21e-17
* device instance cc_XD0_dmodout_XD3_XN3_mid1 r0 *1 0,0
Ccc_XD0_dmodout_XD3_XN3_mid1 XD0_dmodout XD3_XN3_mid1 1.21e-17
* device instance cc_XD0_dmodout_XD3_XN3_mid2 r0 *1 0,0
Ccc_XD0_dmodout_XD3_XN3_mid2 XD0_dmodout XD3_XN3_mid2 1.21e-17
* device instance cc_XD0_dmodout_XD3_dmodout r0 *1 0,0
Ccc_XD0_dmodout_XD3_dmodout XD0_dmodout XD3_dmodout 1.21e-17
* device instance cc_XD0_dmodout_XD3_dq r0 *1 0,0
Ccc_XD0_dmodout_XD3_dq XD0_dmodout XD3_dq 1.8151e-17
* device instance cc_XD0_dmodout_XD3_nm r0 *1 0,0
Ccc_XD0_dmodout_XD3_nm XD0_dmodout XD3_nm 1.21e-17
* device instance cc_XD0_dmodout_XD3_nt r0 *1 0,0
Ccc_XD0_dmodout_XD3_nt XD0_dmodout XD3_nt 1.21e-17
* device instance cc_XD0_dmodout_XD3_t1 r0 *1 0,0
Ccc_XD0_dmodout_XD3_t1 XD0_dmodout XD3_t1 1.21e-17
* device instance cc_XD0_dmodout_XD4_XDFFM_CKBB r0 *1 0,0
Ccc_XD0_dmodout_XD4_XDFFM_CKBB XD0_dmodout XD4_XDFFM_CKBB 1.8151e-17
* device instance cc_XD0_dmodout_XD4_XDFFM_CLKB r0 *1 0,0
Ccc_XD0_dmodout_XD4_XDFFM_CLKB XD0_dmodout XD4_XDFFM_CLKB 2.4201e-17
* device instance cc_XD0_dmodout_XD4_XDFFM_M r0 *1 0,0
Ccc_XD0_dmodout_XD4_XDFFM_M XD0_dmodout XD4_XDFFM_M 2.4201e-17
* device instance cc_XD0_dmodout_XD4_XDFFM_MB r0 *1 0,0
Ccc_XD0_dmodout_XD4_XDFFM_MB XD0_dmodout XD4_XDFFM_MB 1.21e-17
* device instance cc_XD0_dmodout_XD4_XDFFM_MFB r0 *1 0,0
Ccc_XD0_dmodout_XD4_XDFFM_MFB XD0_dmodout XD4_XDFFM_MFB 1.21e-17
* device instance cc_XD0_dmodout_XD4_XDFFM_S r0 *1 0,0
Ccc_XD0_dmodout_XD4_XDFFM_S XD0_dmodout XD4_XDFFM_S 1.8151e-17
* device instance cc_XD0_dmodout_XD4_XDFFM_SB r0 *1 0,0
Ccc_XD0_dmodout_XD4_XDFFM_SB XD0_dmodout XD4_XDFFM_SB 1.8151e-17
* device instance cc_XD0_dmodout_XD4_XDFFM_SFB r0 *1 0,0
Ccc_XD0_dmodout_XD4_XDFFM_SFB XD0_dmodout XD4_XDFFM_SFB 1.21e-17
* device instance cc_XD0_dmodout_XD4_XDFFQ_CKBB r0 *1 0,0
Ccc_XD0_dmodout_XD4_XDFFQ_CKBB XD0_dmodout XD4_XDFFQ_CKBB 1.8151e-17
* device instance cc_XD0_dmodout_XD4_XDFFQ_CLKB r0 *1 0,0
Ccc_XD0_dmodout_XD4_XDFFQ_CLKB XD0_dmodout XD4_XDFFQ_CLKB 2.4201e-17
* device instance cc_XD0_dmodout_XD4_XDFFQ_M r0 *1 0,0
Ccc_XD0_dmodout_XD4_XDFFQ_M XD0_dmodout XD4_XDFFQ_M 2.4201e-17
* device instance cc_XD0_dmodout_XD4_XDFFQ_MB r0 *1 0,0
Ccc_XD0_dmodout_XD4_XDFFQ_MB XD0_dmodout XD4_XDFFQ_MB 1.21e-17
* device instance cc_XD0_dmodout_XD4_XDFFQ_MFB r0 *1 0,0
Ccc_XD0_dmodout_XD4_XDFFQ_MFB XD0_dmodout XD4_XDFFQ_MFB 1.21e-17
* device instance cc_XD0_dmodout_XD4_XDFFQ_S r0 *1 0,0
Ccc_XD0_dmodout_XD4_XDFFQ_S XD0_dmodout XD4_XDFFQ_S 1.8151e-17
* device instance cc_XD0_dmodout_XD4_XDFFQ_SB r0 *1 0,0
Ccc_XD0_dmodout_XD4_XDFFQ_SB XD0_dmodout XD4_XDFFQ_SB 1.8151e-17
* device instance cc_XD0_dmodout_XD4_XDFFQ_SFB r0 *1 0,0
Ccc_XD0_dmodout_XD4_XDFFQ_SFB XD0_dmodout XD4_XDFFQ_SFB 1.21e-17
* device instance cc_XD0_dmodout_XD4_XN2_mid1 r0 *1 0,0
Ccc_XD0_dmodout_XD4_XN2_mid1 XD0_dmodout XD4_XN2_mid1 1.21e-17
* device instance cc_XD0_dmodout_XD4_XN3_mid1 r0 *1 0,0
Ccc_XD0_dmodout_XD4_XN3_mid1 XD0_dmodout XD4_XN3_mid1 1.21e-17
* device instance cc_XD0_dmodout_XD4_XN3_mid2 r0 *1 0,0
Ccc_XD0_dmodout_XD4_XN3_mid2 XD0_dmodout XD4_XN3_mid2 1.21e-17
* device instance cc_XD0_dmodout_XD4_dmodout r0 *1 0,0
Ccc_XD0_dmodout_XD4_dmodout XD0_dmodout XD4_dmodout 1.21e-17
* device instance cc_XD0_dmodout_XD4_dq r0 *1 0,0
Ccc_XD0_dmodout_XD4_dq XD0_dmodout XD4_dq 1.8151e-17
* device instance cc_XD0_dmodout_XD4_nm r0 *1 0,0
Ccc_XD0_dmodout_XD4_nm XD0_dmodout XD4_nm 1.21e-17
* device instance cc_XD0_dmodout_XD4_nt r0 *1 0,0
Ccc_XD0_dmodout_XD4_nt XD0_dmodout XD4_nt 1.21e-17
* device instance cc_XD0_dmodout_XD4_t1 r0 *1 0,0
Ccc_XD0_dmodout_XD4_t1 XD0_dmodout XD4_t1 1.21e-17
* device instance cc_XD0_dmodout_XD5_XDFFM_CKBB r0 *1 0,0
Ccc_XD0_dmodout_XD5_XDFFM_CKBB XD0_dmodout XD5_XDFFM_CKBB 1.8151e-17
* device instance cc_XD0_dmodout_XD5_XDFFM_CLKB r0 *1 0,0
Ccc_XD0_dmodout_XD5_XDFFM_CLKB XD0_dmodout XD5_XDFFM_CLKB 2.4201e-17
* device instance cc_XD0_dmodout_XD5_XDFFM_M r0 *1 0,0
Ccc_XD0_dmodout_XD5_XDFFM_M XD0_dmodout XD5_XDFFM_M 2.4201e-17
* device instance cc_XD0_dmodout_XD5_XDFFM_MB r0 *1 0,0
Ccc_XD0_dmodout_XD5_XDFFM_MB XD0_dmodout XD5_XDFFM_MB 1.21e-17
* device instance cc_XD0_dmodout_XD5_XDFFM_MFB r0 *1 0,0
Ccc_XD0_dmodout_XD5_XDFFM_MFB XD0_dmodout XD5_XDFFM_MFB 1.21e-17
* device instance cc_XD0_dmodout_XD5_XDFFM_S r0 *1 0,0
Ccc_XD0_dmodout_XD5_XDFFM_S XD0_dmodout XD5_XDFFM_S 1.8151e-17
* device instance cc_XD0_dmodout_XD5_XDFFM_SB r0 *1 0,0
Ccc_XD0_dmodout_XD5_XDFFM_SB XD0_dmodout XD5_XDFFM_SB 1.8151e-17
* device instance cc_XD0_dmodout_XD5_XDFFM_SFB r0 *1 0,0
Ccc_XD0_dmodout_XD5_XDFFM_SFB XD0_dmodout XD5_XDFFM_SFB 1.21e-17
* device instance cc_XD0_dmodout_XD5_XDFFQ_CKBB r0 *1 0,0
Ccc_XD0_dmodout_XD5_XDFFQ_CKBB XD0_dmodout XD5_XDFFQ_CKBB 1.8151e-17
* device instance cc_XD0_dmodout_XD5_XDFFQ_CLKB r0 *1 0,0
Ccc_XD0_dmodout_XD5_XDFFQ_CLKB XD0_dmodout XD5_XDFFQ_CLKB 2.4201e-17
* device instance cc_XD0_dmodout_XD5_XDFFQ_M r0 *1 0,0
Ccc_XD0_dmodout_XD5_XDFFQ_M XD0_dmodout XD5_XDFFQ_M 2.4201e-17
* device instance cc_XD0_dmodout_XD5_XDFFQ_MB r0 *1 0,0
Ccc_XD0_dmodout_XD5_XDFFQ_MB XD0_dmodout XD5_XDFFQ_MB 1.21e-17
* device instance cc_XD0_dmodout_XD5_XDFFQ_MFB r0 *1 0,0
Ccc_XD0_dmodout_XD5_XDFFQ_MFB XD0_dmodout XD5_XDFFQ_MFB 1.21e-17
* device instance cc_XD0_dmodout_XD5_XDFFQ_S r0 *1 0,0
Ccc_XD0_dmodout_XD5_XDFFQ_S XD0_dmodout XD5_XDFFQ_S 1.8151e-17
* device instance cc_XD0_dmodout_XD5_XDFFQ_SB r0 *1 0,0
Ccc_XD0_dmodout_XD5_XDFFQ_SB XD0_dmodout XD5_XDFFQ_SB 1.8151e-17
* device instance cc_XD0_dmodout_XD5_XDFFQ_SFB r0 *1 0,0
Ccc_XD0_dmodout_XD5_XDFFQ_SFB XD0_dmodout XD5_XDFFQ_SFB 1.21e-17
* device instance cc_XD0_dmodout_XD5_XN2_mid1 r0 *1 0,0
Ccc_XD0_dmodout_XD5_XN2_mid1 XD0_dmodout XD5_XN2_mid1 1.21e-17
* device instance cc_XD0_dmodout_XD5_XN3_mid1 r0 *1 0,0
Ccc_XD0_dmodout_XD5_XN3_mid1 XD0_dmodout XD5_XN3_mid1 1.21e-17
* device instance cc_XD0_dmodout_XD5_XN3_mid2 r0 *1 0,0
Ccc_XD0_dmodout_XD5_XN3_mid2 XD0_dmodout XD5_XN3_mid2 1.21e-17
* device instance cc_XD0_dmodout_XD5_dmodout r0 *1 0,0
Ccc_XD0_dmodout_XD5_dmodout XD0_dmodout XD5_dmodout 1.21e-17
* device instance cc_XD0_dmodout_XD5_dq r0 *1 0,0
Ccc_XD0_dmodout_XD5_dq XD0_dmodout XD5_dq 1.8151e-17
* device instance cc_XD0_dmodout_XD5_nm r0 *1 0,0
Ccc_XD0_dmodout_XD5_nm XD0_dmodout XD5_nm 1.21e-17
* device instance cc_XD0_dmodout_XD5_nt r0 *1 0,0
Ccc_XD0_dmodout_XD5_nt XD0_dmodout XD5_nt 1.21e-17
* device instance cc_XD0_dmodout_XD5_t1 r0 *1 0,0
Ccc_XD0_dmodout_XD5_t1 XD0_dmodout XD5_t1 1.21e-17
* device instance cc_XD0_dmodout_XFRT_CKBB r0 *1 0,0
Ccc_XD0_dmodout_XFRT_CKBB XD0_dmodout XFRT_CKBB 1.8151e-17
* device instance cc_XD0_dmodout_XFRT_CLKB r0 *1 0,0
Ccc_XD0_dmodout_XFRT_CLKB XD0_dmodout XFRT_CLKB 2.4201e-17
* device instance cc_XD0_dmodout_XFRT_M r0 *1 0,0
Ccc_XD0_dmodout_XFRT_M XD0_dmodout XFRT_M 2.4201e-17
* device instance cc_XD0_dmodout_XFRT_MB r0 *1 0,0
Ccc_XD0_dmodout_XFRT_MB XD0_dmodout XFRT_MB 1.21e-17
* device instance cc_XD0_dmodout_XFRT_MFB r0 *1 0,0
Ccc_XD0_dmodout_XFRT_MFB XD0_dmodout XFRT_MFB 1.21e-17
* device instance cc_XD0_dmodout_XFRT_S r0 *1 0,0
Ccc_XD0_dmodout_XFRT_S XD0_dmodout XFRT_S 1.8151e-17
* device instance cc_XD0_dmodout_XFRT_SB r0 *1 0,0
Ccc_XD0_dmodout_XFRT_SB XD0_dmodout XFRT_SB 1.8151e-17
* device instance cc_XD0_dmodout_XFRT_SFB r0 *1 0,0
Ccc_XD0_dmodout_XFRT_SFB XD0_dmodout XFRT_SFB 1.21e-17
* device instance cc_XD0_dmodout_ck1 r0 *1 0,0
Ccc_XD0_dmodout_ck1 XD0_dmodout ck1 3.0251e-17
* device instance cc_XD0_dmodout_ck2 r0 *1 0,0
Ccc_XD0_dmodout_ck2 XD0_dmodout ck2 3.0251e-17
* device instance cc_XD0_dmodout_ck3 r0 *1 0,0
Ccc_XD0_dmodout_ck3 XD0_dmodout ck3 3.0251e-17
* device instance cc_XD0_dmodout_ck4 r0 *1 0,0
Ccc_XD0_dmodout_ck4 XD0_dmodout ck4 3.0251e-17
* device instance cc_XD0_dmodout_ck5 r0 *1 0,0
Ccc_XD0_dmodout_ck5 XD0_dmodout ck5 3.0251e-17
* device instance cc_XD0_dmodout_mod0 r0 *1 0,0
Ccc_XD0_dmodout_mod0 XD0_dmodout mod0 2.4201e-17
* device instance cc_XD0_dmodout_mod1 r0 *1 0,0
Ccc_XD0_dmodout_mod1 XD0_dmodout mod1 2.4201e-17
* device instance cc_XD0_dmodout_mod2 r0 *1 0,0
Ccc_XD0_dmodout_mod2 XD0_dmodout mod2 2.4201e-17
* device instance cc_XD0_dmodout_mod3 r0 *1 0,0
Ccc_XD0_dmodout_mod3 XD0_dmodout mod3 2.4201e-17
* device instance cc_XD0_dmodout_mod4 r0 *1 0,0
Ccc_XD0_dmodout_mod4 XD0_dmodout mod4 2.4201e-17
* device instance cc_XD0_dmodout_net1 r0 *1 0,0
Ccc_XD0_dmodout_net1 XD0_dmodout net1 1.21e-17
* device instance cc_XD0_dq_XD0_nm r0 *1 0,0
Ccc_XD0_dq_XD0_nm XD0_dq XD0_nm 1.21e-17
* device instance cc_XD0_dq_XD0_nt r0 *1 0,0
Ccc_XD0_dq_XD0_nt XD0_dq XD0_nt 2.4201e-17
* device instance cc_XD0_dq_XD0_t1 r0 *1 0,0
Ccc_XD0_dq_XD0_t1 XD0_dq XD0_t1 1.8151e-17
* device instance cc_XD0_dq_XD1_XDFFM_CKBB r0 *1 0,0
Ccc_XD0_dq_XD1_XDFFM_CKBB XD0_dq XD1_XDFFM_CKBB 1.8151e-17
* device instance cc_XD0_dq_XD1_XDFFM_CLKB r0 *1 0,0
Ccc_XD0_dq_XD1_XDFFM_CLKB XD0_dq XD1_XDFFM_CLKB 2.4201e-17
* device instance cc_XD0_dq_XD1_XDFFM_M r0 *1 0,0
Ccc_XD0_dq_XD1_XDFFM_M XD0_dq XD1_XDFFM_M 2.4201e-17
* device instance cc_XD0_dq_XD1_XDFFM_MB r0 *1 0,0
Ccc_XD0_dq_XD1_XDFFM_MB XD0_dq XD1_XDFFM_MB 1.21e-17
* device instance cc_XD0_dq_XD1_XDFFM_MFB r0 *1 0,0
Ccc_XD0_dq_XD1_XDFFM_MFB XD0_dq XD1_XDFFM_MFB 1.21e-17
* device instance cc_XD0_dq_XD1_XDFFM_S r0 *1 0,0
Ccc_XD0_dq_XD1_XDFFM_S XD0_dq XD1_XDFFM_S 1.8151e-17
* device instance cc_XD0_dq_XD1_XDFFM_SB r0 *1 0,0
Ccc_XD0_dq_XD1_XDFFM_SB XD0_dq XD1_XDFFM_SB 1.8151e-17
* device instance cc_XD0_dq_XD1_XDFFM_SFB r0 *1 0,0
Ccc_XD0_dq_XD1_XDFFM_SFB XD0_dq XD1_XDFFM_SFB 1.21e-17
* device instance cc_XD0_dq_XD1_XDFFQ_CKBB r0 *1 0,0
Ccc_XD0_dq_XD1_XDFFQ_CKBB XD0_dq XD1_XDFFQ_CKBB 1.8151e-17
* device instance cc_XD0_dq_XD1_XDFFQ_CLKB r0 *1 0,0
Ccc_XD0_dq_XD1_XDFFQ_CLKB XD0_dq XD1_XDFFQ_CLKB 2.4201e-17
* device instance cc_XD0_dq_XD1_XDFFQ_M r0 *1 0,0
Ccc_XD0_dq_XD1_XDFFQ_M XD0_dq XD1_XDFFQ_M 2.4201e-17
* device instance cc_XD0_dq_XD1_XDFFQ_MB r0 *1 0,0
Ccc_XD0_dq_XD1_XDFFQ_MB XD0_dq XD1_XDFFQ_MB 1.21e-17
* device instance cc_XD0_dq_XD1_XDFFQ_MFB r0 *1 0,0
Ccc_XD0_dq_XD1_XDFFQ_MFB XD0_dq XD1_XDFFQ_MFB 1.21e-17
* device instance cc_XD0_dq_XD1_XDFFQ_S r0 *1 0,0
Ccc_XD0_dq_XD1_XDFFQ_S XD0_dq XD1_XDFFQ_S 1.8151e-17
* device instance cc_XD0_dq_XD1_XDFFQ_SB r0 *1 0,0
Ccc_XD0_dq_XD1_XDFFQ_SB XD0_dq XD1_XDFFQ_SB 1.8151e-17
* device instance cc_XD0_dq_XD1_XDFFQ_SFB r0 *1 0,0
Ccc_XD0_dq_XD1_XDFFQ_SFB XD0_dq XD1_XDFFQ_SFB 1.21e-17
* device instance cc_XD0_dq_XD1_XN2_mid1 r0 *1 0,0
Ccc_XD0_dq_XD1_XN2_mid1 XD0_dq XD1_XN2_mid1 1.21e-17
* device instance cc_XD0_dq_XD1_XN3_mid1 r0 *1 0,0
Ccc_XD0_dq_XD1_XN3_mid1 XD0_dq XD1_XN3_mid1 1.21e-17
* device instance cc_XD0_dq_XD1_XN3_mid2 r0 *1 0,0
Ccc_XD0_dq_XD1_XN3_mid2 XD0_dq XD1_XN3_mid2 1.21e-17
* device instance cc_XD0_dq_XD1_dmodout r0 *1 0,0
Ccc_XD0_dq_XD1_dmodout XD0_dq XD1_dmodout 1.21e-17
* device instance cc_XD0_dq_XD1_dq r0 *1 0,0
Ccc_XD0_dq_XD1_dq XD0_dq XD1_dq 1.8151e-17
* device instance cc_XD0_dq_XD1_nm r0 *1 0,0
Ccc_XD0_dq_XD1_nm XD0_dq XD1_nm 1.21e-17
* device instance cc_XD0_dq_XD1_nt r0 *1 0,0
Ccc_XD0_dq_XD1_nt XD0_dq XD1_nt 1.21e-17
* device instance cc_XD0_dq_XD1_t1 r0 *1 0,0
Ccc_XD0_dq_XD1_t1 XD0_dq XD1_t1 1.21e-17
* device instance cc_XD0_dq_XD2_XDFFM_CKBB r0 *1 0,0
Ccc_XD0_dq_XD2_XDFFM_CKBB XD0_dq XD2_XDFFM_CKBB 1.8151e-17
* device instance cc_XD0_dq_XD2_XDFFM_CLKB r0 *1 0,0
Ccc_XD0_dq_XD2_XDFFM_CLKB XD0_dq XD2_XDFFM_CLKB 2.4201e-17
* device instance cc_XD0_dq_XD2_XDFFM_M r0 *1 0,0
Ccc_XD0_dq_XD2_XDFFM_M XD0_dq XD2_XDFFM_M 2.4201e-17
* device instance cc_XD0_dq_XD2_XDFFM_MB r0 *1 0,0
Ccc_XD0_dq_XD2_XDFFM_MB XD0_dq XD2_XDFFM_MB 1.21e-17
* device instance cc_XD0_dq_XD2_XDFFM_MFB r0 *1 0,0
Ccc_XD0_dq_XD2_XDFFM_MFB XD0_dq XD2_XDFFM_MFB 1.21e-17
* device instance cc_XD0_dq_XD2_XDFFM_S r0 *1 0,0
Ccc_XD0_dq_XD2_XDFFM_S XD0_dq XD2_XDFFM_S 1.8151e-17
* device instance cc_XD0_dq_XD2_XDFFM_SB r0 *1 0,0
Ccc_XD0_dq_XD2_XDFFM_SB XD0_dq XD2_XDFFM_SB 1.8151e-17
* device instance cc_XD0_dq_XD2_XDFFM_SFB r0 *1 0,0
Ccc_XD0_dq_XD2_XDFFM_SFB XD0_dq XD2_XDFFM_SFB 1.21e-17
* device instance cc_XD0_dq_XD2_XDFFQ_CKBB r0 *1 0,0
Ccc_XD0_dq_XD2_XDFFQ_CKBB XD0_dq XD2_XDFFQ_CKBB 1.8151e-17
* device instance cc_XD0_dq_XD2_XDFFQ_CLKB r0 *1 0,0
Ccc_XD0_dq_XD2_XDFFQ_CLKB XD0_dq XD2_XDFFQ_CLKB 2.4201e-17
* device instance cc_XD0_dq_XD2_XDFFQ_M r0 *1 0,0
Ccc_XD0_dq_XD2_XDFFQ_M XD0_dq XD2_XDFFQ_M 2.4201e-17
* device instance cc_XD0_dq_XD2_XDFFQ_MB r0 *1 0,0
Ccc_XD0_dq_XD2_XDFFQ_MB XD0_dq XD2_XDFFQ_MB 1.21e-17
* device instance cc_XD0_dq_XD2_XDFFQ_MFB r0 *1 0,0
Ccc_XD0_dq_XD2_XDFFQ_MFB XD0_dq XD2_XDFFQ_MFB 1.21e-17
* device instance cc_XD0_dq_XD2_XDFFQ_S r0 *1 0,0
Ccc_XD0_dq_XD2_XDFFQ_S XD0_dq XD2_XDFFQ_S 1.8151e-17
* device instance cc_XD0_dq_XD2_XDFFQ_SB r0 *1 0,0
Ccc_XD0_dq_XD2_XDFFQ_SB XD0_dq XD2_XDFFQ_SB 1.8151e-17
* device instance cc_XD0_dq_XD2_XDFFQ_SFB r0 *1 0,0
Ccc_XD0_dq_XD2_XDFFQ_SFB XD0_dq XD2_XDFFQ_SFB 1.21e-17
* device instance cc_XD0_dq_XD2_XN2_mid1 r0 *1 0,0
Ccc_XD0_dq_XD2_XN2_mid1 XD0_dq XD2_XN2_mid1 1.21e-17
* device instance cc_XD0_dq_XD2_XN3_mid1 r0 *1 0,0
Ccc_XD0_dq_XD2_XN3_mid1 XD0_dq XD2_XN3_mid1 1.21e-17
* device instance cc_XD0_dq_XD2_XN3_mid2 r0 *1 0,0
Ccc_XD0_dq_XD2_XN3_mid2 XD0_dq XD2_XN3_mid2 1.21e-17
* device instance cc_XD0_dq_XD2_dmodout r0 *1 0,0
Ccc_XD0_dq_XD2_dmodout XD0_dq XD2_dmodout 1.21e-17
* device instance cc_XD0_dq_XD2_dq r0 *1 0,0
Ccc_XD0_dq_XD2_dq XD0_dq XD2_dq 1.8151e-17
* device instance cc_XD0_dq_XD2_nm r0 *1 0,0
Ccc_XD0_dq_XD2_nm XD0_dq XD2_nm 1.21e-17
* device instance cc_XD0_dq_XD2_nt r0 *1 0,0
Ccc_XD0_dq_XD2_nt XD0_dq XD2_nt 1.21e-17
* device instance cc_XD0_dq_XD2_t1 r0 *1 0,0
Ccc_XD0_dq_XD2_t1 XD0_dq XD2_t1 1.21e-17
* device instance cc_XD0_dq_XD3_XDFFM_CKBB r0 *1 0,0
Ccc_XD0_dq_XD3_XDFFM_CKBB XD0_dq XD3_XDFFM_CKBB 1.8151e-17
* device instance cc_XD0_dq_XD3_XDFFM_CLKB r0 *1 0,0
Ccc_XD0_dq_XD3_XDFFM_CLKB XD0_dq XD3_XDFFM_CLKB 2.4201e-17
* device instance cc_XD0_dq_XD3_XDFFM_M r0 *1 0,0
Ccc_XD0_dq_XD3_XDFFM_M XD0_dq XD3_XDFFM_M 2.4201e-17
* device instance cc_XD0_dq_XD3_XDFFM_MB r0 *1 0,0
Ccc_XD0_dq_XD3_XDFFM_MB XD0_dq XD3_XDFFM_MB 1.21e-17
* device instance cc_XD0_dq_XD3_XDFFM_MFB r0 *1 0,0
Ccc_XD0_dq_XD3_XDFFM_MFB XD0_dq XD3_XDFFM_MFB 1.21e-17
* device instance cc_XD0_dq_XD3_XDFFM_S r0 *1 0,0
Ccc_XD0_dq_XD3_XDFFM_S XD0_dq XD3_XDFFM_S 1.8151e-17
* device instance cc_XD0_dq_XD3_XDFFM_SB r0 *1 0,0
Ccc_XD0_dq_XD3_XDFFM_SB XD0_dq XD3_XDFFM_SB 1.8151e-17
* device instance cc_XD0_dq_XD3_XDFFM_SFB r0 *1 0,0
Ccc_XD0_dq_XD3_XDFFM_SFB XD0_dq XD3_XDFFM_SFB 1.21e-17
* device instance cc_XD0_dq_XD3_XDFFQ_CKBB r0 *1 0,0
Ccc_XD0_dq_XD3_XDFFQ_CKBB XD0_dq XD3_XDFFQ_CKBB 1.8151e-17
* device instance cc_XD0_dq_XD3_XDFFQ_CLKB r0 *1 0,0
Ccc_XD0_dq_XD3_XDFFQ_CLKB XD0_dq XD3_XDFFQ_CLKB 2.4201e-17
* device instance cc_XD0_dq_XD3_XDFFQ_M r0 *1 0,0
Ccc_XD0_dq_XD3_XDFFQ_M XD0_dq XD3_XDFFQ_M 2.4201e-17
* device instance cc_XD0_dq_XD3_XDFFQ_MB r0 *1 0,0
Ccc_XD0_dq_XD3_XDFFQ_MB XD0_dq XD3_XDFFQ_MB 1.21e-17
* device instance cc_XD0_dq_XD3_XDFFQ_MFB r0 *1 0,0
Ccc_XD0_dq_XD3_XDFFQ_MFB XD0_dq XD3_XDFFQ_MFB 1.21e-17
* device instance cc_XD0_dq_XD3_XDFFQ_S r0 *1 0,0
Ccc_XD0_dq_XD3_XDFFQ_S XD0_dq XD3_XDFFQ_S 1.8151e-17
* device instance cc_XD0_dq_XD3_XDFFQ_SB r0 *1 0,0
Ccc_XD0_dq_XD3_XDFFQ_SB XD0_dq XD3_XDFFQ_SB 1.8151e-17
* device instance cc_XD0_dq_XD3_XDFFQ_SFB r0 *1 0,0
Ccc_XD0_dq_XD3_XDFFQ_SFB XD0_dq XD3_XDFFQ_SFB 1.21e-17
* device instance cc_XD0_dq_XD3_XN2_mid1 r0 *1 0,0
Ccc_XD0_dq_XD3_XN2_mid1 XD0_dq XD3_XN2_mid1 1.21e-17
* device instance cc_XD0_dq_XD3_XN3_mid1 r0 *1 0,0
Ccc_XD0_dq_XD3_XN3_mid1 XD0_dq XD3_XN3_mid1 1.21e-17
* device instance cc_XD0_dq_XD3_XN3_mid2 r0 *1 0,0
Ccc_XD0_dq_XD3_XN3_mid2 XD0_dq XD3_XN3_mid2 1.21e-17
* device instance cc_XD0_dq_XD3_dmodout r0 *1 0,0
Ccc_XD0_dq_XD3_dmodout XD0_dq XD3_dmodout 1.21e-17
* device instance cc_XD0_dq_XD3_dq r0 *1 0,0
Ccc_XD0_dq_XD3_dq XD0_dq XD3_dq 1.8151e-17
* device instance cc_XD0_dq_XD3_nm r0 *1 0,0
Ccc_XD0_dq_XD3_nm XD0_dq XD3_nm 1.21e-17
* device instance cc_XD0_dq_XD3_nt r0 *1 0,0
Ccc_XD0_dq_XD3_nt XD0_dq XD3_nt 1.21e-17
* device instance cc_XD0_dq_XD3_t1 r0 *1 0,0
Ccc_XD0_dq_XD3_t1 XD0_dq XD3_t1 1.21e-17
* device instance cc_XD0_dq_XD4_XDFFM_CKBB r0 *1 0,0
Ccc_XD0_dq_XD4_XDFFM_CKBB XD0_dq XD4_XDFFM_CKBB 1.8151e-17
* device instance cc_XD0_dq_XD4_XDFFM_CLKB r0 *1 0,0
Ccc_XD0_dq_XD4_XDFFM_CLKB XD0_dq XD4_XDFFM_CLKB 2.4201e-17
* device instance cc_XD0_dq_XD4_XDFFM_M r0 *1 0,0
Ccc_XD0_dq_XD4_XDFFM_M XD0_dq XD4_XDFFM_M 2.4201e-17
* device instance cc_XD0_dq_XD4_XDFFM_MB r0 *1 0,0
Ccc_XD0_dq_XD4_XDFFM_MB XD0_dq XD4_XDFFM_MB 1.21e-17
* device instance cc_XD0_dq_XD4_XDFFM_MFB r0 *1 0,0
Ccc_XD0_dq_XD4_XDFFM_MFB XD0_dq XD4_XDFFM_MFB 1.21e-17
* device instance cc_XD0_dq_XD4_XDFFM_S r0 *1 0,0
Ccc_XD0_dq_XD4_XDFFM_S XD0_dq XD4_XDFFM_S 1.8151e-17
* device instance cc_XD0_dq_XD4_XDFFM_SB r0 *1 0,0
Ccc_XD0_dq_XD4_XDFFM_SB XD0_dq XD4_XDFFM_SB 1.8151e-17
* device instance cc_XD0_dq_XD4_XDFFM_SFB r0 *1 0,0
Ccc_XD0_dq_XD4_XDFFM_SFB XD0_dq XD4_XDFFM_SFB 1.21e-17
* device instance cc_XD0_dq_XD4_XDFFQ_CKBB r0 *1 0,0
Ccc_XD0_dq_XD4_XDFFQ_CKBB XD0_dq XD4_XDFFQ_CKBB 1.8151e-17
* device instance cc_XD0_dq_XD4_XDFFQ_CLKB r0 *1 0,0
Ccc_XD0_dq_XD4_XDFFQ_CLKB XD0_dq XD4_XDFFQ_CLKB 2.4201e-17
* device instance cc_XD0_dq_XD4_XDFFQ_M r0 *1 0,0
Ccc_XD0_dq_XD4_XDFFQ_M XD0_dq XD4_XDFFQ_M 2.4201e-17
* device instance cc_XD0_dq_XD4_XDFFQ_MB r0 *1 0,0
Ccc_XD0_dq_XD4_XDFFQ_MB XD0_dq XD4_XDFFQ_MB 1.21e-17
* device instance cc_XD0_dq_XD4_XDFFQ_MFB r0 *1 0,0
Ccc_XD0_dq_XD4_XDFFQ_MFB XD0_dq XD4_XDFFQ_MFB 1.21e-17
* device instance cc_XD0_dq_XD4_XDFFQ_S r0 *1 0,0
Ccc_XD0_dq_XD4_XDFFQ_S XD0_dq XD4_XDFFQ_S 1.8151e-17
* device instance cc_XD0_dq_XD4_XDFFQ_SB r0 *1 0,0
Ccc_XD0_dq_XD4_XDFFQ_SB XD0_dq XD4_XDFFQ_SB 1.8151e-17
* device instance cc_XD0_dq_XD4_XDFFQ_SFB r0 *1 0,0
Ccc_XD0_dq_XD4_XDFFQ_SFB XD0_dq XD4_XDFFQ_SFB 1.21e-17
* device instance cc_XD0_dq_XD4_XN2_mid1 r0 *1 0,0
Ccc_XD0_dq_XD4_XN2_mid1 XD0_dq XD4_XN2_mid1 1.21e-17
* device instance cc_XD0_dq_XD4_XN3_mid1 r0 *1 0,0
Ccc_XD0_dq_XD4_XN3_mid1 XD0_dq XD4_XN3_mid1 1.21e-17
* device instance cc_XD0_dq_XD4_XN3_mid2 r0 *1 0,0
Ccc_XD0_dq_XD4_XN3_mid2 XD0_dq XD4_XN3_mid2 1.21e-17
* device instance cc_XD0_dq_XD4_dmodout r0 *1 0,0
Ccc_XD0_dq_XD4_dmodout XD0_dq XD4_dmodout 1.21e-17
* device instance cc_XD0_dq_XD4_dq r0 *1 0,0
Ccc_XD0_dq_XD4_dq XD0_dq XD4_dq 1.8151e-17
* device instance cc_XD0_dq_XD4_nm r0 *1 0,0
Ccc_XD0_dq_XD4_nm XD0_dq XD4_nm 1.21e-17
* device instance cc_XD0_dq_XD4_nt r0 *1 0,0
Ccc_XD0_dq_XD4_nt XD0_dq XD4_nt 1.21e-17
* device instance cc_XD0_dq_XD4_t1 r0 *1 0,0
Ccc_XD0_dq_XD4_t1 XD0_dq XD4_t1 1.21e-17
* device instance cc_XD0_dq_XD5_XDFFM_CKBB r0 *1 0,0
Ccc_XD0_dq_XD5_XDFFM_CKBB XD0_dq XD5_XDFFM_CKBB 1.8151e-17
* device instance cc_XD0_dq_XD5_XDFFM_CLKB r0 *1 0,0
Ccc_XD0_dq_XD5_XDFFM_CLKB XD0_dq XD5_XDFFM_CLKB 2.4201e-17
* device instance cc_XD0_dq_XD5_XDFFM_M r0 *1 0,0
Ccc_XD0_dq_XD5_XDFFM_M XD0_dq XD5_XDFFM_M 2.4201e-17
* device instance cc_XD0_dq_XD5_XDFFM_MB r0 *1 0,0
Ccc_XD0_dq_XD5_XDFFM_MB XD0_dq XD5_XDFFM_MB 1.21e-17
* device instance cc_XD0_dq_XD5_XDFFM_MFB r0 *1 0,0
Ccc_XD0_dq_XD5_XDFFM_MFB XD0_dq XD5_XDFFM_MFB 1.21e-17
* device instance cc_XD0_dq_XD5_XDFFM_S r0 *1 0,0
Ccc_XD0_dq_XD5_XDFFM_S XD0_dq XD5_XDFFM_S 1.8151e-17
* device instance cc_XD0_dq_XD5_XDFFM_SB r0 *1 0,0
Ccc_XD0_dq_XD5_XDFFM_SB XD0_dq XD5_XDFFM_SB 1.8151e-17
* device instance cc_XD0_dq_XD5_XDFFM_SFB r0 *1 0,0
Ccc_XD0_dq_XD5_XDFFM_SFB XD0_dq XD5_XDFFM_SFB 1.21e-17
* device instance cc_XD0_dq_XD5_XDFFQ_CKBB r0 *1 0,0
Ccc_XD0_dq_XD5_XDFFQ_CKBB XD0_dq XD5_XDFFQ_CKBB 1.8151e-17
* device instance cc_XD0_dq_XD5_XDFFQ_CLKB r0 *1 0,0
Ccc_XD0_dq_XD5_XDFFQ_CLKB XD0_dq XD5_XDFFQ_CLKB 2.4201e-17
* device instance cc_XD0_dq_XD5_XDFFQ_M r0 *1 0,0
Ccc_XD0_dq_XD5_XDFFQ_M XD0_dq XD5_XDFFQ_M 2.4201e-17
* device instance cc_XD0_dq_XD5_XDFFQ_MB r0 *1 0,0
Ccc_XD0_dq_XD5_XDFFQ_MB XD0_dq XD5_XDFFQ_MB 1.21e-17
* device instance cc_XD0_dq_XD5_XDFFQ_MFB r0 *1 0,0
Ccc_XD0_dq_XD5_XDFFQ_MFB XD0_dq XD5_XDFFQ_MFB 1.21e-17
* device instance cc_XD0_dq_XD5_XDFFQ_S r0 *1 0,0
Ccc_XD0_dq_XD5_XDFFQ_S XD0_dq XD5_XDFFQ_S 1.8151e-17
* device instance cc_XD0_dq_XD5_XDFFQ_SB r0 *1 0,0
Ccc_XD0_dq_XD5_XDFFQ_SB XD0_dq XD5_XDFFQ_SB 1.8151e-17
* device instance cc_XD0_dq_XD5_XDFFQ_SFB r0 *1 0,0
Ccc_XD0_dq_XD5_XDFFQ_SFB XD0_dq XD5_XDFFQ_SFB 1.21e-17
* device instance cc_XD0_dq_XD5_XN2_mid1 r0 *1 0,0
Ccc_XD0_dq_XD5_XN2_mid1 XD0_dq XD5_XN2_mid1 1.21e-17
* device instance cc_XD0_dq_XD5_XN3_mid1 r0 *1 0,0
Ccc_XD0_dq_XD5_XN3_mid1 XD0_dq XD5_XN3_mid1 1.21e-17
* device instance cc_XD0_dq_XD5_XN3_mid2 r0 *1 0,0
Ccc_XD0_dq_XD5_XN3_mid2 XD0_dq XD5_XN3_mid2 1.21e-17
* device instance cc_XD0_dq_XD5_dmodout r0 *1 0,0
Ccc_XD0_dq_XD5_dmodout XD0_dq XD5_dmodout 1.21e-17
* device instance cc_XD0_dq_XD5_dq r0 *1 0,0
Ccc_XD0_dq_XD5_dq XD0_dq XD5_dq 1.8151e-17
* device instance cc_XD0_dq_XD5_nm r0 *1 0,0
Ccc_XD0_dq_XD5_nm XD0_dq XD5_nm 1.21e-17
* device instance cc_XD0_dq_XD5_nt r0 *1 0,0
Ccc_XD0_dq_XD5_nt XD0_dq XD5_nt 1.21e-17
* device instance cc_XD0_dq_XD5_t1 r0 *1 0,0
Ccc_XD0_dq_XD5_t1 XD0_dq XD5_t1 1.21e-17
* device instance cc_XD0_dq_XFRT_CKBB r0 *1 0,0
Ccc_XD0_dq_XFRT_CKBB XD0_dq XFRT_CKBB 1.8151e-17
* device instance cc_XD0_dq_XFRT_CLKB r0 *1 0,0
Ccc_XD0_dq_XFRT_CLKB XD0_dq XFRT_CLKB 2.4201e-17
* device instance cc_XD0_dq_XFRT_M r0 *1 0,0
Ccc_XD0_dq_XFRT_M XD0_dq XFRT_M 2.4201e-17
* device instance cc_XD0_dq_XFRT_MB r0 *1 0,0
Ccc_XD0_dq_XFRT_MB XD0_dq XFRT_MB 1.21e-17
* device instance cc_XD0_dq_XFRT_MFB r0 *1 0,0
Ccc_XD0_dq_XFRT_MFB XD0_dq XFRT_MFB 1.21e-17
* device instance cc_XD0_dq_XFRT_S r0 *1 0,0
Ccc_XD0_dq_XFRT_S XD0_dq XFRT_S 1.8151e-17
* device instance cc_XD0_dq_XFRT_SB r0 *1 0,0
Ccc_XD0_dq_XFRT_SB XD0_dq XFRT_SB 1.8151e-17
* device instance cc_XD0_dq_XFRT_SFB r0 *1 0,0
Ccc_XD0_dq_XFRT_SFB XD0_dq XFRT_SFB 1.21e-17
* device instance cc_XD0_dq_ck1 r0 *1 0,0
Ccc_XD0_dq_ck1 XD0_dq ck1 3.0251e-17
* device instance cc_XD0_dq_ck2 r0 *1 0,0
Ccc_XD0_dq_ck2 XD0_dq ck2 3.0251e-17
* device instance cc_XD0_dq_ck3 r0 *1 0,0
Ccc_XD0_dq_ck3 XD0_dq ck3 3.0251e-17
* device instance cc_XD0_dq_ck4 r0 *1 0,0
Ccc_XD0_dq_ck4 XD0_dq ck4 3.0251e-17
* device instance cc_XD0_dq_ck5 r0 *1 0,0
Ccc_XD0_dq_ck5 XD0_dq ck5 3.0251e-17
* device instance cc_XD0_dq_mod0 r0 *1 0,0
Ccc_XD0_dq_mod0 XD0_dq mod0 2.4201e-17
* device instance cc_XD0_dq_mod1 r0 *1 0,0
Ccc_XD0_dq_mod1 XD0_dq mod1 2.4201e-17
* device instance cc_XD0_dq_mod2 r0 *1 0,0
Ccc_XD0_dq_mod2 XD0_dq mod2 2.4201e-17
* device instance cc_XD0_dq_mod3 r0 *1 0,0
Ccc_XD0_dq_mod3 XD0_dq mod3 2.4201e-17
* device instance cc_XD0_dq_mod4 r0 *1 0,0
Ccc_XD0_dq_mod4 XD0_dq mod4 2.4201e-17
* device instance cc_XD0_dq_net1 r0 *1 0,0
Ccc_XD0_dq_net1 XD0_dq net1 1.21e-17
* device instance cc_XD0_nm_XD0_nt r0 *1 0,0
Ccc_XD0_nm_XD0_nt XD0_nm XD0_nt 2.4201e-17
* device instance cc_XD0_nm_XD0_t1 r0 *1 0,0
Ccc_XD0_nm_XD0_t1 XD0_nm XD0_t1 1.21e-17
* device instance cc_XD0_nm_XD1_XDFFM_CKBB r0 *1 0,0
Ccc_XD0_nm_XD1_XDFFM_CKBB XD0_nm XD1_XDFFM_CKBB 1.8151e-17
* device instance cc_XD0_nm_XD1_XDFFM_CLKB r0 *1 0,0
Ccc_XD0_nm_XD1_XDFFM_CLKB XD0_nm XD1_XDFFM_CLKB 2.4201e-17
* device instance cc_XD0_nm_XD1_XDFFM_M r0 *1 0,0
Ccc_XD0_nm_XD1_XDFFM_M XD0_nm XD1_XDFFM_M 2.4201e-17
* device instance cc_XD0_nm_XD1_XDFFM_MB r0 *1 0,0
Ccc_XD0_nm_XD1_XDFFM_MB XD0_nm XD1_XDFFM_MB 1.21e-17
* device instance cc_XD0_nm_XD1_XDFFM_MFB r0 *1 0,0
Ccc_XD0_nm_XD1_XDFFM_MFB XD0_nm XD1_XDFFM_MFB 1.21e-17
* device instance cc_XD0_nm_XD1_XDFFM_S r0 *1 0,0
Ccc_XD0_nm_XD1_XDFFM_S XD0_nm XD1_XDFFM_S 1.8151e-17
* device instance cc_XD0_nm_XD1_XDFFM_SB r0 *1 0,0
Ccc_XD0_nm_XD1_XDFFM_SB XD0_nm XD1_XDFFM_SB 1.8151e-17
* device instance cc_XD0_nm_XD1_XDFFM_SFB r0 *1 0,0
Ccc_XD0_nm_XD1_XDFFM_SFB XD0_nm XD1_XDFFM_SFB 1.21e-17
* device instance cc_XD0_nm_XD1_XDFFQ_CKBB r0 *1 0,0
Ccc_XD0_nm_XD1_XDFFQ_CKBB XD0_nm XD1_XDFFQ_CKBB 1.8151e-17
* device instance cc_XD0_nm_XD1_XDFFQ_CLKB r0 *1 0,0
Ccc_XD0_nm_XD1_XDFFQ_CLKB XD0_nm XD1_XDFFQ_CLKB 2.4201e-17
* device instance cc_XD0_nm_XD1_XDFFQ_M r0 *1 0,0
Ccc_XD0_nm_XD1_XDFFQ_M XD0_nm XD1_XDFFQ_M 2.4201e-17
* device instance cc_XD0_nm_XD1_XDFFQ_MB r0 *1 0,0
Ccc_XD0_nm_XD1_XDFFQ_MB XD0_nm XD1_XDFFQ_MB 1.21e-17
* device instance cc_XD0_nm_XD1_XDFFQ_MFB r0 *1 0,0
Ccc_XD0_nm_XD1_XDFFQ_MFB XD0_nm XD1_XDFFQ_MFB 1.21e-17
* device instance cc_XD0_nm_XD1_XDFFQ_S r0 *1 0,0
Ccc_XD0_nm_XD1_XDFFQ_S XD0_nm XD1_XDFFQ_S 1.8151e-17
* device instance cc_XD0_nm_XD1_XDFFQ_SB r0 *1 0,0
Ccc_XD0_nm_XD1_XDFFQ_SB XD0_nm XD1_XDFFQ_SB 1.8151e-17
* device instance cc_XD0_nm_XD1_XDFFQ_SFB r0 *1 0,0
Ccc_XD0_nm_XD1_XDFFQ_SFB XD0_nm XD1_XDFFQ_SFB 1.21e-17
* device instance cc_XD0_nm_XD1_XN2_mid1 r0 *1 0,0
Ccc_XD0_nm_XD1_XN2_mid1 XD0_nm XD1_XN2_mid1 1.21e-17
* device instance cc_XD0_nm_XD1_XN3_mid1 r0 *1 0,0
Ccc_XD0_nm_XD1_XN3_mid1 XD0_nm XD1_XN3_mid1 1.21e-17
* device instance cc_XD0_nm_XD1_XN3_mid2 r0 *1 0,0
Ccc_XD0_nm_XD1_XN3_mid2 XD0_nm XD1_XN3_mid2 1.21e-17
* device instance cc_XD0_nm_XD1_dmodout r0 *1 0,0
Ccc_XD0_nm_XD1_dmodout XD0_nm XD1_dmodout 1.21e-17
* device instance cc_XD0_nm_XD1_dq r0 *1 0,0
Ccc_XD0_nm_XD1_dq XD0_nm XD1_dq 1.8151e-17
* device instance cc_XD0_nm_XD1_nm r0 *1 0,0
Ccc_XD0_nm_XD1_nm XD0_nm XD1_nm 1.21e-17
* device instance cc_XD0_nm_XD1_nt r0 *1 0,0
Ccc_XD0_nm_XD1_nt XD0_nm XD1_nt 1.21e-17
* device instance cc_XD0_nm_XD1_t1 r0 *1 0,0
Ccc_XD0_nm_XD1_t1 XD0_nm XD1_t1 1.21e-17
* device instance cc_XD0_nm_XD2_XDFFM_CKBB r0 *1 0,0
Ccc_XD0_nm_XD2_XDFFM_CKBB XD0_nm XD2_XDFFM_CKBB 1.8151e-17
* device instance cc_XD0_nm_XD2_XDFFM_CLKB r0 *1 0,0
Ccc_XD0_nm_XD2_XDFFM_CLKB XD0_nm XD2_XDFFM_CLKB 2.4201e-17
* device instance cc_XD0_nm_XD2_XDFFM_M r0 *1 0,0
Ccc_XD0_nm_XD2_XDFFM_M XD0_nm XD2_XDFFM_M 2.4201e-17
* device instance cc_XD0_nm_XD2_XDFFM_MB r0 *1 0,0
Ccc_XD0_nm_XD2_XDFFM_MB XD0_nm XD2_XDFFM_MB 1.21e-17
* device instance cc_XD0_nm_XD2_XDFFM_MFB r0 *1 0,0
Ccc_XD0_nm_XD2_XDFFM_MFB XD0_nm XD2_XDFFM_MFB 1.21e-17
* device instance cc_XD0_nm_XD2_XDFFM_S r0 *1 0,0
Ccc_XD0_nm_XD2_XDFFM_S XD0_nm XD2_XDFFM_S 1.8151e-17
* device instance cc_XD0_nm_XD2_XDFFM_SB r0 *1 0,0
Ccc_XD0_nm_XD2_XDFFM_SB XD0_nm XD2_XDFFM_SB 1.8151e-17
* device instance cc_XD0_nm_XD2_XDFFM_SFB r0 *1 0,0
Ccc_XD0_nm_XD2_XDFFM_SFB XD0_nm XD2_XDFFM_SFB 1.21e-17
* device instance cc_XD0_nm_XD2_XDFFQ_CKBB r0 *1 0,0
Ccc_XD0_nm_XD2_XDFFQ_CKBB XD0_nm XD2_XDFFQ_CKBB 1.8151e-17
* device instance cc_XD0_nm_XD2_XDFFQ_CLKB r0 *1 0,0
Ccc_XD0_nm_XD2_XDFFQ_CLKB XD0_nm XD2_XDFFQ_CLKB 2.4201e-17
* device instance cc_XD0_nm_XD2_XDFFQ_M r0 *1 0,0
Ccc_XD0_nm_XD2_XDFFQ_M XD0_nm XD2_XDFFQ_M 2.4201e-17
* device instance cc_XD0_nm_XD2_XDFFQ_MB r0 *1 0,0
Ccc_XD0_nm_XD2_XDFFQ_MB XD0_nm XD2_XDFFQ_MB 1.21e-17
* device instance cc_XD0_nm_XD2_XDFFQ_MFB r0 *1 0,0
Ccc_XD0_nm_XD2_XDFFQ_MFB XD0_nm XD2_XDFFQ_MFB 1.21e-17
* device instance cc_XD0_nm_XD2_XDFFQ_S r0 *1 0,0
Ccc_XD0_nm_XD2_XDFFQ_S XD0_nm XD2_XDFFQ_S 1.8151e-17
* device instance cc_XD0_nm_XD2_XDFFQ_SB r0 *1 0,0
Ccc_XD0_nm_XD2_XDFFQ_SB XD0_nm XD2_XDFFQ_SB 1.8151e-17
* device instance cc_XD0_nm_XD2_XDFFQ_SFB r0 *1 0,0
Ccc_XD0_nm_XD2_XDFFQ_SFB XD0_nm XD2_XDFFQ_SFB 1.21e-17
* device instance cc_XD0_nm_XD2_XN2_mid1 r0 *1 0,0
Ccc_XD0_nm_XD2_XN2_mid1 XD0_nm XD2_XN2_mid1 1.21e-17
* device instance cc_XD0_nm_XD2_XN3_mid1 r0 *1 0,0
Ccc_XD0_nm_XD2_XN3_mid1 XD0_nm XD2_XN3_mid1 1.21e-17
* device instance cc_XD0_nm_XD2_XN3_mid2 r0 *1 0,0
Ccc_XD0_nm_XD2_XN3_mid2 XD0_nm XD2_XN3_mid2 1.21e-17
* device instance cc_XD0_nm_XD2_dmodout r0 *1 0,0
Ccc_XD0_nm_XD2_dmodout XD0_nm XD2_dmodout 1.21e-17
* device instance cc_XD0_nm_XD2_dq r0 *1 0,0
Ccc_XD0_nm_XD2_dq XD0_nm XD2_dq 1.8151e-17
* device instance cc_XD0_nm_XD2_nm r0 *1 0,0
Ccc_XD0_nm_XD2_nm XD0_nm XD2_nm 1.21e-17
* device instance cc_XD0_nm_XD2_nt r0 *1 0,0
Ccc_XD0_nm_XD2_nt XD0_nm XD2_nt 1.21e-17
* device instance cc_XD0_nm_XD2_t1 r0 *1 0,0
Ccc_XD0_nm_XD2_t1 XD0_nm XD2_t1 1.21e-17
* device instance cc_XD0_nm_XD3_XDFFM_CKBB r0 *1 0,0
Ccc_XD0_nm_XD3_XDFFM_CKBB XD0_nm XD3_XDFFM_CKBB 1.8151e-17
* device instance cc_XD0_nm_XD3_XDFFM_CLKB r0 *1 0,0
Ccc_XD0_nm_XD3_XDFFM_CLKB XD0_nm XD3_XDFFM_CLKB 2.4201e-17
* device instance cc_XD0_nm_XD3_XDFFM_M r0 *1 0,0
Ccc_XD0_nm_XD3_XDFFM_M XD0_nm XD3_XDFFM_M 2.4201e-17
* device instance cc_XD0_nm_XD3_XDFFM_MB r0 *1 0,0
Ccc_XD0_nm_XD3_XDFFM_MB XD0_nm XD3_XDFFM_MB 1.21e-17
* device instance cc_XD0_nm_XD3_XDFFM_MFB r0 *1 0,0
Ccc_XD0_nm_XD3_XDFFM_MFB XD0_nm XD3_XDFFM_MFB 1.21e-17
* device instance cc_XD0_nm_XD3_XDFFM_S r0 *1 0,0
Ccc_XD0_nm_XD3_XDFFM_S XD0_nm XD3_XDFFM_S 1.8151e-17
* device instance cc_XD0_nm_XD3_XDFFM_SB r0 *1 0,0
Ccc_XD0_nm_XD3_XDFFM_SB XD0_nm XD3_XDFFM_SB 1.8151e-17
* device instance cc_XD0_nm_XD3_XDFFM_SFB r0 *1 0,0
Ccc_XD0_nm_XD3_XDFFM_SFB XD0_nm XD3_XDFFM_SFB 1.21e-17
* device instance cc_XD0_nm_XD3_XDFFQ_CKBB r0 *1 0,0
Ccc_XD0_nm_XD3_XDFFQ_CKBB XD0_nm XD3_XDFFQ_CKBB 1.8151e-17
* device instance cc_XD0_nm_XD3_XDFFQ_CLKB r0 *1 0,0
Ccc_XD0_nm_XD3_XDFFQ_CLKB XD0_nm XD3_XDFFQ_CLKB 2.4201e-17
* device instance cc_XD0_nm_XD3_XDFFQ_M r0 *1 0,0
Ccc_XD0_nm_XD3_XDFFQ_M XD0_nm XD3_XDFFQ_M 2.4201e-17
* device instance cc_XD0_nm_XD3_XDFFQ_MB r0 *1 0,0
Ccc_XD0_nm_XD3_XDFFQ_MB XD0_nm XD3_XDFFQ_MB 1.21e-17
* device instance cc_XD0_nm_XD3_XDFFQ_MFB r0 *1 0,0
Ccc_XD0_nm_XD3_XDFFQ_MFB XD0_nm XD3_XDFFQ_MFB 1.21e-17
* device instance cc_XD0_nm_XD3_XDFFQ_S r0 *1 0,0
Ccc_XD0_nm_XD3_XDFFQ_S XD0_nm XD3_XDFFQ_S 1.8151e-17
* device instance cc_XD0_nm_XD3_XDFFQ_SB r0 *1 0,0
Ccc_XD0_nm_XD3_XDFFQ_SB XD0_nm XD3_XDFFQ_SB 1.8151e-17
* device instance cc_XD0_nm_XD3_XDFFQ_SFB r0 *1 0,0
Ccc_XD0_nm_XD3_XDFFQ_SFB XD0_nm XD3_XDFFQ_SFB 1.21e-17
* device instance cc_XD0_nm_XD3_XN2_mid1 r0 *1 0,0
Ccc_XD0_nm_XD3_XN2_mid1 XD0_nm XD3_XN2_mid1 1.21e-17
* device instance cc_XD0_nm_XD3_XN3_mid1 r0 *1 0,0
Ccc_XD0_nm_XD3_XN3_mid1 XD0_nm XD3_XN3_mid1 1.21e-17
* device instance cc_XD0_nm_XD3_XN3_mid2 r0 *1 0,0
Ccc_XD0_nm_XD3_XN3_mid2 XD0_nm XD3_XN3_mid2 1.21e-17
* device instance cc_XD0_nm_XD3_dmodout r0 *1 0,0
Ccc_XD0_nm_XD3_dmodout XD0_nm XD3_dmodout 1.21e-17
* device instance cc_XD0_nm_XD3_dq r0 *1 0,0
Ccc_XD0_nm_XD3_dq XD0_nm XD3_dq 1.8151e-17
* device instance cc_XD0_nm_XD3_nm r0 *1 0,0
Ccc_XD0_nm_XD3_nm XD0_nm XD3_nm 1.21e-17
* device instance cc_XD0_nm_XD3_nt r0 *1 0,0
Ccc_XD0_nm_XD3_nt XD0_nm XD3_nt 1.21e-17
* device instance cc_XD0_nm_XD3_t1 r0 *1 0,0
Ccc_XD0_nm_XD3_t1 XD0_nm XD3_t1 1.21e-17
* device instance cc_XD0_nm_XD4_XDFFM_CKBB r0 *1 0,0
Ccc_XD0_nm_XD4_XDFFM_CKBB XD0_nm XD4_XDFFM_CKBB 1.8151e-17
* device instance cc_XD0_nm_XD4_XDFFM_CLKB r0 *1 0,0
Ccc_XD0_nm_XD4_XDFFM_CLKB XD0_nm XD4_XDFFM_CLKB 2.4201e-17
* device instance cc_XD0_nm_XD4_XDFFM_M r0 *1 0,0
Ccc_XD0_nm_XD4_XDFFM_M XD0_nm XD4_XDFFM_M 2.4201e-17
* device instance cc_XD0_nm_XD4_XDFFM_MB r0 *1 0,0
Ccc_XD0_nm_XD4_XDFFM_MB XD0_nm XD4_XDFFM_MB 1.21e-17
* device instance cc_XD0_nm_XD4_XDFFM_MFB r0 *1 0,0
Ccc_XD0_nm_XD4_XDFFM_MFB XD0_nm XD4_XDFFM_MFB 1.21e-17
* device instance cc_XD0_nm_XD4_XDFFM_S r0 *1 0,0
Ccc_XD0_nm_XD4_XDFFM_S XD0_nm XD4_XDFFM_S 1.8151e-17
* device instance cc_XD0_nm_XD4_XDFFM_SB r0 *1 0,0
Ccc_XD0_nm_XD4_XDFFM_SB XD0_nm XD4_XDFFM_SB 1.8151e-17
* device instance cc_XD0_nm_XD4_XDFFM_SFB r0 *1 0,0
Ccc_XD0_nm_XD4_XDFFM_SFB XD0_nm XD4_XDFFM_SFB 1.21e-17
* device instance cc_XD0_nm_XD4_XDFFQ_CKBB r0 *1 0,0
Ccc_XD0_nm_XD4_XDFFQ_CKBB XD0_nm XD4_XDFFQ_CKBB 1.8151e-17
* device instance cc_XD0_nm_XD4_XDFFQ_CLKB r0 *1 0,0
Ccc_XD0_nm_XD4_XDFFQ_CLKB XD0_nm XD4_XDFFQ_CLKB 2.4201e-17
* device instance cc_XD0_nm_XD4_XDFFQ_M r0 *1 0,0
Ccc_XD0_nm_XD4_XDFFQ_M XD0_nm XD4_XDFFQ_M 2.4201e-17
* device instance cc_XD0_nm_XD4_XDFFQ_MB r0 *1 0,0
Ccc_XD0_nm_XD4_XDFFQ_MB XD0_nm XD4_XDFFQ_MB 1.21e-17
* device instance cc_XD0_nm_XD4_XDFFQ_MFB r0 *1 0,0
Ccc_XD0_nm_XD4_XDFFQ_MFB XD0_nm XD4_XDFFQ_MFB 1.21e-17
* device instance cc_XD0_nm_XD4_XDFFQ_S r0 *1 0,0
Ccc_XD0_nm_XD4_XDFFQ_S XD0_nm XD4_XDFFQ_S 1.8151e-17
* device instance cc_XD0_nm_XD4_XDFFQ_SB r0 *1 0,0
Ccc_XD0_nm_XD4_XDFFQ_SB XD0_nm XD4_XDFFQ_SB 1.8151e-17
* device instance cc_XD0_nm_XD4_XDFFQ_SFB r0 *1 0,0
Ccc_XD0_nm_XD4_XDFFQ_SFB XD0_nm XD4_XDFFQ_SFB 1.21e-17
* device instance cc_XD0_nm_XD4_XN2_mid1 r0 *1 0,0
Ccc_XD0_nm_XD4_XN2_mid1 XD0_nm XD4_XN2_mid1 1.21e-17
* device instance cc_XD0_nm_XD4_XN3_mid1 r0 *1 0,0
Ccc_XD0_nm_XD4_XN3_mid1 XD0_nm XD4_XN3_mid1 1.21e-17
* device instance cc_XD0_nm_XD4_XN3_mid2 r0 *1 0,0
Ccc_XD0_nm_XD4_XN3_mid2 XD0_nm XD4_XN3_mid2 1.21e-17
* device instance cc_XD0_nm_XD4_dmodout r0 *1 0,0
Ccc_XD0_nm_XD4_dmodout XD0_nm XD4_dmodout 1.21e-17
* device instance cc_XD0_nm_XD4_dq r0 *1 0,0
Ccc_XD0_nm_XD4_dq XD0_nm XD4_dq 1.8151e-17
* device instance cc_XD0_nm_XD4_nm r0 *1 0,0
Ccc_XD0_nm_XD4_nm XD0_nm XD4_nm 1.21e-17
* device instance cc_XD0_nm_XD4_nt r0 *1 0,0
Ccc_XD0_nm_XD4_nt XD0_nm XD4_nt 1.21e-17
* device instance cc_XD0_nm_XD4_t1 r0 *1 0,0
Ccc_XD0_nm_XD4_t1 XD0_nm XD4_t1 1.21e-17
* device instance cc_XD0_nm_XD5_XDFFM_CKBB r0 *1 0,0
Ccc_XD0_nm_XD5_XDFFM_CKBB XD0_nm XD5_XDFFM_CKBB 1.8151e-17
* device instance cc_XD0_nm_XD5_XDFFM_CLKB r0 *1 0,0
Ccc_XD0_nm_XD5_XDFFM_CLKB XD0_nm XD5_XDFFM_CLKB 2.4201e-17
* device instance cc_XD0_nm_XD5_XDFFM_M r0 *1 0,0
Ccc_XD0_nm_XD5_XDFFM_M XD0_nm XD5_XDFFM_M 2.4201e-17
* device instance cc_XD0_nm_XD5_XDFFM_MB r0 *1 0,0
Ccc_XD0_nm_XD5_XDFFM_MB XD0_nm XD5_XDFFM_MB 1.21e-17
* device instance cc_XD0_nm_XD5_XDFFM_MFB r0 *1 0,0
Ccc_XD0_nm_XD5_XDFFM_MFB XD0_nm XD5_XDFFM_MFB 1.21e-17
* device instance cc_XD0_nm_XD5_XDFFM_S r0 *1 0,0
Ccc_XD0_nm_XD5_XDFFM_S XD0_nm XD5_XDFFM_S 1.8151e-17
* device instance cc_XD0_nm_XD5_XDFFM_SB r0 *1 0,0
Ccc_XD0_nm_XD5_XDFFM_SB XD0_nm XD5_XDFFM_SB 1.8151e-17
* device instance cc_XD0_nm_XD5_XDFFM_SFB r0 *1 0,0
Ccc_XD0_nm_XD5_XDFFM_SFB XD0_nm XD5_XDFFM_SFB 1.21e-17
* device instance cc_XD0_nm_XD5_XDFFQ_CKBB r0 *1 0,0
Ccc_XD0_nm_XD5_XDFFQ_CKBB XD0_nm XD5_XDFFQ_CKBB 1.8151e-17
* device instance cc_XD0_nm_XD5_XDFFQ_CLKB r0 *1 0,0
Ccc_XD0_nm_XD5_XDFFQ_CLKB XD0_nm XD5_XDFFQ_CLKB 2.4201e-17
* device instance cc_XD0_nm_XD5_XDFFQ_M r0 *1 0,0
Ccc_XD0_nm_XD5_XDFFQ_M XD0_nm XD5_XDFFQ_M 2.4201e-17
* device instance cc_XD0_nm_XD5_XDFFQ_MB r0 *1 0,0
Ccc_XD0_nm_XD5_XDFFQ_MB XD0_nm XD5_XDFFQ_MB 1.21e-17
* device instance cc_XD0_nm_XD5_XDFFQ_MFB r0 *1 0,0
Ccc_XD0_nm_XD5_XDFFQ_MFB XD0_nm XD5_XDFFQ_MFB 1.21e-17
* device instance cc_XD0_nm_XD5_XDFFQ_S r0 *1 0,0
Ccc_XD0_nm_XD5_XDFFQ_S XD0_nm XD5_XDFFQ_S 1.8151e-17
* device instance cc_XD0_nm_XD5_XDFFQ_SB r0 *1 0,0
Ccc_XD0_nm_XD5_XDFFQ_SB XD0_nm XD5_XDFFQ_SB 1.8151e-17
* device instance cc_XD0_nm_XD5_XDFFQ_SFB r0 *1 0,0
Ccc_XD0_nm_XD5_XDFFQ_SFB XD0_nm XD5_XDFFQ_SFB 1.21e-17
* device instance cc_XD0_nm_XD5_XN2_mid1 r0 *1 0,0
Ccc_XD0_nm_XD5_XN2_mid1 XD0_nm XD5_XN2_mid1 1.21e-17
* device instance cc_XD0_nm_XD5_XN3_mid1 r0 *1 0,0
Ccc_XD0_nm_XD5_XN3_mid1 XD0_nm XD5_XN3_mid1 1.21e-17
* device instance cc_XD0_nm_XD5_XN3_mid2 r0 *1 0,0
Ccc_XD0_nm_XD5_XN3_mid2 XD0_nm XD5_XN3_mid2 1.21e-17
* device instance cc_XD0_nm_XD5_dmodout r0 *1 0,0
Ccc_XD0_nm_XD5_dmodout XD0_nm XD5_dmodout 1.21e-17
* device instance cc_XD0_nm_XD5_dq r0 *1 0,0
Ccc_XD0_nm_XD5_dq XD0_nm XD5_dq 1.8151e-17
* device instance cc_XD0_nm_XD5_nm r0 *1 0,0
Ccc_XD0_nm_XD5_nm XD0_nm XD5_nm 1.21e-17
* device instance cc_XD0_nm_XD5_nt r0 *1 0,0
Ccc_XD0_nm_XD5_nt XD0_nm XD5_nt 1.21e-17
* device instance cc_XD0_nm_XD5_t1 r0 *1 0,0
Ccc_XD0_nm_XD5_t1 XD0_nm XD5_t1 1.21e-17
* device instance cc_XD0_nm_XFRT_CKBB r0 *1 0,0
Ccc_XD0_nm_XFRT_CKBB XD0_nm XFRT_CKBB 1.8151e-17
* device instance cc_XD0_nm_XFRT_CLKB r0 *1 0,0
Ccc_XD0_nm_XFRT_CLKB XD0_nm XFRT_CLKB 2.4201e-17
* device instance cc_XD0_nm_XFRT_M r0 *1 0,0
Ccc_XD0_nm_XFRT_M XD0_nm XFRT_M 2.4201e-17
* device instance cc_XD0_nm_XFRT_MB r0 *1 0,0
Ccc_XD0_nm_XFRT_MB XD0_nm XFRT_MB 1.21e-17
* device instance cc_XD0_nm_XFRT_MFB r0 *1 0,0
Ccc_XD0_nm_XFRT_MFB XD0_nm XFRT_MFB 1.21e-17
* device instance cc_XD0_nm_XFRT_S r0 *1 0,0
Ccc_XD0_nm_XFRT_S XD0_nm XFRT_S 1.8151e-17
* device instance cc_XD0_nm_XFRT_SB r0 *1 0,0
Ccc_XD0_nm_XFRT_SB XD0_nm XFRT_SB 1.8151e-17
* device instance cc_XD0_nm_XFRT_SFB r0 *1 0,0
Ccc_XD0_nm_XFRT_SFB XD0_nm XFRT_SFB 1.21e-17
* device instance cc_XD0_nm_ck1 r0 *1 0,0
Ccc_XD0_nm_ck1 XD0_nm ck1 3.6302e-17
* device instance cc_XD0_nm_ck2 r0 *1 0,0
Ccc_XD0_nm_ck2 XD0_nm ck2 3.0251e-17
* device instance cc_XD0_nm_ck3 r0 *1 0,0
Ccc_XD0_nm_ck3 XD0_nm ck3 3.0251e-17
* device instance cc_XD0_nm_ck4 r0 *1 0,0
Ccc_XD0_nm_ck4 XD0_nm ck4 3.0251e-17
* device instance cc_XD0_nm_ck5 r0 *1 0,0
Ccc_XD0_nm_ck5 XD0_nm ck5 3.0251e-17
* device instance cc_XD0_nm_mod0 r0 *1 0,0
Ccc_XD0_nm_mod0 XD0_nm mod0 2.4201e-17
* device instance cc_XD0_nm_mod1 r0 *1 0,0
Ccc_XD0_nm_mod1 XD0_nm mod1 2.4201e-17
* device instance cc_XD0_nm_mod2 r0 *1 0,0
Ccc_XD0_nm_mod2 XD0_nm mod2 2.4201e-17
* device instance cc_XD0_nm_mod3 r0 *1 0,0
Ccc_XD0_nm_mod3 XD0_nm mod3 2.4201e-17
* device instance cc_XD0_nm_mod4 r0 *1 0,0
Ccc_XD0_nm_mod4 XD0_nm mod4 2.4201e-17
* device instance cc_XD0_nm_net1 r0 *1 0,0
Ccc_XD0_nm_net1 XD0_nm net1 1.21e-17
* device instance cc_XD0_nt_XD0_t1 r0 *1 0,0
Ccc_XD0_nt_XD0_t1 XD0_nt XD0_t1 1.21e-17
* device instance cc_XD0_nt_XD1_XDFFM_CKBB r0 *1 0,0
Ccc_XD0_nt_XD1_XDFFM_CKBB XD0_nt XD1_XDFFM_CKBB 1.8151e-17
* device instance cc_XD0_nt_XD1_XDFFM_CLKB r0 *1 0,0
Ccc_XD0_nt_XD1_XDFFM_CLKB XD0_nt XD1_XDFFM_CLKB 2.4201e-17
* device instance cc_XD0_nt_XD1_XDFFM_M r0 *1 0,0
Ccc_XD0_nt_XD1_XDFFM_M XD0_nt XD1_XDFFM_M 2.4201e-17
* device instance cc_XD0_nt_XD1_XDFFM_MB r0 *1 0,0
Ccc_XD0_nt_XD1_XDFFM_MB XD0_nt XD1_XDFFM_MB 1.21e-17
* device instance cc_XD0_nt_XD1_XDFFM_MFB r0 *1 0,0
Ccc_XD0_nt_XD1_XDFFM_MFB XD0_nt XD1_XDFFM_MFB 1.21e-17
* device instance cc_XD0_nt_XD1_XDFFM_S r0 *1 0,0
Ccc_XD0_nt_XD1_XDFFM_S XD0_nt XD1_XDFFM_S 1.8151e-17
* device instance cc_XD0_nt_XD1_XDFFM_SB r0 *1 0,0
Ccc_XD0_nt_XD1_XDFFM_SB XD0_nt XD1_XDFFM_SB 1.8151e-17
* device instance cc_XD0_nt_XD1_XDFFM_SFB r0 *1 0,0
Ccc_XD0_nt_XD1_XDFFM_SFB XD0_nt XD1_XDFFM_SFB 1.21e-17
* device instance cc_XD0_nt_XD1_XDFFQ_CKBB r0 *1 0,0
Ccc_XD0_nt_XD1_XDFFQ_CKBB XD0_nt XD1_XDFFQ_CKBB 1.8151e-17
* device instance cc_XD0_nt_XD1_XDFFQ_CLKB r0 *1 0,0
Ccc_XD0_nt_XD1_XDFFQ_CLKB XD0_nt XD1_XDFFQ_CLKB 2.4201e-17
* device instance cc_XD0_nt_XD1_XDFFQ_M r0 *1 0,0
Ccc_XD0_nt_XD1_XDFFQ_M XD0_nt XD1_XDFFQ_M 2.4201e-17
* device instance cc_XD0_nt_XD1_XDFFQ_MB r0 *1 0,0
Ccc_XD0_nt_XD1_XDFFQ_MB XD0_nt XD1_XDFFQ_MB 1.21e-17
* device instance cc_XD0_nt_XD1_XDFFQ_MFB r0 *1 0,0
Ccc_XD0_nt_XD1_XDFFQ_MFB XD0_nt XD1_XDFFQ_MFB 1.21e-17
* device instance cc_XD0_nt_XD1_XDFFQ_S r0 *1 0,0
Ccc_XD0_nt_XD1_XDFFQ_S XD0_nt XD1_XDFFQ_S 1.8151e-17
* device instance cc_XD0_nt_XD1_XDFFQ_SB r0 *1 0,0
Ccc_XD0_nt_XD1_XDFFQ_SB XD0_nt XD1_XDFFQ_SB 1.8151e-17
* device instance cc_XD0_nt_XD1_XDFFQ_SFB r0 *1 0,0
Ccc_XD0_nt_XD1_XDFFQ_SFB XD0_nt XD1_XDFFQ_SFB 1.21e-17
* device instance cc_XD0_nt_XD1_XN2_mid1 r0 *1 0,0
Ccc_XD0_nt_XD1_XN2_mid1 XD0_nt XD1_XN2_mid1 1.21e-17
* device instance cc_XD0_nt_XD1_XN3_mid1 r0 *1 0,0
Ccc_XD0_nt_XD1_XN3_mid1 XD0_nt XD1_XN3_mid1 1.21e-17
* device instance cc_XD0_nt_XD1_XN3_mid2 r0 *1 0,0
Ccc_XD0_nt_XD1_XN3_mid2 XD0_nt XD1_XN3_mid2 1.21e-17
* device instance cc_XD0_nt_XD1_dmodout r0 *1 0,0
Ccc_XD0_nt_XD1_dmodout XD0_nt XD1_dmodout 1.21e-17
* device instance cc_XD0_nt_XD1_dq r0 *1 0,0
Ccc_XD0_nt_XD1_dq XD0_nt XD1_dq 1.8151e-17
* device instance cc_XD0_nt_XD1_nm r0 *1 0,0
Ccc_XD0_nt_XD1_nm XD0_nt XD1_nm 1.21e-17
* device instance cc_XD0_nt_XD1_nt r0 *1 0,0
Ccc_XD0_nt_XD1_nt XD0_nt XD1_nt 1.21e-17
* device instance cc_XD0_nt_XD1_t1 r0 *1 0,0
Ccc_XD0_nt_XD1_t1 XD0_nt XD1_t1 1.21e-17
* device instance cc_XD0_nt_XD2_XDFFM_CKBB r0 *1 0,0
Ccc_XD0_nt_XD2_XDFFM_CKBB XD0_nt XD2_XDFFM_CKBB 1.8151e-17
* device instance cc_XD0_nt_XD2_XDFFM_CLKB r0 *1 0,0
Ccc_XD0_nt_XD2_XDFFM_CLKB XD0_nt XD2_XDFFM_CLKB 2.4201e-17
* device instance cc_XD0_nt_XD2_XDFFM_M r0 *1 0,0
Ccc_XD0_nt_XD2_XDFFM_M XD0_nt XD2_XDFFM_M 2.4201e-17
* device instance cc_XD0_nt_XD2_XDFFM_MB r0 *1 0,0
Ccc_XD0_nt_XD2_XDFFM_MB XD0_nt XD2_XDFFM_MB 1.21e-17
* device instance cc_XD0_nt_XD2_XDFFM_MFB r0 *1 0,0
Ccc_XD0_nt_XD2_XDFFM_MFB XD0_nt XD2_XDFFM_MFB 1.21e-17
* device instance cc_XD0_nt_XD2_XDFFM_S r0 *1 0,0
Ccc_XD0_nt_XD2_XDFFM_S XD0_nt XD2_XDFFM_S 1.8151e-17
* device instance cc_XD0_nt_XD2_XDFFM_SB r0 *1 0,0
Ccc_XD0_nt_XD2_XDFFM_SB XD0_nt XD2_XDFFM_SB 1.8151e-17
* device instance cc_XD0_nt_XD2_XDFFM_SFB r0 *1 0,0
Ccc_XD0_nt_XD2_XDFFM_SFB XD0_nt XD2_XDFFM_SFB 1.21e-17
* device instance cc_XD0_nt_XD2_XDFFQ_CKBB r0 *1 0,0
Ccc_XD0_nt_XD2_XDFFQ_CKBB XD0_nt XD2_XDFFQ_CKBB 1.8151e-17
* device instance cc_XD0_nt_XD2_XDFFQ_CLKB r0 *1 0,0
Ccc_XD0_nt_XD2_XDFFQ_CLKB XD0_nt XD2_XDFFQ_CLKB 2.4201e-17
* device instance cc_XD0_nt_XD2_XDFFQ_M r0 *1 0,0
Ccc_XD0_nt_XD2_XDFFQ_M XD0_nt XD2_XDFFQ_M 2.4201e-17
* device instance cc_XD0_nt_XD2_XDFFQ_MB r0 *1 0,0
Ccc_XD0_nt_XD2_XDFFQ_MB XD0_nt XD2_XDFFQ_MB 1.21e-17
* device instance cc_XD0_nt_XD2_XDFFQ_MFB r0 *1 0,0
Ccc_XD0_nt_XD2_XDFFQ_MFB XD0_nt XD2_XDFFQ_MFB 1.21e-17
* device instance cc_XD0_nt_XD2_XDFFQ_S r0 *1 0,0
Ccc_XD0_nt_XD2_XDFFQ_S XD0_nt XD2_XDFFQ_S 1.8151e-17
* device instance cc_XD0_nt_XD2_XDFFQ_SB r0 *1 0,0
Ccc_XD0_nt_XD2_XDFFQ_SB XD0_nt XD2_XDFFQ_SB 1.8151e-17
* device instance cc_XD0_nt_XD2_XDFFQ_SFB r0 *1 0,0
Ccc_XD0_nt_XD2_XDFFQ_SFB XD0_nt XD2_XDFFQ_SFB 1.21e-17
* device instance cc_XD0_nt_XD2_XN2_mid1 r0 *1 0,0
Ccc_XD0_nt_XD2_XN2_mid1 XD0_nt XD2_XN2_mid1 1.21e-17
* device instance cc_XD0_nt_XD2_XN3_mid1 r0 *1 0,0
Ccc_XD0_nt_XD2_XN3_mid1 XD0_nt XD2_XN3_mid1 1.21e-17
* device instance cc_XD0_nt_XD2_XN3_mid2 r0 *1 0,0
Ccc_XD0_nt_XD2_XN3_mid2 XD0_nt XD2_XN3_mid2 1.21e-17
* device instance cc_XD0_nt_XD2_dmodout r0 *1 0,0
Ccc_XD0_nt_XD2_dmodout XD0_nt XD2_dmodout 1.21e-17
* device instance cc_XD0_nt_XD2_dq r0 *1 0,0
Ccc_XD0_nt_XD2_dq XD0_nt XD2_dq 1.8151e-17
* device instance cc_XD0_nt_XD2_nm r0 *1 0,0
Ccc_XD0_nt_XD2_nm XD0_nt XD2_nm 1.21e-17
* device instance cc_XD0_nt_XD2_nt r0 *1 0,0
Ccc_XD0_nt_XD2_nt XD0_nt XD2_nt 1.21e-17
* device instance cc_XD0_nt_XD2_t1 r0 *1 0,0
Ccc_XD0_nt_XD2_t1 XD0_nt XD2_t1 1.21e-17
* device instance cc_XD0_nt_XD3_XDFFM_CKBB r0 *1 0,0
Ccc_XD0_nt_XD3_XDFFM_CKBB XD0_nt XD3_XDFFM_CKBB 1.8151e-17
* device instance cc_XD0_nt_XD3_XDFFM_CLKB r0 *1 0,0
Ccc_XD0_nt_XD3_XDFFM_CLKB XD0_nt XD3_XDFFM_CLKB 2.4201e-17
* device instance cc_XD0_nt_XD3_XDFFM_M r0 *1 0,0
Ccc_XD0_nt_XD3_XDFFM_M XD0_nt XD3_XDFFM_M 2.4201e-17
* device instance cc_XD0_nt_XD3_XDFFM_MB r0 *1 0,0
Ccc_XD0_nt_XD3_XDFFM_MB XD0_nt XD3_XDFFM_MB 1.21e-17
* device instance cc_XD0_nt_XD3_XDFFM_MFB r0 *1 0,0
Ccc_XD0_nt_XD3_XDFFM_MFB XD0_nt XD3_XDFFM_MFB 1.21e-17
* device instance cc_XD0_nt_XD3_XDFFM_S r0 *1 0,0
Ccc_XD0_nt_XD3_XDFFM_S XD0_nt XD3_XDFFM_S 1.8151e-17
* device instance cc_XD0_nt_XD3_XDFFM_SB r0 *1 0,0
Ccc_XD0_nt_XD3_XDFFM_SB XD0_nt XD3_XDFFM_SB 1.8151e-17
* device instance cc_XD0_nt_XD3_XDFFM_SFB r0 *1 0,0
Ccc_XD0_nt_XD3_XDFFM_SFB XD0_nt XD3_XDFFM_SFB 1.21e-17
* device instance cc_XD0_nt_XD3_XDFFQ_CKBB r0 *1 0,0
Ccc_XD0_nt_XD3_XDFFQ_CKBB XD0_nt XD3_XDFFQ_CKBB 1.8151e-17
* device instance cc_XD0_nt_XD3_XDFFQ_CLKB r0 *1 0,0
Ccc_XD0_nt_XD3_XDFFQ_CLKB XD0_nt XD3_XDFFQ_CLKB 2.4201e-17
* device instance cc_XD0_nt_XD3_XDFFQ_M r0 *1 0,0
Ccc_XD0_nt_XD3_XDFFQ_M XD0_nt XD3_XDFFQ_M 2.4201e-17
* device instance cc_XD0_nt_XD3_XDFFQ_MB r0 *1 0,0
Ccc_XD0_nt_XD3_XDFFQ_MB XD0_nt XD3_XDFFQ_MB 1.21e-17
* device instance cc_XD0_nt_XD3_XDFFQ_MFB r0 *1 0,0
Ccc_XD0_nt_XD3_XDFFQ_MFB XD0_nt XD3_XDFFQ_MFB 1.21e-17
* device instance cc_XD0_nt_XD3_XDFFQ_S r0 *1 0,0
Ccc_XD0_nt_XD3_XDFFQ_S XD0_nt XD3_XDFFQ_S 1.8151e-17
* device instance cc_XD0_nt_XD3_XDFFQ_SB r0 *1 0,0
Ccc_XD0_nt_XD3_XDFFQ_SB XD0_nt XD3_XDFFQ_SB 1.8151e-17
* device instance cc_XD0_nt_XD3_XDFFQ_SFB r0 *1 0,0
Ccc_XD0_nt_XD3_XDFFQ_SFB XD0_nt XD3_XDFFQ_SFB 1.21e-17
* device instance cc_XD0_nt_XD3_XN2_mid1 r0 *1 0,0
Ccc_XD0_nt_XD3_XN2_mid1 XD0_nt XD3_XN2_mid1 1.21e-17
* device instance cc_XD0_nt_XD3_XN3_mid1 r0 *1 0,0
Ccc_XD0_nt_XD3_XN3_mid1 XD0_nt XD3_XN3_mid1 1.21e-17
* device instance cc_XD0_nt_XD3_XN3_mid2 r0 *1 0,0
Ccc_XD0_nt_XD3_XN3_mid2 XD0_nt XD3_XN3_mid2 1.21e-17
* device instance cc_XD0_nt_XD3_dmodout r0 *1 0,0
Ccc_XD0_nt_XD3_dmodout XD0_nt XD3_dmodout 1.21e-17
* device instance cc_XD0_nt_XD3_dq r0 *1 0,0
Ccc_XD0_nt_XD3_dq XD0_nt XD3_dq 1.8151e-17
* device instance cc_XD0_nt_XD3_nm r0 *1 0,0
Ccc_XD0_nt_XD3_nm XD0_nt XD3_nm 1.21e-17
* device instance cc_XD0_nt_XD3_nt r0 *1 0,0
Ccc_XD0_nt_XD3_nt XD0_nt XD3_nt 1.21e-17
* device instance cc_XD0_nt_XD3_t1 r0 *1 0,0
Ccc_XD0_nt_XD3_t1 XD0_nt XD3_t1 1.21e-17
* device instance cc_XD0_nt_XD4_XDFFM_CKBB r0 *1 0,0
Ccc_XD0_nt_XD4_XDFFM_CKBB XD0_nt XD4_XDFFM_CKBB 1.8151e-17
* device instance cc_XD0_nt_XD4_XDFFM_CLKB r0 *1 0,0
Ccc_XD0_nt_XD4_XDFFM_CLKB XD0_nt XD4_XDFFM_CLKB 2.4201e-17
* device instance cc_XD0_nt_XD4_XDFFM_M r0 *1 0,0
Ccc_XD0_nt_XD4_XDFFM_M XD0_nt XD4_XDFFM_M 2.4201e-17
* device instance cc_XD0_nt_XD4_XDFFM_MB r0 *1 0,0
Ccc_XD0_nt_XD4_XDFFM_MB XD0_nt XD4_XDFFM_MB 1.21e-17
* device instance cc_XD0_nt_XD4_XDFFM_MFB r0 *1 0,0
Ccc_XD0_nt_XD4_XDFFM_MFB XD0_nt XD4_XDFFM_MFB 1.21e-17
* device instance cc_XD0_nt_XD4_XDFFM_S r0 *1 0,0
Ccc_XD0_nt_XD4_XDFFM_S XD0_nt XD4_XDFFM_S 1.8151e-17
* device instance cc_XD0_nt_XD4_XDFFM_SB r0 *1 0,0
Ccc_XD0_nt_XD4_XDFFM_SB XD0_nt XD4_XDFFM_SB 1.8151e-17
* device instance cc_XD0_nt_XD4_XDFFM_SFB r0 *1 0,0
Ccc_XD0_nt_XD4_XDFFM_SFB XD0_nt XD4_XDFFM_SFB 1.21e-17
* device instance cc_XD0_nt_XD4_XDFFQ_CKBB r0 *1 0,0
Ccc_XD0_nt_XD4_XDFFQ_CKBB XD0_nt XD4_XDFFQ_CKBB 1.8151e-17
* device instance cc_XD0_nt_XD4_XDFFQ_CLKB r0 *1 0,0
Ccc_XD0_nt_XD4_XDFFQ_CLKB XD0_nt XD4_XDFFQ_CLKB 2.4201e-17
* device instance cc_XD0_nt_XD4_XDFFQ_M r0 *1 0,0
Ccc_XD0_nt_XD4_XDFFQ_M XD0_nt XD4_XDFFQ_M 2.4201e-17
* device instance cc_XD0_nt_XD4_XDFFQ_MB r0 *1 0,0
Ccc_XD0_nt_XD4_XDFFQ_MB XD0_nt XD4_XDFFQ_MB 1.21e-17
* device instance cc_XD0_nt_XD4_XDFFQ_MFB r0 *1 0,0
Ccc_XD0_nt_XD4_XDFFQ_MFB XD0_nt XD4_XDFFQ_MFB 1.21e-17
* device instance cc_XD0_nt_XD4_XDFFQ_S r0 *1 0,0
Ccc_XD0_nt_XD4_XDFFQ_S XD0_nt XD4_XDFFQ_S 1.8151e-17
* device instance cc_XD0_nt_XD4_XDFFQ_SB r0 *1 0,0
Ccc_XD0_nt_XD4_XDFFQ_SB XD0_nt XD4_XDFFQ_SB 1.8151e-17
* device instance cc_XD0_nt_XD4_XDFFQ_SFB r0 *1 0,0
Ccc_XD0_nt_XD4_XDFFQ_SFB XD0_nt XD4_XDFFQ_SFB 1.21e-17
* device instance cc_XD0_nt_XD4_XN2_mid1 r0 *1 0,0
Ccc_XD0_nt_XD4_XN2_mid1 XD0_nt XD4_XN2_mid1 1.21e-17
* device instance cc_XD0_nt_XD4_XN3_mid1 r0 *1 0,0
Ccc_XD0_nt_XD4_XN3_mid1 XD0_nt XD4_XN3_mid1 1.21e-17
* device instance cc_XD0_nt_XD4_XN3_mid2 r0 *1 0,0
Ccc_XD0_nt_XD4_XN3_mid2 XD0_nt XD4_XN3_mid2 1.21e-17
* device instance cc_XD0_nt_XD4_dmodout r0 *1 0,0
Ccc_XD0_nt_XD4_dmodout XD0_nt XD4_dmodout 1.21e-17
* device instance cc_XD0_nt_XD4_dq r0 *1 0,0
Ccc_XD0_nt_XD4_dq XD0_nt XD4_dq 1.8151e-17
* device instance cc_XD0_nt_XD4_nm r0 *1 0,0
Ccc_XD0_nt_XD4_nm XD0_nt XD4_nm 1.21e-17
* device instance cc_XD0_nt_XD4_nt r0 *1 0,0
Ccc_XD0_nt_XD4_nt XD0_nt XD4_nt 1.21e-17
* device instance cc_XD0_nt_XD4_t1 r0 *1 0,0
Ccc_XD0_nt_XD4_t1 XD0_nt XD4_t1 1.21e-17
* device instance cc_XD0_nt_XD5_XDFFM_CKBB r0 *1 0,0
Ccc_XD0_nt_XD5_XDFFM_CKBB XD0_nt XD5_XDFFM_CKBB 1.8151e-17
* device instance cc_XD0_nt_XD5_XDFFM_CLKB r0 *1 0,0
Ccc_XD0_nt_XD5_XDFFM_CLKB XD0_nt XD5_XDFFM_CLKB 2.4201e-17
* device instance cc_XD0_nt_XD5_XDFFM_M r0 *1 0,0
Ccc_XD0_nt_XD5_XDFFM_M XD0_nt XD5_XDFFM_M 2.4201e-17
* device instance cc_XD0_nt_XD5_XDFFM_MB r0 *1 0,0
Ccc_XD0_nt_XD5_XDFFM_MB XD0_nt XD5_XDFFM_MB 1.21e-17
* device instance cc_XD0_nt_XD5_XDFFM_MFB r0 *1 0,0
Ccc_XD0_nt_XD5_XDFFM_MFB XD0_nt XD5_XDFFM_MFB 1.21e-17
* device instance cc_XD0_nt_XD5_XDFFM_S r0 *1 0,0
Ccc_XD0_nt_XD5_XDFFM_S XD0_nt XD5_XDFFM_S 1.8151e-17
* device instance cc_XD0_nt_XD5_XDFFM_SB r0 *1 0,0
Ccc_XD0_nt_XD5_XDFFM_SB XD0_nt XD5_XDFFM_SB 1.8151e-17
* device instance cc_XD0_nt_XD5_XDFFM_SFB r0 *1 0,0
Ccc_XD0_nt_XD5_XDFFM_SFB XD0_nt XD5_XDFFM_SFB 1.21e-17
* device instance cc_XD0_nt_XD5_XDFFQ_CKBB r0 *1 0,0
Ccc_XD0_nt_XD5_XDFFQ_CKBB XD0_nt XD5_XDFFQ_CKBB 1.8151e-17
* device instance cc_XD0_nt_XD5_XDFFQ_CLKB r0 *1 0,0
Ccc_XD0_nt_XD5_XDFFQ_CLKB XD0_nt XD5_XDFFQ_CLKB 2.4201e-17
* device instance cc_XD0_nt_XD5_XDFFQ_M r0 *1 0,0
Ccc_XD0_nt_XD5_XDFFQ_M XD0_nt XD5_XDFFQ_M 2.4201e-17
* device instance cc_XD0_nt_XD5_XDFFQ_MB r0 *1 0,0
Ccc_XD0_nt_XD5_XDFFQ_MB XD0_nt XD5_XDFFQ_MB 1.21e-17
* device instance cc_XD0_nt_XD5_XDFFQ_MFB r0 *1 0,0
Ccc_XD0_nt_XD5_XDFFQ_MFB XD0_nt XD5_XDFFQ_MFB 1.21e-17
* device instance cc_XD0_nt_XD5_XDFFQ_S r0 *1 0,0
Ccc_XD0_nt_XD5_XDFFQ_S XD0_nt XD5_XDFFQ_S 1.8151e-17
* device instance cc_XD0_nt_XD5_XDFFQ_SB r0 *1 0,0
Ccc_XD0_nt_XD5_XDFFQ_SB XD0_nt XD5_XDFFQ_SB 1.8151e-17
* device instance cc_XD0_nt_XD5_XDFFQ_SFB r0 *1 0,0
Ccc_XD0_nt_XD5_XDFFQ_SFB XD0_nt XD5_XDFFQ_SFB 1.21e-17
* device instance cc_XD0_nt_XD5_XN2_mid1 r0 *1 0,0
Ccc_XD0_nt_XD5_XN2_mid1 XD0_nt XD5_XN2_mid1 1.21e-17
* device instance cc_XD0_nt_XD5_XN3_mid1 r0 *1 0,0
Ccc_XD0_nt_XD5_XN3_mid1 XD0_nt XD5_XN3_mid1 1.21e-17
* device instance cc_XD0_nt_XD5_XN3_mid2 r0 *1 0,0
Ccc_XD0_nt_XD5_XN3_mid2 XD0_nt XD5_XN3_mid2 1.21e-17
* device instance cc_XD0_nt_XD5_dmodout r0 *1 0,0
Ccc_XD0_nt_XD5_dmodout XD0_nt XD5_dmodout 1.21e-17
* device instance cc_XD0_nt_XD5_dq r0 *1 0,0
Ccc_XD0_nt_XD5_dq XD0_nt XD5_dq 1.8151e-17
* device instance cc_XD0_nt_XD5_nm r0 *1 0,0
Ccc_XD0_nt_XD5_nm XD0_nt XD5_nm 1.21e-17
* device instance cc_XD0_nt_XD5_nt r0 *1 0,0
Ccc_XD0_nt_XD5_nt XD0_nt XD5_nt 1.21e-17
* device instance cc_XD0_nt_XD5_t1 r0 *1 0,0
Ccc_XD0_nt_XD5_t1 XD0_nt XD5_t1 1.21e-17
* device instance cc_XD0_nt_XFRT_CKBB r0 *1 0,0
Ccc_XD0_nt_XFRT_CKBB XD0_nt XFRT_CKBB 1.8151e-17
* device instance cc_XD0_nt_XFRT_CLKB r0 *1 0,0
Ccc_XD0_nt_XFRT_CLKB XD0_nt XFRT_CLKB 2.4201e-17
* device instance cc_XD0_nt_XFRT_M r0 *1 0,0
Ccc_XD0_nt_XFRT_M XD0_nt XFRT_M 2.4201e-17
* device instance cc_XD0_nt_XFRT_MB r0 *1 0,0
Ccc_XD0_nt_XFRT_MB XD0_nt XFRT_MB 1.21e-17
* device instance cc_XD0_nt_XFRT_MFB r0 *1 0,0
Ccc_XD0_nt_XFRT_MFB XD0_nt XFRT_MFB 1.21e-17
* device instance cc_XD0_nt_XFRT_S r0 *1 0,0
Ccc_XD0_nt_XFRT_S XD0_nt XFRT_S 1.8151e-17
* device instance cc_XD0_nt_XFRT_SB r0 *1 0,0
Ccc_XD0_nt_XFRT_SB XD0_nt XFRT_SB 1.8151e-17
* device instance cc_XD0_nt_XFRT_SFB r0 *1 0,0
Ccc_XD0_nt_XFRT_SFB XD0_nt XFRT_SFB 1.21e-17
* device instance cc_XD0_nt_ck1 r0 *1 0,0
Ccc_XD0_nt_ck1 XD0_nt ck1 3.0251e-17
* device instance cc_XD0_nt_ck2 r0 *1 0,0
Ccc_XD0_nt_ck2 XD0_nt ck2 3.0251e-17
* device instance cc_XD0_nt_ck3 r0 *1 0,0
Ccc_XD0_nt_ck3 XD0_nt ck3 3.0251e-17
* device instance cc_XD0_nt_ck4 r0 *1 0,0
Ccc_XD0_nt_ck4 XD0_nt ck4 3.0251e-17
* device instance cc_XD0_nt_ck5 r0 *1 0,0
Ccc_XD0_nt_ck5 XD0_nt ck5 3.0251e-17
* device instance cc_XD0_nt_mod0 r0 *1 0,0
Ccc_XD0_nt_mod0 XD0_nt mod0 2.4201e-17
* device instance cc_XD0_nt_mod1 r0 *1 0,0
Ccc_XD0_nt_mod1 XD0_nt mod1 2.4201e-17
* device instance cc_XD0_nt_mod2 r0 *1 0,0
Ccc_XD0_nt_mod2 XD0_nt mod2 2.4201e-17
* device instance cc_XD0_nt_mod3 r0 *1 0,0
Ccc_XD0_nt_mod3 XD0_nt mod3 2.4201e-17
* device instance cc_XD0_nt_mod4 r0 *1 0,0
Ccc_XD0_nt_mod4 XD0_nt mod4 2.4201e-17
* device instance cc_XD0_nt_net1 r0 *1 0,0
Ccc_XD0_nt_net1 XD0_nt net1 1.8151e-17
* device instance cc_XD0_t1_XD1_XDFFM_CKBB r0 *1 0,0
Ccc_XD0_t1_XD1_XDFFM_CKBB XD0_t1 XD1_XDFFM_CKBB 1.8151e-17
* device instance cc_XD0_t1_XD1_XDFFM_CLKB r0 *1 0,0
Ccc_XD0_t1_XD1_XDFFM_CLKB XD0_t1 XD1_XDFFM_CLKB 2.4201e-17
* device instance cc_XD0_t1_XD1_XDFFM_M r0 *1 0,0
Ccc_XD0_t1_XD1_XDFFM_M XD0_t1 XD1_XDFFM_M 2.4201e-17
* device instance cc_XD0_t1_XD1_XDFFM_MB r0 *1 0,0
Ccc_XD0_t1_XD1_XDFFM_MB XD0_t1 XD1_XDFFM_MB 1.21e-17
* device instance cc_XD0_t1_XD1_XDFFM_MFB r0 *1 0,0
Ccc_XD0_t1_XD1_XDFFM_MFB XD0_t1 XD1_XDFFM_MFB 1.21e-17
* device instance cc_XD0_t1_XD1_XDFFM_S r0 *1 0,0
Ccc_XD0_t1_XD1_XDFFM_S XD0_t1 XD1_XDFFM_S 1.8151e-17
* device instance cc_XD0_t1_XD1_XDFFM_SB r0 *1 0,0
Ccc_XD0_t1_XD1_XDFFM_SB XD0_t1 XD1_XDFFM_SB 1.8151e-17
* device instance cc_XD0_t1_XD1_XDFFM_SFB r0 *1 0,0
Ccc_XD0_t1_XD1_XDFFM_SFB XD0_t1 XD1_XDFFM_SFB 1.21e-17
* device instance cc_XD0_t1_XD1_XDFFQ_CKBB r0 *1 0,0
Ccc_XD0_t1_XD1_XDFFQ_CKBB XD0_t1 XD1_XDFFQ_CKBB 1.8151e-17
* device instance cc_XD0_t1_XD1_XDFFQ_CLKB r0 *1 0,0
Ccc_XD0_t1_XD1_XDFFQ_CLKB XD0_t1 XD1_XDFFQ_CLKB 2.4201e-17
* device instance cc_XD0_t1_XD1_XDFFQ_M r0 *1 0,0
Ccc_XD0_t1_XD1_XDFFQ_M XD0_t1 XD1_XDFFQ_M 2.4201e-17
* device instance cc_XD0_t1_XD1_XDFFQ_MB r0 *1 0,0
Ccc_XD0_t1_XD1_XDFFQ_MB XD0_t1 XD1_XDFFQ_MB 1.21e-17
* device instance cc_XD0_t1_XD1_XDFFQ_MFB r0 *1 0,0
Ccc_XD0_t1_XD1_XDFFQ_MFB XD0_t1 XD1_XDFFQ_MFB 1.21e-17
* device instance cc_XD0_t1_XD1_XDFFQ_S r0 *1 0,0
Ccc_XD0_t1_XD1_XDFFQ_S XD0_t1 XD1_XDFFQ_S 1.8151e-17
* device instance cc_XD0_t1_XD1_XDFFQ_SB r0 *1 0,0
Ccc_XD0_t1_XD1_XDFFQ_SB XD0_t1 XD1_XDFFQ_SB 1.8151e-17
* device instance cc_XD0_t1_XD1_XDFFQ_SFB r0 *1 0,0
Ccc_XD0_t1_XD1_XDFFQ_SFB XD0_t1 XD1_XDFFQ_SFB 1.21e-17
* device instance cc_XD0_t1_XD1_XN2_mid1 r0 *1 0,0
Ccc_XD0_t1_XD1_XN2_mid1 XD0_t1 XD1_XN2_mid1 1.21e-17
* device instance cc_XD0_t1_XD1_XN3_mid1 r0 *1 0,0
Ccc_XD0_t1_XD1_XN3_mid1 XD0_t1 XD1_XN3_mid1 1.21e-17
* device instance cc_XD0_t1_XD1_XN3_mid2 r0 *1 0,0
Ccc_XD0_t1_XD1_XN3_mid2 XD0_t1 XD1_XN3_mid2 1.21e-17
* device instance cc_XD0_t1_XD1_dmodout r0 *1 0,0
Ccc_XD0_t1_XD1_dmodout XD0_t1 XD1_dmodout 1.21e-17
* device instance cc_XD0_t1_XD1_dq r0 *1 0,0
Ccc_XD0_t1_XD1_dq XD0_t1 XD1_dq 1.8151e-17
* device instance cc_XD0_t1_XD1_nm r0 *1 0,0
Ccc_XD0_t1_XD1_nm XD0_t1 XD1_nm 1.21e-17
* device instance cc_XD0_t1_XD1_nt r0 *1 0,0
Ccc_XD0_t1_XD1_nt XD0_t1 XD1_nt 1.21e-17
* device instance cc_XD0_t1_XD1_t1 r0 *1 0,0
Ccc_XD0_t1_XD1_t1 XD0_t1 XD1_t1 1.21e-17
* device instance cc_XD0_t1_XD2_XDFFM_CKBB r0 *1 0,0
Ccc_XD0_t1_XD2_XDFFM_CKBB XD0_t1 XD2_XDFFM_CKBB 1.8151e-17
* device instance cc_XD0_t1_XD2_XDFFM_CLKB r0 *1 0,0
Ccc_XD0_t1_XD2_XDFFM_CLKB XD0_t1 XD2_XDFFM_CLKB 2.4201e-17
* device instance cc_XD0_t1_XD2_XDFFM_M r0 *1 0,0
Ccc_XD0_t1_XD2_XDFFM_M XD0_t1 XD2_XDFFM_M 2.4201e-17
* device instance cc_XD0_t1_XD2_XDFFM_MB r0 *1 0,0
Ccc_XD0_t1_XD2_XDFFM_MB XD0_t1 XD2_XDFFM_MB 1.21e-17
* device instance cc_XD0_t1_XD2_XDFFM_MFB r0 *1 0,0
Ccc_XD0_t1_XD2_XDFFM_MFB XD0_t1 XD2_XDFFM_MFB 1.21e-17
* device instance cc_XD0_t1_XD2_XDFFM_S r0 *1 0,0
Ccc_XD0_t1_XD2_XDFFM_S XD0_t1 XD2_XDFFM_S 1.8151e-17
* device instance cc_XD0_t1_XD2_XDFFM_SB r0 *1 0,0
Ccc_XD0_t1_XD2_XDFFM_SB XD0_t1 XD2_XDFFM_SB 1.8151e-17
* device instance cc_XD0_t1_XD2_XDFFM_SFB r0 *1 0,0
Ccc_XD0_t1_XD2_XDFFM_SFB XD0_t1 XD2_XDFFM_SFB 1.21e-17
* device instance cc_XD0_t1_XD2_XDFFQ_CKBB r0 *1 0,0
Ccc_XD0_t1_XD2_XDFFQ_CKBB XD0_t1 XD2_XDFFQ_CKBB 1.8151e-17
* device instance cc_XD0_t1_XD2_XDFFQ_CLKB r0 *1 0,0
Ccc_XD0_t1_XD2_XDFFQ_CLKB XD0_t1 XD2_XDFFQ_CLKB 2.4201e-17
* device instance cc_XD0_t1_XD2_XDFFQ_M r0 *1 0,0
Ccc_XD0_t1_XD2_XDFFQ_M XD0_t1 XD2_XDFFQ_M 2.4201e-17
* device instance cc_XD0_t1_XD2_XDFFQ_MB r0 *1 0,0
Ccc_XD0_t1_XD2_XDFFQ_MB XD0_t1 XD2_XDFFQ_MB 1.21e-17
* device instance cc_XD0_t1_XD2_XDFFQ_MFB r0 *1 0,0
Ccc_XD0_t1_XD2_XDFFQ_MFB XD0_t1 XD2_XDFFQ_MFB 1.21e-17
* device instance cc_XD0_t1_XD2_XDFFQ_S r0 *1 0,0
Ccc_XD0_t1_XD2_XDFFQ_S XD0_t1 XD2_XDFFQ_S 1.8151e-17
* device instance cc_XD0_t1_XD2_XDFFQ_SB r0 *1 0,0
Ccc_XD0_t1_XD2_XDFFQ_SB XD0_t1 XD2_XDFFQ_SB 1.8151e-17
* device instance cc_XD0_t1_XD2_XDFFQ_SFB r0 *1 0,0
Ccc_XD0_t1_XD2_XDFFQ_SFB XD0_t1 XD2_XDFFQ_SFB 1.21e-17
* device instance cc_XD0_t1_XD2_XN2_mid1 r0 *1 0,0
Ccc_XD0_t1_XD2_XN2_mid1 XD0_t1 XD2_XN2_mid1 1.21e-17
* device instance cc_XD0_t1_XD2_XN3_mid1 r0 *1 0,0
Ccc_XD0_t1_XD2_XN3_mid1 XD0_t1 XD2_XN3_mid1 1.21e-17
* device instance cc_XD0_t1_XD2_XN3_mid2 r0 *1 0,0
Ccc_XD0_t1_XD2_XN3_mid2 XD0_t1 XD2_XN3_mid2 1.21e-17
* device instance cc_XD0_t1_XD2_dmodout r0 *1 0,0
Ccc_XD0_t1_XD2_dmodout XD0_t1 XD2_dmodout 1.21e-17
* device instance cc_XD0_t1_XD2_dq r0 *1 0,0
Ccc_XD0_t1_XD2_dq XD0_t1 XD2_dq 1.8151e-17
* device instance cc_XD0_t1_XD2_nm r0 *1 0,0
Ccc_XD0_t1_XD2_nm XD0_t1 XD2_nm 1.21e-17
* device instance cc_XD0_t1_XD2_nt r0 *1 0,0
Ccc_XD0_t1_XD2_nt XD0_t1 XD2_nt 1.21e-17
* device instance cc_XD0_t1_XD2_t1 r0 *1 0,0
Ccc_XD0_t1_XD2_t1 XD0_t1 XD2_t1 1.21e-17
* device instance cc_XD0_t1_XD3_XDFFM_CKBB r0 *1 0,0
Ccc_XD0_t1_XD3_XDFFM_CKBB XD0_t1 XD3_XDFFM_CKBB 1.8151e-17
* device instance cc_XD0_t1_XD3_XDFFM_CLKB r0 *1 0,0
Ccc_XD0_t1_XD3_XDFFM_CLKB XD0_t1 XD3_XDFFM_CLKB 2.4201e-17
* device instance cc_XD0_t1_XD3_XDFFM_M r0 *1 0,0
Ccc_XD0_t1_XD3_XDFFM_M XD0_t1 XD3_XDFFM_M 2.4201e-17
* device instance cc_XD0_t1_XD3_XDFFM_MB r0 *1 0,0
Ccc_XD0_t1_XD3_XDFFM_MB XD0_t1 XD3_XDFFM_MB 1.21e-17
* device instance cc_XD0_t1_XD3_XDFFM_MFB r0 *1 0,0
Ccc_XD0_t1_XD3_XDFFM_MFB XD0_t1 XD3_XDFFM_MFB 1.21e-17
* device instance cc_XD0_t1_XD3_XDFFM_S r0 *1 0,0
Ccc_XD0_t1_XD3_XDFFM_S XD0_t1 XD3_XDFFM_S 1.8151e-17
* device instance cc_XD0_t1_XD3_XDFFM_SB r0 *1 0,0
Ccc_XD0_t1_XD3_XDFFM_SB XD0_t1 XD3_XDFFM_SB 1.8151e-17
* device instance cc_XD0_t1_XD3_XDFFM_SFB r0 *1 0,0
Ccc_XD0_t1_XD3_XDFFM_SFB XD0_t1 XD3_XDFFM_SFB 1.21e-17
* device instance cc_XD0_t1_XD3_XDFFQ_CKBB r0 *1 0,0
Ccc_XD0_t1_XD3_XDFFQ_CKBB XD0_t1 XD3_XDFFQ_CKBB 1.8151e-17
* device instance cc_XD0_t1_XD3_XDFFQ_CLKB r0 *1 0,0
Ccc_XD0_t1_XD3_XDFFQ_CLKB XD0_t1 XD3_XDFFQ_CLKB 2.4201e-17
* device instance cc_XD0_t1_XD3_XDFFQ_M r0 *1 0,0
Ccc_XD0_t1_XD3_XDFFQ_M XD0_t1 XD3_XDFFQ_M 2.4201e-17
* device instance cc_XD0_t1_XD3_XDFFQ_MB r0 *1 0,0
Ccc_XD0_t1_XD3_XDFFQ_MB XD0_t1 XD3_XDFFQ_MB 1.21e-17
* device instance cc_XD0_t1_XD3_XDFFQ_MFB r0 *1 0,0
Ccc_XD0_t1_XD3_XDFFQ_MFB XD0_t1 XD3_XDFFQ_MFB 1.21e-17
* device instance cc_XD0_t1_XD3_XDFFQ_S r0 *1 0,0
Ccc_XD0_t1_XD3_XDFFQ_S XD0_t1 XD3_XDFFQ_S 1.8151e-17
* device instance cc_XD0_t1_XD3_XDFFQ_SB r0 *1 0,0
Ccc_XD0_t1_XD3_XDFFQ_SB XD0_t1 XD3_XDFFQ_SB 1.8151e-17
* device instance cc_XD0_t1_XD3_XDFFQ_SFB r0 *1 0,0
Ccc_XD0_t1_XD3_XDFFQ_SFB XD0_t1 XD3_XDFFQ_SFB 1.21e-17
* device instance cc_XD0_t1_XD3_XN2_mid1 r0 *1 0,0
Ccc_XD0_t1_XD3_XN2_mid1 XD0_t1 XD3_XN2_mid1 1.21e-17
* device instance cc_XD0_t1_XD3_XN3_mid1 r0 *1 0,0
Ccc_XD0_t1_XD3_XN3_mid1 XD0_t1 XD3_XN3_mid1 1.21e-17
* device instance cc_XD0_t1_XD3_XN3_mid2 r0 *1 0,0
Ccc_XD0_t1_XD3_XN3_mid2 XD0_t1 XD3_XN3_mid2 1.21e-17
* device instance cc_XD0_t1_XD3_dmodout r0 *1 0,0
Ccc_XD0_t1_XD3_dmodout XD0_t1 XD3_dmodout 1.21e-17
* device instance cc_XD0_t1_XD3_dq r0 *1 0,0
Ccc_XD0_t1_XD3_dq XD0_t1 XD3_dq 1.8151e-17
* device instance cc_XD0_t1_XD3_nm r0 *1 0,0
Ccc_XD0_t1_XD3_nm XD0_t1 XD3_nm 1.21e-17
* device instance cc_XD0_t1_XD3_nt r0 *1 0,0
Ccc_XD0_t1_XD3_nt XD0_t1 XD3_nt 1.21e-17
* device instance cc_XD0_t1_XD3_t1 r0 *1 0,0
Ccc_XD0_t1_XD3_t1 XD0_t1 XD3_t1 1.21e-17
* device instance cc_XD0_t1_XD4_XDFFM_CKBB r0 *1 0,0
Ccc_XD0_t1_XD4_XDFFM_CKBB XD0_t1 XD4_XDFFM_CKBB 1.8151e-17
* device instance cc_XD0_t1_XD4_XDFFM_CLKB r0 *1 0,0
Ccc_XD0_t1_XD4_XDFFM_CLKB XD0_t1 XD4_XDFFM_CLKB 2.4201e-17
* device instance cc_XD0_t1_XD4_XDFFM_M r0 *1 0,0
Ccc_XD0_t1_XD4_XDFFM_M XD0_t1 XD4_XDFFM_M 2.4201e-17
* device instance cc_XD0_t1_XD4_XDFFM_MB r0 *1 0,0
Ccc_XD0_t1_XD4_XDFFM_MB XD0_t1 XD4_XDFFM_MB 1.21e-17
* device instance cc_XD0_t1_XD4_XDFFM_MFB r0 *1 0,0
Ccc_XD0_t1_XD4_XDFFM_MFB XD0_t1 XD4_XDFFM_MFB 1.21e-17
* device instance cc_XD0_t1_XD4_XDFFM_S r0 *1 0,0
Ccc_XD0_t1_XD4_XDFFM_S XD0_t1 XD4_XDFFM_S 1.8151e-17
* device instance cc_XD0_t1_XD4_XDFFM_SB r0 *1 0,0
Ccc_XD0_t1_XD4_XDFFM_SB XD0_t1 XD4_XDFFM_SB 1.8151e-17
* device instance cc_XD0_t1_XD4_XDFFM_SFB r0 *1 0,0
Ccc_XD0_t1_XD4_XDFFM_SFB XD0_t1 XD4_XDFFM_SFB 1.21e-17
* device instance cc_XD0_t1_XD4_XDFFQ_CKBB r0 *1 0,0
Ccc_XD0_t1_XD4_XDFFQ_CKBB XD0_t1 XD4_XDFFQ_CKBB 1.8151e-17
* device instance cc_XD0_t1_XD4_XDFFQ_CLKB r0 *1 0,0
Ccc_XD0_t1_XD4_XDFFQ_CLKB XD0_t1 XD4_XDFFQ_CLKB 2.4201e-17
* device instance cc_XD0_t1_XD4_XDFFQ_M r0 *1 0,0
Ccc_XD0_t1_XD4_XDFFQ_M XD0_t1 XD4_XDFFQ_M 2.4201e-17
* device instance cc_XD0_t1_XD4_XDFFQ_MB r0 *1 0,0
Ccc_XD0_t1_XD4_XDFFQ_MB XD0_t1 XD4_XDFFQ_MB 1.21e-17
* device instance cc_XD0_t1_XD4_XDFFQ_MFB r0 *1 0,0
Ccc_XD0_t1_XD4_XDFFQ_MFB XD0_t1 XD4_XDFFQ_MFB 1.21e-17
* device instance cc_XD0_t1_XD4_XDFFQ_S r0 *1 0,0
Ccc_XD0_t1_XD4_XDFFQ_S XD0_t1 XD4_XDFFQ_S 1.8151e-17
* device instance cc_XD0_t1_XD4_XDFFQ_SB r0 *1 0,0
Ccc_XD0_t1_XD4_XDFFQ_SB XD0_t1 XD4_XDFFQ_SB 1.8151e-17
* device instance cc_XD0_t1_XD4_XDFFQ_SFB r0 *1 0,0
Ccc_XD0_t1_XD4_XDFFQ_SFB XD0_t1 XD4_XDFFQ_SFB 1.21e-17
* device instance cc_XD0_t1_XD4_XN2_mid1 r0 *1 0,0
Ccc_XD0_t1_XD4_XN2_mid1 XD0_t1 XD4_XN2_mid1 1.21e-17
* device instance cc_XD0_t1_XD4_XN3_mid1 r0 *1 0,0
Ccc_XD0_t1_XD4_XN3_mid1 XD0_t1 XD4_XN3_mid1 1.21e-17
* device instance cc_XD0_t1_XD4_XN3_mid2 r0 *1 0,0
Ccc_XD0_t1_XD4_XN3_mid2 XD0_t1 XD4_XN3_mid2 1.21e-17
* device instance cc_XD0_t1_XD4_dmodout r0 *1 0,0
Ccc_XD0_t1_XD4_dmodout XD0_t1 XD4_dmodout 1.21e-17
* device instance cc_XD0_t1_XD4_dq r0 *1 0,0
Ccc_XD0_t1_XD4_dq XD0_t1 XD4_dq 1.8151e-17
* device instance cc_XD0_t1_XD4_nm r0 *1 0,0
Ccc_XD0_t1_XD4_nm XD0_t1 XD4_nm 1.21e-17
* device instance cc_XD0_t1_XD4_nt r0 *1 0,0
Ccc_XD0_t1_XD4_nt XD0_t1 XD4_nt 1.21e-17
* device instance cc_XD0_t1_XD4_t1 r0 *1 0,0
Ccc_XD0_t1_XD4_t1 XD0_t1 XD4_t1 1.21e-17
* device instance cc_XD0_t1_XD5_XDFFM_CKBB r0 *1 0,0
Ccc_XD0_t1_XD5_XDFFM_CKBB XD0_t1 XD5_XDFFM_CKBB 1.8151e-17
* device instance cc_XD0_t1_XD5_XDFFM_CLKB r0 *1 0,0
Ccc_XD0_t1_XD5_XDFFM_CLKB XD0_t1 XD5_XDFFM_CLKB 2.4201e-17
* device instance cc_XD0_t1_XD5_XDFFM_M r0 *1 0,0
Ccc_XD0_t1_XD5_XDFFM_M XD0_t1 XD5_XDFFM_M 2.4201e-17
* device instance cc_XD0_t1_XD5_XDFFM_MB r0 *1 0,0
Ccc_XD0_t1_XD5_XDFFM_MB XD0_t1 XD5_XDFFM_MB 1.21e-17
* device instance cc_XD0_t1_XD5_XDFFM_MFB r0 *1 0,0
Ccc_XD0_t1_XD5_XDFFM_MFB XD0_t1 XD5_XDFFM_MFB 1.21e-17
* device instance cc_XD0_t1_XD5_XDFFM_S r0 *1 0,0
Ccc_XD0_t1_XD5_XDFFM_S XD0_t1 XD5_XDFFM_S 1.8151e-17
* device instance cc_XD0_t1_XD5_XDFFM_SB r0 *1 0,0
Ccc_XD0_t1_XD5_XDFFM_SB XD0_t1 XD5_XDFFM_SB 1.8151e-17
* device instance cc_XD0_t1_XD5_XDFFM_SFB r0 *1 0,0
Ccc_XD0_t1_XD5_XDFFM_SFB XD0_t1 XD5_XDFFM_SFB 1.21e-17
* device instance cc_XD0_t1_XD5_XDFFQ_CKBB r0 *1 0,0
Ccc_XD0_t1_XD5_XDFFQ_CKBB XD0_t1 XD5_XDFFQ_CKBB 1.8151e-17
* device instance cc_XD0_t1_XD5_XDFFQ_CLKB r0 *1 0,0
Ccc_XD0_t1_XD5_XDFFQ_CLKB XD0_t1 XD5_XDFFQ_CLKB 2.4201e-17
* device instance cc_XD0_t1_XD5_XDFFQ_M r0 *1 0,0
Ccc_XD0_t1_XD5_XDFFQ_M XD0_t1 XD5_XDFFQ_M 2.4201e-17
* device instance cc_XD0_t1_XD5_XDFFQ_MB r0 *1 0,0
Ccc_XD0_t1_XD5_XDFFQ_MB XD0_t1 XD5_XDFFQ_MB 1.21e-17
* device instance cc_XD0_t1_XD5_XDFFQ_MFB r0 *1 0,0
Ccc_XD0_t1_XD5_XDFFQ_MFB XD0_t1 XD5_XDFFQ_MFB 1.21e-17
* device instance cc_XD0_t1_XD5_XDFFQ_S r0 *1 0,0
Ccc_XD0_t1_XD5_XDFFQ_S XD0_t1 XD5_XDFFQ_S 1.8151e-17
* device instance cc_XD0_t1_XD5_XDFFQ_SB r0 *1 0,0
Ccc_XD0_t1_XD5_XDFFQ_SB XD0_t1 XD5_XDFFQ_SB 1.8151e-17
* device instance cc_XD0_t1_XD5_XDFFQ_SFB r0 *1 0,0
Ccc_XD0_t1_XD5_XDFFQ_SFB XD0_t1 XD5_XDFFQ_SFB 1.21e-17
* device instance cc_XD0_t1_XD5_XN2_mid1 r0 *1 0,0
Ccc_XD0_t1_XD5_XN2_mid1 XD0_t1 XD5_XN2_mid1 1.21e-17
* device instance cc_XD0_t1_XD5_XN3_mid1 r0 *1 0,0
Ccc_XD0_t1_XD5_XN3_mid1 XD0_t1 XD5_XN3_mid1 1.21e-17
* device instance cc_XD0_t1_XD5_XN3_mid2 r0 *1 0,0
Ccc_XD0_t1_XD5_XN3_mid2 XD0_t1 XD5_XN3_mid2 1.21e-17
* device instance cc_XD0_t1_XD5_dmodout r0 *1 0,0
Ccc_XD0_t1_XD5_dmodout XD0_t1 XD5_dmodout 1.21e-17
* device instance cc_XD0_t1_XD5_dq r0 *1 0,0
Ccc_XD0_t1_XD5_dq XD0_t1 XD5_dq 1.8151e-17
* device instance cc_XD0_t1_XD5_nm r0 *1 0,0
Ccc_XD0_t1_XD5_nm XD0_t1 XD5_nm 1.21e-17
* device instance cc_XD0_t1_XD5_nt r0 *1 0,0
Ccc_XD0_t1_XD5_nt XD0_t1 XD5_nt 1.21e-17
* device instance cc_XD0_t1_XD5_t1 r0 *1 0,0
Ccc_XD0_t1_XD5_t1 XD0_t1 XD5_t1 1.21e-17
* device instance cc_XD0_t1_XFRT_CKBB r0 *1 0,0
Ccc_XD0_t1_XFRT_CKBB XD0_t1 XFRT_CKBB 1.8151e-17
* device instance cc_XD0_t1_XFRT_CLKB r0 *1 0,0
Ccc_XD0_t1_XFRT_CLKB XD0_t1 XFRT_CLKB 2.4201e-17
* device instance cc_XD0_t1_XFRT_M r0 *1 0,0
Ccc_XD0_t1_XFRT_M XD0_t1 XFRT_M 2.4201e-17
* device instance cc_XD0_t1_XFRT_MB r0 *1 0,0
Ccc_XD0_t1_XFRT_MB XD0_t1 XFRT_MB 1.21e-17
* device instance cc_XD0_t1_XFRT_MFB r0 *1 0,0
Ccc_XD0_t1_XFRT_MFB XD0_t1 XFRT_MFB 1.21e-17
* device instance cc_XD0_t1_XFRT_S r0 *1 0,0
Ccc_XD0_t1_XFRT_S XD0_t1 XFRT_S 1.8151e-17
* device instance cc_XD0_t1_XFRT_SB r0 *1 0,0
Ccc_XD0_t1_XFRT_SB XD0_t1 XFRT_SB 1.8151e-17
* device instance cc_XD0_t1_XFRT_SFB r0 *1 0,0
Ccc_XD0_t1_XFRT_SFB XD0_t1 XFRT_SFB 1.21e-17
* device instance cc_XD0_t1_ck1 r0 *1 0,0
Ccc_XD0_t1_ck1 XD0_t1 ck1 3.6302e-17
* device instance cc_XD0_t1_ck2 r0 *1 0,0
Ccc_XD0_t1_ck2 XD0_t1 ck2 3.0251e-17
* device instance cc_XD0_t1_ck3 r0 *1 0,0
Ccc_XD0_t1_ck3 XD0_t1 ck3 3.0251e-17
* device instance cc_XD0_t1_ck4 r0 *1 0,0
Ccc_XD0_t1_ck4 XD0_t1 ck4 3.0251e-17
* device instance cc_XD0_t1_ck5 r0 *1 0,0
Ccc_XD0_t1_ck5 XD0_t1 ck5 3.0251e-17
* device instance cc_XD0_t1_mod0 r0 *1 0,0
Ccc_XD0_t1_mod0 XD0_t1 mod0 2.4201e-17
* device instance cc_XD0_t1_mod1 r0 *1 0,0
Ccc_XD0_t1_mod1 XD0_t1 mod1 2.4201e-17
* device instance cc_XD0_t1_mod2 r0 *1 0,0
Ccc_XD0_t1_mod2 XD0_t1 mod2 2.4201e-17
* device instance cc_XD0_t1_mod3 r0 *1 0,0
Ccc_XD0_t1_mod3 XD0_t1 mod3 2.4201e-17
* device instance cc_XD0_t1_mod4 r0 *1 0,0
Ccc_XD0_t1_mod4 XD0_t1 mod4 2.4201e-17
* device instance cc_XD0_t1_net1 r0 *1 0,0
Ccc_XD0_t1_net1 XD0_t1 net1 1.21e-17
* device instance cc_XD1_XDFFM_CKBB_XD1_XDFFM_CLKB r0 *1 0,0
Ccc_XD1_XDFFM_CKBB_XD1_XDFFM_CLKB XD1_XDFFM_CKBB XD1_XDFFM_CLKB 3.6302e-17
* device instance cc_XD1_XDFFM_CKBB_XD1_XDFFM_M r0 *1 0,0
Ccc_XD1_XDFFM_CKBB_XD1_XDFFM_M XD1_XDFFM_CKBB XD1_XDFFM_M 4.8402e-17
* device instance cc_XD1_XDFFM_CKBB_XD1_XDFFM_MB r0 *1 0,0
Ccc_XD1_XDFFM_CKBB_XD1_XDFFM_MB XD1_XDFFM_CKBB XD1_XDFFM_MB 2.4201e-17
* device instance cc_XD1_XDFFM_CKBB_XD1_XDFFM_MFB r0 *1 0,0
Ccc_XD1_XDFFM_CKBB_XD1_XDFFM_MFB XD1_XDFFM_CKBB XD1_XDFFM_MFB 2.4201e-17
* device instance cc_XD1_XDFFM_CKBB_XD1_XDFFM_S r0 *1 0,0
Ccc_XD1_XDFFM_CKBB_XD1_XDFFM_S XD1_XDFFM_CKBB XD1_XDFFM_S 3.0251e-17
* device instance cc_XD1_XDFFM_CKBB_XD1_XDFFM_SB r0 *1 0,0
Ccc_XD1_XDFFM_CKBB_XD1_XDFFM_SB XD1_XDFFM_CKBB XD1_XDFFM_SB 3.0251e-17
* device instance cc_XD1_XDFFM_CKBB_XD1_XDFFM_SFB r0 *1 0,0
Ccc_XD1_XDFFM_CKBB_XD1_XDFFM_SFB XD1_XDFFM_CKBB XD1_XDFFM_SFB 1.8151e-17
* device instance cc_XD1_XDFFM_CKBB_XD1_XDFFQ_CKBB r0 *1 0,0
Ccc_XD1_XDFFM_CKBB_XD1_XDFFQ_CKBB XD1_XDFFM_CKBB XD1_XDFFQ_CKBB 1.8151e-17
* device instance cc_XD1_XDFFM_CKBB_XD1_XDFFQ_CLKB r0 *1 0,0
Ccc_XD1_XDFFM_CKBB_XD1_XDFFQ_CLKB XD1_XDFFM_CKBB XD1_XDFFQ_CLKB 2.4201e-17
* device instance cc_XD1_XDFFM_CKBB_XD1_XDFFQ_M r0 *1 0,0
Ccc_XD1_XDFFM_CKBB_XD1_XDFFQ_M XD1_XDFFM_CKBB XD1_XDFFQ_M 2.4201e-17
* device instance cc_XD1_XDFFM_CKBB_XD1_XDFFQ_MB r0 *1 0,0
Ccc_XD1_XDFFM_CKBB_XD1_XDFFQ_MB XD1_XDFFM_CKBB XD1_XDFFQ_MB 1.21e-17
* device instance cc_XD1_XDFFM_CKBB_XD1_XDFFQ_MFB r0 *1 0,0
Ccc_XD1_XDFFM_CKBB_XD1_XDFFQ_MFB XD1_XDFFM_CKBB XD1_XDFFQ_MFB 1.21e-17
* device instance cc_XD1_XDFFM_CKBB_XD1_XDFFQ_S r0 *1 0,0
Ccc_XD1_XDFFM_CKBB_XD1_XDFFQ_S XD1_XDFFM_CKBB XD1_XDFFQ_S 1.8151e-17
* device instance cc_XD1_XDFFM_CKBB_XD1_XDFFQ_SB r0 *1 0,0
Ccc_XD1_XDFFM_CKBB_XD1_XDFFQ_SB XD1_XDFFM_CKBB XD1_XDFFQ_SB 1.8151e-17
* device instance cc_XD1_XDFFM_CKBB_XD1_XDFFQ_SFB r0 *1 0,0
Ccc_XD1_XDFFM_CKBB_XD1_XDFFQ_SFB XD1_XDFFM_CKBB XD1_XDFFQ_SFB 1.21e-17
* device instance cc_XD1_XDFFM_CKBB_XD1_XNOR_midp r0 *1 0,0
Ccc_XD1_XDFFM_CKBB_XD1_XNOR_midp XD1_XDFFM_CKBB XD1_XNOR_midp 1.21e-17
* device instance cc_XD1_XDFFM_CKBB_XD1_dmodout r0 *1 0,0
Ccc_XD1_XDFFM_CKBB_XD1_dmodout XD1_XDFFM_CKBB XD1_dmodout 1.8151e-17
* device instance cc_XD1_XDFFM_CKBB_XD1_dq r0 *1 0,0
Ccc_XD1_XDFFM_CKBB_XD1_dq XD1_XDFFM_CKBB XD1_dq 1.21e-17
* device instance cc_XD1_XDFFM_CKBB_XD1_nm r0 *1 0,0
Ccc_XD1_XDFFM_CKBB_XD1_nm XD1_XDFFM_CKBB XD1_nm 1.8151e-17
* device instance cc_XD1_XDFFM_CKBB_XD1_nt r0 *1 0,0
Ccc_XD1_XDFFM_CKBB_XD1_nt XD1_XDFFM_CKBB XD1_nt 2.4201e-17
* device instance cc_XD1_XDFFM_CKBB_XD1_t1 r0 *1 0,0
Ccc_XD1_XDFFM_CKBB_XD1_t1 XD1_XDFFM_CKBB XD1_t1 1.21e-17
* device instance cc_XD1_XDFFM_CKBB_XD2_XDFFM_CKBB r0 *1 0,0
Ccc_XD1_XDFFM_CKBB_XD2_XDFFM_CKBB XD1_XDFFM_CKBB XD2_XDFFM_CKBB 1.8151e-17
* device instance cc_XD1_XDFFM_CKBB_XD2_XDFFM_CLKB r0 *1 0,0
Ccc_XD1_XDFFM_CKBB_XD2_XDFFM_CLKB XD1_XDFFM_CKBB XD2_XDFFM_CLKB 2.4201e-17
* device instance cc_XD1_XDFFM_CKBB_XD2_XDFFM_M r0 *1 0,0
Ccc_XD1_XDFFM_CKBB_XD2_XDFFM_M XD1_XDFFM_CKBB XD2_XDFFM_M 2.4201e-17
* device instance cc_XD1_XDFFM_CKBB_XD2_XDFFM_MB r0 *1 0,0
Ccc_XD1_XDFFM_CKBB_XD2_XDFFM_MB XD1_XDFFM_CKBB XD2_XDFFM_MB 1.21e-17
* device instance cc_XD1_XDFFM_CKBB_XD2_XDFFM_MFB r0 *1 0,0
Ccc_XD1_XDFFM_CKBB_XD2_XDFFM_MFB XD1_XDFFM_CKBB XD2_XDFFM_MFB 1.21e-17
* device instance cc_XD1_XDFFM_CKBB_XD2_XDFFM_S r0 *1 0,0
Ccc_XD1_XDFFM_CKBB_XD2_XDFFM_S XD1_XDFFM_CKBB XD2_XDFFM_S 1.8151e-17
* device instance cc_XD1_XDFFM_CKBB_XD2_XDFFM_SB r0 *1 0,0
Ccc_XD1_XDFFM_CKBB_XD2_XDFFM_SB XD1_XDFFM_CKBB XD2_XDFFM_SB 1.8151e-17
* device instance cc_XD1_XDFFM_CKBB_XD2_XDFFM_SFB r0 *1 0,0
Ccc_XD1_XDFFM_CKBB_XD2_XDFFM_SFB XD1_XDFFM_CKBB XD2_XDFFM_SFB 1.21e-17
* device instance cc_XD1_XDFFM_CKBB_XD2_XDFFQ_CKBB r0 *1 0,0
Ccc_XD1_XDFFM_CKBB_XD2_XDFFQ_CKBB XD1_XDFFM_CKBB XD2_XDFFQ_CKBB 1.8151e-17
* device instance cc_XD1_XDFFM_CKBB_XD2_XDFFQ_CLKB r0 *1 0,0
Ccc_XD1_XDFFM_CKBB_XD2_XDFFQ_CLKB XD1_XDFFM_CKBB XD2_XDFFQ_CLKB 2.4201e-17
* device instance cc_XD1_XDFFM_CKBB_XD2_XDFFQ_M r0 *1 0,0
Ccc_XD1_XDFFM_CKBB_XD2_XDFFQ_M XD1_XDFFM_CKBB XD2_XDFFQ_M 2.4201e-17
* device instance cc_XD1_XDFFM_CKBB_XD2_XDFFQ_MB r0 *1 0,0
Ccc_XD1_XDFFM_CKBB_XD2_XDFFQ_MB XD1_XDFFM_CKBB XD2_XDFFQ_MB 1.21e-17
* device instance cc_XD1_XDFFM_CKBB_XD2_XDFFQ_MFB r0 *1 0,0
Ccc_XD1_XDFFM_CKBB_XD2_XDFFQ_MFB XD1_XDFFM_CKBB XD2_XDFFQ_MFB 1.21e-17
* device instance cc_XD1_XDFFM_CKBB_XD2_XDFFQ_S r0 *1 0,0
Ccc_XD1_XDFFM_CKBB_XD2_XDFFQ_S XD1_XDFFM_CKBB XD2_XDFFQ_S 1.8151e-17
* device instance cc_XD1_XDFFM_CKBB_XD2_XDFFQ_SB r0 *1 0,0
Ccc_XD1_XDFFM_CKBB_XD2_XDFFQ_SB XD1_XDFFM_CKBB XD2_XDFFQ_SB 1.8151e-17
* device instance cc_XD1_XDFFM_CKBB_XD2_XDFFQ_SFB r0 *1 0,0
Ccc_XD1_XDFFM_CKBB_XD2_XDFFQ_SFB XD1_XDFFM_CKBB XD2_XDFFQ_SFB 1.21e-17
* device instance cc_XD1_XDFFM_CKBB_XD2_XN2_mid1 r0 *1 0,0
Ccc_XD1_XDFFM_CKBB_XD2_XN2_mid1 XD1_XDFFM_CKBB XD2_XN2_mid1 1.21e-17
* device instance cc_XD1_XDFFM_CKBB_XD2_XN3_mid1 r0 *1 0,0
Ccc_XD1_XDFFM_CKBB_XD2_XN3_mid1 XD1_XDFFM_CKBB XD2_XN3_mid1 1.21e-17
* device instance cc_XD1_XDFFM_CKBB_XD2_XN3_mid2 r0 *1 0,0
Ccc_XD1_XDFFM_CKBB_XD2_XN3_mid2 XD1_XDFFM_CKBB XD2_XN3_mid2 1.21e-17
* device instance cc_XD1_XDFFM_CKBB_XD2_dmodout r0 *1 0,0
Ccc_XD1_XDFFM_CKBB_XD2_dmodout XD1_XDFFM_CKBB XD2_dmodout 1.21e-17
* device instance cc_XD1_XDFFM_CKBB_XD2_dq r0 *1 0,0
Ccc_XD1_XDFFM_CKBB_XD2_dq XD1_XDFFM_CKBB XD2_dq 1.8151e-17
* device instance cc_XD1_XDFFM_CKBB_XD2_nm r0 *1 0,0
Ccc_XD1_XDFFM_CKBB_XD2_nm XD1_XDFFM_CKBB XD2_nm 1.21e-17
* device instance cc_XD1_XDFFM_CKBB_XD2_nt r0 *1 0,0
Ccc_XD1_XDFFM_CKBB_XD2_nt XD1_XDFFM_CKBB XD2_nt 1.21e-17
* device instance cc_XD1_XDFFM_CKBB_XD2_t1 r0 *1 0,0
Ccc_XD1_XDFFM_CKBB_XD2_t1 XD1_XDFFM_CKBB XD2_t1 1.21e-17
* device instance cc_XD1_XDFFM_CKBB_XD3_XDFFM_CKBB r0 *1 0,0
Ccc_XD1_XDFFM_CKBB_XD3_XDFFM_CKBB XD1_XDFFM_CKBB XD3_XDFFM_CKBB 1.8151e-17
* device instance cc_XD1_XDFFM_CKBB_XD3_XDFFM_CLKB r0 *1 0,0
Ccc_XD1_XDFFM_CKBB_XD3_XDFFM_CLKB XD1_XDFFM_CKBB XD3_XDFFM_CLKB 2.4201e-17
* device instance cc_XD1_XDFFM_CKBB_XD3_XDFFM_M r0 *1 0,0
Ccc_XD1_XDFFM_CKBB_XD3_XDFFM_M XD1_XDFFM_CKBB XD3_XDFFM_M 2.4201e-17
* device instance cc_XD1_XDFFM_CKBB_XD3_XDFFM_MB r0 *1 0,0
Ccc_XD1_XDFFM_CKBB_XD3_XDFFM_MB XD1_XDFFM_CKBB XD3_XDFFM_MB 1.21e-17
* device instance cc_XD1_XDFFM_CKBB_XD3_XDFFM_MFB r0 *1 0,0
Ccc_XD1_XDFFM_CKBB_XD3_XDFFM_MFB XD1_XDFFM_CKBB XD3_XDFFM_MFB 1.21e-17
* device instance cc_XD1_XDFFM_CKBB_XD3_XDFFM_S r0 *1 0,0
Ccc_XD1_XDFFM_CKBB_XD3_XDFFM_S XD1_XDFFM_CKBB XD3_XDFFM_S 1.8151e-17
* device instance cc_XD1_XDFFM_CKBB_XD3_XDFFM_SB r0 *1 0,0
Ccc_XD1_XDFFM_CKBB_XD3_XDFFM_SB XD1_XDFFM_CKBB XD3_XDFFM_SB 1.8151e-17
* device instance cc_XD1_XDFFM_CKBB_XD3_XDFFM_SFB r0 *1 0,0
Ccc_XD1_XDFFM_CKBB_XD3_XDFFM_SFB XD1_XDFFM_CKBB XD3_XDFFM_SFB 1.21e-17
* device instance cc_XD1_XDFFM_CKBB_XD3_XDFFQ_CKBB r0 *1 0,0
Ccc_XD1_XDFFM_CKBB_XD3_XDFFQ_CKBB XD1_XDFFM_CKBB XD3_XDFFQ_CKBB 1.8151e-17
* device instance cc_XD1_XDFFM_CKBB_XD3_XDFFQ_CLKB r0 *1 0,0
Ccc_XD1_XDFFM_CKBB_XD3_XDFFQ_CLKB XD1_XDFFM_CKBB XD3_XDFFQ_CLKB 2.4201e-17
* device instance cc_XD1_XDFFM_CKBB_XD3_XDFFQ_M r0 *1 0,0
Ccc_XD1_XDFFM_CKBB_XD3_XDFFQ_M XD1_XDFFM_CKBB XD3_XDFFQ_M 2.4201e-17
* device instance cc_XD1_XDFFM_CKBB_XD3_XDFFQ_MB r0 *1 0,0
Ccc_XD1_XDFFM_CKBB_XD3_XDFFQ_MB XD1_XDFFM_CKBB XD3_XDFFQ_MB 1.21e-17
* device instance cc_XD1_XDFFM_CKBB_XD3_XDFFQ_MFB r0 *1 0,0
Ccc_XD1_XDFFM_CKBB_XD3_XDFFQ_MFB XD1_XDFFM_CKBB XD3_XDFFQ_MFB 1.21e-17
* device instance cc_XD1_XDFFM_CKBB_XD3_XDFFQ_S r0 *1 0,0
Ccc_XD1_XDFFM_CKBB_XD3_XDFFQ_S XD1_XDFFM_CKBB XD3_XDFFQ_S 1.8151e-17
* device instance cc_XD1_XDFFM_CKBB_XD3_XDFFQ_SB r0 *1 0,0
Ccc_XD1_XDFFM_CKBB_XD3_XDFFQ_SB XD1_XDFFM_CKBB XD3_XDFFQ_SB 1.8151e-17
* device instance cc_XD1_XDFFM_CKBB_XD3_XDFFQ_SFB r0 *1 0,0
Ccc_XD1_XDFFM_CKBB_XD3_XDFFQ_SFB XD1_XDFFM_CKBB XD3_XDFFQ_SFB 1.21e-17
* device instance cc_XD1_XDFFM_CKBB_XD3_XN2_mid1 r0 *1 0,0
Ccc_XD1_XDFFM_CKBB_XD3_XN2_mid1 XD1_XDFFM_CKBB XD3_XN2_mid1 1.21e-17
* device instance cc_XD1_XDFFM_CKBB_XD3_XN3_mid1 r0 *1 0,0
Ccc_XD1_XDFFM_CKBB_XD3_XN3_mid1 XD1_XDFFM_CKBB XD3_XN3_mid1 1.21e-17
* device instance cc_XD1_XDFFM_CKBB_XD3_XN3_mid2 r0 *1 0,0
Ccc_XD1_XDFFM_CKBB_XD3_XN3_mid2 XD1_XDFFM_CKBB XD3_XN3_mid2 1.21e-17
* device instance cc_XD1_XDFFM_CKBB_XD3_dmodout r0 *1 0,0
Ccc_XD1_XDFFM_CKBB_XD3_dmodout XD1_XDFFM_CKBB XD3_dmodout 1.21e-17
* device instance cc_XD1_XDFFM_CKBB_XD3_dq r0 *1 0,0
Ccc_XD1_XDFFM_CKBB_XD3_dq XD1_XDFFM_CKBB XD3_dq 1.8151e-17
* device instance cc_XD1_XDFFM_CKBB_XD3_nm r0 *1 0,0
Ccc_XD1_XDFFM_CKBB_XD3_nm XD1_XDFFM_CKBB XD3_nm 1.21e-17
* device instance cc_XD1_XDFFM_CKBB_XD3_nt r0 *1 0,0
Ccc_XD1_XDFFM_CKBB_XD3_nt XD1_XDFFM_CKBB XD3_nt 1.21e-17
* device instance cc_XD1_XDFFM_CKBB_XD3_t1 r0 *1 0,0
Ccc_XD1_XDFFM_CKBB_XD3_t1 XD1_XDFFM_CKBB XD3_t1 1.21e-17
* device instance cc_XD1_XDFFM_CKBB_XD4_XDFFM_CKBB r0 *1 0,0
Ccc_XD1_XDFFM_CKBB_XD4_XDFFM_CKBB XD1_XDFFM_CKBB XD4_XDFFM_CKBB 1.8151e-17
* device instance cc_XD1_XDFFM_CKBB_XD4_XDFFM_CLKB r0 *1 0,0
Ccc_XD1_XDFFM_CKBB_XD4_XDFFM_CLKB XD1_XDFFM_CKBB XD4_XDFFM_CLKB 2.4201e-17
* device instance cc_XD1_XDFFM_CKBB_XD4_XDFFM_M r0 *1 0,0
Ccc_XD1_XDFFM_CKBB_XD4_XDFFM_M XD1_XDFFM_CKBB XD4_XDFFM_M 2.4201e-17
* device instance cc_XD1_XDFFM_CKBB_XD4_XDFFM_MB r0 *1 0,0
Ccc_XD1_XDFFM_CKBB_XD4_XDFFM_MB XD1_XDFFM_CKBB XD4_XDFFM_MB 1.21e-17
* device instance cc_XD1_XDFFM_CKBB_XD4_XDFFM_MFB r0 *1 0,0
Ccc_XD1_XDFFM_CKBB_XD4_XDFFM_MFB XD1_XDFFM_CKBB XD4_XDFFM_MFB 1.21e-17
* device instance cc_XD1_XDFFM_CKBB_XD4_XDFFM_S r0 *1 0,0
Ccc_XD1_XDFFM_CKBB_XD4_XDFFM_S XD1_XDFFM_CKBB XD4_XDFFM_S 1.8151e-17
* device instance cc_XD1_XDFFM_CKBB_XD4_XDFFM_SB r0 *1 0,0
Ccc_XD1_XDFFM_CKBB_XD4_XDFFM_SB XD1_XDFFM_CKBB XD4_XDFFM_SB 1.8151e-17
* device instance cc_XD1_XDFFM_CKBB_XD4_XDFFM_SFB r0 *1 0,0
Ccc_XD1_XDFFM_CKBB_XD4_XDFFM_SFB XD1_XDFFM_CKBB XD4_XDFFM_SFB 1.21e-17
* device instance cc_XD1_XDFFM_CKBB_XD4_XDFFQ_CKBB r0 *1 0,0
Ccc_XD1_XDFFM_CKBB_XD4_XDFFQ_CKBB XD1_XDFFM_CKBB XD4_XDFFQ_CKBB 1.8151e-17
* device instance cc_XD1_XDFFM_CKBB_XD4_XDFFQ_CLKB r0 *1 0,0
Ccc_XD1_XDFFM_CKBB_XD4_XDFFQ_CLKB XD1_XDFFM_CKBB XD4_XDFFQ_CLKB 2.4201e-17
* device instance cc_XD1_XDFFM_CKBB_XD4_XDFFQ_M r0 *1 0,0
Ccc_XD1_XDFFM_CKBB_XD4_XDFFQ_M XD1_XDFFM_CKBB XD4_XDFFQ_M 2.4201e-17
* device instance cc_XD1_XDFFM_CKBB_XD4_XDFFQ_MB r0 *1 0,0
Ccc_XD1_XDFFM_CKBB_XD4_XDFFQ_MB XD1_XDFFM_CKBB XD4_XDFFQ_MB 1.21e-17
* device instance cc_XD1_XDFFM_CKBB_XD4_XDFFQ_MFB r0 *1 0,0
Ccc_XD1_XDFFM_CKBB_XD4_XDFFQ_MFB XD1_XDFFM_CKBB XD4_XDFFQ_MFB 1.21e-17
* device instance cc_XD1_XDFFM_CKBB_XD4_XDFFQ_S r0 *1 0,0
Ccc_XD1_XDFFM_CKBB_XD4_XDFFQ_S XD1_XDFFM_CKBB XD4_XDFFQ_S 1.8151e-17
* device instance cc_XD1_XDFFM_CKBB_XD4_XDFFQ_SB r0 *1 0,0
Ccc_XD1_XDFFM_CKBB_XD4_XDFFQ_SB XD1_XDFFM_CKBB XD4_XDFFQ_SB 1.8151e-17
* device instance cc_XD1_XDFFM_CKBB_XD4_XDFFQ_SFB r0 *1 0,0
Ccc_XD1_XDFFM_CKBB_XD4_XDFFQ_SFB XD1_XDFFM_CKBB XD4_XDFFQ_SFB 1.21e-17
* device instance cc_XD1_XDFFM_CKBB_XD4_XN2_mid1 r0 *1 0,0
Ccc_XD1_XDFFM_CKBB_XD4_XN2_mid1 XD1_XDFFM_CKBB XD4_XN2_mid1 1.21e-17
* device instance cc_XD1_XDFFM_CKBB_XD4_XN3_mid1 r0 *1 0,0
Ccc_XD1_XDFFM_CKBB_XD4_XN3_mid1 XD1_XDFFM_CKBB XD4_XN3_mid1 1.21e-17
* device instance cc_XD1_XDFFM_CKBB_XD4_XN3_mid2 r0 *1 0,0
Ccc_XD1_XDFFM_CKBB_XD4_XN3_mid2 XD1_XDFFM_CKBB XD4_XN3_mid2 1.21e-17
* device instance cc_XD1_XDFFM_CKBB_XD4_dmodout r0 *1 0,0
Ccc_XD1_XDFFM_CKBB_XD4_dmodout XD1_XDFFM_CKBB XD4_dmodout 1.21e-17
* device instance cc_XD1_XDFFM_CKBB_XD4_dq r0 *1 0,0
Ccc_XD1_XDFFM_CKBB_XD4_dq XD1_XDFFM_CKBB XD4_dq 1.8151e-17
* device instance cc_XD1_XDFFM_CKBB_XD4_nm r0 *1 0,0
Ccc_XD1_XDFFM_CKBB_XD4_nm XD1_XDFFM_CKBB XD4_nm 1.21e-17
* device instance cc_XD1_XDFFM_CKBB_XD4_nt r0 *1 0,0
Ccc_XD1_XDFFM_CKBB_XD4_nt XD1_XDFFM_CKBB XD4_nt 1.21e-17
* device instance cc_XD1_XDFFM_CKBB_XD4_t1 r0 *1 0,0
Ccc_XD1_XDFFM_CKBB_XD4_t1 XD1_XDFFM_CKBB XD4_t1 1.21e-17
* device instance cc_XD1_XDFFM_CKBB_XD5_XDFFM_CKBB r0 *1 0,0
Ccc_XD1_XDFFM_CKBB_XD5_XDFFM_CKBB XD1_XDFFM_CKBB XD5_XDFFM_CKBB 1.8151e-17
* device instance cc_XD1_XDFFM_CKBB_XD5_XDFFM_CLKB r0 *1 0,0
Ccc_XD1_XDFFM_CKBB_XD5_XDFFM_CLKB XD1_XDFFM_CKBB XD5_XDFFM_CLKB 2.4201e-17
* device instance cc_XD1_XDFFM_CKBB_XD5_XDFFM_M r0 *1 0,0
Ccc_XD1_XDFFM_CKBB_XD5_XDFFM_M XD1_XDFFM_CKBB XD5_XDFFM_M 2.4201e-17
* device instance cc_XD1_XDFFM_CKBB_XD5_XDFFM_MB r0 *1 0,0
Ccc_XD1_XDFFM_CKBB_XD5_XDFFM_MB XD1_XDFFM_CKBB XD5_XDFFM_MB 1.21e-17
* device instance cc_XD1_XDFFM_CKBB_XD5_XDFFM_MFB r0 *1 0,0
Ccc_XD1_XDFFM_CKBB_XD5_XDFFM_MFB XD1_XDFFM_CKBB XD5_XDFFM_MFB 1.21e-17
* device instance cc_XD1_XDFFM_CKBB_XD5_XDFFM_S r0 *1 0,0
Ccc_XD1_XDFFM_CKBB_XD5_XDFFM_S XD1_XDFFM_CKBB XD5_XDFFM_S 1.8151e-17
* device instance cc_XD1_XDFFM_CKBB_XD5_XDFFM_SB r0 *1 0,0
Ccc_XD1_XDFFM_CKBB_XD5_XDFFM_SB XD1_XDFFM_CKBB XD5_XDFFM_SB 1.8151e-17
* device instance cc_XD1_XDFFM_CKBB_XD5_XDFFM_SFB r0 *1 0,0
Ccc_XD1_XDFFM_CKBB_XD5_XDFFM_SFB XD1_XDFFM_CKBB XD5_XDFFM_SFB 1.21e-17
* device instance cc_XD1_XDFFM_CKBB_XD5_XDFFQ_CKBB r0 *1 0,0
Ccc_XD1_XDFFM_CKBB_XD5_XDFFQ_CKBB XD1_XDFFM_CKBB XD5_XDFFQ_CKBB 1.8151e-17
* device instance cc_XD1_XDFFM_CKBB_XD5_XDFFQ_CLKB r0 *1 0,0
Ccc_XD1_XDFFM_CKBB_XD5_XDFFQ_CLKB XD1_XDFFM_CKBB XD5_XDFFQ_CLKB 2.4201e-17
* device instance cc_XD1_XDFFM_CKBB_XD5_XDFFQ_M r0 *1 0,0
Ccc_XD1_XDFFM_CKBB_XD5_XDFFQ_M XD1_XDFFM_CKBB XD5_XDFFQ_M 2.4201e-17
* device instance cc_XD1_XDFFM_CKBB_XD5_XDFFQ_MB r0 *1 0,0
Ccc_XD1_XDFFM_CKBB_XD5_XDFFQ_MB XD1_XDFFM_CKBB XD5_XDFFQ_MB 1.21e-17
* device instance cc_XD1_XDFFM_CKBB_XD5_XDFFQ_MFB r0 *1 0,0
Ccc_XD1_XDFFM_CKBB_XD5_XDFFQ_MFB XD1_XDFFM_CKBB XD5_XDFFQ_MFB 1.21e-17
* device instance cc_XD1_XDFFM_CKBB_XD5_XDFFQ_S r0 *1 0,0
Ccc_XD1_XDFFM_CKBB_XD5_XDFFQ_S XD1_XDFFM_CKBB XD5_XDFFQ_S 1.8151e-17
* device instance cc_XD1_XDFFM_CKBB_XD5_XDFFQ_SB r0 *1 0,0
Ccc_XD1_XDFFM_CKBB_XD5_XDFFQ_SB XD1_XDFFM_CKBB XD5_XDFFQ_SB 1.8151e-17
* device instance cc_XD1_XDFFM_CKBB_XD5_XDFFQ_SFB r0 *1 0,0
Ccc_XD1_XDFFM_CKBB_XD5_XDFFQ_SFB XD1_XDFFM_CKBB XD5_XDFFQ_SFB 1.21e-17
* device instance cc_XD1_XDFFM_CKBB_XD5_XN2_mid1 r0 *1 0,0
Ccc_XD1_XDFFM_CKBB_XD5_XN2_mid1 XD1_XDFFM_CKBB XD5_XN2_mid1 1.21e-17
* device instance cc_XD1_XDFFM_CKBB_XD5_XN3_mid1 r0 *1 0,0
Ccc_XD1_XDFFM_CKBB_XD5_XN3_mid1 XD1_XDFFM_CKBB XD5_XN3_mid1 1.21e-17
* device instance cc_XD1_XDFFM_CKBB_XD5_XN3_mid2 r0 *1 0,0
Ccc_XD1_XDFFM_CKBB_XD5_XN3_mid2 XD1_XDFFM_CKBB XD5_XN3_mid2 1.21e-17
* device instance cc_XD1_XDFFM_CKBB_XD5_dmodout r0 *1 0,0
Ccc_XD1_XDFFM_CKBB_XD5_dmodout XD1_XDFFM_CKBB XD5_dmodout 1.21e-17
* device instance cc_XD1_XDFFM_CKBB_XD5_dq r0 *1 0,0
Ccc_XD1_XDFFM_CKBB_XD5_dq XD1_XDFFM_CKBB XD5_dq 1.8151e-17
* device instance cc_XD1_XDFFM_CKBB_XD5_nm r0 *1 0,0
Ccc_XD1_XDFFM_CKBB_XD5_nm XD1_XDFFM_CKBB XD5_nm 1.21e-17
* device instance cc_XD1_XDFFM_CKBB_XD5_nt r0 *1 0,0
Ccc_XD1_XDFFM_CKBB_XD5_nt XD1_XDFFM_CKBB XD5_nt 1.21e-17
* device instance cc_XD1_XDFFM_CKBB_XD5_t1 r0 *1 0,0
Ccc_XD1_XDFFM_CKBB_XD5_t1 XD1_XDFFM_CKBB XD5_t1 1.21e-17
* device instance cc_XD1_XDFFM_CKBB_XFRT_CKBB r0 *1 0,0
Ccc_XD1_XDFFM_CKBB_XFRT_CKBB XD1_XDFFM_CKBB XFRT_CKBB 1.8151e-17
* device instance cc_XD1_XDFFM_CKBB_XFRT_CLKB r0 *1 0,0
Ccc_XD1_XDFFM_CKBB_XFRT_CLKB XD1_XDFFM_CKBB XFRT_CLKB 2.4201e-17
* device instance cc_XD1_XDFFM_CKBB_XFRT_M r0 *1 0,0
Ccc_XD1_XDFFM_CKBB_XFRT_M XD1_XDFFM_CKBB XFRT_M 2.4201e-17
* device instance cc_XD1_XDFFM_CKBB_XFRT_MB r0 *1 0,0
Ccc_XD1_XDFFM_CKBB_XFRT_MB XD1_XDFFM_CKBB XFRT_MB 1.21e-17
* device instance cc_XD1_XDFFM_CKBB_XFRT_MFB r0 *1 0,0
Ccc_XD1_XDFFM_CKBB_XFRT_MFB XD1_XDFFM_CKBB XFRT_MFB 1.21e-17
* device instance cc_XD1_XDFFM_CKBB_XFRT_S r0 *1 0,0
Ccc_XD1_XDFFM_CKBB_XFRT_S XD1_XDFFM_CKBB XFRT_S 1.8151e-17
* device instance cc_XD1_XDFFM_CKBB_XFRT_SB r0 *1 0,0
Ccc_XD1_XDFFM_CKBB_XFRT_SB XD1_XDFFM_CKBB XFRT_SB 1.8151e-17
* device instance cc_XD1_XDFFM_CKBB_XFRT_SFB r0 *1 0,0
Ccc_XD1_XDFFM_CKBB_XFRT_SFB XD1_XDFFM_CKBB XFRT_SFB 1.21e-17
* device instance cc_XD1_XDFFM_CKBB_ck1 r0 *1 0,0
Ccc_XD1_XDFFM_CKBB_ck1 XD1_XDFFM_CKBB ck1 3.0251e-17
* device instance cc_XD1_XDFFM_CKBB_ck2 r0 *1 0,0
Ccc_XD1_XDFFM_CKBB_ck2 XD1_XDFFM_CKBB ck2 3.0251e-17
* device instance cc_XD1_XDFFM_CKBB_ck3 r0 *1 0,0
Ccc_XD1_XDFFM_CKBB_ck3 XD1_XDFFM_CKBB ck3 3.0251e-17
* device instance cc_XD1_XDFFM_CKBB_ck4 r0 *1 0,0
Ccc_XD1_XDFFM_CKBB_ck4 XD1_XDFFM_CKBB ck4 3.0251e-17
* device instance cc_XD1_XDFFM_CKBB_ck5 r0 *1 0,0
Ccc_XD1_XDFFM_CKBB_ck5 XD1_XDFFM_CKBB ck5 3.0251e-17
* device instance cc_XD1_XDFFM_CKBB_mod0 r0 *1 0,0
Ccc_XD1_XDFFM_CKBB_mod0 XD1_XDFFM_CKBB mod0 2.4201e-17
* device instance cc_XD1_XDFFM_CKBB_mod1 r0 *1 0,0
Ccc_XD1_XDFFM_CKBB_mod1 XD1_XDFFM_CKBB mod1 2.4201e-17
* device instance cc_XD1_XDFFM_CKBB_mod2 r0 *1 0,0
Ccc_XD1_XDFFM_CKBB_mod2 XD1_XDFFM_CKBB mod2 2.4201e-17
* device instance cc_XD1_XDFFM_CKBB_mod3 r0 *1 0,0
Ccc_XD1_XDFFM_CKBB_mod3 XD1_XDFFM_CKBB mod3 2.4201e-17
* device instance cc_XD1_XDFFM_CKBB_mod4 r0 *1 0,0
Ccc_XD1_XDFFM_CKBB_mod4 XD1_XDFFM_CKBB mod4 2.4201e-17
* device instance cc_XD1_XDFFM_CKBB_net1 r0 *1 0,0
Ccc_XD1_XDFFM_CKBB_net1 XD1_XDFFM_CKBB net1 1.21e-17
* device instance cc_XD1_XDFFM_CLKB_XD1_XDFFM_M r0 *1 0,0
Ccc_XD1_XDFFM_CLKB_XD1_XDFFM_M XD1_XDFFM_CLKB XD1_XDFFM_M 4.2352e-17
* device instance cc_XD1_XDFFM_CLKB_XD1_XDFFM_MB r0 *1 0,0
Ccc_XD1_XDFFM_CLKB_XD1_XDFFM_MB XD1_XDFFM_CLKB XD1_XDFFM_MB 2.4201e-17
* device instance cc_XD1_XDFFM_CLKB_XD1_XDFFM_MFB r0 *1 0,0
Ccc_XD1_XDFFM_CLKB_XD1_XDFFM_MFB XD1_XDFFM_CLKB XD1_XDFFM_MFB 2.4201e-17
* device instance cc_XD1_XDFFM_CLKB_XD1_XDFFM_S r0 *1 0,0
Ccc_XD1_XDFFM_CLKB_XD1_XDFFM_S XD1_XDFFM_CLKB XD1_XDFFM_S 1.8151e-17
* device instance cc_XD1_XDFFM_CLKB_XD1_XDFFM_SB r0 *1 0,0
Ccc_XD1_XDFFM_CLKB_XD1_XDFFM_SB XD1_XDFFM_CLKB XD1_XDFFM_SB 1.8151e-17
* device instance cc_XD1_XDFFM_CLKB_XD1_XDFFM_SFB r0 *1 0,0
Ccc_XD1_XDFFM_CLKB_XD1_XDFFM_SFB XD1_XDFFM_CLKB XD1_XDFFM_SFB 1.21e-17
* device instance cc_XD1_XDFFM_CLKB_XD1_XDFFQ_CKBB r0 *1 0,0
Ccc_XD1_XDFFM_CLKB_XD1_XDFFQ_CKBB XD1_XDFFM_CLKB XD1_XDFFQ_CKBB 1.8151e-17
* device instance cc_XD1_XDFFM_CLKB_XD1_XDFFQ_CLKB r0 *1 0,0
Ccc_XD1_XDFFM_CLKB_XD1_XDFFQ_CLKB XD1_XDFFM_CLKB XD1_XDFFQ_CLKB 2.4201e-17
* device instance cc_XD1_XDFFM_CLKB_XD1_XDFFQ_M r0 *1 0,0
Ccc_XD1_XDFFM_CLKB_XD1_XDFFQ_M XD1_XDFFM_CLKB XD1_XDFFQ_M 2.4201e-17
* device instance cc_XD1_XDFFM_CLKB_XD1_XDFFQ_MB r0 *1 0,0
Ccc_XD1_XDFFM_CLKB_XD1_XDFFQ_MB XD1_XDFFM_CLKB XD1_XDFFQ_MB 1.21e-17
* device instance cc_XD1_XDFFM_CLKB_XD1_XDFFQ_MFB r0 *1 0,0
Ccc_XD1_XDFFM_CLKB_XD1_XDFFQ_MFB XD1_XDFFM_CLKB XD1_XDFFQ_MFB 1.21e-17
* device instance cc_XD1_XDFFM_CLKB_XD1_XDFFQ_S r0 *1 0,0
Ccc_XD1_XDFFM_CLKB_XD1_XDFFQ_S XD1_XDFFM_CLKB XD1_XDFFQ_S 1.8151e-17
* device instance cc_XD1_XDFFM_CLKB_XD1_XDFFQ_SB r0 *1 0,0
Ccc_XD1_XDFFM_CLKB_XD1_XDFFQ_SB XD1_XDFFM_CLKB XD1_XDFFQ_SB 1.8151e-17
* device instance cc_XD1_XDFFM_CLKB_XD1_XDFFQ_SFB r0 *1 0,0
Ccc_XD1_XDFFM_CLKB_XD1_XDFFQ_SFB XD1_XDFFM_CLKB XD1_XDFFQ_SFB 1.21e-17
* device instance cc_XD1_XDFFM_CLKB_XD1_XNOR_midp r0 *1 0,0
Ccc_XD1_XDFFM_CLKB_XD1_XNOR_midp XD1_XDFFM_CLKB XD1_XNOR_midp 1.21e-17
* device instance cc_XD1_XDFFM_CLKB_XD1_dmodout r0 *1 0,0
Ccc_XD1_XDFFM_CLKB_XD1_dmodout XD1_XDFFM_CLKB XD1_dmodout 1.8151e-17
* device instance cc_XD1_XDFFM_CLKB_XD1_dq r0 *1 0,0
Ccc_XD1_XDFFM_CLKB_XD1_dq XD1_XDFFM_CLKB XD1_dq 1.21e-17
* device instance cc_XD1_XDFFM_CLKB_XD1_nm r0 *1 0,0
Ccc_XD1_XDFFM_CLKB_XD1_nm XD1_XDFFM_CLKB XD1_nm 1.8151e-17
* device instance cc_XD1_XDFFM_CLKB_XD1_nt r0 *1 0,0
Ccc_XD1_XDFFM_CLKB_XD1_nt XD1_XDFFM_CLKB XD1_nt 2.4201e-17
* device instance cc_XD1_XDFFM_CLKB_XD1_t1 r0 *1 0,0
Ccc_XD1_XDFFM_CLKB_XD1_t1 XD1_XDFFM_CLKB XD1_t1 1.21e-17
* device instance cc_XD1_XDFFM_CLKB_XD2_XDFFM_CKBB r0 *1 0,0
Ccc_XD1_XDFFM_CLKB_XD2_XDFFM_CKBB XD1_XDFFM_CLKB XD2_XDFFM_CKBB 1.8151e-17
* device instance cc_XD1_XDFFM_CLKB_XD2_XDFFM_CLKB r0 *1 0,0
Ccc_XD1_XDFFM_CLKB_XD2_XDFFM_CLKB XD1_XDFFM_CLKB XD2_XDFFM_CLKB 2.4201e-17
* device instance cc_XD1_XDFFM_CLKB_XD2_XDFFM_M r0 *1 0,0
Ccc_XD1_XDFFM_CLKB_XD2_XDFFM_M XD1_XDFFM_CLKB XD2_XDFFM_M 2.4201e-17
* device instance cc_XD1_XDFFM_CLKB_XD2_XDFFM_MB r0 *1 0,0
Ccc_XD1_XDFFM_CLKB_XD2_XDFFM_MB XD1_XDFFM_CLKB XD2_XDFFM_MB 1.21e-17
* device instance cc_XD1_XDFFM_CLKB_XD2_XDFFM_MFB r0 *1 0,0
Ccc_XD1_XDFFM_CLKB_XD2_XDFFM_MFB XD1_XDFFM_CLKB XD2_XDFFM_MFB 1.21e-17
* device instance cc_XD1_XDFFM_CLKB_XD2_XDFFM_S r0 *1 0,0
Ccc_XD1_XDFFM_CLKB_XD2_XDFFM_S XD1_XDFFM_CLKB XD2_XDFFM_S 1.8151e-17
* device instance cc_XD1_XDFFM_CLKB_XD2_XDFFM_SB r0 *1 0,0
Ccc_XD1_XDFFM_CLKB_XD2_XDFFM_SB XD1_XDFFM_CLKB XD2_XDFFM_SB 1.8151e-17
* device instance cc_XD1_XDFFM_CLKB_XD2_XDFFM_SFB r0 *1 0,0
Ccc_XD1_XDFFM_CLKB_XD2_XDFFM_SFB XD1_XDFFM_CLKB XD2_XDFFM_SFB 1.21e-17
* device instance cc_XD1_XDFFM_CLKB_XD2_XDFFQ_CKBB r0 *1 0,0
Ccc_XD1_XDFFM_CLKB_XD2_XDFFQ_CKBB XD1_XDFFM_CLKB XD2_XDFFQ_CKBB 1.8151e-17
* device instance cc_XD1_XDFFM_CLKB_XD2_XDFFQ_CLKB r0 *1 0,0
Ccc_XD1_XDFFM_CLKB_XD2_XDFFQ_CLKB XD1_XDFFM_CLKB XD2_XDFFQ_CLKB 2.4201e-17
* device instance cc_XD1_XDFFM_CLKB_XD2_XDFFQ_M r0 *1 0,0
Ccc_XD1_XDFFM_CLKB_XD2_XDFFQ_M XD1_XDFFM_CLKB XD2_XDFFQ_M 2.4201e-17
* device instance cc_XD1_XDFFM_CLKB_XD2_XDFFQ_MB r0 *1 0,0
Ccc_XD1_XDFFM_CLKB_XD2_XDFFQ_MB XD1_XDFFM_CLKB XD2_XDFFQ_MB 1.21e-17
* device instance cc_XD1_XDFFM_CLKB_XD2_XDFFQ_MFB r0 *1 0,0
Ccc_XD1_XDFFM_CLKB_XD2_XDFFQ_MFB XD1_XDFFM_CLKB XD2_XDFFQ_MFB 1.21e-17
* device instance cc_XD1_XDFFM_CLKB_XD2_XDFFQ_S r0 *1 0,0
Ccc_XD1_XDFFM_CLKB_XD2_XDFFQ_S XD1_XDFFM_CLKB XD2_XDFFQ_S 1.8151e-17
* device instance cc_XD1_XDFFM_CLKB_XD2_XDFFQ_SB r0 *1 0,0
Ccc_XD1_XDFFM_CLKB_XD2_XDFFQ_SB XD1_XDFFM_CLKB XD2_XDFFQ_SB 1.8151e-17
* device instance cc_XD1_XDFFM_CLKB_XD2_XDFFQ_SFB r0 *1 0,0
Ccc_XD1_XDFFM_CLKB_XD2_XDFFQ_SFB XD1_XDFFM_CLKB XD2_XDFFQ_SFB 1.21e-17
* device instance cc_XD1_XDFFM_CLKB_XD2_XN2_mid1 r0 *1 0,0
Ccc_XD1_XDFFM_CLKB_XD2_XN2_mid1 XD1_XDFFM_CLKB XD2_XN2_mid1 1.21e-17
* device instance cc_XD1_XDFFM_CLKB_XD2_XN3_mid1 r0 *1 0,0
Ccc_XD1_XDFFM_CLKB_XD2_XN3_mid1 XD1_XDFFM_CLKB XD2_XN3_mid1 1.21e-17
* device instance cc_XD1_XDFFM_CLKB_XD2_XN3_mid2 r0 *1 0,0
Ccc_XD1_XDFFM_CLKB_XD2_XN3_mid2 XD1_XDFFM_CLKB XD2_XN3_mid2 1.21e-17
* device instance cc_XD1_XDFFM_CLKB_XD2_dmodout r0 *1 0,0
Ccc_XD1_XDFFM_CLKB_XD2_dmodout XD1_XDFFM_CLKB XD2_dmodout 1.21e-17
* device instance cc_XD1_XDFFM_CLKB_XD2_dq r0 *1 0,0
Ccc_XD1_XDFFM_CLKB_XD2_dq XD1_XDFFM_CLKB XD2_dq 1.8151e-17
* device instance cc_XD1_XDFFM_CLKB_XD2_nm r0 *1 0,0
Ccc_XD1_XDFFM_CLKB_XD2_nm XD1_XDFFM_CLKB XD2_nm 1.21e-17
* device instance cc_XD1_XDFFM_CLKB_XD2_nt r0 *1 0,0
Ccc_XD1_XDFFM_CLKB_XD2_nt XD1_XDFFM_CLKB XD2_nt 1.21e-17
* device instance cc_XD1_XDFFM_CLKB_XD2_t1 r0 *1 0,0
Ccc_XD1_XDFFM_CLKB_XD2_t1 XD1_XDFFM_CLKB XD2_t1 1.21e-17
* device instance cc_XD1_XDFFM_CLKB_XD3_XDFFM_CKBB r0 *1 0,0
Ccc_XD1_XDFFM_CLKB_XD3_XDFFM_CKBB XD1_XDFFM_CLKB XD3_XDFFM_CKBB 1.8151e-17
* device instance cc_XD1_XDFFM_CLKB_XD3_XDFFM_CLKB r0 *1 0,0
Ccc_XD1_XDFFM_CLKB_XD3_XDFFM_CLKB XD1_XDFFM_CLKB XD3_XDFFM_CLKB 2.4201e-17
* device instance cc_XD1_XDFFM_CLKB_XD3_XDFFM_M r0 *1 0,0
Ccc_XD1_XDFFM_CLKB_XD3_XDFFM_M XD1_XDFFM_CLKB XD3_XDFFM_M 2.4201e-17
* device instance cc_XD1_XDFFM_CLKB_XD3_XDFFM_MB r0 *1 0,0
Ccc_XD1_XDFFM_CLKB_XD3_XDFFM_MB XD1_XDFFM_CLKB XD3_XDFFM_MB 1.21e-17
* device instance cc_XD1_XDFFM_CLKB_XD3_XDFFM_MFB r0 *1 0,0
Ccc_XD1_XDFFM_CLKB_XD3_XDFFM_MFB XD1_XDFFM_CLKB XD3_XDFFM_MFB 1.21e-17
* device instance cc_XD1_XDFFM_CLKB_XD3_XDFFM_S r0 *1 0,0
Ccc_XD1_XDFFM_CLKB_XD3_XDFFM_S XD1_XDFFM_CLKB XD3_XDFFM_S 1.8151e-17
* device instance cc_XD1_XDFFM_CLKB_XD3_XDFFM_SB r0 *1 0,0
Ccc_XD1_XDFFM_CLKB_XD3_XDFFM_SB XD1_XDFFM_CLKB XD3_XDFFM_SB 1.8151e-17
* device instance cc_XD1_XDFFM_CLKB_XD3_XDFFM_SFB r0 *1 0,0
Ccc_XD1_XDFFM_CLKB_XD3_XDFFM_SFB XD1_XDFFM_CLKB XD3_XDFFM_SFB 1.21e-17
* device instance cc_XD1_XDFFM_CLKB_XD3_XDFFQ_CKBB r0 *1 0,0
Ccc_XD1_XDFFM_CLKB_XD3_XDFFQ_CKBB XD1_XDFFM_CLKB XD3_XDFFQ_CKBB 1.8151e-17
* device instance cc_XD1_XDFFM_CLKB_XD3_XDFFQ_CLKB r0 *1 0,0
Ccc_XD1_XDFFM_CLKB_XD3_XDFFQ_CLKB XD1_XDFFM_CLKB XD3_XDFFQ_CLKB 2.4201e-17
* device instance cc_XD1_XDFFM_CLKB_XD3_XDFFQ_M r0 *1 0,0
Ccc_XD1_XDFFM_CLKB_XD3_XDFFQ_M XD1_XDFFM_CLKB XD3_XDFFQ_M 2.4201e-17
* device instance cc_XD1_XDFFM_CLKB_XD3_XDFFQ_MB r0 *1 0,0
Ccc_XD1_XDFFM_CLKB_XD3_XDFFQ_MB XD1_XDFFM_CLKB XD3_XDFFQ_MB 1.21e-17
* device instance cc_XD1_XDFFM_CLKB_XD3_XDFFQ_MFB r0 *1 0,0
Ccc_XD1_XDFFM_CLKB_XD3_XDFFQ_MFB XD1_XDFFM_CLKB XD3_XDFFQ_MFB 1.21e-17
* device instance cc_XD1_XDFFM_CLKB_XD3_XDFFQ_S r0 *1 0,0
Ccc_XD1_XDFFM_CLKB_XD3_XDFFQ_S XD1_XDFFM_CLKB XD3_XDFFQ_S 1.8151e-17
* device instance cc_XD1_XDFFM_CLKB_XD3_XDFFQ_SB r0 *1 0,0
Ccc_XD1_XDFFM_CLKB_XD3_XDFFQ_SB XD1_XDFFM_CLKB XD3_XDFFQ_SB 1.8151e-17
* device instance cc_XD1_XDFFM_CLKB_XD3_XDFFQ_SFB r0 *1 0,0
Ccc_XD1_XDFFM_CLKB_XD3_XDFFQ_SFB XD1_XDFFM_CLKB XD3_XDFFQ_SFB 1.21e-17
* device instance cc_XD1_XDFFM_CLKB_XD3_XN2_mid1 r0 *1 0,0
Ccc_XD1_XDFFM_CLKB_XD3_XN2_mid1 XD1_XDFFM_CLKB XD3_XN2_mid1 1.21e-17
* device instance cc_XD1_XDFFM_CLKB_XD3_XN3_mid1 r0 *1 0,0
Ccc_XD1_XDFFM_CLKB_XD3_XN3_mid1 XD1_XDFFM_CLKB XD3_XN3_mid1 1.21e-17
* device instance cc_XD1_XDFFM_CLKB_XD3_XN3_mid2 r0 *1 0,0
Ccc_XD1_XDFFM_CLKB_XD3_XN3_mid2 XD1_XDFFM_CLKB XD3_XN3_mid2 1.21e-17
* device instance cc_XD1_XDFFM_CLKB_XD3_dmodout r0 *1 0,0
Ccc_XD1_XDFFM_CLKB_XD3_dmodout XD1_XDFFM_CLKB XD3_dmodout 1.21e-17
* device instance cc_XD1_XDFFM_CLKB_XD3_dq r0 *1 0,0
Ccc_XD1_XDFFM_CLKB_XD3_dq XD1_XDFFM_CLKB XD3_dq 1.8151e-17
* device instance cc_XD1_XDFFM_CLKB_XD3_nm r0 *1 0,0
Ccc_XD1_XDFFM_CLKB_XD3_nm XD1_XDFFM_CLKB XD3_nm 1.21e-17
* device instance cc_XD1_XDFFM_CLKB_XD3_nt r0 *1 0,0
Ccc_XD1_XDFFM_CLKB_XD3_nt XD1_XDFFM_CLKB XD3_nt 1.21e-17
* device instance cc_XD1_XDFFM_CLKB_XD3_t1 r0 *1 0,0
Ccc_XD1_XDFFM_CLKB_XD3_t1 XD1_XDFFM_CLKB XD3_t1 1.21e-17
* device instance cc_XD1_XDFFM_CLKB_XD4_XDFFM_CKBB r0 *1 0,0
Ccc_XD1_XDFFM_CLKB_XD4_XDFFM_CKBB XD1_XDFFM_CLKB XD4_XDFFM_CKBB 1.8151e-17
* device instance cc_XD1_XDFFM_CLKB_XD4_XDFFM_CLKB r0 *1 0,0
Ccc_XD1_XDFFM_CLKB_XD4_XDFFM_CLKB XD1_XDFFM_CLKB XD4_XDFFM_CLKB 2.4201e-17
* device instance cc_XD1_XDFFM_CLKB_XD4_XDFFM_M r0 *1 0,0
Ccc_XD1_XDFFM_CLKB_XD4_XDFFM_M XD1_XDFFM_CLKB XD4_XDFFM_M 2.4201e-17
* device instance cc_XD1_XDFFM_CLKB_XD4_XDFFM_MB r0 *1 0,0
Ccc_XD1_XDFFM_CLKB_XD4_XDFFM_MB XD1_XDFFM_CLKB XD4_XDFFM_MB 1.21e-17
* device instance cc_XD1_XDFFM_CLKB_XD4_XDFFM_MFB r0 *1 0,0
Ccc_XD1_XDFFM_CLKB_XD4_XDFFM_MFB XD1_XDFFM_CLKB XD4_XDFFM_MFB 1.21e-17
* device instance cc_XD1_XDFFM_CLKB_XD4_XDFFM_S r0 *1 0,0
Ccc_XD1_XDFFM_CLKB_XD4_XDFFM_S XD1_XDFFM_CLKB XD4_XDFFM_S 1.8151e-17
* device instance cc_XD1_XDFFM_CLKB_XD4_XDFFM_SB r0 *1 0,0
Ccc_XD1_XDFFM_CLKB_XD4_XDFFM_SB XD1_XDFFM_CLKB XD4_XDFFM_SB 1.8151e-17
* device instance cc_XD1_XDFFM_CLKB_XD4_XDFFM_SFB r0 *1 0,0
Ccc_XD1_XDFFM_CLKB_XD4_XDFFM_SFB XD1_XDFFM_CLKB XD4_XDFFM_SFB 1.21e-17
* device instance cc_XD1_XDFFM_CLKB_XD4_XDFFQ_CKBB r0 *1 0,0
Ccc_XD1_XDFFM_CLKB_XD4_XDFFQ_CKBB XD1_XDFFM_CLKB XD4_XDFFQ_CKBB 1.8151e-17
* device instance cc_XD1_XDFFM_CLKB_XD4_XDFFQ_CLKB r0 *1 0,0
Ccc_XD1_XDFFM_CLKB_XD4_XDFFQ_CLKB XD1_XDFFM_CLKB XD4_XDFFQ_CLKB 2.4201e-17
* device instance cc_XD1_XDFFM_CLKB_XD4_XDFFQ_M r0 *1 0,0
Ccc_XD1_XDFFM_CLKB_XD4_XDFFQ_M XD1_XDFFM_CLKB XD4_XDFFQ_M 2.4201e-17
* device instance cc_XD1_XDFFM_CLKB_XD4_XDFFQ_MB r0 *1 0,0
Ccc_XD1_XDFFM_CLKB_XD4_XDFFQ_MB XD1_XDFFM_CLKB XD4_XDFFQ_MB 1.21e-17
* device instance cc_XD1_XDFFM_CLKB_XD4_XDFFQ_MFB r0 *1 0,0
Ccc_XD1_XDFFM_CLKB_XD4_XDFFQ_MFB XD1_XDFFM_CLKB XD4_XDFFQ_MFB 1.21e-17
* device instance cc_XD1_XDFFM_CLKB_XD4_XDFFQ_S r0 *1 0,0
Ccc_XD1_XDFFM_CLKB_XD4_XDFFQ_S XD1_XDFFM_CLKB XD4_XDFFQ_S 1.8151e-17
* device instance cc_XD1_XDFFM_CLKB_XD4_XDFFQ_SB r0 *1 0,0
Ccc_XD1_XDFFM_CLKB_XD4_XDFFQ_SB XD1_XDFFM_CLKB XD4_XDFFQ_SB 1.8151e-17
* device instance cc_XD1_XDFFM_CLKB_XD4_XDFFQ_SFB r0 *1 0,0
Ccc_XD1_XDFFM_CLKB_XD4_XDFFQ_SFB XD1_XDFFM_CLKB XD4_XDFFQ_SFB 1.21e-17
* device instance cc_XD1_XDFFM_CLKB_XD4_XN2_mid1 r0 *1 0,0
Ccc_XD1_XDFFM_CLKB_XD4_XN2_mid1 XD1_XDFFM_CLKB XD4_XN2_mid1 1.21e-17
* device instance cc_XD1_XDFFM_CLKB_XD4_XN3_mid1 r0 *1 0,0
Ccc_XD1_XDFFM_CLKB_XD4_XN3_mid1 XD1_XDFFM_CLKB XD4_XN3_mid1 1.21e-17
* device instance cc_XD1_XDFFM_CLKB_XD4_XN3_mid2 r0 *1 0,0
Ccc_XD1_XDFFM_CLKB_XD4_XN3_mid2 XD1_XDFFM_CLKB XD4_XN3_mid2 1.21e-17
* device instance cc_XD1_XDFFM_CLKB_XD4_dmodout r0 *1 0,0
Ccc_XD1_XDFFM_CLKB_XD4_dmodout XD1_XDFFM_CLKB XD4_dmodout 1.21e-17
* device instance cc_XD1_XDFFM_CLKB_XD4_dq r0 *1 0,0
Ccc_XD1_XDFFM_CLKB_XD4_dq XD1_XDFFM_CLKB XD4_dq 1.8151e-17
* device instance cc_XD1_XDFFM_CLKB_XD4_nm r0 *1 0,0
Ccc_XD1_XDFFM_CLKB_XD4_nm XD1_XDFFM_CLKB XD4_nm 1.21e-17
* device instance cc_XD1_XDFFM_CLKB_XD4_nt r0 *1 0,0
Ccc_XD1_XDFFM_CLKB_XD4_nt XD1_XDFFM_CLKB XD4_nt 1.21e-17
* device instance cc_XD1_XDFFM_CLKB_XD4_t1 r0 *1 0,0
Ccc_XD1_XDFFM_CLKB_XD4_t1 XD1_XDFFM_CLKB XD4_t1 1.21e-17
* device instance cc_XD1_XDFFM_CLKB_XD5_XDFFM_CKBB r0 *1 0,0
Ccc_XD1_XDFFM_CLKB_XD5_XDFFM_CKBB XD1_XDFFM_CLKB XD5_XDFFM_CKBB 1.8151e-17
* device instance cc_XD1_XDFFM_CLKB_XD5_XDFFM_CLKB r0 *1 0,0
Ccc_XD1_XDFFM_CLKB_XD5_XDFFM_CLKB XD1_XDFFM_CLKB XD5_XDFFM_CLKB 2.4201e-17
* device instance cc_XD1_XDFFM_CLKB_XD5_XDFFM_M r0 *1 0,0
Ccc_XD1_XDFFM_CLKB_XD5_XDFFM_M XD1_XDFFM_CLKB XD5_XDFFM_M 2.4201e-17
* device instance cc_XD1_XDFFM_CLKB_XD5_XDFFM_MB r0 *1 0,0
Ccc_XD1_XDFFM_CLKB_XD5_XDFFM_MB XD1_XDFFM_CLKB XD5_XDFFM_MB 1.21e-17
* device instance cc_XD1_XDFFM_CLKB_XD5_XDFFM_MFB r0 *1 0,0
Ccc_XD1_XDFFM_CLKB_XD5_XDFFM_MFB XD1_XDFFM_CLKB XD5_XDFFM_MFB 1.21e-17
* device instance cc_XD1_XDFFM_CLKB_XD5_XDFFM_S r0 *1 0,0
Ccc_XD1_XDFFM_CLKB_XD5_XDFFM_S XD1_XDFFM_CLKB XD5_XDFFM_S 1.8151e-17
* device instance cc_XD1_XDFFM_CLKB_XD5_XDFFM_SB r0 *1 0,0
Ccc_XD1_XDFFM_CLKB_XD5_XDFFM_SB XD1_XDFFM_CLKB XD5_XDFFM_SB 1.8151e-17
* device instance cc_XD1_XDFFM_CLKB_XD5_XDFFM_SFB r0 *1 0,0
Ccc_XD1_XDFFM_CLKB_XD5_XDFFM_SFB XD1_XDFFM_CLKB XD5_XDFFM_SFB 1.21e-17
* device instance cc_XD1_XDFFM_CLKB_XD5_XDFFQ_CKBB r0 *1 0,0
Ccc_XD1_XDFFM_CLKB_XD5_XDFFQ_CKBB XD1_XDFFM_CLKB XD5_XDFFQ_CKBB 1.8151e-17
* device instance cc_XD1_XDFFM_CLKB_XD5_XDFFQ_CLKB r0 *1 0,0
Ccc_XD1_XDFFM_CLKB_XD5_XDFFQ_CLKB XD1_XDFFM_CLKB XD5_XDFFQ_CLKB 2.4201e-17
* device instance cc_XD1_XDFFM_CLKB_XD5_XDFFQ_M r0 *1 0,0
Ccc_XD1_XDFFM_CLKB_XD5_XDFFQ_M XD1_XDFFM_CLKB XD5_XDFFQ_M 2.4201e-17
* device instance cc_XD1_XDFFM_CLKB_XD5_XDFFQ_MB r0 *1 0,0
Ccc_XD1_XDFFM_CLKB_XD5_XDFFQ_MB XD1_XDFFM_CLKB XD5_XDFFQ_MB 1.21e-17
* device instance cc_XD1_XDFFM_CLKB_XD5_XDFFQ_MFB r0 *1 0,0
Ccc_XD1_XDFFM_CLKB_XD5_XDFFQ_MFB XD1_XDFFM_CLKB XD5_XDFFQ_MFB 1.21e-17
* device instance cc_XD1_XDFFM_CLKB_XD5_XDFFQ_S r0 *1 0,0
Ccc_XD1_XDFFM_CLKB_XD5_XDFFQ_S XD1_XDFFM_CLKB XD5_XDFFQ_S 1.8151e-17
* device instance cc_XD1_XDFFM_CLKB_XD5_XDFFQ_SB r0 *1 0,0
Ccc_XD1_XDFFM_CLKB_XD5_XDFFQ_SB XD1_XDFFM_CLKB XD5_XDFFQ_SB 1.8151e-17
* device instance cc_XD1_XDFFM_CLKB_XD5_XDFFQ_SFB r0 *1 0,0
Ccc_XD1_XDFFM_CLKB_XD5_XDFFQ_SFB XD1_XDFFM_CLKB XD5_XDFFQ_SFB 1.21e-17
* device instance cc_XD1_XDFFM_CLKB_XD5_XN2_mid1 r0 *1 0,0
Ccc_XD1_XDFFM_CLKB_XD5_XN2_mid1 XD1_XDFFM_CLKB XD5_XN2_mid1 1.21e-17
* device instance cc_XD1_XDFFM_CLKB_XD5_XN3_mid1 r0 *1 0,0
Ccc_XD1_XDFFM_CLKB_XD5_XN3_mid1 XD1_XDFFM_CLKB XD5_XN3_mid1 1.21e-17
* device instance cc_XD1_XDFFM_CLKB_XD5_XN3_mid2 r0 *1 0,0
Ccc_XD1_XDFFM_CLKB_XD5_XN3_mid2 XD1_XDFFM_CLKB XD5_XN3_mid2 1.21e-17
* device instance cc_XD1_XDFFM_CLKB_XD5_dmodout r0 *1 0,0
Ccc_XD1_XDFFM_CLKB_XD5_dmodout XD1_XDFFM_CLKB XD5_dmodout 1.21e-17
* device instance cc_XD1_XDFFM_CLKB_XD5_dq r0 *1 0,0
Ccc_XD1_XDFFM_CLKB_XD5_dq XD1_XDFFM_CLKB XD5_dq 1.8151e-17
* device instance cc_XD1_XDFFM_CLKB_XD5_nm r0 *1 0,0
Ccc_XD1_XDFFM_CLKB_XD5_nm XD1_XDFFM_CLKB XD5_nm 1.21e-17
* device instance cc_XD1_XDFFM_CLKB_XD5_nt r0 *1 0,0
Ccc_XD1_XDFFM_CLKB_XD5_nt XD1_XDFFM_CLKB XD5_nt 1.21e-17
* device instance cc_XD1_XDFFM_CLKB_XD5_t1 r0 *1 0,0
Ccc_XD1_XDFFM_CLKB_XD5_t1 XD1_XDFFM_CLKB XD5_t1 1.21e-17
* device instance cc_XD1_XDFFM_CLKB_XFRT_CKBB r0 *1 0,0
Ccc_XD1_XDFFM_CLKB_XFRT_CKBB XD1_XDFFM_CLKB XFRT_CKBB 1.8151e-17
* device instance cc_XD1_XDFFM_CLKB_XFRT_CLKB r0 *1 0,0
Ccc_XD1_XDFFM_CLKB_XFRT_CLKB XD1_XDFFM_CLKB XFRT_CLKB 2.4201e-17
* device instance cc_XD1_XDFFM_CLKB_XFRT_M r0 *1 0,0
Ccc_XD1_XDFFM_CLKB_XFRT_M XD1_XDFFM_CLKB XFRT_M 2.4201e-17
* device instance cc_XD1_XDFFM_CLKB_XFRT_MB r0 *1 0,0
Ccc_XD1_XDFFM_CLKB_XFRT_MB XD1_XDFFM_CLKB XFRT_MB 1.21e-17
* device instance cc_XD1_XDFFM_CLKB_XFRT_MFB r0 *1 0,0
Ccc_XD1_XDFFM_CLKB_XFRT_MFB XD1_XDFFM_CLKB XFRT_MFB 1.21e-17
* device instance cc_XD1_XDFFM_CLKB_XFRT_S r0 *1 0,0
Ccc_XD1_XDFFM_CLKB_XFRT_S XD1_XDFFM_CLKB XFRT_S 1.8151e-17
* device instance cc_XD1_XDFFM_CLKB_XFRT_SB r0 *1 0,0
Ccc_XD1_XDFFM_CLKB_XFRT_SB XD1_XDFFM_CLKB XFRT_SB 1.8151e-17
* device instance cc_XD1_XDFFM_CLKB_XFRT_SFB r0 *1 0,0
Ccc_XD1_XDFFM_CLKB_XFRT_SFB XD1_XDFFM_CLKB XFRT_SFB 1.21e-17
* device instance cc_XD1_XDFFM_CLKB_ck1 r0 *1 0,0
Ccc_XD1_XDFFM_CLKB_ck1 XD1_XDFFM_CLKB ck1 3.0251e-17
* device instance cc_XD1_XDFFM_CLKB_ck2 r0 *1 0,0
Ccc_XD1_XDFFM_CLKB_ck2 XD1_XDFFM_CLKB ck2 3.0251e-17
* device instance cc_XD1_XDFFM_CLKB_ck3 r0 *1 0,0
Ccc_XD1_XDFFM_CLKB_ck3 XD1_XDFFM_CLKB ck3 3.0251e-17
* device instance cc_XD1_XDFFM_CLKB_ck4 r0 *1 0,0
Ccc_XD1_XDFFM_CLKB_ck4 XD1_XDFFM_CLKB ck4 3.0251e-17
* device instance cc_XD1_XDFFM_CLKB_ck5 r0 *1 0,0
Ccc_XD1_XDFFM_CLKB_ck5 XD1_XDFFM_CLKB ck5 3.0251e-17
* device instance cc_XD1_XDFFM_CLKB_mod0 r0 *1 0,0
Ccc_XD1_XDFFM_CLKB_mod0 XD1_XDFFM_CLKB mod0 2.4201e-17
* device instance cc_XD1_XDFFM_CLKB_mod1 r0 *1 0,0
Ccc_XD1_XDFFM_CLKB_mod1 XD1_XDFFM_CLKB mod1 2.4201e-17
* device instance cc_XD1_XDFFM_CLKB_mod2 r0 *1 0,0
Ccc_XD1_XDFFM_CLKB_mod2 XD1_XDFFM_CLKB mod2 2.4201e-17
* device instance cc_XD1_XDFFM_CLKB_mod3 r0 *1 0,0
Ccc_XD1_XDFFM_CLKB_mod3 XD1_XDFFM_CLKB mod3 2.4201e-17
* device instance cc_XD1_XDFFM_CLKB_mod4 r0 *1 0,0
Ccc_XD1_XDFFM_CLKB_mod4 XD1_XDFFM_CLKB mod4 2.4201e-17
* device instance cc_XD1_XDFFM_CLKB_net1 r0 *1 0,0
Ccc_XD1_XDFFM_CLKB_net1 XD1_XDFFM_CLKB net1 1.21e-17
* device instance cc_XD1_XDFFM_M_XD1_XDFFM_MB r0 *1 0,0
Ccc_XD1_XDFFM_M_XD1_XDFFM_MB XD1_XDFFM_M XD1_XDFFM_MB 2.4201e-17
* device instance cc_XD1_XDFFM_M_XD1_XDFFM_MFB r0 *1 0,0
Ccc_XD1_XDFFM_M_XD1_XDFFM_MFB XD1_XDFFM_M XD1_XDFFM_MFB 3.4688e-17
* device instance cc_XD1_XDFFM_M_XD1_XDFFM_S r0 *1 0,0
Ccc_XD1_XDFFM_M_XD1_XDFFM_S XD1_XDFFM_M XD1_XDFFM_S 2.8638e-17
* device instance cc_XD1_XDFFM_M_XD1_XDFFM_SB r0 *1 0,0
Ccc_XD1_XDFFM_M_XD1_XDFFM_SB XD1_XDFFM_M XD1_XDFFM_SB 1.8151e-17
* device instance cc_XD1_XDFFM_M_XD1_XDFFM_SFB r0 *1 0,0
Ccc_XD1_XDFFM_M_XD1_XDFFM_SFB XD1_XDFFM_M XD1_XDFFM_SFB 1.21e-17
* device instance cc_XD1_XDFFM_M_XD1_XDFFQ_CKBB r0 *1 0,0
Ccc_XD1_XDFFM_M_XD1_XDFFQ_CKBB XD1_XDFFM_M XD1_XDFFQ_CKBB 1.8151e-17
* device instance cc_XD1_XDFFM_M_XD1_XDFFQ_CLKB r0 *1 0,0
Ccc_XD1_XDFFM_M_XD1_XDFFQ_CLKB XD1_XDFFM_M XD1_XDFFQ_CLKB 2.4201e-17
* device instance cc_XD1_XDFFM_M_XD1_XDFFQ_M r0 *1 0,0
Ccc_XD1_XDFFM_M_XD1_XDFFQ_M XD1_XDFFM_M XD1_XDFFQ_M 2.4201e-17
* device instance cc_XD1_XDFFM_M_XD1_XDFFQ_MB r0 *1 0,0
Ccc_XD1_XDFFM_M_XD1_XDFFQ_MB XD1_XDFFM_M XD1_XDFFQ_MB 1.21e-17
* device instance cc_XD1_XDFFM_M_XD1_XDFFQ_MFB r0 *1 0,0
Ccc_XD1_XDFFM_M_XD1_XDFFQ_MFB XD1_XDFFM_M XD1_XDFFQ_MFB 1.21e-17
* device instance cc_XD1_XDFFM_M_XD1_XDFFQ_S r0 *1 0,0
Ccc_XD1_XDFFM_M_XD1_XDFFQ_S XD1_XDFFM_M XD1_XDFFQ_S 1.8151e-17
* device instance cc_XD1_XDFFM_M_XD1_XDFFQ_SB r0 *1 0,0
Ccc_XD1_XDFFM_M_XD1_XDFFQ_SB XD1_XDFFM_M XD1_XDFFQ_SB 1.8151e-17
* device instance cc_XD1_XDFFM_M_XD1_XDFFQ_SFB r0 *1 0,0
Ccc_XD1_XDFFM_M_XD1_XDFFQ_SFB XD1_XDFFM_M XD1_XDFFQ_SFB 1.21e-17
* device instance cc_XD1_XDFFM_M_XD1_XNOR_midp r0 *1 0,0
Ccc_XD1_XDFFM_M_XD1_XNOR_midp XD1_XDFFM_M XD1_XNOR_midp 1.21e-17
* device instance cc_XD1_XDFFM_M_XD1_dmodout r0 *1 0,0
Ccc_XD1_XDFFM_M_XD1_dmodout XD1_XDFFM_M XD1_dmodout 2.8638e-17
* device instance cc_XD1_XDFFM_M_XD1_dq r0 *1 0,0
Ccc_XD1_XDFFM_M_XD1_dq XD1_XDFFM_M XD1_dq 1.21e-17
* device instance cc_XD1_XDFFM_M_XD1_nm r0 *1 0,0
Ccc_XD1_XDFFM_M_XD1_nm XD1_XDFFM_M XD1_nm 1.8151e-17
* device instance cc_XD1_XDFFM_M_XD1_nt r0 *1 0,0
Ccc_XD1_XDFFM_M_XD1_nt XD1_XDFFM_M XD1_nt 2.4201e-17
* device instance cc_XD1_XDFFM_M_XD1_t1 r0 *1 0,0
Ccc_XD1_XDFFM_M_XD1_t1 XD1_XDFFM_M XD1_t1 1.21e-17
* device instance cc_XD1_XDFFM_M_XD2_XDFFM_CKBB r0 *1 0,0
Ccc_XD1_XDFFM_M_XD2_XDFFM_CKBB XD1_XDFFM_M XD2_XDFFM_CKBB 1.8151e-17
* device instance cc_XD1_XDFFM_M_XD2_XDFFM_CLKB r0 *1 0,0
Ccc_XD1_XDFFM_M_XD2_XDFFM_CLKB XD1_XDFFM_M XD2_XDFFM_CLKB 2.4201e-17
* device instance cc_XD1_XDFFM_M_XD2_XDFFM_M r0 *1 0,0
Ccc_XD1_XDFFM_M_XD2_XDFFM_M XD1_XDFFM_M XD2_XDFFM_M 2.4201e-17
* device instance cc_XD1_XDFFM_M_XD2_XDFFM_MB r0 *1 0,0
Ccc_XD1_XDFFM_M_XD2_XDFFM_MB XD1_XDFFM_M XD2_XDFFM_MB 1.21e-17
* device instance cc_XD1_XDFFM_M_XD2_XDFFM_MFB r0 *1 0,0
Ccc_XD1_XDFFM_M_XD2_XDFFM_MFB XD1_XDFFM_M XD2_XDFFM_MFB 1.21e-17
* device instance cc_XD1_XDFFM_M_XD2_XDFFM_S r0 *1 0,0
Ccc_XD1_XDFFM_M_XD2_XDFFM_S XD1_XDFFM_M XD2_XDFFM_S 1.8151e-17
* device instance cc_XD1_XDFFM_M_XD2_XDFFM_SB r0 *1 0,0
Ccc_XD1_XDFFM_M_XD2_XDFFM_SB XD1_XDFFM_M XD2_XDFFM_SB 1.8151e-17
* device instance cc_XD1_XDFFM_M_XD2_XDFFM_SFB r0 *1 0,0
Ccc_XD1_XDFFM_M_XD2_XDFFM_SFB XD1_XDFFM_M XD2_XDFFM_SFB 1.21e-17
* device instance cc_XD1_XDFFM_M_XD2_XDFFQ_CKBB r0 *1 0,0
Ccc_XD1_XDFFM_M_XD2_XDFFQ_CKBB XD1_XDFFM_M XD2_XDFFQ_CKBB 1.8151e-17
* device instance cc_XD1_XDFFM_M_XD2_XDFFQ_CLKB r0 *1 0,0
Ccc_XD1_XDFFM_M_XD2_XDFFQ_CLKB XD1_XDFFM_M XD2_XDFFQ_CLKB 2.4201e-17
* device instance cc_XD1_XDFFM_M_XD2_XDFFQ_M r0 *1 0,0
Ccc_XD1_XDFFM_M_XD2_XDFFQ_M XD1_XDFFM_M XD2_XDFFQ_M 2.4201e-17
* device instance cc_XD1_XDFFM_M_XD2_XDFFQ_MB r0 *1 0,0
Ccc_XD1_XDFFM_M_XD2_XDFFQ_MB XD1_XDFFM_M XD2_XDFFQ_MB 1.21e-17
* device instance cc_XD1_XDFFM_M_XD2_XDFFQ_MFB r0 *1 0,0
Ccc_XD1_XDFFM_M_XD2_XDFFQ_MFB XD1_XDFFM_M XD2_XDFFQ_MFB 1.21e-17
* device instance cc_XD1_XDFFM_M_XD2_XDFFQ_S r0 *1 0,0
Ccc_XD1_XDFFM_M_XD2_XDFFQ_S XD1_XDFFM_M XD2_XDFFQ_S 1.8151e-17
* device instance cc_XD1_XDFFM_M_XD2_XDFFQ_SB r0 *1 0,0
Ccc_XD1_XDFFM_M_XD2_XDFFQ_SB XD1_XDFFM_M XD2_XDFFQ_SB 1.8151e-17
* device instance cc_XD1_XDFFM_M_XD2_XDFFQ_SFB r0 *1 0,0
Ccc_XD1_XDFFM_M_XD2_XDFFQ_SFB XD1_XDFFM_M XD2_XDFFQ_SFB 1.21e-17
* device instance cc_XD1_XDFFM_M_XD2_XN2_mid1 r0 *1 0,0
Ccc_XD1_XDFFM_M_XD2_XN2_mid1 XD1_XDFFM_M XD2_XN2_mid1 1.21e-17
* device instance cc_XD1_XDFFM_M_XD2_XN3_mid1 r0 *1 0,0
Ccc_XD1_XDFFM_M_XD2_XN3_mid1 XD1_XDFFM_M XD2_XN3_mid1 1.21e-17
* device instance cc_XD1_XDFFM_M_XD2_XN3_mid2 r0 *1 0,0
Ccc_XD1_XDFFM_M_XD2_XN3_mid2 XD1_XDFFM_M XD2_XN3_mid2 1.21e-17
* device instance cc_XD1_XDFFM_M_XD2_dmodout r0 *1 0,0
Ccc_XD1_XDFFM_M_XD2_dmodout XD1_XDFFM_M XD2_dmodout 1.21e-17
* device instance cc_XD1_XDFFM_M_XD2_dq r0 *1 0,0
Ccc_XD1_XDFFM_M_XD2_dq XD1_XDFFM_M XD2_dq 1.8151e-17
* device instance cc_XD1_XDFFM_M_XD2_nm r0 *1 0,0
Ccc_XD1_XDFFM_M_XD2_nm XD1_XDFFM_M XD2_nm 1.21e-17
* device instance cc_XD1_XDFFM_M_XD2_nt r0 *1 0,0
Ccc_XD1_XDFFM_M_XD2_nt XD1_XDFFM_M XD2_nt 1.21e-17
* device instance cc_XD1_XDFFM_M_XD2_t1 r0 *1 0,0
Ccc_XD1_XDFFM_M_XD2_t1 XD1_XDFFM_M XD2_t1 1.21e-17
* device instance cc_XD1_XDFFM_M_XD3_XDFFM_CKBB r0 *1 0,0
Ccc_XD1_XDFFM_M_XD3_XDFFM_CKBB XD1_XDFFM_M XD3_XDFFM_CKBB 1.8151e-17
* device instance cc_XD1_XDFFM_M_XD3_XDFFM_CLKB r0 *1 0,0
Ccc_XD1_XDFFM_M_XD3_XDFFM_CLKB XD1_XDFFM_M XD3_XDFFM_CLKB 2.4201e-17
* device instance cc_XD1_XDFFM_M_XD3_XDFFM_M r0 *1 0,0
Ccc_XD1_XDFFM_M_XD3_XDFFM_M XD1_XDFFM_M XD3_XDFFM_M 2.4201e-17
* device instance cc_XD1_XDFFM_M_XD3_XDFFM_MB r0 *1 0,0
Ccc_XD1_XDFFM_M_XD3_XDFFM_MB XD1_XDFFM_M XD3_XDFFM_MB 1.21e-17
* device instance cc_XD1_XDFFM_M_XD3_XDFFM_MFB r0 *1 0,0
Ccc_XD1_XDFFM_M_XD3_XDFFM_MFB XD1_XDFFM_M XD3_XDFFM_MFB 1.21e-17
* device instance cc_XD1_XDFFM_M_XD3_XDFFM_S r0 *1 0,0
Ccc_XD1_XDFFM_M_XD3_XDFFM_S XD1_XDFFM_M XD3_XDFFM_S 1.8151e-17
* device instance cc_XD1_XDFFM_M_XD3_XDFFM_SB r0 *1 0,0
Ccc_XD1_XDFFM_M_XD3_XDFFM_SB XD1_XDFFM_M XD3_XDFFM_SB 1.8151e-17
* device instance cc_XD1_XDFFM_M_XD3_XDFFM_SFB r0 *1 0,0
Ccc_XD1_XDFFM_M_XD3_XDFFM_SFB XD1_XDFFM_M XD3_XDFFM_SFB 1.21e-17
* device instance cc_XD1_XDFFM_M_XD3_XDFFQ_CKBB r0 *1 0,0
Ccc_XD1_XDFFM_M_XD3_XDFFQ_CKBB XD1_XDFFM_M XD3_XDFFQ_CKBB 1.8151e-17
* device instance cc_XD1_XDFFM_M_XD3_XDFFQ_CLKB r0 *1 0,0
Ccc_XD1_XDFFM_M_XD3_XDFFQ_CLKB XD1_XDFFM_M XD3_XDFFQ_CLKB 2.4201e-17
* device instance cc_XD1_XDFFM_M_XD3_XDFFQ_M r0 *1 0,0
Ccc_XD1_XDFFM_M_XD3_XDFFQ_M XD1_XDFFM_M XD3_XDFFQ_M 2.4201e-17
* device instance cc_XD1_XDFFM_M_XD3_XDFFQ_MB r0 *1 0,0
Ccc_XD1_XDFFM_M_XD3_XDFFQ_MB XD1_XDFFM_M XD3_XDFFQ_MB 1.21e-17
* device instance cc_XD1_XDFFM_M_XD3_XDFFQ_MFB r0 *1 0,0
Ccc_XD1_XDFFM_M_XD3_XDFFQ_MFB XD1_XDFFM_M XD3_XDFFQ_MFB 1.21e-17
* device instance cc_XD1_XDFFM_M_XD3_XDFFQ_S r0 *1 0,0
Ccc_XD1_XDFFM_M_XD3_XDFFQ_S XD1_XDFFM_M XD3_XDFFQ_S 1.8151e-17
* device instance cc_XD1_XDFFM_M_XD3_XDFFQ_SB r0 *1 0,0
Ccc_XD1_XDFFM_M_XD3_XDFFQ_SB XD1_XDFFM_M XD3_XDFFQ_SB 1.8151e-17
* device instance cc_XD1_XDFFM_M_XD3_XDFFQ_SFB r0 *1 0,0
Ccc_XD1_XDFFM_M_XD3_XDFFQ_SFB XD1_XDFFM_M XD3_XDFFQ_SFB 1.21e-17
* device instance cc_XD1_XDFFM_M_XD3_XN2_mid1 r0 *1 0,0
Ccc_XD1_XDFFM_M_XD3_XN2_mid1 XD1_XDFFM_M XD3_XN2_mid1 1.21e-17
* device instance cc_XD1_XDFFM_M_XD3_XN3_mid1 r0 *1 0,0
Ccc_XD1_XDFFM_M_XD3_XN3_mid1 XD1_XDFFM_M XD3_XN3_mid1 1.21e-17
* device instance cc_XD1_XDFFM_M_XD3_XN3_mid2 r0 *1 0,0
Ccc_XD1_XDFFM_M_XD3_XN3_mid2 XD1_XDFFM_M XD3_XN3_mid2 1.21e-17
* device instance cc_XD1_XDFFM_M_XD3_dmodout r0 *1 0,0
Ccc_XD1_XDFFM_M_XD3_dmodout XD1_XDFFM_M XD3_dmodout 1.21e-17
* device instance cc_XD1_XDFFM_M_XD3_dq r0 *1 0,0
Ccc_XD1_XDFFM_M_XD3_dq XD1_XDFFM_M XD3_dq 1.8151e-17
* device instance cc_XD1_XDFFM_M_XD3_nm r0 *1 0,0
Ccc_XD1_XDFFM_M_XD3_nm XD1_XDFFM_M XD3_nm 1.21e-17
* device instance cc_XD1_XDFFM_M_XD3_nt r0 *1 0,0
Ccc_XD1_XDFFM_M_XD3_nt XD1_XDFFM_M XD3_nt 1.21e-17
* device instance cc_XD1_XDFFM_M_XD3_t1 r0 *1 0,0
Ccc_XD1_XDFFM_M_XD3_t1 XD1_XDFFM_M XD3_t1 1.21e-17
* device instance cc_XD1_XDFFM_M_XD4_XDFFM_CKBB r0 *1 0,0
Ccc_XD1_XDFFM_M_XD4_XDFFM_CKBB XD1_XDFFM_M XD4_XDFFM_CKBB 1.8151e-17
* device instance cc_XD1_XDFFM_M_XD4_XDFFM_CLKB r0 *1 0,0
Ccc_XD1_XDFFM_M_XD4_XDFFM_CLKB XD1_XDFFM_M XD4_XDFFM_CLKB 2.4201e-17
* device instance cc_XD1_XDFFM_M_XD4_XDFFM_M r0 *1 0,0
Ccc_XD1_XDFFM_M_XD4_XDFFM_M XD1_XDFFM_M XD4_XDFFM_M 2.4201e-17
* device instance cc_XD1_XDFFM_M_XD4_XDFFM_MB r0 *1 0,0
Ccc_XD1_XDFFM_M_XD4_XDFFM_MB XD1_XDFFM_M XD4_XDFFM_MB 1.21e-17
* device instance cc_XD1_XDFFM_M_XD4_XDFFM_MFB r0 *1 0,0
Ccc_XD1_XDFFM_M_XD4_XDFFM_MFB XD1_XDFFM_M XD4_XDFFM_MFB 1.21e-17
* device instance cc_XD1_XDFFM_M_XD4_XDFFM_S r0 *1 0,0
Ccc_XD1_XDFFM_M_XD4_XDFFM_S XD1_XDFFM_M XD4_XDFFM_S 1.8151e-17
* device instance cc_XD1_XDFFM_M_XD4_XDFFM_SB r0 *1 0,0
Ccc_XD1_XDFFM_M_XD4_XDFFM_SB XD1_XDFFM_M XD4_XDFFM_SB 1.8151e-17
* device instance cc_XD1_XDFFM_M_XD4_XDFFM_SFB r0 *1 0,0
Ccc_XD1_XDFFM_M_XD4_XDFFM_SFB XD1_XDFFM_M XD4_XDFFM_SFB 1.21e-17
* device instance cc_XD1_XDFFM_M_XD4_XDFFQ_CKBB r0 *1 0,0
Ccc_XD1_XDFFM_M_XD4_XDFFQ_CKBB XD1_XDFFM_M XD4_XDFFQ_CKBB 1.8151e-17
* device instance cc_XD1_XDFFM_M_XD4_XDFFQ_CLKB r0 *1 0,0
Ccc_XD1_XDFFM_M_XD4_XDFFQ_CLKB XD1_XDFFM_M XD4_XDFFQ_CLKB 2.4201e-17
* device instance cc_XD1_XDFFM_M_XD4_XDFFQ_M r0 *1 0,0
Ccc_XD1_XDFFM_M_XD4_XDFFQ_M XD1_XDFFM_M XD4_XDFFQ_M 2.4201e-17
* device instance cc_XD1_XDFFM_M_XD4_XDFFQ_MB r0 *1 0,0
Ccc_XD1_XDFFM_M_XD4_XDFFQ_MB XD1_XDFFM_M XD4_XDFFQ_MB 1.21e-17
* device instance cc_XD1_XDFFM_M_XD4_XDFFQ_MFB r0 *1 0,0
Ccc_XD1_XDFFM_M_XD4_XDFFQ_MFB XD1_XDFFM_M XD4_XDFFQ_MFB 1.21e-17
* device instance cc_XD1_XDFFM_M_XD4_XDFFQ_S r0 *1 0,0
Ccc_XD1_XDFFM_M_XD4_XDFFQ_S XD1_XDFFM_M XD4_XDFFQ_S 1.8151e-17
* device instance cc_XD1_XDFFM_M_XD4_XDFFQ_SB r0 *1 0,0
Ccc_XD1_XDFFM_M_XD4_XDFFQ_SB XD1_XDFFM_M XD4_XDFFQ_SB 1.8151e-17
* device instance cc_XD1_XDFFM_M_XD4_XDFFQ_SFB r0 *1 0,0
Ccc_XD1_XDFFM_M_XD4_XDFFQ_SFB XD1_XDFFM_M XD4_XDFFQ_SFB 1.21e-17
* device instance cc_XD1_XDFFM_M_XD4_XN2_mid1 r0 *1 0,0
Ccc_XD1_XDFFM_M_XD4_XN2_mid1 XD1_XDFFM_M XD4_XN2_mid1 1.21e-17
* device instance cc_XD1_XDFFM_M_XD4_XN3_mid1 r0 *1 0,0
Ccc_XD1_XDFFM_M_XD4_XN3_mid1 XD1_XDFFM_M XD4_XN3_mid1 1.21e-17
* device instance cc_XD1_XDFFM_M_XD4_XN3_mid2 r0 *1 0,0
Ccc_XD1_XDFFM_M_XD4_XN3_mid2 XD1_XDFFM_M XD4_XN3_mid2 1.21e-17
* device instance cc_XD1_XDFFM_M_XD4_dmodout r0 *1 0,0
Ccc_XD1_XDFFM_M_XD4_dmodout XD1_XDFFM_M XD4_dmodout 1.21e-17
* device instance cc_XD1_XDFFM_M_XD4_dq r0 *1 0,0
Ccc_XD1_XDFFM_M_XD4_dq XD1_XDFFM_M XD4_dq 1.8151e-17
* device instance cc_XD1_XDFFM_M_XD4_nm r0 *1 0,0
Ccc_XD1_XDFFM_M_XD4_nm XD1_XDFFM_M XD4_nm 1.21e-17
* device instance cc_XD1_XDFFM_M_XD4_nt r0 *1 0,0
Ccc_XD1_XDFFM_M_XD4_nt XD1_XDFFM_M XD4_nt 1.21e-17
* device instance cc_XD1_XDFFM_M_XD4_t1 r0 *1 0,0
Ccc_XD1_XDFFM_M_XD4_t1 XD1_XDFFM_M XD4_t1 1.21e-17
* device instance cc_XD1_XDFFM_M_XD5_XDFFM_CKBB r0 *1 0,0
Ccc_XD1_XDFFM_M_XD5_XDFFM_CKBB XD1_XDFFM_M XD5_XDFFM_CKBB 1.8151e-17
* device instance cc_XD1_XDFFM_M_XD5_XDFFM_CLKB r0 *1 0,0
Ccc_XD1_XDFFM_M_XD5_XDFFM_CLKB XD1_XDFFM_M XD5_XDFFM_CLKB 2.4201e-17
* device instance cc_XD1_XDFFM_M_XD5_XDFFM_M r0 *1 0,0
Ccc_XD1_XDFFM_M_XD5_XDFFM_M XD1_XDFFM_M XD5_XDFFM_M 2.4201e-17
* device instance cc_XD1_XDFFM_M_XD5_XDFFM_MB r0 *1 0,0
Ccc_XD1_XDFFM_M_XD5_XDFFM_MB XD1_XDFFM_M XD5_XDFFM_MB 1.21e-17
* device instance cc_XD1_XDFFM_M_XD5_XDFFM_MFB r0 *1 0,0
Ccc_XD1_XDFFM_M_XD5_XDFFM_MFB XD1_XDFFM_M XD5_XDFFM_MFB 1.21e-17
* device instance cc_XD1_XDFFM_M_XD5_XDFFM_S r0 *1 0,0
Ccc_XD1_XDFFM_M_XD5_XDFFM_S XD1_XDFFM_M XD5_XDFFM_S 1.8151e-17
* device instance cc_XD1_XDFFM_M_XD5_XDFFM_SB r0 *1 0,0
Ccc_XD1_XDFFM_M_XD5_XDFFM_SB XD1_XDFFM_M XD5_XDFFM_SB 1.8151e-17
* device instance cc_XD1_XDFFM_M_XD5_XDFFM_SFB r0 *1 0,0
Ccc_XD1_XDFFM_M_XD5_XDFFM_SFB XD1_XDFFM_M XD5_XDFFM_SFB 1.21e-17
* device instance cc_XD1_XDFFM_M_XD5_XDFFQ_CKBB r0 *1 0,0
Ccc_XD1_XDFFM_M_XD5_XDFFQ_CKBB XD1_XDFFM_M XD5_XDFFQ_CKBB 1.8151e-17
* device instance cc_XD1_XDFFM_M_XD5_XDFFQ_CLKB r0 *1 0,0
Ccc_XD1_XDFFM_M_XD5_XDFFQ_CLKB XD1_XDFFM_M XD5_XDFFQ_CLKB 2.4201e-17
* device instance cc_XD1_XDFFM_M_XD5_XDFFQ_M r0 *1 0,0
Ccc_XD1_XDFFM_M_XD5_XDFFQ_M XD1_XDFFM_M XD5_XDFFQ_M 2.4201e-17
* device instance cc_XD1_XDFFM_M_XD5_XDFFQ_MB r0 *1 0,0
Ccc_XD1_XDFFM_M_XD5_XDFFQ_MB XD1_XDFFM_M XD5_XDFFQ_MB 1.21e-17
* device instance cc_XD1_XDFFM_M_XD5_XDFFQ_MFB r0 *1 0,0
Ccc_XD1_XDFFM_M_XD5_XDFFQ_MFB XD1_XDFFM_M XD5_XDFFQ_MFB 1.21e-17
* device instance cc_XD1_XDFFM_M_XD5_XDFFQ_S r0 *1 0,0
Ccc_XD1_XDFFM_M_XD5_XDFFQ_S XD1_XDFFM_M XD5_XDFFQ_S 1.8151e-17
* device instance cc_XD1_XDFFM_M_XD5_XDFFQ_SB r0 *1 0,0
Ccc_XD1_XDFFM_M_XD5_XDFFQ_SB XD1_XDFFM_M XD5_XDFFQ_SB 1.8151e-17
* device instance cc_XD1_XDFFM_M_XD5_XDFFQ_SFB r0 *1 0,0
Ccc_XD1_XDFFM_M_XD5_XDFFQ_SFB XD1_XDFFM_M XD5_XDFFQ_SFB 1.21e-17
* device instance cc_XD1_XDFFM_M_XD5_XN2_mid1 r0 *1 0,0
Ccc_XD1_XDFFM_M_XD5_XN2_mid1 XD1_XDFFM_M XD5_XN2_mid1 1.21e-17
* device instance cc_XD1_XDFFM_M_XD5_XN3_mid1 r0 *1 0,0
Ccc_XD1_XDFFM_M_XD5_XN3_mid1 XD1_XDFFM_M XD5_XN3_mid1 1.21e-17
* device instance cc_XD1_XDFFM_M_XD5_XN3_mid2 r0 *1 0,0
Ccc_XD1_XDFFM_M_XD5_XN3_mid2 XD1_XDFFM_M XD5_XN3_mid2 1.21e-17
* device instance cc_XD1_XDFFM_M_XD5_dmodout r0 *1 0,0
Ccc_XD1_XDFFM_M_XD5_dmodout XD1_XDFFM_M XD5_dmodout 1.21e-17
* device instance cc_XD1_XDFFM_M_XD5_dq r0 *1 0,0
Ccc_XD1_XDFFM_M_XD5_dq XD1_XDFFM_M XD5_dq 1.8151e-17
* device instance cc_XD1_XDFFM_M_XD5_nm r0 *1 0,0
Ccc_XD1_XDFFM_M_XD5_nm XD1_XDFFM_M XD5_nm 1.21e-17
* device instance cc_XD1_XDFFM_M_XD5_nt r0 *1 0,0
Ccc_XD1_XDFFM_M_XD5_nt XD1_XDFFM_M XD5_nt 1.21e-17
* device instance cc_XD1_XDFFM_M_XD5_t1 r0 *1 0,0
Ccc_XD1_XDFFM_M_XD5_t1 XD1_XDFFM_M XD5_t1 1.21e-17
* device instance cc_XD1_XDFFM_M_XFRT_CKBB r0 *1 0,0
Ccc_XD1_XDFFM_M_XFRT_CKBB XD1_XDFFM_M XFRT_CKBB 1.8151e-17
* device instance cc_XD1_XDFFM_M_XFRT_CLKB r0 *1 0,0
Ccc_XD1_XDFFM_M_XFRT_CLKB XD1_XDFFM_M XFRT_CLKB 2.4201e-17
* device instance cc_XD1_XDFFM_M_XFRT_M r0 *1 0,0
Ccc_XD1_XDFFM_M_XFRT_M XD1_XDFFM_M XFRT_M 2.4201e-17
* device instance cc_XD1_XDFFM_M_XFRT_MB r0 *1 0,0
Ccc_XD1_XDFFM_M_XFRT_MB XD1_XDFFM_M XFRT_MB 1.21e-17
* device instance cc_XD1_XDFFM_M_XFRT_MFB r0 *1 0,0
Ccc_XD1_XDFFM_M_XFRT_MFB XD1_XDFFM_M XFRT_MFB 1.21e-17
* device instance cc_XD1_XDFFM_M_XFRT_S r0 *1 0,0
Ccc_XD1_XDFFM_M_XFRT_S XD1_XDFFM_M XFRT_S 1.8151e-17
* device instance cc_XD1_XDFFM_M_XFRT_SB r0 *1 0,0
Ccc_XD1_XDFFM_M_XFRT_SB XD1_XDFFM_M XFRT_SB 1.8151e-17
* device instance cc_XD1_XDFFM_M_XFRT_SFB r0 *1 0,0
Ccc_XD1_XDFFM_M_XFRT_SFB XD1_XDFFM_M XFRT_SFB 1.21e-17
* device instance cc_XD1_XDFFM_M_ck1 r0 *1 0,0
Ccc_XD1_XDFFM_M_ck1 XD1_XDFFM_M ck1 3.0251e-17
* device instance cc_XD1_XDFFM_M_ck2 r0 *1 0,0
Ccc_XD1_XDFFM_M_ck2 XD1_XDFFM_M ck2 3.0251e-17
* device instance cc_XD1_XDFFM_M_ck3 r0 *1 0,0
Ccc_XD1_XDFFM_M_ck3 XD1_XDFFM_M ck3 3.0251e-17
* device instance cc_XD1_XDFFM_M_ck4 r0 *1 0,0
Ccc_XD1_XDFFM_M_ck4 XD1_XDFFM_M ck4 3.0251e-17
* device instance cc_XD1_XDFFM_M_ck5 r0 *1 0,0
Ccc_XD1_XDFFM_M_ck5 XD1_XDFFM_M ck5 3.0251e-17
* device instance cc_XD1_XDFFM_M_mod0 r0 *1 0,0
Ccc_XD1_XDFFM_M_mod0 XD1_XDFFM_M mod0 2.4201e-17
* device instance cc_XD1_XDFFM_M_mod1 r0 *1 0,0
Ccc_XD1_XDFFM_M_mod1 XD1_XDFFM_M mod1 2.4201e-17
* device instance cc_XD1_XDFFM_M_mod2 r0 *1 0,0
Ccc_XD1_XDFFM_M_mod2 XD1_XDFFM_M mod2 2.4201e-17
* device instance cc_XD1_XDFFM_M_mod3 r0 *1 0,0
Ccc_XD1_XDFFM_M_mod3 XD1_XDFFM_M mod3 2.4201e-17
* device instance cc_XD1_XDFFM_M_mod4 r0 *1 0,0
Ccc_XD1_XDFFM_M_mod4 XD1_XDFFM_M mod4 2.4201e-17
* device instance cc_XD1_XDFFM_M_net1 r0 *1 0,0
Ccc_XD1_XDFFM_M_net1 XD1_XDFFM_M net1 1.21e-17
* device instance cc_XD1_XDFFM_MB_XD1_XDFFM_MFB r0 *1 0,0
Ccc_XD1_XDFFM_MB_XD1_XDFFM_MFB XD1_XDFFM_MB XD1_XDFFM_MFB 1.21e-17
* device instance cc_XD1_XDFFM_MB_XD1_XDFFM_S r0 *1 0,0
Ccc_XD1_XDFFM_MB_XD1_XDFFM_S XD1_XDFFM_MB XD1_XDFFM_S 1.8151e-17
* device instance cc_XD1_XDFFM_MB_XD1_XDFFM_SB r0 *1 0,0
Ccc_XD1_XDFFM_MB_XD1_XDFFM_SB XD1_XDFFM_MB XD1_XDFFM_SB 1.8151e-17
* device instance cc_XD1_XDFFM_MB_XD1_XDFFM_SFB r0 *1 0,0
Ccc_XD1_XDFFM_MB_XD1_XDFFM_SFB XD1_XDFFM_MB XD1_XDFFM_SFB 1.21e-17
* device instance cc_XD1_XDFFM_MB_XD1_XDFFQ_CKBB r0 *1 0,0
Ccc_XD1_XDFFM_MB_XD1_XDFFQ_CKBB XD1_XDFFM_MB XD1_XDFFQ_CKBB 1.8151e-17
* device instance cc_XD1_XDFFM_MB_XD1_XDFFQ_CLKB r0 *1 0,0
Ccc_XD1_XDFFM_MB_XD1_XDFFQ_CLKB XD1_XDFFM_MB XD1_XDFFQ_CLKB 2.4201e-17
* device instance cc_XD1_XDFFM_MB_XD1_XDFFQ_M r0 *1 0,0
Ccc_XD1_XDFFM_MB_XD1_XDFFQ_M XD1_XDFFM_MB XD1_XDFFQ_M 2.4201e-17
* device instance cc_XD1_XDFFM_MB_XD1_XDFFQ_MB r0 *1 0,0
Ccc_XD1_XDFFM_MB_XD1_XDFFQ_MB XD1_XDFFM_MB XD1_XDFFQ_MB 1.21e-17
* device instance cc_XD1_XDFFM_MB_XD1_XDFFQ_MFB r0 *1 0,0
Ccc_XD1_XDFFM_MB_XD1_XDFFQ_MFB XD1_XDFFM_MB XD1_XDFFQ_MFB 1.21e-17
* device instance cc_XD1_XDFFM_MB_XD1_XDFFQ_S r0 *1 0,0
Ccc_XD1_XDFFM_MB_XD1_XDFFQ_S XD1_XDFFM_MB XD1_XDFFQ_S 1.8151e-17
* device instance cc_XD1_XDFFM_MB_XD1_XDFFQ_SB r0 *1 0,0
Ccc_XD1_XDFFM_MB_XD1_XDFFQ_SB XD1_XDFFM_MB XD1_XDFFQ_SB 1.8151e-17
* device instance cc_XD1_XDFFM_MB_XD1_XDFFQ_SFB r0 *1 0,0
Ccc_XD1_XDFFM_MB_XD1_XDFFQ_SFB XD1_XDFFM_MB XD1_XDFFQ_SFB 1.21e-17
* device instance cc_XD1_XDFFM_MB_XD1_XNOR_midp r0 *1 0,0
Ccc_XD1_XDFFM_MB_XD1_XNOR_midp XD1_XDFFM_MB XD1_XNOR_midp 1.21e-17
* device instance cc_XD1_XDFFM_MB_XD1_dmodout r0 *1 0,0
Ccc_XD1_XDFFM_MB_XD1_dmodout XD1_XDFFM_MB XD1_dmodout 1.21e-17
* device instance cc_XD1_XDFFM_MB_XD1_dq r0 *1 0,0
Ccc_XD1_XDFFM_MB_XD1_dq XD1_XDFFM_MB XD1_dq 1.21e-17
* device instance cc_XD1_XDFFM_MB_XD1_nm r0 *1 0,0
Ccc_XD1_XDFFM_MB_XD1_nm XD1_XDFFM_MB XD1_nm 1.8151e-17
* device instance cc_XD1_XDFFM_MB_XD1_nt r0 *1 0,0
Ccc_XD1_XDFFM_MB_XD1_nt XD1_XDFFM_MB XD1_nt 2.4201e-17
* device instance cc_XD1_XDFFM_MB_XD1_t1 r0 *1 0,0
Ccc_XD1_XDFFM_MB_XD1_t1 XD1_XDFFM_MB XD1_t1 1.21e-17
* device instance cc_XD1_XDFFM_MB_XD2_XDFFM_CKBB r0 *1 0,0
Ccc_XD1_XDFFM_MB_XD2_XDFFM_CKBB XD1_XDFFM_MB XD2_XDFFM_CKBB 1.8151e-17
* device instance cc_XD1_XDFFM_MB_XD2_XDFFM_CLKB r0 *1 0,0
Ccc_XD1_XDFFM_MB_XD2_XDFFM_CLKB XD1_XDFFM_MB XD2_XDFFM_CLKB 2.4201e-17
* device instance cc_XD1_XDFFM_MB_XD2_XDFFM_M r0 *1 0,0
Ccc_XD1_XDFFM_MB_XD2_XDFFM_M XD1_XDFFM_MB XD2_XDFFM_M 2.4201e-17
* device instance cc_XD1_XDFFM_MB_XD2_XDFFM_MB r0 *1 0,0
Ccc_XD1_XDFFM_MB_XD2_XDFFM_MB XD1_XDFFM_MB XD2_XDFFM_MB 1.21e-17
* device instance cc_XD1_XDFFM_MB_XD2_XDFFM_MFB r0 *1 0,0
Ccc_XD1_XDFFM_MB_XD2_XDFFM_MFB XD1_XDFFM_MB XD2_XDFFM_MFB 1.21e-17
* device instance cc_XD1_XDFFM_MB_XD2_XDFFM_S r0 *1 0,0
Ccc_XD1_XDFFM_MB_XD2_XDFFM_S XD1_XDFFM_MB XD2_XDFFM_S 1.8151e-17
* device instance cc_XD1_XDFFM_MB_XD2_XDFFM_SB r0 *1 0,0
Ccc_XD1_XDFFM_MB_XD2_XDFFM_SB XD1_XDFFM_MB XD2_XDFFM_SB 1.8151e-17
* device instance cc_XD1_XDFFM_MB_XD2_XDFFM_SFB r0 *1 0,0
Ccc_XD1_XDFFM_MB_XD2_XDFFM_SFB XD1_XDFFM_MB XD2_XDFFM_SFB 1.21e-17
* device instance cc_XD1_XDFFM_MB_XD2_XDFFQ_CKBB r0 *1 0,0
Ccc_XD1_XDFFM_MB_XD2_XDFFQ_CKBB XD1_XDFFM_MB XD2_XDFFQ_CKBB 1.8151e-17
* device instance cc_XD1_XDFFM_MB_XD2_XDFFQ_CLKB r0 *1 0,0
Ccc_XD1_XDFFM_MB_XD2_XDFFQ_CLKB XD1_XDFFM_MB XD2_XDFFQ_CLKB 2.4201e-17
* device instance cc_XD1_XDFFM_MB_XD2_XDFFQ_M r0 *1 0,0
Ccc_XD1_XDFFM_MB_XD2_XDFFQ_M XD1_XDFFM_MB XD2_XDFFQ_M 2.4201e-17
* device instance cc_XD1_XDFFM_MB_XD2_XDFFQ_MB r0 *1 0,0
Ccc_XD1_XDFFM_MB_XD2_XDFFQ_MB XD1_XDFFM_MB XD2_XDFFQ_MB 1.21e-17
* device instance cc_XD1_XDFFM_MB_XD2_XDFFQ_MFB r0 *1 0,0
Ccc_XD1_XDFFM_MB_XD2_XDFFQ_MFB XD1_XDFFM_MB XD2_XDFFQ_MFB 1.21e-17
* device instance cc_XD1_XDFFM_MB_XD2_XDFFQ_S r0 *1 0,0
Ccc_XD1_XDFFM_MB_XD2_XDFFQ_S XD1_XDFFM_MB XD2_XDFFQ_S 1.8151e-17
* device instance cc_XD1_XDFFM_MB_XD2_XDFFQ_SB r0 *1 0,0
Ccc_XD1_XDFFM_MB_XD2_XDFFQ_SB XD1_XDFFM_MB XD2_XDFFQ_SB 1.8151e-17
* device instance cc_XD1_XDFFM_MB_XD2_XDFFQ_SFB r0 *1 0,0
Ccc_XD1_XDFFM_MB_XD2_XDFFQ_SFB XD1_XDFFM_MB XD2_XDFFQ_SFB 1.21e-17
* device instance cc_XD1_XDFFM_MB_XD2_XN2_mid1 r0 *1 0,0
Ccc_XD1_XDFFM_MB_XD2_XN2_mid1 XD1_XDFFM_MB XD2_XN2_mid1 1.21e-17
* device instance cc_XD1_XDFFM_MB_XD2_XN3_mid1 r0 *1 0,0
Ccc_XD1_XDFFM_MB_XD2_XN3_mid1 XD1_XDFFM_MB XD2_XN3_mid1 1.21e-17
* device instance cc_XD1_XDFFM_MB_XD2_XN3_mid2 r0 *1 0,0
Ccc_XD1_XDFFM_MB_XD2_XN3_mid2 XD1_XDFFM_MB XD2_XN3_mid2 1.21e-17
* device instance cc_XD1_XDFFM_MB_XD2_dmodout r0 *1 0,0
Ccc_XD1_XDFFM_MB_XD2_dmodout XD1_XDFFM_MB XD2_dmodout 1.21e-17
* device instance cc_XD1_XDFFM_MB_XD2_dq r0 *1 0,0
Ccc_XD1_XDFFM_MB_XD2_dq XD1_XDFFM_MB XD2_dq 1.8151e-17
* device instance cc_XD1_XDFFM_MB_XD2_nm r0 *1 0,0
Ccc_XD1_XDFFM_MB_XD2_nm XD1_XDFFM_MB XD2_nm 1.21e-17
* device instance cc_XD1_XDFFM_MB_XD2_nt r0 *1 0,0
Ccc_XD1_XDFFM_MB_XD2_nt XD1_XDFFM_MB XD2_nt 1.21e-17
* device instance cc_XD1_XDFFM_MB_XD2_t1 r0 *1 0,0
Ccc_XD1_XDFFM_MB_XD2_t1 XD1_XDFFM_MB XD2_t1 1.21e-17
* device instance cc_XD1_XDFFM_MB_XD3_XDFFM_CKBB r0 *1 0,0
Ccc_XD1_XDFFM_MB_XD3_XDFFM_CKBB XD1_XDFFM_MB XD3_XDFFM_CKBB 1.8151e-17
* device instance cc_XD1_XDFFM_MB_XD3_XDFFM_CLKB r0 *1 0,0
Ccc_XD1_XDFFM_MB_XD3_XDFFM_CLKB XD1_XDFFM_MB XD3_XDFFM_CLKB 2.4201e-17
* device instance cc_XD1_XDFFM_MB_XD3_XDFFM_M r0 *1 0,0
Ccc_XD1_XDFFM_MB_XD3_XDFFM_M XD1_XDFFM_MB XD3_XDFFM_M 2.4201e-17
* device instance cc_XD1_XDFFM_MB_XD3_XDFFM_MB r0 *1 0,0
Ccc_XD1_XDFFM_MB_XD3_XDFFM_MB XD1_XDFFM_MB XD3_XDFFM_MB 1.21e-17
* device instance cc_XD1_XDFFM_MB_XD3_XDFFM_MFB r0 *1 0,0
Ccc_XD1_XDFFM_MB_XD3_XDFFM_MFB XD1_XDFFM_MB XD3_XDFFM_MFB 1.21e-17
* device instance cc_XD1_XDFFM_MB_XD3_XDFFM_S r0 *1 0,0
Ccc_XD1_XDFFM_MB_XD3_XDFFM_S XD1_XDFFM_MB XD3_XDFFM_S 1.8151e-17
* device instance cc_XD1_XDFFM_MB_XD3_XDFFM_SB r0 *1 0,0
Ccc_XD1_XDFFM_MB_XD3_XDFFM_SB XD1_XDFFM_MB XD3_XDFFM_SB 1.8151e-17
* device instance cc_XD1_XDFFM_MB_XD3_XDFFM_SFB r0 *1 0,0
Ccc_XD1_XDFFM_MB_XD3_XDFFM_SFB XD1_XDFFM_MB XD3_XDFFM_SFB 1.21e-17
* device instance cc_XD1_XDFFM_MB_XD3_XDFFQ_CKBB r0 *1 0,0
Ccc_XD1_XDFFM_MB_XD3_XDFFQ_CKBB XD1_XDFFM_MB XD3_XDFFQ_CKBB 1.8151e-17
* device instance cc_XD1_XDFFM_MB_XD3_XDFFQ_CLKB r0 *1 0,0
Ccc_XD1_XDFFM_MB_XD3_XDFFQ_CLKB XD1_XDFFM_MB XD3_XDFFQ_CLKB 2.4201e-17
* device instance cc_XD1_XDFFM_MB_XD3_XDFFQ_M r0 *1 0,0
Ccc_XD1_XDFFM_MB_XD3_XDFFQ_M XD1_XDFFM_MB XD3_XDFFQ_M 2.4201e-17
* device instance cc_XD1_XDFFM_MB_XD3_XDFFQ_MB r0 *1 0,0
Ccc_XD1_XDFFM_MB_XD3_XDFFQ_MB XD1_XDFFM_MB XD3_XDFFQ_MB 1.21e-17
* device instance cc_XD1_XDFFM_MB_XD3_XDFFQ_MFB r0 *1 0,0
Ccc_XD1_XDFFM_MB_XD3_XDFFQ_MFB XD1_XDFFM_MB XD3_XDFFQ_MFB 1.21e-17
* device instance cc_XD1_XDFFM_MB_XD3_XDFFQ_S r0 *1 0,0
Ccc_XD1_XDFFM_MB_XD3_XDFFQ_S XD1_XDFFM_MB XD3_XDFFQ_S 1.8151e-17
* device instance cc_XD1_XDFFM_MB_XD3_XDFFQ_SB r0 *1 0,0
Ccc_XD1_XDFFM_MB_XD3_XDFFQ_SB XD1_XDFFM_MB XD3_XDFFQ_SB 1.8151e-17
* device instance cc_XD1_XDFFM_MB_XD3_XDFFQ_SFB r0 *1 0,0
Ccc_XD1_XDFFM_MB_XD3_XDFFQ_SFB XD1_XDFFM_MB XD3_XDFFQ_SFB 1.21e-17
* device instance cc_XD1_XDFFM_MB_XD3_XN2_mid1 r0 *1 0,0
Ccc_XD1_XDFFM_MB_XD3_XN2_mid1 XD1_XDFFM_MB XD3_XN2_mid1 1.21e-17
* device instance cc_XD1_XDFFM_MB_XD3_XN3_mid1 r0 *1 0,0
Ccc_XD1_XDFFM_MB_XD3_XN3_mid1 XD1_XDFFM_MB XD3_XN3_mid1 1.21e-17
* device instance cc_XD1_XDFFM_MB_XD3_XN3_mid2 r0 *1 0,0
Ccc_XD1_XDFFM_MB_XD3_XN3_mid2 XD1_XDFFM_MB XD3_XN3_mid2 1.21e-17
* device instance cc_XD1_XDFFM_MB_XD3_dmodout r0 *1 0,0
Ccc_XD1_XDFFM_MB_XD3_dmodout XD1_XDFFM_MB XD3_dmodout 1.21e-17
* device instance cc_XD1_XDFFM_MB_XD3_dq r0 *1 0,0
Ccc_XD1_XDFFM_MB_XD3_dq XD1_XDFFM_MB XD3_dq 1.8151e-17
* device instance cc_XD1_XDFFM_MB_XD3_nm r0 *1 0,0
Ccc_XD1_XDFFM_MB_XD3_nm XD1_XDFFM_MB XD3_nm 1.21e-17
* device instance cc_XD1_XDFFM_MB_XD3_nt r0 *1 0,0
Ccc_XD1_XDFFM_MB_XD3_nt XD1_XDFFM_MB XD3_nt 1.21e-17
* device instance cc_XD1_XDFFM_MB_XD3_t1 r0 *1 0,0
Ccc_XD1_XDFFM_MB_XD3_t1 XD1_XDFFM_MB XD3_t1 1.21e-17
* device instance cc_XD1_XDFFM_MB_XD4_XDFFM_CKBB r0 *1 0,0
Ccc_XD1_XDFFM_MB_XD4_XDFFM_CKBB XD1_XDFFM_MB XD4_XDFFM_CKBB 1.8151e-17
* device instance cc_XD1_XDFFM_MB_XD4_XDFFM_CLKB r0 *1 0,0
Ccc_XD1_XDFFM_MB_XD4_XDFFM_CLKB XD1_XDFFM_MB XD4_XDFFM_CLKB 2.4201e-17
* device instance cc_XD1_XDFFM_MB_XD4_XDFFM_M r0 *1 0,0
Ccc_XD1_XDFFM_MB_XD4_XDFFM_M XD1_XDFFM_MB XD4_XDFFM_M 2.4201e-17
* device instance cc_XD1_XDFFM_MB_XD4_XDFFM_MB r0 *1 0,0
Ccc_XD1_XDFFM_MB_XD4_XDFFM_MB XD1_XDFFM_MB XD4_XDFFM_MB 1.21e-17
* device instance cc_XD1_XDFFM_MB_XD4_XDFFM_MFB r0 *1 0,0
Ccc_XD1_XDFFM_MB_XD4_XDFFM_MFB XD1_XDFFM_MB XD4_XDFFM_MFB 1.21e-17
* device instance cc_XD1_XDFFM_MB_XD4_XDFFM_S r0 *1 0,0
Ccc_XD1_XDFFM_MB_XD4_XDFFM_S XD1_XDFFM_MB XD4_XDFFM_S 1.8151e-17
* device instance cc_XD1_XDFFM_MB_XD4_XDFFM_SB r0 *1 0,0
Ccc_XD1_XDFFM_MB_XD4_XDFFM_SB XD1_XDFFM_MB XD4_XDFFM_SB 1.8151e-17
* device instance cc_XD1_XDFFM_MB_XD4_XDFFM_SFB r0 *1 0,0
Ccc_XD1_XDFFM_MB_XD4_XDFFM_SFB XD1_XDFFM_MB XD4_XDFFM_SFB 1.21e-17
* device instance cc_XD1_XDFFM_MB_XD4_XDFFQ_CKBB r0 *1 0,0
Ccc_XD1_XDFFM_MB_XD4_XDFFQ_CKBB XD1_XDFFM_MB XD4_XDFFQ_CKBB 1.8151e-17
* device instance cc_XD1_XDFFM_MB_XD4_XDFFQ_CLKB r0 *1 0,0
Ccc_XD1_XDFFM_MB_XD4_XDFFQ_CLKB XD1_XDFFM_MB XD4_XDFFQ_CLKB 2.4201e-17
* device instance cc_XD1_XDFFM_MB_XD4_XDFFQ_M r0 *1 0,0
Ccc_XD1_XDFFM_MB_XD4_XDFFQ_M XD1_XDFFM_MB XD4_XDFFQ_M 2.4201e-17
* device instance cc_XD1_XDFFM_MB_XD4_XDFFQ_MB r0 *1 0,0
Ccc_XD1_XDFFM_MB_XD4_XDFFQ_MB XD1_XDFFM_MB XD4_XDFFQ_MB 1.21e-17
* device instance cc_XD1_XDFFM_MB_XD4_XDFFQ_MFB r0 *1 0,0
Ccc_XD1_XDFFM_MB_XD4_XDFFQ_MFB XD1_XDFFM_MB XD4_XDFFQ_MFB 1.21e-17
* device instance cc_XD1_XDFFM_MB_XD4_XDFFQ_S r0 *1 0,0
Ccc_XD1_XDFFM_MB_XD4_XDFFQ_S XD1_XDFFM_MB XD4_XDFFQ_S 1.8151e-17
* device instance cc_XD1_XDFFM_MB_XD4_XDFFQ_SB r0 *1 0,0
Ccc_XD1_XDFFM_MB_XD4_XDFFQ_SB XD1_XDFFM_MB XD4_XDFFQ_SB 1.8151e-17
* device instance cc_XD1_XDFFM_MB_XD4_XDFFQ_SFB r0 *1 0,0
Ccc_XD1_XDFFM_MB_XD4_XDFFQ_SFB XD1_XDFFM_MB XD4_XDFFQ_SFB 1.21e-17
* device instance cc_XD1_XDFFM_MB_XD4_XN2_mid1 r0 *1 0,0
Ccc_XD1_XDFFM_MB_XD4_XN2_mid1 XD1_XDFFM_MB XD4_XN2_mid1 1.21e-17
* device instance cc_XD1_XDFFM_MB_XD4_XN3_mid1 r0 *1 0,0
Ccc_XD1_XDFFM_MB_XD4_XN3_mid1 XD1_XDFFM_MB XD4_XN3_mid1 1.21e-17
* device instance cc_XD1_XDFFM_MB_XD4_XN3_mid2 r0 *1 0,0
Ccc_XD1_XDFFM_MB_XD4_XN3_mid2 XD1_XDFFM_MB XD4_XN3_mid2 1.21e-17
* device instance cc_XD1_XDFFM_MB_XD4_dmodout r0 *1 0,0
Ccc_XD1_XDFFM_MB_XD4_dmodout XD1_XDFFM_MB XD4_dmodout 1.21e-17
* device instance cc_XD1_XDFFM_MB_XD4_dq r0 *1 0,0
Ccc_XD1_XDFFM_MB_XD4_dq XD1_XDFFM_MB XD4_dq 1.8151e-17
* device instance cc_XD1_XDFFM_MB_XD4_nm r0 *1 0,0
Ccc_XD1_XDFFM_MB_XD4_nm XD1_XDFFM_MB XD4_nm 1.21e-17
* device instance cc_XD1_XDFFM_MB_XD4_nt r0 *1 0,0
Ccc_XD1_XDFFM_MB_XD4_nt XD1_XDFFM_MB XD4_nt 1.21e-17
* device instance cc_XD1_XDFFM_MB_XD4_t1 r0 *1 0,0
Ccc_XD1_XDFFM_MB_XD4_t1 XD1_XDFFM_MB XD4_t1 1.21e-17
* device instance cc_XD1_XDFFM_MB_XD5_XDFFM_CKBB r0 *1 0,0
Ccc_XD1_XDFFM_MB_XD5_XDFFM_CKBB XD1_XDFFM_MB XD5_XDFFM_CKBB 1.8151e-17
* device instance cc_XD1_XDFFM_MB_XD5_XDFFM_CLKB r0 *1 0,0
Ccc_XD1_XDFFM_MB_XD5_XDFFM_CLKB XD1_XDFFM_MB XD5_XDFFM_CLKB 2.4201e-17
* device instance cc_XD1_XDFFM_MB_XD5_XDFFM_M r0 *1 0,0
Ccc_XD1_XDFFM_MB_XD5_XDFFM_M XD1_XDFFM_MB XD5_XDFFM_M 2.4201e-17
* device instance cc_XD1_XDFFM_MB_XD5_XDFFM_MB r0 *1 0,0
Ccc_XD1_XDFFM_MB_XD5_XDFFM_MB XD1_XDFFM_MB XD5_XDFFM_MB 1.21e-17
* device instance cc_XD1_XDFFM_MB_XD5_XDFFM_MFB r0 *1 0,0
Ccc_XD1_XDFFM_MB_XD5_XDFFM_MFB XD1_XDFFM_MB XD5_XDFFM_MFB 1.21e-17
* device instance cc_XD1_XDFFM_MB_XD5_XDFFM_S r0 *1 0,0
Ccc_XD1_XDFFM_MB_XD5_XDFFM_S XD1_XDFFM_MB XD5_XDFFM_S 1.8151e-17
* device instance cc_XD1_XDFFM_MB_XD5_XDFFM_SB r0 *1 0,0
Ccc_XD1_XDFFM_MB_XD5_XDFFM_SB XD1_XDFFM_MB XD5_XDFFM_SB 1.8151e-17
* device instance cc_XD1_XDFFM_MB_XD5_XDFFM_SFB r0 *1 0,0
Ccc_XD1_XDFFM_MB_XD5_XDFFM_SFB XD1_XDFFM_MB XD5_XDFFM_SFB 1.21e-17
* device instance cc_XD1_XDFFM_MB_XD5_XDFFQ_CKBB r0 *1 0,0
Ccc_XD1_XDFFM_MB_XD5_XDFFQ_CKBB XD1_XDFFM_MB XD5_XDFFQ_CKBB 1.8151e-17
* device instance cc_XD1_XDFFM_MB_XD5_XDFFQ_CLKB r0 *1 0,0
Ccc_XD1_XDFFM_MB_XD5_XDFFQ_CLKB XD1_XDFFM_MB XD5_XDFFQ_CLKB 2.4201e-17
* device instance cc_XD1_XDFFM_MB_XD5_XDFFQ_M r0 *1 0,0
Ccc_XD1_XDFFM_MB_XD5_XDFFQ_M XD1_XDFFM_MB XD5_XDFFQ_M 2.4201e-17
* device instance cc_XD1_XDFFM_MB_XD5_XDFFQ_MB r0 *1 0,0
Ccc_XD1_XDFFM_MB_XD5_XDFFQ_MB XD1_XDFFM_MB XD5_XDFFQ_MB 1.21e-17
* device instance cc_XD1_XDFFM_MB_XD5_XDFFQ_MFB r0 *1 0,0
Ccc_XD1_XDFFM_MB_XD5_XDFFQ_MFB XD1_XDFFM_MB XD5_XDFFQ_MFB 1.21e-17
* device instance cc_XD1_XDFFM_MB_XD5_XDFFQ_S r0 *1 0,0
Ccc_XD1_XDFFM_MB_XD5_XDFFQ_S XD1_XDFFM_MB XD5_XDFFQ_S 1.8151e-17
* device instance cc_XD1_XDFFM_MB_XD5_XDFFQ_SB r0 *1 0,0
Ccc_XD1_XDFFM_MB_XD5_XDFFQ_SB XD1_XDFFM_MB XD5_XDFFQ_SB 1.8151e-17
* device instance cc_XD1_XDFFM_MB_XD5_XDFFQ_SFB r0 *1 0,0
Ccc_XD1_XDFFM_MB_XD5_XDFFQ_SFB XD1_XDFFM_MB XD5_XDFFQ_SFB 1.21e-17
* device instance cc_XD1_XDFFM_MB_XD5_XN2_mid1 r0 *1 0,0
Ccc_XD1_XDFFM_MB_XD5_XN2_mid1 XD1_XDFFM_MB XD5_XN2_mid1 1.21e-17
* device instance cc_XD1_XDFFM_MB_XD5_XN3_mid1 r0 *1 0,0
Ccc_XD1_XDFFM_MB_XD5_XN3_mid1 XD1_XDFFM_MB XD5_XN3_mid1 1.21e-17
* device instance cc_XD1_XDFFM_MB_XD5_XN3_mid2 r0 *1 0,0
Ccc_XD1_XDFFM_MB_XD5_XN3_mid2 XD1_XDFFM_MB XD5_XN3_mid2 1.21e-17
* device instance cc_XD1_XDFFM_MB_XD5_dmodout r0 *1 0,0
Ccc_XD1_XDFFM_MB_XD5_dmodout XD1_XDFFM_MB XD5_dmodout 1.21e-17
* device instance cc_XD1_XDFFM_MB_XD5_dq r0 *1 0,0
Ccc_XD1_XDFFM_MB_XD5_dq XD1_XDFFM_MB XD5_dq 1.8151e-17
* device instance cc_XD1_XDFFM_MB_XD5_nm r0 *1 0,0
Ccc_XD1_XDFFM_MB_XD5_nm XD1_XDFFM_MB XD5_nm 1.21e-17
* device instance cc_XD1_XDFFM_MB_XD5_nt r0 *1 0,0
Ccc_XD1_XDFFM_MB_XD5_nt XD1_XDFFM_MB XD5_nt 1.21e-17
* device instance cc_XD1_XDFFM_MB_XD5_t1 r0 *1 0,0
Ccc_XD1_XDFFM_MB_XD5_t1 XD1_XDFFM_MB XD5_t1 1.21e-17
* device instance cc_XD1_XDFFM_MB_XFRT_CKBB r0 *1 0,0
Ccc_XD1_XDFFM_MB_XFRT_CKBB XD1_XDFFM_MB XFRT_CKBB 1.8151e-17
* device instance cc_XD1_XDFFM_MB_XFRT_CLKB r0 *1 0,0
Ccc_XD1_XDFFM_MB_XFRT_CLKB XD1_XDFFM_MB XFRT_CLKB 2.4201e-17
* device instance cc_XD1_XDFFM_MB_XFRT_M r0 *1 0,0
Ccc_XD1_XDFFM_MB_XFRT_M XD1_XDFFM_MB XFRT_M 2.4201e-17
* device instance cc_XD1_XDFFM_MB_XFRT_MB r0 *1 0,0
Ccc_XD1_XDFFM_MB_XFRT_MB XD1_XDFFM_MB XFRT_MB 1.21e-17
* device instance cc_XD1_XDFFM_MB_XFRT_MFB r0 *1 0,0
Ccc_XD1_XDFFM_MB_XFRT_MFB XD1_XDFFM_MB XFRT_MFB 1.21e-17
* device instance cc_XD1_XDFFM_MB_XFRT_S r0 *1 0,0
Ccc_XD1_XDFFM_MB_XFRT_S XD1_XDFFM_MB XFRT_S 1.8151e-17
* device instance cc_XD1_XDFFM_MB_XFRT_SB r0 *1 0,0
Ccc_XD1_XDFFM_MB_XFRT_SB XD1_XDFFM_MB XFRT_SB 1.8151e-17
* device instance cc_XD1_XDFFM_MB_XFRT_SFB r0 *1 0,0
Ccc_XD1_XDFFM_MB_XFRT_SFB XD1_XDFFM_MB XFRT_SFB 1.21e-17
* device instance cc_XD1_XDFFM_MB_ck1 r0 *1 0,0
Ccc_XD1_XDFFM_MB_ck1 XD1_XDFFM_MB ck1 3.0251e-17
* device instance cc_XD1_XDFFM_MB_ck2 r0 *1 0,0
Ccc_XD1_XDFFM_MB_ck2 XD1_XDFFM_MB ck2 3.0251e-17
* device instance cc_XD1_XDFFM_MB_ck3 r0 *1 0,0
Ccc_XD1_XDFFM_MB_ck3 XD1_XDFFM_MB ck3 3.0251e-17
* device instance cc_XD1_XDFFM_MB_ck4 r0 *1 0,0
Ccc_XD1_XDFFM_MB_ck4 XD1_XDFFM_MB ck4 3.0251e-17
* device instance cc_XD1_XDFFM_MB_ck5 r0 *1 0,0
Ccc_XD1_XDFFM_MB_ck5 XD1_XDFFM_MB ck5 3.0251e-17
* device instance cc_XD1_XDFFM_MB_mod0 r0 *1 0,0
Ccc_XD1_XDFFM_MB_mod0 XD1_XDFFM_MB mod0 2.4201e-17
* device instance cc_XD1_XDFFM_MB_mod1 r0 *1 0,0
Ccc_XD1_XDFFM_MB_mod1 XD1_XDFFM_MB mod1 2.4201e-17
* device instance cc_XD1_XDFFM_MB_mod2 r0 *1 0,0
Ccc_XD1_XDFFM_MB_mod2 XD1_XDFFM_MB mod2 2.4201e-17
* device instance cc_XD1_XDFFM_MB_mod3 r0 *1 0,0
Ccc_XD1_XDFFM_MB_mod3 XD1_XDFFM_MB mod3 2.4201e-17
* device instance cc_XD1_XDFFM_MB_mod4 r0 *1 0,0
Ccc_XD1_XDFFM_MB_mod4 XD1_XDFFM_MB mod4 2.4201e-17
* device instance cc_XD1_XDFFM_MB_net1 r0 *1 0,0
Ccc_XD1_XDFFM_MB_net1 XD1_XDFFM_MB net1 1.21e-17
* device instance cc_XD1_XDFFM_MFB_XD1_XDFFM_S r0 *1 0,0
Ccc_XD1_XDFFM_MFB_XD1_XDFFM_S XD1_XDFFM_MFB XD1_XDFFM_S 1.8151e-17
* device instance cc_XD1_XDFFM_MFB_XD1_XDFFM_SB r0 *1 0,0
Ccc_XD1_XDFFM_MFB_XD1_XDFFM_SB XD1_XDFFM_MFB XD1_XDFFM_SB 1.8151e-17
* device instance cc_XD1_XDFFM_MFB_XD1_XDFFM_SFB r0 *1 0,0
Ccc_XD1_XDFFM_MFB_XD1_XDFFM_SFB XD1_XDFFM_MFB XD1_XDFFM_SFB 1.21e-17
* device instance cc_XD1_XDFFM_MFB_XD1_XDFFQ_CKBB r0 *1 0,0
Ccc_XD1_XDFFM_MFB_XD1_XDFFQ_CKBB XD1_XDFFM_MFB XD1_XDFFQ_CKBB 1.8151e-17
* device instance cc_XD1_XDFFM_MFB_XD1_XDFFQ_CLKB r0 *1 0,0
Ccc_XD1_XDFFM_MFB_XD1_XDFFQ_CLKB XD1_XDFFM_MFB XD1_XDFFQ_CLKB 2.4201e-17
* device instance cc_XD1_XDFFM_MFB_XD1_XDFFQ_M r0 *1 0,0
Ccc_XD1_XDFFM_MFB_XD1_XDFFQ_M XD1_XDFFM_MFB XD1_XDFFQ_M 2.4201e-17
* device instance cc_XD1_XDFFM_MFB_XD1_XDFFQ_MB r0 *1 0,0
Ccc_XD1_XDFFM_MFB_XD1_XDFFQ_MB XD1_XDFFM_MFB XD1_XDFFQ_MB 1.21e-17
* device instance cc_XD1_XDFFM_MFB_XD1_XDFFQ_MFB r0 *1 0,0
Ccc_XD1_XDFFM_MFB_XD1_XDFFQ_MFB XD1_XDFFM_MFB XD1_XDFFQ_MFB 1.21e-17
* device instance cc_XD1_XDFFM_MFB_XD1_XDFFQ_S r0 *1 0,0
Ccc_XD1_XDFFM_MFB_XD1_XDFFQ_S XD1_XDFFM_MFB XD1_XDFFQ_S 1.8151e-17
* device instance cc_XD1_XDFFM_MFB_XD1_XDFFQ_SB r0 *1 0,0
Ccc_XD1_XDFFM_MFB_XD1_XDFFQ_SB XD1_XDFFM_MFB XD1_XDFFQ_SB 1.8151e-17
* device instance cc_XD1_XDFFM_MFB_XD1_XDFFQ_SFB r0 *1 0,0
Ccc_XD1_XDFFM_MFB_XD1_XDFFQ_SFB XD1_XDFFM_MFB XD1_XDFFQ_SFB 1.21e-17
* device instance cc_XD1_XDFFM_MFB_XD1_XNOR_midp r0 *1 0,0
Ccc_XD1_XDFFM_MFB_XD1_XNOR_midp XD1_XDFFM_MFB XD1_XNOR_midp 1.21e-17
* device instance cc_XD1_XDFFM_MFB_XD1_dmodout r0 *1 0,0
Ccc_XD1_XDFFM_MFB_XD1_dmodout XD1_XDFFM_MFB XD1_dmodout 1.21e-17
* device instance cc_XD1_XDFFM_MFB_XD1_dq r0 *1 0,0
Ccc_XD1_XDFFM_MFB_XD1_dq XD1_XDFFM_MFB XD1_dq 1.21e-17
* device instance cc_XD1_XDFFM_MFB_XD1_nm r0 *1 0,0
Ccc_XD1_XDFFM_MFB_XD1_nm XD1_XDFFM_MFB XD1_nm 1.8151e-17
* device instance cc_XD1_XDFFM_MFB_XD1_nt r0 *1 0,0
Ccc_XD1_XDFFM_MFB_XD1_nt XD1_XDFFM_MFB XD1_nt 2.4201e-17
* device instance cc_XD1_XDFFM_MFB_XD1_t1 r0 *1 0,0
Ccc_XD1_XDFFM_MFB_XD1_t1 XD1_XDFFM_MFB XD1_t1 1.21e-17
* device instance cc_XD1_XDFFM_MFB_XD2_XDFFM_CKBB r0 *1 0,0
Ccc_XD1_XDFFM_MFB_XD2_XDFFM_CKBB XD1_XDFFM_MFB XD2_XDFFM_CKBB 1.8151e-17
* device instance cc_XD1_XDFFM_MFB_XD2_XDFFM_CLKB r0 *1 0,0
Ccc_XD1_XDFFM_MFB_XD2_XDFFM_CLKB XD1_XDFFM_MFB XD2_XDFFM_CLKB 2.4201e-17
* device instance cc_XD1_XDFFM_MFB_XD2_XDFFM_M r0 *1 0,0
Ccc_XD1_XDFFM_MFB_XD2_XDFFM_M XD1_XDFFM_MFB XD2_XDFFM_M 2.4201e-17
* device instance cc_XD1_XDFFM_MFB_XD2_XDFFM_MB r0 *1 0,0
Ccc_XD1_XDFFM_MFB_XD2_XDFFM_MB XD1_XDFFM_MFB XD2_XDFFM_MB 1.21e-17
* device instance cc_XD1_XDFFM_MFB_XD2_XDFFM_MFB r0 *1 0,0
Ccc_XD1_XDFFM_MFB_XD2_XDFFM_MFB XD1_XDFFM_MFB XD2_XDFFM_MFB 1.21e-17
* device instance cc_XD1_XDFFM_MFB_XD2_XDFFM_S r0 *1 0,0
Ccc_XD1_XDFFM_MFB_XD2_XDFFM_S XD1_XDFFM_MFB XD2_XDFFM_S 1.8151e-17
* device instance cc_XD1_XDFFM_MFB_XD2_XDFFM_SB r0 *1 0,0
Ccc_XD1_XDFFM_MFB_XD2_XDFFM_SB XD1_XDFFM_MFB XD2_XDFFM_SB 1.8151e-17
* device instance cc_XD1_XDFFM_MFB_XD2_XDFFM_SFB r0 *1 0,0
Ccc_XD1_XDFFM_MFB_XD2_XDFFM_SFB XD1_XDFFM_MFB XD2_XDFFM_SFB 1.21e-17
* device instance cc_XD1_XDFFM_MFB_XD2_XDFFQ_CKBB r0 *1 0,0
Ccc_XD1_XDFFM_MFB_XD2_XDFFQ_CKBB XD1_XDFFM_MFB XD2_XDFFQ_CKBB 1.8151e-17
* device instance cc_XD1_XDFFM_MFB_XD2_XDFFQ_CLKB r0 *1 0,0
Ccc_XD1_XDFFM_MFB_XD2_XDFFQ_CLKB XD1_XDFFM_MFB XD2_XDFFQ_CLKB 2.4201e-17
* device instance cc_XD1_XDFFM_MFB_XD2_XDFFQ_M r0 *1 0,0
Ccc_XD1_XDFFM_MFB_XD2_XDFFQ_M XD1_XDFFM_MFB XD2_XDFFQ_M 2.4201e-17
* device instance cc_XD1_XDFFM_MFB_XD2_XDFFQ_MB r0 *1 0,0
Ccc_XD1_XDFFM_MFB_XD2_XDFFQ_MB XD1_XDFFM_MFB XD2_XDFFQ_MB 1.21e-17
* device instance cc_XD1_XDFFM_MFB_XD2_XDFFQ_MFB r0 *1 0,0
Ccc_XD1_XDFFM_MFB_XD2_XDFFQ_MFB XD1_XDFFM_MFB XD2_XDFFQ_MFB 1.21e-17
* device instance cc_XD1_XDFFM_MFB_XD2_XDFFQ_S r0 *1 0,0
Ccc_XD1_XDFFM_MFB_XD2_XDFFQ_S XD1_XDFFM_MFB XD2_XDFFQ_S 1.8151e-17
* device instance cc_XD1_XDFFM_MFB_XD2_XDFFQ_SB r0 *1 0,0
Ccc_XD1_XDFFM_MFB_XD2_XDFFQ_SB XD1_XDFFM_MFB XD2_XDFFQ_SB 1.8151e-17
* device instance cc_XD1_XDFFM_MFB_XD2_XDFFQ_SFB r0 *1 0,0
Ccc_XD1_XDFFM_MFB_XD2_XDFFQ_SFB XD1_XDFFM_MFB XD2_XDFFQ_SFB 1.21e-17
* device instance cc_XD1_XDFFM_MFB_XD2_XN2_mid1 r0 *1 0,0
Ccc_XD1_XDFFM_MFB_XD2_XN2_mid1 XD1_XDFFM_MFB XD2_XN2_mid1 1.21e-17
* device instance cc_XD1_XDFFM_MFB_XD2_XN3_mid1 r0 *1 0,0
Ccc_XD1_XDFFM_MFB_XD2_XN3_mid1 XD1_XDFFM_MFB XD2_XN3_mid1 1.21e-17
* device instance cc_XD1_XDFFM_MFB_XD2_XN3_mid2 r0 *1 0,0
Ccc_XD1_XDFFM_MFB_XD2_XN3_mid2 XD1_XDFFM_MFB XD2_XN3_mid2 1.21e-17
* device instance cc_XD1_XDFFM_MFB_XD2_dmodout r0 *1 0,0
Ccc_XD1_XDFFM_MFB_XD2_dmodout XD1_XDFFM_MFB XD2_dmodout 1.21e-17
* device instance cc_XD1_XDFFM_MFB_XD2_dq r0 *1 0,0
Ccc_XD1_XDFFM_MFB_XD2_dq XD1_XDFFM_MFB XD2_dq 1.8151e-17
* device instance cc_XD1_XDFFM_MFB_XD2_nm r0 *1 0,0
Ccc_XD1_XDFFM_MFB_XD2_nm XD1_XDFFM_MFB XD2_nm 1.21e-17
* device instance cc_XD1_XDFFM_MFB_XD2_nt r0 *1 0,0
Ccc_XD1_XDFFM_MFB_XD2_nt XD1_XDFFM_MFB XD2_nt 1.21e-17
* device instance cc_XD1_XDFFM_MFB_XD2_t1 r0 *1 0,0
Ccc_XD1_XDFFM_MFB_XD2_t1 XD1_XDFFM_MFB XD2_t1 1.21e-17
* device instance cc_XD1_XDFFM_MFB_XD3_XDFFM_CKBB r0 *1 0,0
Ccc_XD1_XDFFM_MFB_XD3_XDFFM_CKBB XD1_XDFFM_MFB XD3_XDFFM_CKBB 1.8151e-17
* device instance cc_XD1_XDFFM_MFB_XD3_XDFFM_CLKB r0 *1 0,0
Ccc_XD1_XDFFM_MFB_XD3_XDFFM_CLKB XD1_XDFFM_MFB XD3_XDFFM_CLKB 2.4201e-17
* device instance cc_XD1_XDFFM_MFB_XD3_XDFFM_M r0 *1 0,0
Ccc_XD1_XDFFM_MFB_XD3_XDFFM_M XD1_XDFFM_MFB XD3_XDFFM_M 2.4201e-17
* device instance cc_XD1_XDFFM_MFB_XD3_XDFFM_MB r0 *1 0,0
Ccc_XD1_XDFFM_MFB_XD3_XDFFM_MB XD1_XDFFM_MFB XD3_XDFFM_MB 1.21e-17
* device instance cc_XD1_XDFFM_MFB_XD3_XDFFM_MFB r0 *1 0,0
Ccc_XD1_XDFFM_MFB_XD3_XDFFM_MFB XD1_XDFFM_MFB XD3_XDFFM_MFB 1.21e-17
* device instance cc_XD1_XDFFM_MFB_XD3_XDFFM_S r0 *1 0,0
Ccc_XD1_XDFFM_MFB_XD3_XDFFM_S XD1_XDFFM_MFB XD3_XDFFM_S 1.8151e-17
* device instance cc_XD1_XDFFM_MFB_XD3_XDFFM_SB r0 *1 0,0
Ccc_XD1_XDFFM_MFB_XD3_XDFFM_SB XD1_XDFFM_MFB XD3_XDFFM_SB 1.8151e-17
* device instance cc_XD1_XDFFM_MFB_XD3_XDFFM_SFB r0 *1 0,0
Ccc_XD1_XDFFM_MFB_XD3_XDFFM_SFB XD1_XDFFM_MFB XD3_XDFFM_SFB 1.21e-17
* device instance cc_XD1_XDFFM_MFB_XD3_XDFFQ_CKBB r0 *1 0,0
Ccc_XD1_XDFFM_MFB_XD3_XDFFQ_CKBB XD1_XDFFM_MFB XD3_XDFFQ_CKBB 1.8151e-17
* device instance cc_XD1_XDFFM_MFB_XD3_XDFFQ_CLKB r0 *1 0,0
Ccc_XD1_XDFFM_MFB_XD3_XDFFQ_CLKB XD1_XDFFM_MFB XD3_XDFFQ_CLKB 2.4201e-17
* device instance cc_XD1_XDFFM_MFB_XD3_XDFFQ_M r0 *1 0,0
Ccc_XD1_XDFFM_MFB_XD3_XDFFQ_M XD1_XDFFM_MFB XD3_XDFFQ_M 2.4201e-17
* device instance cc_XD1_XDFFM_MFB_XD3_XDFFQ_MB r0 *1 0,0
Ccc_XD1_XDFFM_MFB_XD3_XDFFQ_MB XD1_XDFFM_MFB XD3_XDFFQ_MB 1.21e-17
* device instance cc_XD1_XDFFM_MFB_XD3_XDFFQ_MFB r0 *1 0,0
Ccc_XD1_XDFFM_MFB_XD3_XDFFQ_MFB XD1_XDFFM_MFB XD3_XDFFQ_MFB 1.21e-17
* device instance cc_XD1_XDFFM_MFB_XD3_XDFFQ_S r0 *1 0,0
Ccc_XD1_XDFFM_MFB_XD3_XDFFQ_S XD1_XDFFM_MFB XD3_XDFFQ_S 1.8151e-17
* device instance cc_XD1_XDFFM_MFB_XD3_XDFFQ_SB r0 *1 0,0
Ccc_XD1_XDFFM_MFB_XD3_XDFFQ_SB XD1_XDFFM_MFB XD3_XDFFQ_SB 1.8151e-17
* device instance cc_XD1_XDFFM_MFB_XD3_XDFFQ_SFB r0 *1 0,0
Ccc_XD1_XDFFM_MFB_XD3_XDFFQ_SFB XD1_XDFFM_MFB XD3_XDFFQ_SFB 1.21e-17
* device instance cc_XD1_XDFFM_MFB_XD3_XN2_mid1 r0 *1 0,0
Ccc_XD1_XDFFM_MFB_XD3_XN2_mid1 XD1_XDFFM_MFB XD3_XN2_mid1 1.21e-17
* device instance cc_XD1_XDFFM_MFB_XD3_XN3_mid1 r0 *1 0,0
Ccc_XD1_XDFFM_MFB_XD3_XN3_mid1 XD1_XDFFM_MFB XD3_XN3_mid1 1.21e-17
* device instance cc_XD1_XDFFM_MFB_XD3_XN3_mid2 r0 *1 0,0
Ccc_XD1_XDFFM_MFB_XD3_XN3_mid2 XD1_XDFFM_MFB XD3_XN3_mid2 1.21e-17
* device instance cc_XD1_XDFFM_MFB_XD3_dmodout r0 *1 0,0
Ccc_XD1_XDFFM_MFB_XD3_dmodout XD1_XDFFM_MFB XD3_dmodout 1.21e-17
* device instance cc_XD1_XDFFM_MFB_XD3_dq r0 *1 0,0
Ccc_XD1_XDFFM_MFB_XD3_dq XD1_XDFFM_MFB XD3_dq 1.8151e-17
* device instance cc_XD1_XDFFM_MFB_XD3_nm r0 *1 0,0
Ccc_XD1_XDFFM_MFB_XD3_nm XD1_XDFFM_MFB XD3_nm 1.21e-17
* device instance cc_XD1_XDFFM_MFB_XD3_nt r0 *1 0,0
Ccc_XD1_XDFFM_MFB_XD3_nt XD1_XDFFM_MFB XD3_nt 1.21e-17
* device instance cc_XD1_XDFFM_MFB_XD3_t1 r0 *1 0,0
Ccc_XD1_XDFFM_MFB_XD3_t1 XD1_XDFFM_MFB XD3_t1 1.21e-17
* device instance cc_XD1_XDFFM_MFB_XD4_XDFFM_CKBB r0 *1 0,0
Ccc_XD1_XDFFM_MFB_XD4_XDFFM_CKBB XD1_XDFFM_MFB XD4_XDFFM_CKBB 1.8151e-17
* device instance cc_XD1_XDFFM_MFB_XD4_XDFFM_CLKB r0 *1 0,0
Ccc_XD1_XDFFM_MFB_XD4_XDFFM_CLKB XD1_XDFFM_MFB XD4_XDFFM_CLKB 2.4201e-17
* device instance cc_XD1_XDFFM_MFB_XD4_XDFFM_M r0 *1 0,0
Ccc_XD1_XDFFM_MFB_XD4_XDFFM_M XD1_XDFFM_MFB XD4_XDFFM_M 2.4201e-17
* device instance cc_XD1_XDFFM_MFB_XD4_XDFFM_MB r0 *1 0,0
Ccc_XD1_XDFFM_MFB_XD4_XDFFM_MB XD1_XDFFM_MFB XD4_XDFFM_MB 1.21e-17
* device instance cc_XD1_XDFFM_MFB_XD4_XDFFM_MFB r0 *1 0,0
Ccc_XD1_XDFFM_MFB_XD4_XDFFM_MFB XD1_XDFFM_MFB XD4_XDFFM_MFB 1.21e-17
* device instance cc_XD1_XDFFM_MFB_XD4_XDFFM_S r0 *1 0,0
Ccc_XD1_XDFFM_MFB_XD4_XDFFM_S XD1_XDFFM_MFB XD4_XDFFM_S 1.8151e-17
* device instance cc_XD1_XDFFM_MFB_XD4_XDFFM_SB r0 *1 0,0
Ccc_XD1_XDFFM_MFB_XD4_XDFFM_SB XD1_XDFFM_MFB XD4_XDFFM_SB 1.8151e-17
* device instance cc_XD1_XDFFM_MFB_XD4_XDFFM_SFB r0 *1 0,0
Ccc_XD1_XDFFM_MFB_XD4_XDFFM_SFB XD1_XDFFM_MFB XD4_XDFFM_SFB 1.21e-17
* device instance cc_XD1_XDFFM_MFB_XD4_XDFFQ_CKBB r0 *1 0,0
Ccc_XD1_XDFFM_MFB_XD4_XDFFQ_CKBB XD1_XDFFM_MFB XD4_XDFFQ_CKBB 1.8151e-17
* device instance cc_XD1_XDFFM_MFB_XD4_XDFFQ_CLKB r0 *1 0,0
Ccc_XD1_XDFFM_MFB_XD4_XDFFQ_CLKB XD1_XDFFM_MFB XD4_XDFFQ_CLKB 2.4201e-17
* device instance cc_XD1_XDFFM_MFB_XD4_XDFFQ_M r0 *1 0,0
Ccc_XD1_XDFFM_MFB_XD4_XDFFQ_M XD1_XDFFM_MFB XD4_XDFFQ_M 2.4201e-17
* device instance cc_XD1_XDFFM_MFB_XD4_XDFFQ_MB r0 *1 0,0
Ccc_XD1_XDFFM_MFB_XD4_XDFFQ_MB XD1_XDFFM_MFB XD4_XDFFQ_MB 1.21e-17
* device instance cc_XD1_XDFFM_MFB_XD4_XDFFQ_MFB r0 *1 0,0
Ccc_XD1_XDFFM_MFB_XD4_XDFFQ_MFB XD1_XDFFM_MFB XD4_XDFFQ_MFB 1.21e-17
* device instance cc_XD1_XDFFM_MFB_XD4_XDFFQ_S r0 *1 0,0
Ccc_XD1_XDFFM_MFB_XD4_XDFFQ_S XD1_XDFFM_MFB XD4_XDFFQ_S 1.8151e-17
* device instance cc_XD1_XDFFM_MFB_XD4_XDFFQ_SB r0 *1 0,0
Ccc_XD1_XDFFM_MFB_XD4_XDFFQ_SB XD1_XDFFM_MFB XD4_XDFFQ_SB 1.8151e-17
* device instance cc_XD1_XDFFM_MFB_XD4_XDFFQ_SFB r0 *1 0,0
Ccc_XD1_XDFFM_MFB_XD4_XDFFQ_SFB XD1_XDFFM_MFB XD4_XDFFQ_SFB 1.21e-17
* device instance cc_XD1_XDFFM_MFB_XD4_XN2_mid1 r0 *1 0,0
Ccc_XD1_XDFFM_MFB_XD4_XN2_mid1 XD1_XDFFM_MFB XD4_XN2_mid1 1.21e-17
* device instance cc_XD1_XDFFM_MFB_XD4_XN3_mid1 r0 *1 0,0
Ccc_XD1_XDFFM_MFB_XD4_XN3_mid1 XD1_XDFFM_MFB XD4_XN3_mid1 1.21e-17
* device instance cc_XD1_XDFFM_MFB_XD4_XN3_mid2 r0 *1 0,0
Ccc_XD1_XDFFM_MFB_XD4_XN3_mid2 XD1_XDFFM_MFB XD4_XN3_mid2 1.21e-17
* device instance cc_XD1_XDFFM_MFB_XD4_dmodout r0 *1 0,0
Ccc_XD1_XDFFM_MFB_XD4_dmodout XD1_XDFFM_MFB XD4_dmodout 1.21e-17
* device instance cc_XD1_XDFFM_MFB_XD4_dq r0 *1 0,0
Ccc_XD1_XDFFM_MFB_XD4_dq XD1_XDFFM_MFB XD4_dq 1.8151e-17
* device instance cc_XD1_XDFFM_MFB_XD4_nm r0 *1 0,0
Ccc_XD1_XDFFM_MFB_XD4_nm XD1_XDFFM_MFB XD4_nm 1.21e-17
* device instance cc_XD1_XDFFM_MFB_XD4_nt r0 *1 0,0
Ccc_XD1_XDFFM_MFB_XD4_nt XD1_XDFFM_MFB XD4_nt 1.21e-17
* device instance cc_XD1_XDFFM_MFB_XD4_t1 r0 *1 0,0
Ccc_XD1_XDFFM_MFB_XD4_t1 XD1_XDFFM_MFB XD4_t1 1.21e-17
* device instance cc_XD1_XDFFM_MFB_XD5_XDFFM_CKBB r0 *1 0,0
Ccc_XD1_XDFFM_MFB_XD5_XDFFM_CKBB XD1_XDFFM_MFB XD5_XDFFM_CKBB 1.8151e-17
* device instance cc_XD1_XDFFM_MFB_XD5_XDFFM_CLKB r0 *1 0,0
Ccc_XD1_XDFFM_MFB_XD5_XDFFM_CLKB XD1_XDFFM_MFB XD5_XDFFM_CLKB 2.4201e-17
* device instance cc_XD1_XDFFM_MFB_XD5_XDFFM_M r0 *1 0,0
Ccc_XD1_XDFFM_MFB_XD5_XDFFM_M XD1_XDFFM_MFB XD5_XDFFM_M 2.4201e-17
* device instance cc_XD1_XDFFM_MFB_XD5_XDFFM_MB r0 *1 0,0
Ccc_XD1_XDFFM_MFB_XD5_XDFFM_MB XD1_XDFFM_MFB XD5_XDFFM_MB 1.21e-17
* device instance cc_XD1_XDFFM_MFB_XD5_XDFFM_MFB r0 *1 0,0
Ccc_XD1_XDFFM_MFB_XD5_XDFFM_MFB XD1_XDFFM_MFB XD5_XDFFM_MFB 1.21e-17
* device instance cc_XD1_XDFFM_MFB_XD5_XDFFM_S r0 *1 0,0
Ccc_XD1_XDFFM_MFB_XD5_XDFFM_S XD1_XDFFM_MFB XD5_XDFFM_S 1.8151e-17
* device instance cc_XD1_XDFFM_MFB_XD5_XDFFM_SB r0 *1 0,0
Ccc_XD1_XDFFM_MFB_XD5_XDFFM_SB XD1_XDFFM_MFB XD5_XDFFM_SB 1.8151e-17
* device instance cc_XD1_XDFFM_MFB_XD5_XDFFM_SFB r0 *1 0,0
Ccc_XD1_XDFFM_MFB_XD5_XDFFM_SFB XD1_XDFFM_MFB XD5_XDFFM_SFB 1.21e-17
* device instance cc_XD1_XDFFM_MFB_XD5_XDFFQ_CKBB r0 *1 0,0
Ccc_XD1_XDFFM_MFB_XD5_XDFFQ_CKBB XD1_XDFFM_MFB XD5_XDFFQ_CKBB 1.8151e-17
* device instance cc_XD1_XDFFM_MFB_XD5_XDFFQ_CLKB r0 *1 0,0
Ccc_XD1_XDFFM_MFB_XD5_XDFFQ_CLKB XD1_XDFFM_MFB XD5_XDFFQ_CLKB 2.4201e-17
* device instance cc_XD1_XDFFM_MFB_XD5_XDFFQ_M r0 *1 0,0
Ccc_XD1_XDFFM_MFB_XD5_XDFFQ_M XD1_XDFFM_MFB XD5_XDFFQ_M 2.4201e-17
* device instance cc_XD1_XDFFM_MFB_XD5_XDFFQ_MB r0 *1 0,0
Ccc_XD1_XDFFM_MFB_XD5_XDFFQ_MB XD1_XDFFM_MFB XD5_XDFFQ_MB 1.21e-17
* device instance cc_XD1_XDFFM_MFB_XD5_XDFFQ_MFB r0 *1 0,0
Ccc_XD1_XDFFM_MFB_XD5_XDFFQ_MFB XD1_XDFFM_MFB XD5_XDFFQ_MFB 1.21e-17
* device instance cc_XD1_XDFFM_MFB_XD5_XDFFQ_S r0 *1 0,0
Ccc_XD1_XDFFM_MFB_XD5_XDFFQ_S XD1_XDFFM_MFB XD5_XDFFQ_S 1.8151e-17
* device instance cc_XD1_XDFFM_MFB_XD5_XDFFQ_SB r0 *1 0,0
Ccc_XD1_XDFFM_MFB_XD5_XDFFQ_SB XD1_XDFFM_MFB XD5_XDFFQ_SB 1.8151e-17
* device instance cc_XD1_XDFFM_MFB_XD5_XDFFQ_SFB r0 *1 0,0
Ccc_XD1_XDFFM_MFB_XD5_XDFFQ_SFB XD1_XDFFM_MFB XD5_XDFFQ_SFB 1.21e-17
* device instance cc_XD1_XDFFM_MFB_XD5_XN2_mid1 r0 *1 0,0
Ccc_XD1_XDFFM_MFB_XD5_XN2_mid1 XD1_XDFFM_MFB XD5_XN2_mid1 1.21e-17
* device instance cc_XD1_XDFFM_MFB_XD5_XN3_mid1 r0 *1 0,0
Ccc_XD1_XDFFM_MFB_XD5_XN3_mid1 XD1_XDFFM_MFB XD5_XN3_mid1 1.21e-17
* device instance cc_XD1_XDFFM_MFB_XD5_XN3_mid2 r0 *1 0,0
Ccc_XD1_XDFFM_MFB_XD5_XN3_mid2 XD1_XDFFM_MFB XD5_XN3_mid2 1.21e-17
* device instance cc_XD1_XDFFM_MFB_XD5_dmodout r0 *1 0,0
Ccc_XD1_XDFFM_MFB_XD5_dmodout XD1_XDFFM_MFB XD5_dmodout 1.21e-17
* device instance cc_XD1_XDFFM_MFB_XD5_dq r0 *1 0,0
Ccc_XD1_XDFFM_MFB_XD5_dq XD1_XDFFM_MFB XD5_dq 1.8151e-17
* device instance cc_XD1_XDFFM_MFB_XD5_nm r0 *1 0,0
Ccc_XD1_XDFFM_MFB_XD5_nm XD1_XDFFM_MFB XD5_nm 1.21e-17
* device instance cc_XD1_XDFFM_MFB_XD5_nt r0 *1 0,0
Ccc_XD1_XDFFM_MFB_XD5_nt XD1_XDFFM_MFB XD5_nt 1.21e-17
* device instance cc_XD1_XDFFM_MFB_XD5_t1 r0 *1 0,0
Ccc_XD1_XDFFM_MFB_XD5_t1 XD1_XDFFM_MFB XD5_t1 1.21e-17
* device instance cc_XD1_XDFFM_MFB_XFRT_CKBB r0 *1 0,0
Ccc_XD1_XDFFM_MFB_XFRT_CKBB XD1_XDFFM_MFB XFRT_CKBB 1.8151e-17
* device instance cc_XD1_XDFFM_MFB_XFRT_CLKB r0 *1 0,0
Ccc_XD1_XDFFM_MFB_XFRT_CLKB XD1_XDFFM_MFB XFRT_CLKB 2.4201e-17
* device instance cc_XD1_XDFFM_MFB_XFRT_M r0 *1 0,0
Ccc_XD1_XDFFM_MFB_XFRT_M XD1_XDFFM_MFB XFRT_M 2.4201e-17
* device instance cc_XD1_XDFFM_MFB_XFRT_MB r0 *1 0,0
Ccc_XD1_XDFFM_MFB_XFRT_MB XD1_XDFFM_MFB XFRT_MB 1.21e-17
* device instance cc_XD1_XDFFM_MFB_XFRT_MFB r0 *1 0,0
Ccc_XD1_XDFFM_MFB_XFRT_MFB XD1_XDFFM_MFB XFRT_MFB 1.21e-17
* device instance cc_XD1_XDFFM_MFB_XFRT_S r0 *1 0,0
Ccc_XD1_XDFFM_MFB_XFRT_S XD1_XDFFM_MFB XFRT_S 1.8151e-17
* device instance cc_XD1_XDFFM_MFB_XFRT_SB r0 *1 0,0
Ccc_XD1_XDFFM_MFB_XFRT_SB XD1_XDFFM_MFB XFRT_SB 1.8151e-17
* device instance cc_XD1_XDFFM_MFB_XFRT_SFB r0 *1 0,0
Ccc_XD1_XDFFM_MFB_XFRT_SFB XD1_XDFFM_MFB XFRT_SFB 1.21e-17
* device instance cc_XD1_XDFFM_MFB_ck1 r0 *1 0,0
Ccc_XD1_XDFFM_MFB_ck1 XD1_XDFFM_MFB ck1 3.0251e-17
* device instance cc_XD1_XDFFM_MFB_ck2 r0 *1 0,0
Ccc_XD1_XDFFM_MFB_ck2 XD1_XDFFM_MFB ck2 3.0251e-17
* device instance cc_XD1_XDFFM_MFB_ck3 r0 *1 0,0
Ccc_XD1_XDFFM_MFB_ck3 XD1_XDFFM_MFB ck3 3.0251e-17
* device instance cc_XD1_XDFFM_MFB_ck4 r0 *1 0,0
Ccc_XD1_XDFFM_MFB_ck4 XD1_XDFFM_MFB ck4 3.0251e-17
* device instance cc_XD1_XDFFM_MFB_ck5 r0 *1 0,0
Ccc_XD1_XDFFM_MFB_ck5 XD1_XDFFM_MFB ck5 3.0251e-17
* device instance cc_XD1_XDFFM_MFB_mod0 r0 *1 0,0
Ccc_XD1_XDFFM_MFB_mod0 XD1_XDFFM_MFB mod0 2.4201e-17
* device instance cc_XD1_XDFFM_MFB_mod1 r0 *1 0,0
Ccc_XD1_XDFFM_MFB_mod1 XD1_XDFFM_MFB mod1 2.4201e-17
* device instance cc_XD1_XDFFM_MFB_mod2 r0 *1 0,0
Ccc_XD1_XDFFM_MFB_mod2 XD1_XDFFM_MFB mod2 2.4201e-17
* device instance cc_XD1_XDFFM_MFB_mod3 r0 *1 0,0
Ccc_XD1_XDFFM_MFB_mod3 XD1_XDFFM_MFB mod3 2.4201e-17
* device instance cc_XD1_XDFFM_MFB_mod4 r0 *1 0,0
Ccc_XD1_XDFFM_MFB_mod4 XD1_XDFFM_MFB mod4 2.4201e-17
* device instance cc_XD1_XDFFM_MFB_net1 r0 *1 0,0
Ccc_XD1_XDFFM_MFB_net1 XD1_XDFFM_MFB net1 1.21e-17
* device instance cc_XD1_XDFFM_S_XD1_XDFFM_SB r0 *1 0,0
Ccc_XD1_XDFFM_S_XD1_XDFFM_SB XD1_XDFFM_S XD1_XDFFM_SB 3.0251e-17
* device instance cc_XD1_XDFFM_S_XD1_XDFFM_SFB r0 *1 0,0
Ccc_XD1_XDFFM_S_XD1_XDFFM_SFB XD1_XDFFM_S XD1_XDFFM_SFB 3.4688e-17
* device instance cc_XD1_XDFFM_S_XD1_XDFFQ_CKBB r0 *1 0,0
Ccc_XD1_XDFFM_S_XD1_XDFFQ_CKBB XD1_XDFFM_S XD1_XDFFQ_CKBB 1.8151e-17
* device instance cc_XD1_XDFFM_S_XD1_XDFFQ_CLKB r0 *1 0,0
Ccc_XD1_XDFFM_S_XD1_XDFFQ_CLKB XD1_XDFFM_S XD1_XDFFQ_CLKB 2.4201e-17
* device instance cc_XD1_XDFFM_S_XD1_XDFFQ_M r0 *1 0,0
Ccc_XD1_XDFFM_S_XD1_XDFFQ_M XD1_XDFFM_S XD1_XDFFQ_M 2.4201e-17
* device instance cc_XD1_XDFFM_S_XD1_XDFFQ_MB r0 *1 0,0
Ccc_XD1_XDFFM_S_XD1_XDFFQ_MB XD1_XDFFM_S XD1_XDFFQ_MB 1.21e-17
* device instance cc_XD1_XDFFM_S_XD1_XDFFQ_MFB r0 *1 0,0
Ccc_XD1_XDFFM_S_XD1_XDFFQ_MFB XD1_XDFFM_S XD1_XDFFQ_MFB 1.21e-17
* device instance cc_XD1_XDFFM_S_XD1_XDFFQ_S r0 *1 0,0
Ccc_XD1_XDFFM_S_XD1_XDFFQ_S XD1_XDFFM_S XD1_XDFFQ_S 1.8151e-17
* device instance cc_XD1_XDFFM_S_XD1_XDFFQ_SB r0 *1 0,0
Ccc_XD1_XDFFM_S_XD1_XDFFQ_SB XD1_XDFFM_S XD1_XDFFQ_SB 1.8151e-17
* device instance cc_XD1_XDFFM_S_XD1_XDFFQ_SFB r0 *1 0,0
Ccc_XD1_XDFFM_S_XD1_XDFFQ_SFB XD1_XDFFM_S XD1_XDFFQ_SFB 1.21e-17
* device instance cc_XD1_XDFFM_S_XD1_XNOR_midp r0 *1 0,0
Ccc_XD1_XDFFM_S_XD1_XNOR_midp XD1_XDFFM_S XD1_XNOR_midp 1.21e-17
* device instance cc_XD1_XDFFM_S_XD1_dmodout r0 *1 0,0
Ccc_XD1_XDFFM_S_XD1_dmodout XD1_XDFFM_S XD1_dmodout 1.21e-17
* device instance cc_XD1_XDFFM_S_XD1_dq r0 *1 0,0
Ccc_XD1_XDFFM_S_XD1_dq XD1_XDFFM_S XD1_dq 1.21e-17
* device instance cc_XD1_XDFFM_S_XD1_nm r0 *1 0,0
Ccc_XD1_XDFFM_S_XD1_nm XD1_XDFFM_S XD1_nm 1.8151e-17
* device instance cc_XD1_XDFFM_S_XD1_nt r0 *1 0,0
Ccc_XD1_XDFFM_S_XD1_nt XD1_XDFFM_S XD1_nt 2.4201e-17
* device instance cc_XD1_XDFFM_S_XD1_t1 r0 *1 0,0
Ccc_XD1_XDFFM_S_XD1_t1 XD1_XDFFM_S XD1_t1 1.21e-17
* device instance cc_XD1_XDFFM_S_XD2_XDFFM_CKBB r0 *1 0,0
Ccc_XD1_XDFFM_S_XD2_XDFFM_CKBB XD1_XDFFM_S XD2_XDFFM_CKBB 1.8151e-17
* device instance cc_XD1_XDFFM_S_XD2_XDFFM_CLKB r0 *1 0,0
Ccc_XD1_XDFFM_S_XD2_XDFFM_CLKB XD1_XDFFM_S XD2_XDFFM_CLKB 2.4201e-17
* device instance cc_XD1_XDFFM_S_XD2_XDFFM_M r0 *1 0,0
Ccc_XD1_XDFFM_S_XD2_XDFFM_M XD1_XDFFM_S XD2_XDFFM_M 2.4201e-17
* device instance cc_XD1_XDFFM_S_XD2_XDFFM_MB r0 *1 0,0
Ccc_XD1_XDFFM_S_XD2_XDFFM_MB XD1_XDFFM_S XD2_XDFFM_MB 1.21e-17
* device instance cc_XD1_XDFFM_S_XD2_XDFFM_MFB r0 *1 0,0
Ccc_XD1_XDFFM_S_XD2_XDFFM_MFB XD1_XDFFM_S XD2_XDFFM_MFB 1.21e-17
* device instance cc_XD1_XDFFM_S_XD2_XDFFM_S r0 *1 0,0
Ccc_XD1_XDFFM_S_XD2_XDFFM_S XD1_XDFFM_S XD2_XDFFM_S 1.8151e-17
* device instance cc_XD1_XDFFM_S_XD2_XDFFM_SB r0 *1 0,0
Ccc_XD1_XDFFM_S_XD2_XDFFM_SB XD1_XDFFM_S XD2_XDFFM_SB 1.8151e-17
* device instance cc_XD1_XDFFM_S_XD2_XDFFM_SFB r0 *1 0,0
Ccc_XD1_XDFFM_S_XD2_XDFFM_SFB XD1_XDFFM_S XD2_XDFFM_SFB 1.21e-17
* device instance cc_XD1_XDFFM_S_XD2_XDFFQ_CKBB r0 *1 0,0
Ccc_XD1_XDFFM_S_XD2_XDFFQ_CKBB XD1_XDFFM_S XD2_XDFFQ_CKBB 1.8151e-17
* device instance cc_XD1_XDFFM_S_XD2_XDFFQ_CLKB r0 *1 0,0
Ccc_XD1_XDFFM_S_XD2_XDFFQ_CLKB XD1_XDFFM_S XD2_XDFFQ_CLKB 2.4201e-17
* device instance cc_XD1_XDFFM_S_XD2_XDFFQ_M r0 *1 0,0
Ccc_XD1_XDFFM_S_XD2_XDFFQ_M XD1_XDFFM_S XD2_XDFFQ_M 2.4201e-17
* device instance cc_XD1_XDFFM_S_XD2_XDFFQ_MB r0 *1 0,0
Ccc_XD1_XDFFM_S_XD2_XDFFQ_MB XD1_XDFFM_S XD2_XDFFQ_MB 1.21e-17
* device instance cc_XD1_XDFFM_S_XD2_XDFFQ_MFB r0 *1 0,0
Ccc_XD1_XDFFM_S_XD2_XDFFQ_MFB XD1_XDFFM_S XD2_XDFFQ_MFB 1.21e-17
* device instance cc_XD1_XDFFM_S_XD2_XDFFQ_S r0 *1 0,0
Ccc_XD1_XDFFM_S_XD2_XDFFQ_S XD1_XDFFM_S XD2_XDFFQ_S 1.8151e-17
* device instance cc_XD1_XDFFM_S_XD2_XDFFQ_SB r0 *1 0,0
Ccc_XD1_XDFFM_S_XD2_XDFFQ_SB XD1_XDFFM_S XD2_XDFFQ_SB 1.8151e-17
* device instance cc_XD1_XDFFM_S_XD2_XDFFQ_SFB r0 *1 0,0
Ccc_XD1_XDFFM_S_XD2_XDFFQ_SFB XD1_XDFFM_S XD2_XDFFQ_SFB 1.21e-17
* device instance cc_XD1_XDFFM_S_XD2_XN2_mid1 r0 *1 0,0
Ccc_XD1_XDFFM_S_XD2_XN2_mid1 XD1_XDFFM_S XD2_XN2_mid1 1.21e-17
* device instance cc_XD1_XDFFM_S_XD2_XN3_mid1 r0 *1 0,0
Ccc_XD1_XDFFM_S_XD2_XN3_mid1 XD1_XDFFM_S XD2_XN3_mid1 1.21e-17
* device instance cc_XD1_XDFFM_S_XD2_XN3_mid2 r0 *1 0,0
Ccc_XD1_XDFFM_S_XD2_XN3_mid2 XD1_XDFFM_S XD2_XN3_mid2 1.21e-17
* device instance cc_XD1_XDFFM_S_XD2_dmodout r0 *1 0,0
Ccc_XD1_XDFFM_S_XD2_dmodout XD1_XDFFM_S XD2_dmodout 1.21e-17
* device instance cc_XD1_XDFFM_S_XD2_dq r0 *1 0,0
Ccc_XD1_XDFFM_S_XD2_dq XD1_XDFFM_S XD2_dq 1.8151e-17
* device instance cc_XD1_XDFFM_S_XD2_nm r0 *1 0,0
Ccc_XD1_XDFFM_S_XD2_nm XD1_XDFFM_S XD2_nm 1.21e-17
* device instance cc_XD1_XDFFM_S_XD2_nt r0 *1 0,0
Ccc_XD1_XDFFM_S_XD2_nt XD1_XDFFM_S XD2_nt 1.21e-17
* device instance cc_XD1_XDFFM_S_XD2_t1 r0 *1 0,0
Ccc_XD1_XDFFM_S_XD2_t1 XD1_XDFFM_S XD2_t1 1.21e-17
* device instance cc_XD1_XDFFM_S_XD3_XDFFM_CKBB r0 *1 0,0
Ccc_XD1_XDFFM_S_XD3_XDFFM_CKBB XD1_XDFFM_S XD3_XDFFM_CKBB 1.8151e-17
* device instance cc_XD1_XDFFM_S_XD3_XDFFM_CLKB r0 *1 0,0
Ccc_XD1_XDFFM_S_XD3_XDFFM_CLKB XD1_XDFFM_S XD3_XDFFM_CLKB 2.4201e-17
* device instance cc_XD1_XDFFM_S_XD3_XDFFM_M r0 *1 0,0
Ccc_XD1_XDFFM_S_XD3_XDFFM_M XD1_XDFFM_S XD3_XDFFM_M 2.4201e-17
* device instance cc_XD1_XDFFM_S_XD3_XDFFM_MB r0 *1 0,0
Ccc_XD1_XDFFM_S_XD3_XDFFM_MB XD1_XDFFM_S XD3_XDFFM_MB 1.21e-17
* device instance cc_XD1_XDFFM_S_XD3_XDFFM_MFB r0 *1 0,0
Ccc_XD1_XDFFM_S_XD3_XDFFM_MFB XD1_XDFFM_S XD3_XDFFM_MFB 1.21e-17
* device instance cc_XD1_XDFFM_S_XD3_XDFFM_S r0 *1 0,0
Ccc_XD1_XDFFM_S_XD3_XDFFM_S XD1_XDFFM_S XD3_XDFFM_S 1.8151e-17
* device instance cc_XD1_XDFFM_S_XD3_XDFFM_SB r0 *1 0,0
Ccc_XD1_XDFFM_S_XD3_XDFFM_SB XD1_XDFFM_S XD3_XDFFM_SB 1.8151e-17
* device instance cc_XD1_XDFFM_S_XD3_XDFFM_SFB r0 *1 0,0
Ccc_XD1_XDFFM_S_XD3_XDFFM_SFB XD1_XDFFM_S XD3_XDFFM_SFB 1.21e-17
* device instance cc_XD1_XDFFM_S_XD3_XDFFQ_CKBB r0 *1 0,0
Ccc_XD1_XDFFM_S_XD3_XDFFQ_CKBB XD1_XDFFM_S XD3_XDFFQ_CKBB 1.8151e-17
* device instance cc_XD1_XDFFM_S_XD3_XDFFQ_CLKB r0 *1 0,0
Ccc_XD1_XDFFM_S_XD3_XDFFQ_CLKB XD1_XDFFM_S XD3_XDFFQ_CLKB 2.4201e-17
* device instance cc_XD1_XDFFM_S_XD3_XDFFQ_M r0 *1 0,0
Ccc_XD1_XDFFM_S_XD3_XDFFQ_M XD1_XDFFM_S XD3_XDFFQ_M 2.4201e-17
* device instance cc_XD1_XDFFM_S_XD3_XDFFQ_MB r0 *1 0,0
Ccc_XD1_XDFFM_S_XD3_XDFFQ_MB XD1_XDFFM_S XD3_XDFFQ_MB 1.21e-17
* device instance cc_XD1_XDFFM_S_XD3_XDFFQ_MFB r0 *1 0,0
Ccc_XD1_XDFFM_S_XD3_XDFFQ_MFB XD1_XDFFM_S XD3_XDFFQ_MFB 1.21e-17
* device instance cc_XD1_XDFFM_S_XD3_XDFFQ_S r0 *1 0,0
Ccc_XD1_XDFFM_S_XD3_XDFFQ_S XD1_XDFFM_S XD3_XDFFQ_S 1.8151e-17
* device instance cc_XD1_XDFFM_S_XD3_XDFFQ_SB r0 *1 0,0
Ccc_XD1_XDFFM_S_XD3_XDFFQ_SB XD1_XDFFM_S XD3_XDFFQ_SB 1.8151e-17
* device instance cc_XD1_XDFFM_S_XD3_XDFFQ_SFB r0 *1 0,0
Ccc_XD1_XDFFM_S_XD3_XDFFQ_SFB XD1_XDFFM_S XD3_XDFFQ_SFB 1.21e-17
* device instance cc_XD1_XDFFM_S_XD3_XN2_mid1 r0 *1 0,0
Ccc_XD1_XDFFM_S_XD3_XN2_mid1 XD1_XDFFM_S XD3_XN2_mid1 1.21e-17
* device instance cc_XD1_XDFFM_S_XD3_XN3_mid1 r0 *1 0,0
Ccc_XD1_XDFFM_S_XD3_XN3_mid1 XD1_XDFFM_S XD3_XN3_mid1 1.21e-17
* device instance cc_XD1_XDFFM_S_XD3_XN3_mid2 r0 *1 0,0
Ccc_XD1_XDFFM_S_XD3_XN3_mid2 XD1_XDFFM_S XD3_XN3_mid2 1.21e-17
* device instance cc_XD1_XDFFM_S_XD3_dmodout r0 *1 0,0
Ccc_XD1_XDFFM_S_XD3_dmodout XD1_XDFFM_S XD3_dmodout 1.21e-17
* device instance cc_XD1_XDFFM_S_XD3_dq r0 *1 0,0
Ccc_XD1_XDFFM_S_XD3_dq XD1_XDFFM_S XD3_dq 1.8151e-17
* device instance cc_XD1_XDFFM_S_XD3_nm r0 *1 0,0
Ccc_XD1_XDFFM_S_XD3_nm XD1_XDFFM_S XD3_nm 1.21e-17
* device instance cc_XD1_XDFFM_S_XD3_nt r0 *1 0,0
Ccc_XD1_XDFFM_S_XD3_nt XD1_XDFFM_S XD3_nt 1.21e-17
* device instance cc_XD1_XDFFM_S_XD3_t1 r0 *1 0,0
Ccc_XD1_XDFFM_S_XD3_t1 XD1_XDFFM_S XD3_t1 1.21e-17
* device instance cc_XD1_XDFFM_S_XD4_XDFFM_CKBB r0 *1 0,0
Ccc_XD1_XDFFM_S_XD4_XDFFM_CKBB XD1_XDFFM_S XD4_XDFFM_CKBB 1.8151e-17
* device instance cc_XD1_XDFFM_S_XD4_XDFFM_CLKB r0 *1 0,0
Ccc_XD1_XDFFM_S_XD4_XDFFM_CLKB XD1_XDFFM_S XD4_XDFFM_CLKB 2.4201e-17
* device instance cc_XD1_XDFFM_S_XD4_XDFFM_M r0 *1 0,0
Ccc_XD1_XDFFM_S_XD4_XDFFM_M XD1_XDFFM_S XD4_XDFFM_M 2.4201e-17
* device instance cc_XD1_XDFFM_S_XD4_XDFFM_MB r0 *1 0,0
Ccc_XD1_XDFFM_S_XD4_XDFFM_MB XD1_XDFFM_S XD4_XDFFM_MB 1.21e-17
* device instance cc_XD1_XDFFM_S_XD4_XDFFM_MFB r0 *1 0,0
Ccc_XD1_XDFFM_S_XD4_XDFFM_MFB XD1_XDFFM_S XD4_XDFFM_MFB 1.21e-17
* device instance cc_XD1_XDFFM_S_XD4_XDFFM_S r0 *1 0,0
Ccc_XD1_XDFFM_S_XD4_XDFFM_S XD1_XDFFM_S XD4_XDFFM_S 1.8151e-17
* device instance cc_XD1_XDFFM_S_XD4_XDFFM_SB r0 *1 0,0
Ccc_XD1_XDFFM_S_XD4_XDFFM_SB XD1_XDFFM_S XD4_XDFFM_SB 1.8151e-17
* device instance cc_XD1_XDFFM_S_XD4_XDFFM_SFB r0 *1 0,0
Ccc_XD1_XDFFM_S_XD4_XDFFM_SFB XD1_XDFFM_S XD4_XDFFM_SFB 1.21e-17
* device instance cc_XD1_XDFFM_S_XD4_XDFFQ_CKBB r0 *1 0,0
Ccc_XD1_XDFFM_S_XD4_XDFFQ_CKBB XD1_XDFFM_S XD4_XDFFQ_CKBB 1.8151e-17
* device instance cc_XD1_XDFFM_S_XD4_XDFFQ_CLKB r0 *1 0,0
Ccc_XD1_XDFFM_S_XD4_XDFFQ_CLKB XD1_XDFFM_S XD4_XDFFQ_CLKB 2.4201e-17
* device instance cc_XD1_XDFFM_S_XD4_XDFFQ_M r0 *1 0,0
Ccc_XD1_XDFFM_S_XD4_XDFFQ_M XD1_XDFFM_S XD4_XDFFQ_M 2.4201e-17
* device instance cc_XD1_XDFFM_S_XD4_XDFFQ_MB r0 *1 0,0
Ccc_XD1_XDFFM_S_XD4_XDFFQ_MB XD1_XDFFM_S XD4_XDFFQ_MB 1.21e-17
* device instance cc_XD1_XDFFM_S_XD4_XDFFQ_MFB r0 *1 0,0
Ccc_XD1_XDFFM_S_XD4_XDFFQ_MFB XD1_XDFFM_S XD4_XDFFQ_MFB 1.21e-17
* device instance cc_XD1_XDFFM_S_XD4_XDFFQ_S r0 *1 0,0
Ccc_XD1_XDFFM_S_XD4_XDFFQ_S XD1_XDFFM_S XD4_XDFFQ_S 1.8151e-17
* device instance cc_XD1_XDFFM_S_XD4_XDFFQ_SB r0 *1 0,0
Ccc_XD1_XDFFM_S_XD4_XDFFQ_SB XD1_XDFFM_S XD4_XDFFQ_SB 1.8151e-17
* device instance cc_XD1_XDFFM_S_XD4_XDFFQ_SFB r0 *1 0,0
Ccc_XD1_XDFFM_S_XD4_XDFFQ_SFB XD1_XDFFM_S XD4_XDFFQ_SFB 1.21e-17
* device instance cc_XD1_XDFFM_S_XD4_XN2_mid1 r0 *1 0,0
Ccc_XD1_XDFFM_S_XD4_XN2_mid1 XD1_XDFFM_S XD4_XN2_mid1 1.21e-17
* device instance cc_XD1_XDFFM_S_XD4_XN3_mid1 r0 *1 0,0
Ccc_XD1_XDFFM_S_XD4_XN3_mid1 XD1_XDFFM_S XD4_XN3_mid1 1.21e-17
* device instance cc_XD1_XDFFM_S_XD4_XN3_mid2 r0 *1 0,0
Ccc_XD1_XDFFM_S_XD4_XN3_mid2 XD1_XDFFM_S XD4_XN3_mid2 1.21e-17
* device instance cc_XD1_XDFFM_S_XD4_dmodout r0 *1 0,0
Ccc_XD1_XDFFM_S_XD4_dmodout XD1_XDFFM_S XD4_dmodout 1.21e-17
* device instance cc_XD1_XDFFM_S_XD4_dq r0 *1 0,0
Ccc_XD1_XDFFM_S_XD4_dq XD1_XDFFM_S XD4_dq 1.8151e-17
* device instance cc_XD1_XDFFM_S_XD4_nm r0 *1 0,0
Ccc_XD1_XDFFM_S_XD4_nm XD1_XDFFM_S XD4_nm 1.21e-17
* device instance cc_XD1_XDFFM_S_XD4_nt r0 *1 0,0
Ccc_XD1_XDFFM_S_XD4_nt XD1_XDFFM_S XD4_nt 1.21e-17
* device instance cc_XD1_XDFFM_S_XD4_t1 r0 *1 0,0
Ccc_XD1_XDFFM_S_XD4_t1 XD1_XDFFM_S XD4_t1 1.21e-17
* device instance cc_XD1_XDFFM_S_XD5_XDFFM_CKBB r0 *1 0,0
Ccc_XD1_XDFFM_S_XD5_XDFFM_CKBB XD1_XDFFM_S XD5_XDFFM_CKBB 1.8151e-17
* device instance cc_XD1_XDFFM_S_XD5_XDFFM_CLKB r0 *1 0,0
Ccc_XD1_XDFFM_S_XD5_XDFFM_CLKB XD1_XDFFM_S XD5_XDFFM_CLKB 2.4201e-17
* device instance cc_XD1_XDFFM_S_XD5_XDFFM_M r0 *1 0,0
Ccc_XD1_XDFFM_S_XD5_XDFFM_M XD1_XDFFM_S XD5_XDFFM_M 2.4201e-17
* device instance cc_XD1_XDFFM_S_XD5_XDFFM_MB r0 *1 0,0
Ccc_XD1_XDFFM_S_XD5_XDFFM_MB XD1_XDFFM_S XD5_XDFFM_MB 1.21e-17
* device instance cc_XD1_XDFFM_S_XD5_XDFFM_MFB r0 *1 0,0
Ccc_XD1_XDFFM_S_XD5_XDFFM_MFB XD1_XDFFM_S XD5_XDFFM_MFB 1.21e-17
* device instance cc_XD1_XDFFM_S_XD5_XDFFM_S r0 *1 0,0
Ccc_XD1_XDFFM_S_XD5_XDFFM_S XD1_XDFFM_S XD5_XDFFM_S 1.8151e-17
* device instance cc_XD1_XDFFM_S_XD5_XDFFM_SB r0 *1 0,0
Ccc_XD1_XDFFM_S_XD5_XDFFM_SB XD1_XDFFM_S XD5_XDFFM_SB 1.8151e-17
* device instance cc_XD1_XDFFM_S_XD5_XDFFM_SFB r0 *1 0,0
Ccc_XD1_XDFFM_S_XD5_XDFFM_SFB XD1_XDFFM_S XD5_XDFFM_SFB 1.21e-17
* device instance cc_XD1_XDFFM_S_XD5_XDFFQ_CKBB r0 *1 0,0
Ccc_XD1_XDFFM_S_XD5_XDFFQ_CKBB XD1_XDFFM_S XD5_XDFFQ_CKBB 1.8151e-17
* device instance cc_XD1_XDFFM_S_XD5_XDFFQ_CLKB r0 *1 0,0
Ccc_XD1_XDFFM_S_XD5_XDFFQ_CLKB XD1_XDFFM_S XD5_XDFFQ_CLKB 2.4201e-17
* device instance cc_XD1_XDFFM_S_XD5_XDFFQ_M r0 *1 0,0
Ccc_XD1_XDFFM_S_XD5_XDFFQ_M XD1_XDFFM_S XD5_XDFFQ_M 2.4201e-17
* device instance cc_XD1_XDFFM_S_XD5_XDFFQ_MB r0 *1 0,0
Ccc_XD1_XDFFM_S_XD5_XDFFQ_MB XD1_XDFFM_S XD5_XDFFQ_MB 1.21e-17
* device instance cc_XD1_XDFFM_S_XD5_XDFFQ_MFB r0 *1 0,0
Ccc_XD1_XDFFM_S_XD5_XDFFQ_MFB XD1_XDFFM_S XD5_XDFFQ_MFB 1.21e-17
* device instance cc_XD1_XDFFM_S_XD5_XDFFQ_S r0 *1 0,0
Ccc_XD1_XDFFM_S_XD5_XDFFQ_S XD1_XDFFM_S XD5_XDFFQ_S 1.8151e-17
* device instance cc_XD1_XDFFM_S_XD5_XDFFQ_SB r0 *1 0,0
Ccc_XD1_XDFFM_S_XD5_XDFFQ_SB XD1_XDFFM_S XD5_XDFFQ_SB 1.8151e-17
* device instance cc_XD1_XDFFM_S_XD5_XDFFQ_SFB r0 *1 0,0
Ccc_XD1_XDFFM_S_XD5_XDFFQ_SFB XD1_XDFFM_S XD5_XDFFQ_SFB 1.21e-17
* device instance cc_XD1_XDFFM_S_XD5_XN2_mid1 r0 *1 0,0
Ccc_XD1_XDFFM_S_XD5_XN2_mid1 XD1_XDFFM_S XD5_XN2_mid1 1.21e-17
* device instance cc_XD1_XDFFM_S_XD5_XN3_mid1 r0 *1 0,0
Ccc_XD1_XDFFM_S_XD5_XN3_mid1 XD1_XDFFM_S XD5_XN3_mid1 1.21e-17
* device instance cc_XD1_XDFFM_S_XD5_XN3_mid2 r0 *1 0,0
Ccc_XD1_XDFFM_S_XD5_XN3_mid2 XD1_XDFFM_S XD5_XN3_mid2 1.21e-17
* device instance cc_XD1_XDFFM_S_XD5_dmodout r0 *1 0,0
Ccc_XD1_XDFFM_S_XD5_dmodout XD1_XDFFM_S XD5_dmodout 1.21e-17
* device instance cc_XD1_XDFFM_S_XD5_dq r0 *1 0,0
Ccc_XD1_XDFFM_S_XD5_dq XD1_XDFFM_S XD5_dq 1.8151e-17
* device instance cc_XD1_XDFFM_S_XD5_nm r0 *1 0,0
Ccc_XD1_XDFFM_S_XD5_nm XD1_XDFFM_S XD5_nm 1.21e-17
* device instance cc_XD1_XDFFM_S_XD5_nt r0 *1 0,0
Ccc_XD1_XDFFM_S_XD5_nt XD1_XDFFM_S XD5_nt 1.21e-17
* device instance cc_XD1_XDFFM_S_XD5_t1 r0 *1 0,0
Ccc_XD1_XDFFM_S_XD5_t1 XD1_XDFFM_S XD5_t1 1.21e-17
* device instance cc_XD1_XDFFM_S_XFRT_CKBB r0 *1 0,0
Ccc_XD1_XDFFM_S_XFRT_CKBB XD1_XDFFM_S XFRT_CKBB 1.8151e-17
* device instance cc_XD1_XDFFM_S_XFRT_CLKB r0 *1 0,0
Ccc_XD1_XDFFM_S_XFRT_CLKB XD1_XDFFM_S XFRT_CLKB 2.4201e-17
* device instance cc_XD1_XDFFM_S_XFRT_M r0 *1 0,0
Ccc_XD1_XDFFM_S_XFRT_M XD1_XDFFM_S XFRT_M 2.4201e-17
* device instance cc_XD1_XDFFM_S_XFRT_MB r0 *1 0,0
Ccc_XD1_XDFFM_S_XFRT_MB XD1_XDFFM_S XFRT_MB 1.21e-17
* device instance cc_XD1_XDFFM_S_XFRT_MFB r0 *1 0,0
Ccc_XD1_XDFFM_S_XFRT_MFB XD1_XDFFM_S XFRT_MFB 1.21e-17
* device instance cc_XD1_XDFFM_S_XFRT_S r0 *1 0,0
Ccc_XD1_XDFFM_S_XFRT_S XD1_XDFFM_S XFRT_S 1.8151e-17
* device instance cc_XD1_XDFFM_S_XFRT_SB r0 *1 0,0
Ccc_XD1_XDFFM_S_XFRT_SB XD1_XDFFM_S XFRT_SB 1.8151e-17
* device instance cc_XD1_XDFFM_S_XFRT_SFB r0 *1 0,0
Ccc_XD1_XDFFM_S_XFRT_SFB XD1_XDFFM_S XFRT_SFB 1.21e-17
* device instance cc_XD1_XDFFM_S_ck1 r0 *1 0,0
Ccc_XD1_XDFFM_S_ck1 XD1_XDFFM_S ck1 3.0251e-17
* device instance cc_XD1_XDFFM_S_ck2 r0 *1 0,0
Ccc_XD1_XDFFM_S_ck2 XD1_XDFFM_S ck2 3.0251e-17
* device instance cc_XD1_XDFFM_S_ck3 r0 *1 0,0
Ccc_XD1_XDFFM_S_ck3 XD1_XDFFM_S ck3 3.0251e-17
* device instance cc_XD1_XDFFM_S_ck4 r0 *1 0,0
Ccc_XD1_XDFFM_S_ck4 XD1_XDFFM_S ck4 3.0251e-17
* device instance cc_XD1_XDFFM_S_ck5 r0 *1 0,0
Ccc_XD1_XDFFM_S_ck5 XD1_XDFFM_S ck5 3.0251e-17
* device instance cc_XD1_XDFFM_S_mod0 r0 *1 0,0
Ccc_XD1_XDFFM_S_mod0 XD1_XDFFM_S mod0 2.4201e-17
* device instance cc_XD1_XDFFM_S_mod1 r0 *1 0,0
Ccc_XD1_XDFFM_S_mod1 XD1_XDFFM_S mod1 2.4201e-17
* device instance cc_XD1_XDFFM_S_mod2 r0 *1 0,0
Ccc_XD1_XDFFM_S_mod2 XD1_XDFFM_S mod2 2.4201e-17
* device instance cc_XD1_XDFFM_S_mod3 r0 *1 0,0
Ccc_XD1_XDFFM_S_mod3 XD1_XDFFM_S mod3 2.4201e-17
* device instance cc_XD1_XDFFM_S_mod4 r0 *1 0,0
Ccc_XD1_XDFFM_S_mod4 XD1_XDFFM_S mod4 2.4201e-17
* device instance cc_XD1_XDFFM_S_net1 r0 *1 0,0
Ccc_XD1_XDFFM_S_net1 XD1_XDFFM_S net1 1.21e-17
* device instance cc_XD1_XDFFM_SB_XD1_XDFFM_SFB r0 *1 0,0
Ccc_XD1_XDFFM_SB_XD1_XDFFM_SFB XD1_XDFFM_SB XD1_XDFFM_SFB 2.4201e-17
* device instance cc_XD1_XDFFM_SB_XD1_XDFFQ_CKBB r0 *1 0,0
Ccc_XD1_XDFFM_SB_XD1_XDFFQ_CKBB XD1_XDFFM_SB XD1_XDFFQ_CKBB 1.8151e-17
* device instance cc_XD1_XDFFM_SB_XD1_XDFFQ_CLKB r0 *1 0,0
Ccc_XD1_XDFFM_SB_XD1_XDFFQ_CLKB XD1_XDFFM_SB XD1_XDFFQ_CLKB 2.4201e-17
* device instance cc_XD1_XDFFM_SB_XD1_XDFFQ_M r0 *1 0,0
Ccc_XD1_XDFFM_SB_XD1_XDFFQ_M XD1_XDFFM_SB XD1_XDFFQ_M 2.4201e-17
* device instance cc_XD1_XDFFM_SB_XD1_XDFFQ_MB r0 *1 0,0
Ccc_XD1_XDFFM_SB_XD1_XDFFQ_MB XD1_XDFFM_SB XD1_XDFFQ_MB 1.21e-17
* device instance cc_XD1_XDFFM_SB_XD1_XDFFQ_MFB r0 *1 0,0
Ccc_XD1_XDFFM_SB_XD1_XDFFQ_MFB XD1_XDFFM_SB XD1_XDFFQ_MFB 1.21e-17
* device instance cc_XD1_XDFFM_SB_XD1_XDFFQ_S r0 *1 0,0
Ccc_XD1_XDFFM_SB_XD1_XDFFQ_S XD1_XDFFM_SB XD1_XDFFQ_S 1.8151e-17
* device instance cc_XD1_XDFFM_SB_XD1_XDFFQ_SB r0 *1 0,0
Ccc_XD1_XDFFM_SB_XD1_XDFFQ_SB XD1_XDFFM_SB XD1_XDFFQ_SB 1.8151e-17
* device instance cc_XD1_XDFFM_SB_XD1_XDFFQ_SFB r0 *1 0,0
Ccc_XD1_XDFFM_SB_XD1_XDFFQ_SFB XD1_XDFFM_SB XD1_XDFFQ_SFB 1.21e-17
* device instance cc_XD1_XDFFM_SB_XD1_XNOR_midp r0 *1 0,0
Ccc_XD1_XDFFM_SB_XD1_XNOR_midp XD1_XDFFM_SB XD1_XNOR_midp 1.21e-17
* device instance cc_XD1_XDFFM_SB_XD1_dmodout r0 *1 0,0
Ccc_XD1_XDFFM_SB_XD1_dmodout XD1_XDFFM_SB XD1_dmodout 1.21e-17
* device instance cc_XD1_XDFFM_SB_XD1_dq r0 *1 0,0
Ccc_XD1_XDFFM_SB_XD1_dq XD1_XDFFM_SB XD1_dq 1.21e-17
* device instance cc_XD1_XDFFM_SB_XD1_nm r0 *1 0,0
Ccc_XD1_XDFFM_SB_XD1_nm XD1_XDFFM_SB XD1_nm 1.8151e-17
* device instance cc_XD1_XDFFM_SB_XD1_nt r0 *1 0,0
Ccc_XD1_XDFFM_SB_XD1_nt XD1_XDFFM_SB XD1_nt 2.4201e-17
* device instance cc_XD1_XDFFM_SB_XD1_t1 r0 *1 0,0
Ccc_XD1_XDFFM_SB_XD1_t1 XD1_XDFFM_SB XD1_t1 1.21e-17
* device instance cc_XD1_XDFFM_SB_XD2_XDFFM_CKBB r0 *1 0,0
Ccc_XD1_XDFFM_SB_XD2_XDFFM_CKBB XD1_XDFFM_SB XD2_XDFFM_CKBB 1.8151e-17
* device instance cc_XD1_XDFFM_SB_XD2_XDFFM_CLKB r0 *1 0,0
Ccc_XD1_XDFFM_SB_XD2_XDFFM_CLKB XD1_XDFFM_SB XD2_XDFFM_CLKB 2.4201e-17
* device instance cc_XD1_XDFFM_SB_XD2_XDFFM_M r0 *1 0,0
Ccc_XD1_XDFFM_SB_XD2_XDFFM_M XD1_XDFFM_SB XD2_XDFFM_M 2.4201e-17
* device instance cc_XD1_XDFFM_SB_XD2_XDFFM_MB r0 *1 0,0
Ccc_XD1_XDFFM_SB_XD2_XDFFM_MB XD1_XDFFM_SB XD2_XDFFM_MB 1.21e-17
* device instance cc_XD1_XDFFM_SB_XD2_XDFFM_MFB r0 *1 0,0
Ccc_XD1_XDFFM_SB_XD2_XDFFM_MFB XD1_XDFFM_SB XD2_XDFFM_MFB 1.21e-17
* device instance cc_XD1_XDFFM_SB_XD2_XDFFM_S r0 *1 0,0
Ccc_XD1_XDFFM_SB_XD2_XDFFM_S XD1_XDFFM_SB XD2_XDFFM_S 1.8151e-17
* device instance cc_XD1_XDFFM_SB_XD2_XDFFM_SB r0 *1 0,0
Ccc_XD1_XDFFM_SB_XD2_XDFFM_SB XD1_XDFFM_SB XD2_XDFFM_SB 1.8151e-17
* device instance cc_XD1_XDFFM_SB_XD2_XDFFM_SFB r0 *1 0,0
Ccc_XD1_XDFFM_SB_XD2_XDFFM_SFB XD1_XDFFM_SB XD2_XDFFM_SFB 1.21e-17
* device instance cc_XD1_XDFFM_SB_XD2_XDFFQ_CKBB r0 *1 0,0
Ccc_XD1_XDFFM_SB_XD2_XDFFQ_CKBB XD1_XDFFM_SB XD2_XDFFQ_CKBB 1.8151e-17
* device instance cc_XD1_XDFFM_SB_XD2_XDFFQ_CLKB r0 *1 0,0
Ccc_XD1_XDFFM_SB_XD2_XDFFQ_CLKB XD1_XDFFM_SB XD2_XDFFQ_CLKB 2.4201e-17
* device instance cc_XD1_XDFFM_SB_XD2_XDFFQ_M r0 *1 0,0
Ccc_XD1_XDFFM_SB_XD2_XDFFQ_M XD1_XDFFM_SB XD2_XDFFQ_M 2.4201e-17
* device instance cc_XD1_XDFFM_SB_XD2_XDFFQ_MB r0 *1 0,0
Ccc_XD1_XDFFM_SB_XD2_XDFFQ_MB XD1_XDFFM_SB XD2_XDFFQ_MB 1.21e-17
* device instance cc_XD1_XDFFM_SB_XD2_XDFFQ_MFB r0 *1 0,0
Ccc_XD1_XDFFM_SB_XD2_XDFFQ_MFB XD1_XDFFM_SB XD2_XDFFQ_MFB 1.21e-17
* device instance cc_XD1_XDFFM_SB_XD2_XDFFQ_S r0 *1 0,0
Ccc_XD1_XDFFM_SB_XD2_XDFFQ_S XD1_XDFFM_SB XD2_XDFFQ_S 1.8151e-17
* device instance cc_XD1_XDFFM_SB_XD2_XDFFQ_SB r0 *1 0,0
Ccc_XD1_XDFFM_SB_XD2_XDFFQ_SB XD1_XDFFM_SB XD2_XDFFQ_SB 1.8151e-17
* device instance cc_XD1_XDFFM_SB_XD2_XDFFQ_SFB r0 *1 0,0
Ccc_XD1_XDFFM_SB_XD2_XDFFQ_SFB XD1_XDFFM_SB XD2_XDFFQ_SFB 1.21e-17
* device instance cc_XD1_XDFFM_SB_XD2_XN2_mid1 r0 *1 0,0
Ccc_XD1_XDFFM_SB_XD2_XN2_mid1 XD1_XDFFM_SB XD2_XN2_mid1 1.21e-17
* device instance cc_XD1_XDFFM_SB_XD2_XN3_mid1 r0 *1 0,0
Ccc_XD1_XDFFM_SB_XD2_XN3_mid1 XD1_XDFFM_SB XD2_XN3_mid1 1.21e-17
* device instance cc_XD1_XDFFM_SB_XD2_XN3_mid2 r0 *1 0,0
Ccc_XD1_XDFFM_SB_XD2_XN3_mid2 XD1_XDFFM_SB XD2_XN3_mid2 1.21e-17
* device instance cc_XD1_XDFFM_SB_XD2_dmodout r0 *1 0,0
Ccc_XD1_XDFFM_SB_XD2_dmodout XD1_XDFFM_SB XD2_dmodout 1.21e-17
* device instance cc_XD1_XDFFM_SB_XD2_dq r0 *1 0,0
Ccc_XD1_XDFFM_SB_XD2_dq XD1_XDFFM_SB XD2_dq 1.8151e-17
* device instance cc_XD1_XDFFM_SB_XD2_nm r0 *1 0,0
Ccc_XD1_XDFFM_SB_XD2_nm XD1_XDFFM_SB XD2_nm 1.21e-17
* device instance cc_XD1_XDFFM_SB_XD2_nt r0 *1 0,0
Ccc_XD1_XDFFM_SB_XD2_nt XD1_XDFFM_SB XD2_nt 1.21e-17
* device instance cc_XD1_XDFFM_SB_XD2_t1 r0 *1 0,0
Ccc_XD1_XDFFM_SB_XD2_t1 XD1_XDFFM_SB XD2_t1 1.21e-17
* device instance cc_XD1_XDFFM_SB_XD3_XDFFM_CKBB r0 *1 0,0
Ccc_XD1_XDFFM_SB_XD3_XDFFM_CKBB XD1_XDFFM_SB XD3_XDFFM_CKBB 1.8151e-17
* device instance cc_XD1_XDFFM_SB_XD3_XDFFM_CLKB r0 *1 0,0
Ccc_XD1_XDFFM_SB_XD3_XDFFM_CLKB XD1_XDFFM_SB XD3_XDFFM_CLKB 2.4201e-17
* device instance cc_XD1_XDFFM_SB_XD3_XDFFM_M r0 *1 0,0
Ccc_XD1_XDFFM_SB_XD3_XDFFM_M XD1_XDFFM_SB XD3_XDFFM_M 2.4201e-17
* device instance cc_XD1_XDFFM_SB_XD3_XDFFM_MB r0 *1 0,0
Ccc_XD1_XDFFM_SB_XD3_XDFFM_MB XD1_XDFFM_SB XD3_XDFFM_MB 1.21e-17
* device instance cc_XD1_XDFFM_SB_XD3_XDFFM_MFB r0 *1 0,0
Ccc_XD1_XDFFM_SB_XD3_XDFFM_MFB XD1_XDFFM_SB XD3_XDFFM_MFB 1.21e-17
* device instance cc_XD1_XDFFM_SB_XD3_XDFFM_S r0 *1 0,0
Ccc_XD1_XDFFM_SB_XD3_XDFFM_S XD1_XDFFM_SB XD3_XDFFM_S 1.8151e-17
* device instance cc_XD1_XDFFM_SB_XD3_XDFFM_SB r0 *1 0,0
Ccc_XD1_XDFFM_SB_XD3_XDFFM_SB XD1_XDFFM_SB XD3_XDFFM_SB 1.8151e-17
* device instance cc_XD1_XDFFM_SB_XD3_XDFFM_SFB r0 *1 0,0
Ccc_XD1_XDFFM_SB_XD3_XDFFM_SFB XD1_XDFFM_SB XD3_XDFFM_SFB 1.21e-17
* device instance cc_XD1_XDFFM_SB_XD3_XDFFQ_CKBB r0 *1 0,0
Ccc_XD1_XDFFM_SB_XD3_XDFFQ_CKBB XD1_XDFFM_SB XD3_XDFFQ_CKBB 1.8151e-17
* device instance cc_XD1_XDFFM_SB_XD3_XDFFQ_CLKB r0 *1 0,0
Ccc_XD1_XDFFM_SB_XD3_XDFFQ_CLKB XD1_XDFFM_SB XD3_XDFFQ_CLKB 2.4201e-17
* device instance cc_XD1_XDFFM_SB_XD3_XDFFQ_M r0 *1 0,0
Ccc_XD1_XDFFM_SB_XD3_XDFFQ_M XD1_XDFFM_SB XD3_XDFFQ_M 2.4201e-17
* device instance cc_XD1_XDFFM_SB_XD3_XDFFQ_MB r0 *1 0,0
Ccc_XD1_XDFFM_SB_XD3_XDFFQ_MB XD1_XDFFM_SB XD3_XDFFQ_MB 1.21e-17
* device instance cc_XD1_XDFFM_SB_XD3_XDFFQ_MFB r0 *1 0,0
Ccc_XD1_XDFFM_SB_XD3_XDFFQ_MFB XD1_XDFFM_SB XD3_XDFFQ_MFB 1.21e-17
* device instance cc_XD1_XDFFM_SB_XD3_XDFFQ_S r0 *1 0,0
Ccc_XD1_XDFFM_SB_XD3_XDFFQ_S XD1_XDFFM_SB XD3_XDFFQ_S 1.8151e-17
* device instance cc_XD1_XDFFM_SB_XD3_XDFFQ_SB r0 *1 0,0
Ccc_XD1_XDFFM_SB_XD3_XDFFQ_SB XD1_XDFFM_SB XD3_XDFFQ_SB 1.8151e-17
* device instance cc_XD1_XDFFM_SB_XD3_XDFFQ_SFB r0 *1 0,0
Ccc_XD1_XDFFM_SB_XD3_XDFFQ_SFB XD1_XDFFM_SB XD3_XDFFQ_SFB 1.21e-17
* device instance cc_XD1_XDFFM_SB_XD3_XN2_mid1 r0 *1 0,0
Ccc_XD1_XDFFM_SB_XD3_XN2_mid1 XD1_XDFFM_SB XD3_XN2_mid1 1.21e-17
* device instance cc_XD1_XDFFM_SB_XD3_XN3_mid1 r0 *1 0,0
Ccc_XD1_XDFFM_SB_XD3_XN3_mid1 XD1_XDFFM_SB XD3_XN3_mid1 1.21e-17
* device instance cc_XD1_XDFFM_SB_XD3_XN3_mid2 r0 *1 0,0
Ccc_XD1_XDFFM_SB_XD3_XN3_mid2 XD1_XDFFM_SB XD3_XN3_mid2 1.21e-17
* device instance cc_XD1_XDFFM_SB_XD3_dmodout r0 *1 0,0
Ccc_XD1_XDFFM_SB_XD3_dmodout XD1_XDFFM_SB XD3_dmodout 1.21e-17
* device instance cc_XD1_XDFFM_SB_XD3_dq r0 *1 0,0
Ccc_XD1_XDFFM_SB_XD3_dq XD1_XDFFM_SB XD3_dq 1.8151e-17
* device instance cc_XD1_XDFFM_SB_XD3_nm r0 *1 0,0
Ccc_XD1_XDFFM_SB_XD3_nm XD1_XDFFM_SB XD3_nm 1.21e-17
* device instance cc_XD1_XDFFM_SB_XD3_nt r0 *1 0,0
Ccc_XD1_XDFFM_SB_XD3_nt XD1_XDFFM_SB XD3_nt 1.21e-17
* device instance cc_XD1_XDFFM_SB_XD3_t1 r0 *1 0,0
Ccc_XD1_XDFFM_SB_XD3_t1 XD1_XDFFM_SB XD3_t1 1.21e-17
* device instance cc_XD1_XDFFM_SB_XD4_XDFFM_CKBB r0 *1 0,0
Ccc_XD1_XDFFM_SB_XD4_XDFFM_CKBB XD1_XDFFM_SB XD4_XDFFM_CKBB 1.8151e-17
* device instance cc_XD1_XDFFM_SB_XD4_XDFFM_CLKB r0 *1 0,0
Ccc_XD1_XDFFM_SB_XD4_XDFFM_CLKB XD1_XDFFM_SB XD4_XDFFM_CLKB 2.4201e-17
* device instance cc_XD1_XDFFM_SB_XD4_XDFFM_M r0 *1 0,0
Ccc_XD1_XDFFM_SB_XD4_XDFFM_M XD1_XDFFM_SB XD4_XDFFM_M 2.4201e-17
* device instance cc_XD1_XDFFM_SB_XD4_XDFFM_MB r0 *1 0,0
Ccc_XD1_XDFFM_SB_XD4_XDFFM_MB XD1_XDFFM_SB XD4_XDFFM_MB 1.21e-17
* device instance cc_XD1_XDFFM_SB_XD4_XDFFM_MFB r0 *1 0,0
Ccc_XD1_XDFFM_SB_XD4_XDFFM_MFB XD1_XDFFM_SB XD4_XDFFM_MFB 1.21e-17
* device instance cc_XD1_XDFFM_SB_XD4_XDFFM_S r0 *1 0,0
Ccc_XD1_XDFFM_SB_XD4_XDFFM_S XD1_XDFFM_SB XD4_XDFFM_S 1.8151e-17
* device instance cc_XD1_XDFFM_SB_XD4_XDFFM_SB r0 *1 0,0
Ccc_XD1_XDFFM_SB_XD4_XDFFM_SB XD1_XDFFM_SB XD4_XDFFM_SB 1.8151e-17
* device instance cc_XD1_XDFFM_SB_XD4_XDFFM_SFB r0 *1 0,0
Ccc_XD1_XDFFM_SB_XD4_XDFFM_SFB XD1_XDFFM_SB XD4_XDFFM_SFB 1.21e-17
* device instance cc_XD1_XDFFM_SB_XD4_XDFFQ_CKBB r0 *1 0,0
Ccc_XD1_XDFFM_SB_XD4_XDFFQ_CKBB XD1_XDFFM_SB XD4_XDFFQ_CKBB 1.8151e-17
* device instance cc_XD1_XDFFM_SB_XD4_XDFFQ_CLKB r0 *1 0,0
Ccc_XD1_XDFFM_SB_XD4_XDFFQ_CLKB XD1_XDFFM_SB XD4_XDFFQ_CLKB 2.4201e-17
* device instance cc_XD1_XDFFM_SB_XD4_XDFFQ_M r0 *1 0,0
Ccc_XD1_XDFFM_SB_XD4_XDFFQ_M XD1_XDFFM_SB XD4_XDFFQ_M 2.4201e-17
* device instance cc_XD1_XDFFM_SB_XD4_XDFFQ_MB r0 *1 0,0
Ccc_XD1_XDFFM_SB_XD4_XDFFQ_MB XD1_XDFFM_SB XD4_XDFFQ_MB 1.21e-17
* device instance cc_XD1_XDFFM_SB_XD4_XDFFQ_MFB r0 *1 0,0
Ccc_XD1_XDFFM_SB_XD4_XDFFQ_MFB XD1_XDFFM_SB XD4_XDFFQ_MFB 1.21e-17
* device instance cc_XD1_XDFFM_SB_XD4_XDFFQ_S r0 *1 0,0
Ccc_XD1_XDFFM_SB_XD4_XDFFQ_S XD1_XDFFM_SB XD4_XDFFQ_S 1.8151e-17
* device instance cc_XD1_XDFFM_SB_XD4_XDFFQ_SB r0 *1 0,0
Ccc_XD1_XDFFM_SB_XD4_XDFFQ_SB XD1_XDFFM_SB XD4_XDFFQ_SB 1.8151e-17
* device instance cc_XD1_XDFFM_SB_XD4_XDFFQ_SFB r0 *1 0,0
Ccc_XD1_XDFFM_SB_XD4_XDFFQ_SFB XD1_XDFFM_SB XD4_XDFFQ_SFB 1.21e-17
* device instance cc_XD1_XDFFM_SB_XD4_XN2_mid1 r0 *1 0,0
Ccc_XD1_XDFFM_SB_XD4_XN2_mid1 XD1_XDFFM_SB XD4_XN2_mid1 1.21e-17
* device instance cc_XD1_XDFFM_SB_XD4_XN3_mid1 r0 *1 0,0
Ccc_XD1_XDFFM_SB_XD4_XN3_mid1 XD1_XDFFM_SB XD4_XN3_mid1 1.21e-17
* device instance cc_XD1_XDFFM_SB_XD4_XN3_mid2 r0 *1 0,0
Ccc_XD1_XDFFM_SB_XD4_XN3_mid2 XD1_XDFFM_SB XD4_XN3_mid2 1.21e-17
* device instance cc_XD1_XDFFM_SB_XD4_dmodout r0 *1 0,0
Ccc_XD1_XDFFM_SB_XD4_dmodout XD1_XDFFM_SB XD4_dmodout 1.21e-17
* device instance cc_XD1_XDFFM_SB_XD4_dq r0 *1 0,0
Ccc_XD1_XDFFM_SB_XD4_dq XD1_XDFFM_SB XD4_dq 1.8151e-17
* device instance cc_XD1_XDFFM_SB_XD4_nm r0 *1 0,0
Ccc_XD1_XDFFM_SB_XD4_nm XD1_XDFFM_SB XD4_nm 1.21e-17
* device instance cc_XD1_XDFFM_SB_XD4_nt r0 *1 0,0
Ccc_XD1_XDFFM_SB_XD4_nt XD1_XDFFM_SB XD4_nt 1.21e-17
* device instance cc_XD1_XDFFM_SB_XD4_t1 r0 *1 0,0
Ccc_XD1_XDFFM_SB_XD4_t1 XD1_XDFFM_SB XD4_t1 1.21e-17
* device instance cc_XD1_XDFFM_SB_XD5_XDFFM_CKBB r0 *1 0,0
Ccc_XD1_XDFFM_SB_XD5_XDFFM_CKBB XD1_XDFFM_SB XD5_XDFFM_CKBB 1.8151e-17
* device instance cc_XD1_XDFFM_SB_XD5_XDFFM_CLKB r0 *1 0,0
Ccc_XD1_XDFFM_SB_XD5_XDFFM_CLKB XD1_XDFFM_SB XD5_XDFFM_CLKB 2.4201e-17
* device instance cc_XD1_XDFFM_SB_XD5_XDFFM_M r0 *1 0,0
Ccc_XD1_XDFFM_SB_XD5_XDFFM_M XD1_XDFFM_SB XD5_XDFFM_M 2.4201e-17
* device instance cc_XD1_XDFFM_SB_XD5_XDFFM_MB r0 *1 0,0
Ccc_XD1_XDFFM_SB_XD5_XDFFM_MB XD1_XDFFM_SB XD5_XDFFM_MB 1.21e-17
* device instance cc_XD1_XDFFM_SB_XD5_XDFFM_MFB r0 *1 0,0
Ccc_XD1_XDFFM_SB_XD5_XDFFM_MFB XD1_XDFFM_SB XD5_XDFFM_MFB 1.21e-17
* device instance cc_XD1_XDFFM_SB_XD5_XDFFM_S r0 *1 0,0
Ccc_XD1_XDFFM_SB_XD5_XDFFM_S XD1_XDFFM_SB XD5_XDFFM_S 1.8151e-17
* device instance cc_XD1_XDFFM_SB_XD5_XDFFM_SB r0 *1 0,0
Ccc_XD1_XDFFM_SB_XD5_XDFFM_SB XD1_XDFFM_SB XD5_XDFFM_SB 1.8151e-17
* device instance cc_XD1_XDFFM_SB_XD5_XDFFM_SFB r0 *1 0,0
Ccc_XD1_XDFFM_SB_XD5_XDFFM_SFB XD1_XDFFM_SB XD5_XDFFM_SFB 1.21e-17
* device instance cc_XD1_XDFFM_SB_XD5_XDFFQ_CKBB r0 *1 0,0
Ccc_XD1_XDFFM_SB_XD5_XDFFQ_CKBB XD1_XDFFM_SB XD5_XDFFQ_CKBB 1.8151e-17
* device instance cc_XD1_XDFFM_SB_XD5_XDFFQ_CLKB r0 *1 0,0
Ccc_XD1_XDFFM_SB_XD5_XDFFQ_CLKB XD1_XDFFM_SB XD5_XDFFQ_CLKB 2.4201e-17
* device instance cc_XD1_XDFFM_SB_XD5_XDFFQ_M r0 *1 0,0
Ccc_XD1_XDFFM_SB_XD5_XDFFQ_M XD1_XDFFM_SB XD5_XDFFQ_M 2.4201e-17
* device instance cc_XD1_XDFFM_SB_XD5_XDFFQ_MB r0 *1 0,0
Ccc_XD1_XDFFM_SB_XD5_XDFFQ_MB XD1_XDFFM_SB XD5_XDFFQ_MB 1.21e-17
* device instance cc_XD1_XDFFM_SB_XD5_XDFFQ_MFB r0 *1 0,0
Ccc_XD1_XDFFM_SB_XD5_XDFFQ_MFB XD1_XDFFM_SB XD5_XDFFQ_MFB 1.21e-17
* device instance cc_XD1_XDFFM_SB_XD5_XDFFQ_S r0 *1 0,0
Ccc_XD1_XDFFM_SB_XD5_XDFFQ_S XD1_XDFFM_SB XD5_XDFFQ_S 1.8151e-17
* device instance cc_XD1_XDFFM_SB_XD5_XDFFQ_SB r0 *1 0,0
Ccc_XD1_XDFFM_SB_XD5_XDFFQ_SB XD1_XDFFM_SB XD5_XDFFQ_SB 1.8151e-17
* device instance cc_XD1_XDFFM_SB_XD5_XDFFQ_SFB r0 *1 0,0
Ccc_XD1_XDFFM_SB_XD5_XDFFQ_SFB XD1_XDFFM_SB XD5_XDFFQ_SFB 1.21e-17
* device instance cc_XD1_XDFFM_SB_XD5_XN2_mid1 r0 *1 0,0
Ccc_XD1_XDFFM_SB_XD5_XN2_mid1 XD1_XDFFM_SB XD5_XN2_mid1 1.21e-17
* device instance cc_XD1_XDFFM_SB_XD5_XN3_mid1 r0 *1 0,0
Ccc_XD1_XDFFM_SB_XD5_XN3_mid1 XD1_XDFFM_SB XD5_XN3_mid1 1.21e-17
* device instance cc_XD1_XDFFM_SB_XD5_XN3_mid2 r0 *1 0,0
Ccc_XD1_XDFFM_SB_XD5_XN3_mid2 XD1_XDFFM_SB XD5_XN3_mid2 1.21e-17
* device instance cc_XD1_XDFFM_SB_XD5_dmodout r0 *1 0,0
Ccc_XD1_XDFFM_SB_XD5_dmodout XD1_XDFFM_SB XD5_dmodout 1.21e-17
* device instance cc_XD1_XDFFM_SB_XD5_dq r0 *1 0,0
Ccc_XD1_XDFFM_SB_XD5_dq XD1_XDFFM_SB XD5_dq 1.8151e-17
* device instance cc_XD1_XDFFM_SB_XD5_nm r0 *1 0,0
Ccc_XD1_XDFFM_SB_XD5_nm XD1_XDFFM_SB XD5_nm 1.21e-17
* device instance cc_XD1_XDFFM_SB_XD5_nt r0 *1 0,0
Ccc_XD1_XDFFM_SB_XD5_nt XD1_XDFFM_SB XD5_nt 1.21e-17
* device instance cc_XD1_XDFFM_SB_XD5_t1 r0 *1 0,0
Ccc_XD1_XDFFM_SB_XD5_t1 XD1_XDFFM_SB XD5_t1 1.21e-17
* device instance cc_XD1_XDFFM_SB_XFRT_CKBB r0 *1 0,0
Ccc_XD1_XDFFM_SB_XFRT_CKBB XD1_XDFFM_SB XFRT_CKBB 1.8151e-17
* device instance cc_XD1_XDFFM_SB_XFRT_CLKB r0 *1 0,0
Ccc_XD1_XDFFM_SB_XFRT_CLKB XD1_XDFFM_SB XFRT_CLKB 2.4201e-17
* device instance cc_XD1_XDFFM_SB_XFRT_M r0 *1 0,0
Ccc_XD1_XDFFM_SB_XFRT_M XD1_XDFFM_SB XFRT_M 2.4201e-17
* device instance cc_XD1_XDFFM_SB_XFRT_MB r0 *1 0,0
Ccc_XD1_XDFFM_SB_XFRT_MB XD1_XDFFM_SB XFRT_MB 1.21e-17
* device instance cc_XD1_XDFFM_SB_XFRT_MFB r0 *1 0,0
Ccc_XD1_XDFFM_SB_XFRT_MFB XD1_XDFFM_SB XFRT_MFB 1.21e-17
* device instance cc_XD1_XDFFM_SB_XFRT_S r0 *1 0,0
Ccc_XD1_XDFFM_SB_XFRT_S XD1_XDFFM_SB XFRT_S 1.8151e-17
* device instance cc_XD1_XDFFM_SB_XFRT_SB r0 *1 0,0
Ccc_XD1_XDFFM_SB_XFRT_SB XD1_XDFFM_SB XFRT_SB 1.8151e-17
* device instance cc_XD1_XDFFM_SB_XFRT_SFB r0 *1 0,0
Ccc_XD1_XDFFM_SB_XFRT_SFB XD1_XDFFM_SB XFRT_SFB 1.21e-17
* device instance cc_XD1_XDFFM_SB_ck1 r0 *1 0,0
Ccc_XD1_XDFFM_SB_ck1 XD1_XDFFM_SB ck1 3.0251e-17
* device instance cc_XD1_XDFFM_SB_ck2 r0 *1 0,0
Ccc_XD1_XDFFM_SB_ck2 XD1_XDFFM_SB ck2 3.0251e-17
* device instance cc_XD1_XDFFM_SB_ck3 r0 *1 0,0
Ccc_XD1_XDFFM_SB_ck3 XD1_XDFFM_SB ck3 3.0251e-17
* device instance cc_XD1_XDFFM_SB_ck4 r0 *1 0,0
Ccc_XD1_XDFFM_SB_ck4 XD1_XDFFM_SB ck4 3.0251e-17
* device instance cc_XD1_XDFFM_SB_ck5 r0 *1 0,0
Ccc_XD1_XDFFM_SB_ck5 XD1_XDFFM_SB ck5 3.0251e-17
* device instance cc_XD1_XDFFM_SB_mod0 r0 *1 0,0
Ccc_XD1_XDFFM_SB_mod0 XD1_XDFFM_SB mod0 2.4201e-17
* device instance cc_XD1_XDFFM_SB_mod1 r0 *1 0,0
Ccc_XD1_XDFFM_SB_mod1 XD1_XDFFM_SB mod1 2.4201e-17
* device instance cc_XD1_XDFFM_SB_mod2 r0 *1 0,0
Ccc_XD1_XDFFM_SB_mod2 XD1_XDFFM_SB mod2 2.4201e-17
* device instance cc_XD1_XDFFM_SB_mod3 r0 *1 0,0
Ccc_XD1_XDFFM_SB_mod3 XD1_XDFFM_SB mod3 2.4201e-17
* device instance cc_XD1_XDFFM_SB_mod4 r0 *1 0,0
Ccc_XD1_XDFFM_SB_mod4 XD1_XDFFM_SB mod4 2.4201e-17
* device instance cc_XD1_XDFFM_SB_net1 r0 *1 0,0
Ccc_XD1_XDFFM_SB_net1 XD1_XDFFM_SB net1 1.21e-17
* device instance cc_XD1_XDFFM_SFB_XD1_XDFFQ_CKBB r0 *1 0,0
Ccc_XD1_XDFFM_SFB_XD1_XDFFQ_CKBB XD1_XDFFM_SFB XD1_XDFFQ_CKBB 1.8151e-17
* device instance cc_XD1_XDFFM_SFB_XD1_XDFFQ_CLKB r0 *1 0,0
Ccc_XD1_XDFFM_SFB_XD1_XDFFQ_CLKB XD1_XDFFM_SFB XD1_XDFFQ_CLKB 2.4201e-17
* device instance cc_XD1_XDFFM_SFB_XD1_XDFFQ_M r0 *1 0,0
Ccc_XD1_XDFFM_SFB_XD1_XDFFQ_M XD1_XDFFM_SFB XD1_XDFFQ_M 2.4201e-17
* device instance cc_XD1_XDFFM_SFB_XD1_XDFFQ_MB r0 *1 0,0
Ccc_XD1_XDFFM_SFB_XD1_XDFFQ_MB XD1_XDFFM_SFB XD1_XDFFQ_MB 1.21e-17
* device instance cc_XD1_XDFFM_SFB_XD1_XDFFQ_MFB r0 *1 0,0
Ccc_XD1_XDFFM_SFB_XD1_XDFFQ_MFB XD1_XDFFM_SFB XD1_XDFFQ_MFB 1.21e-17
* device instance cc_XD1_XDFFM_SFB_XD1_XDFFQ_S r0 *1 0,0
Ccc_XD1_XDFFM_SFB_XD1_XDFFQ_S XD1_XDFFM_SFB XD1_XDFFQ_S 1.8151e-17
* device instance cc_XD1_XDFFM_SFB_XD1_XDFFQ_SB r0 *1 0,0
Ccc_XD1_XDFFM_SFB_XD1_XDFFQ_SB XD1_XDFFM_SFB XD1_XDFFQ_SB 1.8151e-17
* device instance cc_XD1_XDFFM_SFB_XD1_XDFFQ_SFB r0 *1 0,0
Ccc_XD1_XDFFM_SFB_XD1_XDFFQ_SFB XD1_XDFFM_SFB XD1_XDFFQ_SFB 1.21e-17
* device instance cc_XD1_XDFFM_SFB_XD1_XNOR_midp r0 *1 0,0
Ccc_XD1_XDFFM_SFB_XD1_XNOR_midp XD1_XDFFM_SFB XD1_XNOR_midp 1.21e-17
* device instance cc_XD1_XDFFM_SFB_XD1_dmodout r0 *1 0,0
Ccc_XD1_XDFFM_SFB_XD1_dmodout XD1_XDFFM_SFB XD1_dmodout 1.21e-17
* device instance cc_XD1_XDFFM_SFB_XD1_dq r0 *1 0,0
Ccc_XD1_XDFFM_SFB_XD1_dq XD1_XDFFM_SFB XD1_dq 1.21e-17
* device instance cc_XD1_XDFFM_SFB_XD1_nm r0 *1 0,0
Ccc_XD1_XDFFM_SFB_XD1_nm XD1_XDFFM_SFB XD1_nm 1.8151e-17
* device instance cc_XD1_XDFFM_SFB_XD1_nt r0 *1 0,0
Ccc_XD1_XDFFM_SFB_XD1_nt XD1_XDFFM_SFB XD1_nt 2.4201e-17
* device instance cc_XD1_XDFFM_SFB_XD1_t1 r0 *1 0,0
Ccc_XD1_XDFFM_SFB_XD1_t1 XD1_XDFFM_SFB XD1_t1 1.21e-17
* device instance cc_XD1_XDFFM_SFB_XD2_XDFFM_CKBB r0 *1 0,0
Ccc_XD1_XDFFM_SFB_XD2_XDFFM_CKBB XD1_XDFFM_SFB XD2_XDFFM_CKBB 1.8151e-17
* device instance cc_XD1_XDFFM_SFB_XD2_XDFFM_CLKB r0 *1 0,0
Ccc_XD1_XDFFM_SFB_XD2_XDFFM_CLKB XD1_XDFFM_SFB XD2_XDFFM_CLKB 2.4201e-17
* device instance cc_XD1_XDFFM_SFB_XD2_XDFFM_M r0 *1 0,0
Ccc_XD1_XDFFM_SFB_XD2_XDFFM_M XD1_XDFFM_SFB XD2_XDFFM_M 2.4201e-17
* device instance cc_XD1_XDFFM_SFB_XD2_XDFFM_MB r0 *1 0,0
Ccc_XD1_XDFFM_SFB_XD2_XDFFM_MB XD1_XDFFM_SFB XD2_XDFFM_MB 1.21e-17
* device instance cc_XD1_XDFFM_SFB_XD2_XDFFM_MFB r0 *1 0,0
Ccc_XD1_XDFFM_SFB_XD2_XDFFM_MFB XD1_XDFFM_SFB XD2_XDFFM_MFB 1.21e-17
* device instance cc_XD1_XDFFM_SFB_XD2_XDFFM_S r0 *1 0,0
Ccc_XD1_XDFFM_SFB_XD2_XDFFM_S XD1_XDFFM_SFB XD2_XDFFM_S 1.8151e-17
* device instance cc_XD1_XDFFM_SFB_XD2_XDFFM_SB r0 *1 0,0
Ccc_XD1_XDFFM_SFB_XD2_XDFFM_SB XD1_XDFFM_SFB XD2_XDFFM_SB 1.8151e-17
* device instance cc_XD1_XDFFM_SFB_XD2_XDFFM_SFB r0 *1 0,0
Ccc_XD1_XDFFM_SFB_XD2_XDFFM_SFB XD1_XDFFM_SFB XD2_XDFFM_SFB 1.21e-17
* device instance cc_XD1_XDFFM_SFB_XD2_XDFFQ_CKBB r0 *1 0,0
Ccc_XD1_XDFFM_SFB_XD2_XDFFQ_CKBB XD1_XDFFM_SFB XD2_XDFFQ_CKBB 1.8151e-17
* device instance cc_XD1_XDFFM_SFB_XD2_XDFFQ_CLKB r0 *1 0,0
Ccc_XD1_XDFFM_SFB_XD2_XDFFQ_CLKB XD1_XDFFM_SFB XD2_XDFFQ_CLKB 2.4201e-17
* device instance cc_XD1_XDFFM_SFB_XD2_XDFFQ_M r0 *1 0,0
Ccc_XD1_XDFFM_SFB_XD2_XDFFQ_M XD1_XDFFM_SFB XD2_XDFFQ_M 2.4201e-17
* device instance cc_XD1_XDFFM_SFB_XD2_XDFFQ_MB r0 *1 0,0
Ccc_XD1_XDFFM_SFB_XD2_XDFFQ_MB XD1_XDFFM_SFB XD2_XDFFQ_MB 1.21e-17
* device instance cc_XD1_XDFFM_SFB_XD2_XDFFQ_MFB r0 *1 0,0
Ccc_XD1_XDFFM_SFB_XD2_XDFFQ_MFB XD1_XDFFM_SFB XD2_XDFFQ_MFB 1.21e-17
* device instance cc_XD1_XDFFM_SFB_XD2_XDFFQ_S r0 *1 0,0
Ccc_XD1_XDFFM_SFB_XD2_XDFFQ_S XD1_XDFFM_SFB XD2_XDFFQ_S 1.8151e-17
* device instance cc_XD1_XDFFM_SFB_XD2_XDFFQ_SB r0 *1 0,0
Ccc_XD1_XDFFM_SFB_XD2_XDFFQ_SB XD1_XDFFM_SFB XD2_XDFFQ_SB 1.8151e-17
* device instance cc_XD1_XDFFM_SFB_XD2_XDFFQ_SFB r0 *1 0,0
Ccc_XD1_XDFFM_SFB_XD2_XDFFQ_SFB XD1_XDFFM_SFB XD2_XDFFQ_SFB 1.21e-17
* device instance cc_XD1_XDFFM_SFB_XD2_XN2_mid1 r0 *1 0,0
Ccc_XD1_XDFFM_SFB_XD2_XN2_mid1 XD1_XDFFM_SFB XD2_XN2_mid1 1.21e-17
* device instance cc_XD1_XDFFM_SFB_XD2_XN3_mid1 r0 *1 0,0
Ccc_XD1_XDFFM_SFB_XD2_XN3_mid1 XD1_XDFFM_SFB XD2_XN3_mid1 1.21e-17
* device instance cc_XD1_XDFFM_SFB_XD2_XN3_mid2 r0 *1 0,0
Ccc_XD1_XDFFM_SFB_XD2_XN3_mid2 XD1_XDFFM_SFB XD2_XN3_mid2 1.21e-17
* device instance cc_XD1_XDFFM_SFB_XD2_dmodout r0 *1 0,0
Ccc_XD1_XDFFM_SFB_XD2_dmodout XD1_XDFFM_SFB XD2_dmodout 1.21e-17
* device instance cc_XD1_XDFFM_SFB_XD2_dq r0 *1 0,0
Ccc_XD1_XDFFM_SFB_XD2_dq XD1_XDFFM_SFB XD2_dq 1.8151e-17
* device instance cc_XD1_XDFFM_SFB_XD2_nm r0 *1 0,0
Ccc_XD1_XDFFM_SFB_XD2_nm XD1_XDFFM_SFB XD2_nm 1.21e-17
* device instance cc_XD1_XDFFM_SFB_XD2_nt r0 *1 0,0
Ccc_XD1_XDFFM_SFB_XD2_nt XD1_XDFFM_SFB XD2_nt 1.21e-17
* device instance cc_XD1_XDFFM_SFB_XD2_t1 r0 *1 0,0
Ccc_XD1_XDFFM_SFB_XD2_t1 XD1_XDFFM_SFB XD2_t1 1.21e-17
* device instance cc_XD1_XDFFM_SFB_XD3_XDFFM_CKBB r0 *1 0,0
Ccc_XD1_XDFFM_SFB_XD3_XDFFM_CKBB XD1_XDFFM_SFB XD3_XDFFM_CKBB 1.8151e-17
* device instance cc_XD1_XDFFM_SFB_XD3_XDFFM_CLKB r0 *1 0,0
Ccc_XD1_XDFFM_SFB_XD3_XDFFM_CLKB XD1_XDFFM_SFB XD3_XDFFM_CLKB 2.4201e-17
* device instance cc_XD1_XDFFM_SFB_XD3_XDFFM_M r0 *1 0,0
Ccc_XD1_XDFFM_SFB_XD3_XDFFM_M XD1_XDFFM_SFB XD3_XDFFM_M 2.4201e-17
* device instance cc_XD1_XDFFM_SFB_XD3_XDFFM_MB r0 *1 0,0
Ccc_XD1_XDFFM_SFB_XD3_XDFFM_MB XD1_XDFFM_SFB XD3_XDFFM_MB 1.21e-17
* device instance cc_XD1_XDFFM_SFB_XD3_XDFFM_MFB r0 *1 0,0
Ccc_XD1_XDFFM_SFB_XD3_XDFFM_MFB XD1_XDFFM_SFB XD3_XDFFM_MFB 1.21e-17
* device instance cc_XD1_XDFFM_SFB_XD3_XDFFM_S r0 *1 0,0
Ccc_XD1_XDFFM_SFB_XD3_XDFFM_S XD1_XDFFM_SFB XD3_XDFFM_S 1.8151e-17
* device instance cc_XD1_XDFFM_SFB_XD3_XDFFM_SB r0 *1 0,0
Ccc_XD1_XDFFM_SFB_XD3_XDFFM_SB XD1_XDFFM_SFB XD3_XDFFM_SB 1.8151e-17
* device instance cc_XD1_XDFFM_SFB_XD3_XDFFM_SFB r0 *1 0,0
Ccc_XD1_XDFFM_SFB_XD3_XDFFM_SFB XD1_XDFFM_SFB XD3_XDFFM_SFB 1.21e-17
* device instance cc_XD1_XDFFM_SFB_XD3_XDFFQ_CKBB r0 *1 0,0
Ccc_XD1_XDFFM_SFB_XD3_XDFFQ_CKBB XD1_XDFFM_SFB XD3_XDFFQ_CKBB 1.8151e-17
* device instance cc_XD1_XDFFM_SFB_XD3_XDFFQ_CLKB r0 *1 0,0
Ccc_XD1_XDFFM_SFB_XD3_XDFFQ_CLKB XD1_XDFFM_SFB XD3_XDFFQ_CLKB 2.4201e-17
* device instance cc_XD1_XDFFM_SFB_XD3_XDFFQ_M r0 *1 0,0
Ccc_XD1_XDFFM_SFB_XD3_XDFFQ_M XD1_XDFFM_SFB XD3_XDFFQ_M 2.4201e-17
* device instance cc_XD1_XDFFM_SFB_XD3_XDFFQ_MB r0 *1 0,0
Ccc_XD1_XDFFM_SFB_XD3_XDFFQ_MB XD1_XDFFM_SFB XD3_XDFFQ_MB 1.21e-17
* device instance cc_XD1_XDFFM_SFB_XD3_XDFFQ_MFB r0 *1 0,0
Ccc_XD1_XDFFM_SFB_XD3_XDFFQ_MFB XD1_XDFFM_SFB XD3_XDFFQ_MFB 1.21e-17
* device instance cc_XD1_XDFFM_SFB_XD3_XDFFQ_S r0 *1 0,0
Ccc_XD1_XDFFM_SFB_XD3_XDFFQ_S XD1_XDFFM_SFB XD3_XDFFQ_S 1.8151e-17
* device instance cc_XD1_XDFFM_SFB_XD3_XDFFQ_SB r0 *1 0,0
Ccc_XD1_XDFFM_SFB_XD3_XDFFQ_SB XD1_XDFFM_SFB XD3_XDFFQ_SB 1.8151e-17
* device instance cc_XD1_XDFFM_SFB_XD3_XDFFQ_SFB r0 *1 0,0
Ccc_XD1_XDFFM_SFB_XD3_XDFFQ_SFB XD1_XDFFM_SFB XD3_XDFFQ_SFB 1.21e-17
* device instance cc_XD1_XDFFM_SFB_XD3_XN2_mid1 r0 *1 0,0
Ccc_XD1_XDFFM_SFB_XD3_XN2_mid1 XD1_XDFFM_SFB XD3_XN2_mid1 1.21e-17
* device instance cc_XD1_XDFFM_SFB_XD3_XN3_mid1 r0 *1 0,0
Ccc_XD1_XDFFM_SFB_XD3_XN3_mid1 XD1_XDFFM_SFB XD3_XN3_mid1 1.21e-17
* device instance cc_XD1_XDFFM_SFB_XD3_XN3_mid2 r0 *1 0,0
Ccc_XD1_XDFFM_SFB_XD3_XN3_mid2 XD1_XDFFM_SFB XD3_XN3_mid2 1.21e-17
* device instance cc_XD1_XDFFM_SFB_XD3_dmodout r0 *1 0,0
Ccc_XD1_XDFFM_SFB_XD3_dmodout XD1_XDFFM_SFB XD3_dmodout 1.21e-17
* device instance cc_XD1_XDFFM_SFB_XD3_dq r0 *1 0,0
Ccc_XD1_XDFFM_SFB_XD3_dq XD1_XDFFM_SFB XD3_dq 1.8151e-17
* device instance cc_XD1_XDFFM_SFB_XD3_nm r0 *1 0,0
Ccc_XD1_XDFFM_SFB_XD3_nm XD1_XDFFM_SFB XD3_nm 1.21e-17
* device instance cc_XD1_XDFFM_SFB_XD3_nt r0 *1 0,0
Ccc_XD1_XDFFM_SFB_XD3_nt XD1_XDFFM_SFB XD3_nt 1.21e-17
* device instance cc_XD1_XDFFM_SFB_XD3_t1 r0 *1 0,0
Ccc_XD1_XDFFM_SFB_XD3_t1 XD1_XDFFM_SFB XD3_t1 1.21e-17
* device instance cc_XD1_XDFFM_SFB_XD4_XDFFM_CKBB r0 *1 0,0
Ccc_XD1_XDFFM_SFB_XD4_XDFFM_CKBB XD1_XDFFM_SFB XD4_XDFFM_CKBB 1.8151e-17
* device instance cc_XD1_XDFFM_SFB_XD4_XDFFM_CLKB r0 *1 0,0
Ccc_XD1_XDFFM_SFB_XD4_XDFFM_CLKB XD1_XDFFM_SFB XD4_XDFFM_CLKB 2.4201e-17
* device instance cc_XD1_XDFFM_SFB_XD4_XDFFM_M r0 *1 0,0
Ccc_XD1_XDFFM_SFB_XD4_XDFFM_M XD1_XDFFM_SFB XD4_XDFFM_M 2.4201e-17
* device instance cc_XD1_XDFFM_SFB_XD4_XDFFM_MB r0 *1 0,0
Ccc_XD1_XDFFM_SFB_XD4_XDFFM_MB XD1_XDFFM_SFB XD4_XDFFM_MB 1.21e-17
* device instance cc_XD1_XDFFM_SFB_XD4_XDFFM_MFB r0 *1 0,0
Ccc_XD1_XDFFM_SFB_XD4_XDFFM_MFB XD1_XDFFM_SFB XD4_XDFFM_MFB 1.21e-17
* device instance cc_XD1_XDFFM_SFB_XD4_XDFFM_S r0 *1 0,0
Ccc_XD1_XDFFM_SFB_XD4_XDFFM_S XD1_XDFFM_SFB XD4_XDFFM_S 1.8151e-17
* device instance cc_XD1_XDFFM_SFB_XD4_XDFFM_SB r0 *1 0,0
Ccc_XD1_XDFFM_SFB_XD4_XDFFM_SB XD1_XDFFM_SFB XD4_XDFFM_SB 1.8151e-17
* device instance cc_XD1_XDFFM_SFB_XD4_XDFFM_SFB r0 *1 0,0
Ccc_XD1_XDFFM_SFB_XD4_XDFFM_SFB XD1_XDFFM_SFB XD4_XDFFM_SFB 1.21e-17
* device instance cc_XD1_XDFFM_SFB_XD4_XDFFQ_CKBB r0 *1 0,0
Ccc_XD1_XDFFM_SFB_XD4_XDFFQ_CKBB XD1_XDFFM_SFB XD4_XDFFQ_CKBB 1.8151e-17
* device instance cc_XD1_XDFFM_SFB_XD4_XDFFQ_CLKB r0 *1 0,0
Ccc_XD1_XDFFM_SFB_XD4_XDFFQ_CLKB XD1_XDFFM_SFB XD4_XDFFQ_CLKB 2.4201e-17
* device instance cc_XD1_XDFFM_SFB_XD4_XDFFQ_M r0 *1 0,0
Ccc_XD1_XDFFM_SFB_XD4_XDFFQ_M XD1_XDFFM_SFB XD4_XDFFQ_M 2.4201e-17
* device instance cc_XD1_XDFFM_SFB_XD4_XDFFQ_MB r0 *1 0,0
Ccc_XD1_XDFFM_SFB_XD4_XDFFQ_MB XD1_XDFFM_SFB XD4_XDFFQ_MB 1.21e-17
* device instance cc_XD1_XDFFM_SFB_XD4_XDFFQ_MFB r0 *1 0,0
Ccc_XD1_XDFFM_SFB_XD4_XDFFQ_MFB XD1_XDFFM_SFB XD4_XDFFQ_MFB 1.21e-17
* device instance cc_XD1_XDFFM_SFB_XD4_XDFFQ_S r0 *1 0,0
Ccc_XD1_XDFFM_SFB_XD4_XDFFQ_S XD1_XDFFM_SFB XD4_XDFFQ_S 1.8151e-17
* device instance cc_XD1_XDFFM_SFB_XD4_XDFFQ_SB r0 *1 0,0
Ccc_XD1_XDFFM_SFB_XD4_XDFFQ_SB XD1_XDFFM_SFB XD4_XDFFQ_SB 1.8151e-17
* device instance cc_XD1_XDFFM_SFB_XD4_XDFFQ_SFB r0 *1 0,0
Ccc_XD1_XDFFM_SFB_XD4_XDFFQ_SFB XD1_XDFFM_SFB XD4_XDFFQ_SFB 1.21e-17
* device instance cc_XD1_XDFFM_SFB_XD4_XN2_mid1 r0 *1 0,0
Ccc_XD1_XDFFM_SFB_XD4_XN2_mid1 XD1_XDFFM_SFB XD4_XN2_mid1 1.21e-17
* device instance cc_XD1_XDFFM_SFB_XD4_XN3_mid1 r0 *1 0,0
Ccc_XD1_XDFFM_SFB_XD4_XN3_mid1 XD1_XDFFM_SFB XD4_XN3_mid1 1.21e-17
* device instance cc_XD1_XDFFM_SFB_XD4_XN3_mid2 r0 *1 0,0
Ccc_XD1_XDFFM_SFB_XD4_XN3_mid2 XD1_XDFFM_SFB XD4_XN3_mid2 1.21e-17
* device instance cc_XD1_XDFFM_SFB_XD4_dmodout r0 *1 0,0
Ccc_XD1_XDFFM_SFB_XD4_dmodout XD1_XDFFM_SFB XD4_dmodout 1.21e-17
* device instance cc_XD1_XDFFM_SFB_XD4_dq r0 *1 0,0
Ccc_XD1_XDFFM_SFB_XD4_dq XD1_XDFFM_SFB XD4_dq 1.8151e-17
* device instance cc_XD1_XDFFM_SFB_XD4_nm r0 *1 0,0
Ccc_XD1_XDFFM_SFB_XD4_nm XD1_XDFFM_SFB XD4_nm 1.21e-17
* device instance cc_XD1_XDFFM_SFB_XD4_nt r0 *1 0,0
Ccc_XD1_XDFFM_SFB_XD4_nt XD1_XDFFM_SFB XD4_nt 1.21e-17
* device instance cc_XD1_XDFFM_SFB_XD4_t1 r0 *1 0,0
Ccc_XD1_XDFFM_SFB_XD4_t1 XD1_XDFFM_SFB XD4_t1 1.21e-17
* device instance cc_XD1_XDFFM_SFB_XD5_XDFFM_CKBB r0 *1 0,0
Ccc_XD1_XDFFM_SFB_XD5_XDFFM_CKBB XD1_XDFFM_SFB XD5_XDFFM_CKBB 1.8151e-17
* device instance cc_XD1_XDFFM_SFB_XD5_XDFFM_CLKB r0 *1 0,0
Ccc_XD1_XDFFM_SFB_XD5_XDFFM_CLKB XD1_XDFFM_SFB XD5_XDFFM_CLKB 2.4201e-17
* device instance cc_XD1_XDFFM_SFB_XD5_XDFFM_M r0 *1 0,0
Ccc_XD1_XDFFM_SFB_XD5_XDFFM_M XD1_XDFFM_SFB XD5_XDFFM_M 2.4201e-17
* device instance cc_XD1_XDFFM_SFB_XD5_XDFFM_MB r0 *1 0,0
Ccc_XD1_XDFFM_SFB_XD5_XDFFM_MB XD1_XDFFM_SFB XD5_XDFFM_MB 1.21e-17
* device instance cc_XD1_XDFFM_SFB_XD5_XDFFM_MFB r0 *1 0,0
Ccc_XD1_XDFFM_SFB_XD5_XDFFM_MFB XD1_XDFFM_SFB XD5_XDFFM_MFB 1.21e-17
* device instance cc_XD1_XDFFM_SFB_XD5_XDFFM_S r0 *1 0,0
Ccc_XD1_XDFFM_SFB_XD5_XDFFM_S XD1_XDFFM_SFB XD5_XDFFM_S 1.8151e-17
* device instance cc_XD1_XDFFM_SFB_XD5_XDFFM_SB r0 *1 0,0
Ccc_XD1_XDFFM_SFB_XD5_XDFFM_SB XD1_XDFFM_SFB XD5_XDFFM_SB 1.8151e-17
* device instance cc_XD1_XDFFM_SFB_XD5_XDFFM_SFB r0 *1 0,0
Ccc_XD1_XDFFM_SFB_XD5_XDFFM_SFB XD1_XDFFM_SFB XD5_XDFFM_SFB 1.21e-17
* device instance cc_XD1_XDFFM_SFB_XD5_XDFFQ_CKBB r0 *1 0,0
Ccc_XD1_XDFFM_SFB_XD5_XDFFQ_CKBB XD1_XDFFM_SFB XD5_XDFFQ_CKBB 1.8151e-17
* device instance cc_XD1_XDFFM_SFB_XD5_XDFFQ_CLKB r0 *1 0,0
Ccc_XD1_XDFFM_SFB_XD5_XDFFQ_CLKB XD1_XDFFM_SFB XD5_XDFFQ_CLKB 2.4201e-17
* device instance cc_XD1_XDFFM_SFB_XD5_XDFFQ_M r0 *1 0,0
Ccc_XD1_XDFFM_SFB_XD5_XDFFQ_M XD1_XDFFM_SFB XD5_XDFFQ_M 2.4201e-17
* device instance cc_XD1_XDFFM_SFB_XD5_XDFFQ_MB r0 *1 0,0
Ccc_XD1_XDFFM_SFB_XD5_XDFFQ_MB XD1_XDFFM_SFB XD5_XDFFQ_MB 1.21e-17
* device instance cc_XD1_XDFFM_SFB_XD5_XDFFQ_MFB r0 *1 0,0
Ccc_XD1_XDFFM_SFB_XD5_XDFFQ_MFB XD1_XDFFM_SFB XD5_XDFFQ_MFB 1.21e-17
* device instance cc_XD1_XDFFM_SFB_XD5_XDFFQ_S r0 *1 0,0
Ccc_XD1_XDFFM_SFB_XD5_XDFFQ_S XD1_XDFFM_SFB XD5_XDFFQ_S 1.8151e-17
* device instance cc_XD1_XDFFM_SFB_XD5_XDFFQ_SB r0 *1 0,0
Ccc_XD1_XDFFM_SFB_XD5_XDFFQ_SB XD1_XDFFM_SFB XD5_XDFFQ_SB 1.8151e-17
* device instance cc_XD1_XDFFM_SFB_XD5_XDFFQ_SFB r0 *1 0,0
Ccc_XD1_XDFFM_SFB_XD5_XDFFQ_SFB XD1_XDFFM_SFB XD5_XDFFQ_SFB 1.21e-17
* device instance cc_XD1_XDFFM_SFB_XD5_XN2_mid1 r0 *1 0,0
Ccc_XD1_XDFFM_SFB_XD5_XN2_mid1 XD1_XDFFM_SFB XD5_XN2_mid1 1.21e-17
* device instance cc_XD1_XDFFM_SFB_XD5_XN3_mid1 r0 *1 0,0
Ccc_XD1_XDFFM_SFB_XD5_XN3_mid1 XD1_XDFFM_SFB XD5_XN3_mid1 1.21e-17
* device instance cc_XD1_XDFFM_SFB_XD5_XN3_mid2 r0 *1 0,0
Ccc_XD1_XDFFM_SFB_XD5_XN3_mid2 XD1_XDFFM_SFB XD5_XN3_mid2 1.21e-17
* device instance cc_XD1_XDFFM_SFB_XD5_dmodout r0 *1 0,0
Ccc_XD1_XDFFM_SFB_XD5_dmodout XD1_XDFFM_SFB XD5_dmodout 1.21e-17
* device instance cc_XD1_XDFFM_SFB_XD5_dq r0 *1 0,0
Ccc_XD1_XDFFM_SFB_XD5_dq XD1_XDFFM_SFB XD5_dq 1.8151e-17
* device instance cc_XD1_XDFFM_SFB_XD5_nm r0 *1 0,0
Ccc_XD1_XDFFM_SFB_XD5_nm XD1_XDFFM_SFB XD5_nm 1.21e-17
* device instance cc_XD1_XDFFM_SFB_XD5_nt r0 *1 0,0
Ccc_XD1_XDFFM_SFB_XD5_nt XD1_XDFFM_SFB XD5_nt 1.21e-17
* device instance cc_XD1_XDFFM_SFB_XD5_t1 r0 *1 0,0
Ccc_XD1_XDFFM_SFB_XD5_t1 XD1_XDFFM_SFB XD5_t1 1.21e-17
* device instance cc_XD1_XDFFM_SFB_XFRT_CKBB r0 *1 0,0
Ccc_XD1_XDFFM_SFB_XFRT_CKBB XD1_XDFFM_SFB XFRT_CKBB 1.8151e-17
* device instance cc_XD1_XDFFM_SFB_XFRT_CLKB r0 *1 0,0
Ccc_XD1_XDFFM_SFB_XFRT_CLKB XD1_XDFFM_SFB XFRT_CLKB 2.4201e-17
* device instance cc_XD1_XDFFM_SFB_XFRT_M r0 *1 0,0
Ccc_XD1_XDFFM_SFB_XFRT_M XD1_XDFFM_SFB XFRT_M 2.4201e-17
* device instance cc_XD1_XDFFM_SFB_XFRT_MB r0 *1 0,0
Ccc_XD1_XDFFM_SFB_XFRT_MB XD1_XDFFM_SFB XFRT_MB 1.21e-17
* device instance cc_XD1_XDFFM_SFB_XFRT_MFB r0 *1 0,0
Ccc_XD1_XDFFM_SFB_XFRT_MFB XD1_XDFFM_SFB XFRT_MFB 1.21e-17
* device instance cc_XD1_XDFFM_SFB_XFRT_S r0 *1 0,0
Ccc_XD1_XDFFM_SFB_XFRT_S XD1_XDFFM_SFB XFRT_S 1.8151e-17
* device instance cc_XD1_XDFFM_SFB_XFRT_SB r0 *1 0,0
Ccc_XD1_XDFFM_SFB_XFRT_SB XD1_XDFFM_SFB XFRT_SB 1.8151e-17
* device instance cc_XD1_XDFFM_SFB_XFRT_SFB r0 *1 0,0
Ccc_XD1_XDFFM_SFB_XFRT_SFB XD1_XDFFM_SFB XFRT_SFB 1.21e-17
* device instance cc_XD1_XDFFM_SFB_ck1 r0 *1 0,0
Ccc_XD1_XDFFM_SFB_ck1 XD1_XDFFM_SFB ck1 3.0251e-17
* device instance cc_XD1_XDFFM_SFB_ck2 r0 *1 0,0
Ccc_XD1_XDFFM_SFB_ck2 XD1_XDFFM_SFB ck2 3.0251e-17
* device instance cc_XD1_XDFFM_SFB_ck3 r0 *1 0,0
Ccc_XD1_XDFFM_SFB_ck3 XD1_XDFFM_SFB ck3 3.0251e-17
* device instance cc_XD1_XDFFM_SFB_ck4 r0 *1 0,0
Ccc_XD1_XDFFM_SFB_ck4 XD1_XDFFM_SFB ck4 3.0251e-17
* device instance cc_XD1_XDFFM_SFB_ck5 r0 *1 0,0
Ccc_XD1_XDFFM_SFB_ck5 XD1_XDFFM_SFB ck5 3.0251e-17
* device instance cc_XD1_XDFFM_SFB_mod0 r0 *1 0,0
Ccc_XD1_XDFFM_SFB_mod0 XD1_XDFFM_SFB mod0 2.4201e-17
* device instance cc_XD1_XDFFM_SFB_mod1 r0 *1 0,0
Ccc_XD1_XDFFM_SFB_mod1 XD1_XDFFM_SFB mod1 2.4201e-17
* device instance cc_XD1_XDFFM_SFB_mod2 r0 *1 0,0
Ccc_XD1_XDFFM_SFB_mod2 XD1_XDFFM_SFB mod2 2.4201e-17
* device instance cc_XD1_XDFFM_SFB_mod3 r0 *1 0,0
Ccc_XD1_XDFFM_SFB_mod3 XD1_XDFFM_SFB mod3 2.4201e-17
* device instance cc_XD1_XDFFM_SFB_mod4 r0 *1 0,0
Ccc_XD1_XDFFM_SFB_mod4 XD1_XDFFM_SFB mod4 2.4201e-17
* device instance cc_XD1_XDFFM_SFB_net1 r0 *1 0,0
Ccc_XD1_XDFFM_SFB_net1 XD1_XDFFM_SFB net1 1.21e-17
* device instance cc_XD1_XDFFQ_CKBB_XD1_XDFFQ_CLKB r0 *1 0,0
Ccc_XD1_XDFFQ_CKBB_XD1_XDFFQ_CLKB XD1_XDFFQ_CKBB XD1_XDFFQ_CLKB 3.6302e-17
* device instance cc_XD1_XDFFQ_CKBB_XD1_XDFFQ_M r0 *1 0,0
Ccc_XD1_XDFFQ_CKBB_XD1_XDFFQ_M XD1_XDFFQ_CKBB XD1_XDFFQ_M 4.8402e-17
* device instance cc_XD1_XDFFQ_CKBB_XD1_XDFFQ_MB r0 *1 0,0
Ccc_XD1_XDFFQ_CKBB_XD1_XDFFQ_MB XD1_XDFFQ_CKBB XD1_XDFFQ_MB 2.4201e-17
* device instance cc_XD1_XDFFQ_CKBB_XD1_XDFFQ_MFB r0 *1 0,0
Ccc_XD1_XDFFQ_CKBB_XD1_XDFFQ_MFB XD1_XDFFQ_CKBB XD1_XDFFQ_MFB 2.4201e-17
* device instance cc_XD1_XDFFQ_CKBB_XD1_XDFFQ_S r0 *1 0,0
Ccc_XD1_XDFFQ_CKBB_XD1_XDFFQ_S XD1_XDFFQ_CKBB XD1_XDFFQ_S 3.0251e-17
* device instance cc_XD1_XDFFQ_CKBB_XD1_XDFFQ_SB r0 *1 0,0
Ccc_XD1_XDFFQ_CKBB_XD1_XDFFQ_SB XD1_XDFFQ_CKBB XD1_XDFFQ_SB 3.0251e-17
* device instance cc_XD1_XDFFQ_CKBB_XD1_XDFFQ_SFB r0 *1 0,0
Ccc_XD1_XDFFQ_CKBB_XD1_XDFFQ_SFB XD1_XDFFQ_CKBB XD1_XDFFQ_SFB 1.8151e-17
* device instance cc_XD1_XDFFQ_CKBB_XD1_XN2_mid1 r0 *1 0,0
Ccc_XD1_XDFFQ_CKBB_XD1_XN2_mid1 XD1_XDFFQ_CKBB XD1_XN2_mid1 1.21e-17
* device instance cc_XD1_XDFFQ_CKBB_XD1_XNOR_midp r0 *1 0,0
Ccc_XD1_XDFFQ_CKBB_XD1_XNOR_midp XD1_XDFFQ_CKBB XD1_XNOR_midp 1.21e-17
* device instance cc_XD1_XDFFQ_CKBB_XD1_dmodout r0 *1 0,0
Ccc_XD1_XDFFQ_CKBB_XD1_dmodout XD1_XDFFQ_CKBB XD1_dmodout 1.21e-17
* device instance cc_XD1_XDFFQ_CKBB_XD1_dq r0 *1 0,0
Ccc_XD1_XDFFQ_CKBB_XD1_dq XD1_XDFFQ_CKBB XD1_dq 1.8151e-17
* device instance cc_XD1_XDFFQ_CKBB_XD1_nm r0 *1 0,0
Ccc_XD1_XDFFQ_CKBB_XD1_nm XD1_XDFFQ_CKBB XD1_nm 1.21e-17
* device instance cc_XD1_XDFFQ_CKBB_XD1_nt r0 *1 0,0
Ccc_XD1_XDFFQ_CKBB_XD1_nt XD1_XDFFQ_CKBB XD1_nt 2.4201e-17
* device instance cc_XD1_XDFFQ_CKBB_XD1_t1 r0 *1 0,0
Ccc_XD1_XDFFQ_CKBB_XD1_t1 XD1_XDFFQ_CKBB XD1_t1 1.21e-17
* device instance cc_XD1_XDFFQ_CKBB_XD2_XDFFM_CKBB r0 *1 0,0
Ccc_XD1_XDFFQ_CKBB_XD2_XDFFM_CKBB XD1_XDFFQ_CKBB XD2_XDFFM_CKBB 1.8151e-17
* device instance cc_XD1_XDFFQ_CKBB_XD2_XDFFM_CLKB r0 *1 0,0
Ccc_XD1_XDFFQ_CKBB_XD2_XDFFM_CLKB XD1_XDFFQ_CKBB XD2_XDFFM_CLKB 2.4201e-17
* device instance cc_XD1_XDFFQ_CKBB_XD2_XDFFM_M r0 *1 0,0
Ccc_XD1_XDFFQ_CKBB_XD2_XDFFM_M XD1_XDFFQ_CKBB XD2_XDFFM_M 2.4201e-17
* device instance cc_XD1_XDFFQ_CKBB_XD2_XDFFM_MB r0 *1 0,0
Ccc_XD1_XDFFQ_CKBB_XD2_XDFFM_MB XD1_XDFFQ_CKBB XD2_XDFFM_MB 1.21e-17
* device instance cc_XD1_XDFFQ_CKBB_XD2_XDFFM_MFB r0 *1 0,0
Ccc_XD1_XDFFQ_CKBB_XD2_XDFFM_MFB XD1_XDFFQ_CKBB XD2_XDFFM_MFB 1.21e-17
* device instance cc_XD1_XDFFQ_CKBB_XD2_XDFFM_S r0 *1 0,0
Ccc_XD1_XDFFQ_CKBB_XD2_XDFFM_S XD1_XDFFQ_CKBB XD2_XDFFM_S 1.8151e-17
* device instance cc_XD1_XDFFQ_CKBB_XD2_XDFFM_SB r0 *1 0,0
Ccc_XD1_XDFFQ_CKBB_XD2_XDFFM_SB XD1_XDFFQ_CKBB XD2_XDFFM_SB 1.8151e-17
* device instance cc_XD1_XDFFQ_CKBB_XD2_XDFFM_SFB r0 *1 0,0
Ccc_XD1_XDFFQ_CKBB_XD2_XDFFM_SFB XD1_XDFFQ_CKBB XD2_XDFFM_SFB 1.21e-17
* device instance cc_XD1_XDFFQ_CKBB_XD2_XDFFQ_CKBB r0 *1 0,0
Ccc_XD1_XDFFQ_CKBB_XD2_XDFFQ_CKBB XD1_XDFFQ_CKBB XD2_XDFFQ_CKBB 1.8151e-17
* device instance cc_XD1_XDFFQ_CKBB_XD2_XDFFQ_CLKB r0 *1 0,0
Ccc_XD1_XDFFQ_CKBB_XD2_XDFFQ_CLKB XD1_XDFFQ_CKBB XD2_XDFFQ_CLKB 2.4201e-17
* device instance cc_XD1_XDFFQ_CKBB_XD2_XDFFQ_M r0 *1 0,0
Ccc_XD1_XDFFQ_CKBB_XD2_XDFFQ_M XD1_XDFFQ_CKBB XD2_XDFFQ_M 2.4201e-17
* device instance cc_XD1_XDFFQ_CKBB_XD2_XDFFQ_MB r0 *1 0,0
Ccc_XD1_XDFFQ_CKBB_XD2_XDFFQ_MB XD1_XDFFQ_CKBB XD2_XDFFQ_MB 1.21e-17
* device instance cc_XD1_XDFFQ_CKBB_XD2_XDFFQ_MFB r0 *1 0,0
Ccc_XD1_XDFFQ_CKBB_XD2_XDFFQ_MFB XD1_XDFFQ_CKBB XD2_XDFFQ_MFB 1.21e-17
* device instance cc_XD1_XDFFQ_CKBB_XD2_XDFFQ_S r0 *1 0,0
Ccc_XD1_XDFFQ_CKBB_XD2_XDFFQ_S XD1_XDFFQ_CKBB XD2_XDFFQ_S 1.8151e-17
* device instance cc_XD1_XDFFQ_CKBB_XD2_XDFFQ_SB r0 *1 0,0
Ccc_XD1_XDFFQ_CKBB_XD2_XDFFQ_SB XD1_XDFFQ_CKBB XD2_XDFFQ_SB 1.8151e-17
* device instance cc_XD1_XDFFQ_CKBB_XD2_XDFFQ_SFB r0 *1 0,0
Ccc_XD1_XDFFQ_CKBB_XD2_XDFFQ_SFB XD1_XDFFQ_CKBB XD2_XDFFQ_SFB 1.21e-17
* device instance cc_XD1_XDFFQ_CKBB_XD2_XN2_mid1 r0 *1 0,0
Ccc_XD1_XDFFQ_CKBB_XD2_XN2_mid1 XD1_XDFFQ_CKBB XD2_XN2_mid1 1.21e-17
* device instance cc_XD1_XDFFQ_CKBB_XD2_XN3_mid1 r0 *1 0,0
Ccc_XD1_XDFFQ_CKBB_XD2_XN3_mid1 XD1_XDFFQ_CKBB XD2_XN3_mid1 1.21e-17
* device instance cc_XD1_XDFFQ_CKBB_XD2_XN3_mid2 r0 *1 0,0
Ccc_XD1_XDFFQ_CKBB_XD2_XN3_mid2 XD1_XDFFQ_CKBB XD2_XN3_mid2 1.21e-17
* device instance cc_XD1_XDFFQ_CKBB_XD2_dmodout r0 *1 0,0
Ccc_XD1_XDFFQ_CKBB_XD2_dmodout XD1_XDFFQ_CKBB XD2_dmodout 1.21e-17
* device instance cc_XD1_XDFFQ_CKBB_XD2_dq r0 *1 0,0
Ccc_XD1_XDFFQ_CKBB_XD2_dq XD1_XDFFQ_CKBB XD2_dq 1.8151e-17
* device instance cc_XD1_XDFFQ_CKBB_XD2_nm r0 *1 0,0
Ccc_XD1_XDFFQ_CKBB_XD2_nm XD1_XDFFQ_CKBB XD2_nm 1.21e-17
* device instance cc_XD1_XDFFQ_CKBB_XD2_nt r0 *1 0,0
Ccc_XD1_XDFFQ_CKBB_XD2_nt XD1_XDFFQ_CKBB XD2_nt 1.21e-17
* device instance cc_XD1_XDFFQ_CKBB_XD2_t1 r0 *1 0,0
Ccc_XD1_XDFFQ_CKBB_XD2_t1 XD1_XDFFQ_CKBB XD2_t1 1.21e-17
* device instance cc_XD1_XDFFQ_CKBB_XD3_XDFFM_CKBB r0 *1 0,0
Ccc_XD1_XDFFQ_CKBB_XD3_XDFFM_CKBB XD1_XDFFQ_CKBB XD3_XDFFM_CKBB 1.8151e-17
* device instance cc_XD1_XDFFQ_CKBB_XD3_XDFFM_CLKB r0 *1 0,0
Ccc_XD1_XDFFQ_CKBB_XD3_XDFFM_CLKB XD1_XDFFQ_CKBB XD3_XDFFM_CLKB 2.4201e-17
* device instance cc_XD1_XDFFQ_CKBB_XD3_XDFFM_M r0 *1 0,0
Ccc_XD1_XDFFQ_CKBB_XD3_XDFFM_M XD1_XDFFQ_CKBB XD3_XDFFM_M 2.4201e-17
* device instance cc_XD1_XDFFQ_CKBB_XD3_XDFFM_MB r0 *1 0,0
Ccc_XD1_XDFFQ_CKBB_XD3_XDFFM_MB XD1_XDFFQ_CKBB XD3_XDFFM_MB 1.21e-17
* device instance cc_XD1_XDFFQ_CKBB_XD3_XDFFM_MFB r0 *1 0,0
Ccc_XD1_XDFFQ_CKBB_XD3_XDFFM_MFB XD1_XDFFQ_CKBB XD3_XDFFM_MFB 1.21e-17
* device instance cc_XD1_XDFFQ_CKBB_XD3_XDFFM_S r0 *1 0,0
Ccc_XD1_XDFFQ_CKBB_XD3_XDFFM_S XD1_XDFFQ_CKBB XD3_XDFFM_S 1.8151e-17
* device instance cc_XD1_XDFFQ_CKBB_XD3_XDFFM_SB r0 *1 0,0
Ccc_XD1_XDFFQ_CKBB_XD3_XDFFM_SB XD1_XDFFQ_CKBB XD3_XDFFM_SB 1.8151e-17
* device instance cc_XD1_XDFFQ_CKBB_XD3_XDFFM_SFB r0 *1 0,0
Ccc_XD1_XDFFQ_CKBB_XD3_XDFFM_SFB XD1_XDFFQ_CKBB XD3_XDFFM_SFB 1.21e-17
* device instance cc_XD1_XDFFQ_CKBB_XD3_XDFFQ_CKBB r0 *1 0,0
Ccc_XD1_XDFFQ_CKBB_XD3_XDFFQ_CKBB XD1_XDFFQ_CKBB XD3_XDFFQ_CKBB 1.8151e-17
* device instance cc_XD1_XDFFQ_CKBB_XD3_XDFFQ_CLKB r0 *1 0,0
Ccc_XD1_XDFFQ_CKBB_XD3_XDFFQ_CLKB XD1_XDFFQ_CKBB XD3_XDFFQ_CLKB 2.4201e-17
* device instance cc_XD1_XDFFQ_CKBB_XD3_XDFFQ_M r0 *1 0,0
Ccc_XD1_XDFFQ_CKBB_XD3_XDFFQ_M XD1_XDFFQ_CKBB XD3_XDFFQ_M 2.4201e-17
* device instance cc_XD1_XDFFQ_CKBB_XD3_XDFFQ_MB r0 *1 0,0
Ccc_XD1_XDFFQ_CKBB_XD3_XDFFQ_MB XD1_XDFFQ_CKBB XD3_XDFFQ_MB 1.21e-17
* device instance cc_XD1_XDFFQ_CKBB_XD3_XDFFQ_MFB r0 *1 0,0
Ccc_XD1_XDFFQ_CKBB_XD3_XDFFQ_MFB XD1_XDFFQ_CKBB XD3_XDFFQ_MFB 1.21e-17
* device instance cc_XD1_XDFFQ_CKBB_XD3_XDFFQ_S r0 *1 0,0
Ccc_XD1_XDFFQ_CKBB_XD3_XDFFQ_S XD1_XDFFQ_CKBB XD3_XDFFQ_S 1.8151e-17
* device instance cc_XD1_XDFFQ_CKBB_XD3_XDFFQ_SB r0 *1 0,0
Ccc_XD1_XDFFQ_CKBB_XD3_XDFFQ_SB XD1_XDFFQ_CKBB XD3_XDFFQ_SB 1.8151e-17
* device instance cc_XD1_XDFFQ_CKBB_XD3_XDFFQ_SFB r0 *1 0,0
Ccc_XD1_XDFFQ_CKBB_XD3_XDFFQ_SFB XD1_XDFFQ_CKBB XD3_XDFFQ_SFB 1.21e-17
* device instance cc_XD1_XDFFQ_CKBB_XD3_XN2_mid1 r0 *1 0,0
Ccc_XD1_XDFFQ_CKBB_XD3_XN2_mid1 XD1_XDFFQ_CKBB XD3_XN2_mid1 1.21e-17
* device instance cc_XD1_XDFFQ_CKBB_XD3_XN3_mid1 r0 *1 0,0
Ccc_XD1_XDFFQ_CKBB_XD3_XN3_mid1 XD1_XDFFQ_CKBB XD3_XN3_mid1 1.21e-17
* device instance cc_XD1_XDFFQ_CKBB_XD3_XN3_mid2 r0 *1 0,0
Ccc_XD1_XDFFQ_CKBB_XD3_XN3_mid2 XD1_XDFFQ_CKBB XD3_XN3_mid2 1.21e-17
* device instance cc_XD1_XDFFQ_CKBB_XD3_dmodout r0 *1 0,0
Ccc_XD1_XDFFQ_CKBB_XD3_dmodout XD1_XDFFQ_CKBB XD3_dmodout 1.21e-17
* device instance cc_XD1_XDFFQ_CKBB_XD3_dq r0 *1 0,0
Ccc_XD1_XDFFQ_CKBB_XD3_dq XD1_XDFFQ_CKBB XD3_dq 1.8151e-17
* device instance cc_XD1_XDFFQ_CKBB_XD3_nm r0 *1 0,0
Ccc_XD1_XDFFQ_CKBB_XD3_nm XD1_XDFFQ_CKBB XD3_nm 1.21e-17
* device instance cc_XD1_XDFFQ_CKBB_XD3_nt r0 *1 0,0
Ccc_XD1_XDFFQ_CKBB_XD3_nt XD1_XDFFQ_CKBB XD3_nt 1.21e-17
* device instance cc_XD1_XDFFQ_CKBB_XD3_t1 r0 *1 0,0
Ccc_XD1_XDFFQ_CKBB_XD3_t1 XD1_XDFFQ_CKBB XD3_t1 1.21e-17
* device instance cc_XD1_XDFFQ_CKBB_XD4_XDFFM_CKBB r0 *1 0,0
Ccc_XD1_XDFFQ_CKBB_XD4_XDFFM_CKBB XD1_XDFFQ_CKBB XD4_XDFFM_CKBB 1.8151e-17
* device instance cc_XD1_XDFFQ_CKBB_XD4_XDFFM_CLKB r0 *1 0,0
Ccc_XD1_XDFFQ_CKBB_XD4_XDFFM_CLKB XD1_XDFFQ_CKBB XD4_XDFFM_CLKB 2.4201e-17
* device instance cc_XD1_XDFFQ_CKBB_XD4_XDFFM_M r0 *1 0,0
Ccc_XD1_XDFFQ_CKBB_XD4_XDFFM_M XD1_XDFFQ_CKBB XD4_XDFFM_M 2.4201e-17
* device instance cc_XD1_XDFFQ_CKBB_XD4_XDFFM_MB r0 *1 0,0
Ccc_XD1_XDFFQ_CKBB_XD4_XDFFM_MB XD1_XDFFQ_CKBB XD4_XDFFM_MB 1.21e-17
* device instance cc_XD1_XDFFQ_CKBB_XD4_XDFFM_MFB r0 *1 0,0
Ccc_XD1_XDFFQ_CKBB_XD4_XDFFM_MFB XD1_XDFFQ_CKBB XD4_XDFFM_MFB 1.21e-17
* device instance cc_XD1_XDFFQ_CKBB_XD4_XDFFM_S r0 *1 0,0
Ccc_XD1_XDFFQ_CKBB_XD4_XDFFM_S XD1_XDFFQ_CKBB XD4_XDFFM_S 1.8151e-17
* device instance cc_XD1_XDFFQ_CKBB_XD4_XDFFM_SB r0 *1 0,0
Ccc_XD1_XDFFQ_CKBB_XD4_XDFFM_SB XD1_XDFFQ_CKBB XD4_XDFFM_SB 1.8151e-17
* device instance cc_XD1_XDFFQ_CKBB_XD4_XDFFM_SFB r0 *1 0,0
Ccc_XD1_XDFFQ_CKBB_XD4_XDFFM_SFB XD1_XDFFQ_CKBB XD4_XDFFM_SFB 1.21e-17
* device instance cc_XD1_XDFFQ_CKBB_XD4_XDFFQ_CKBB r0 *1 0,0
Ccc_XD1_XDFFQ_CKBB_XD4_XDFFQ_CKBB XD1_XDFFQ_CKBB XD4_XDFFQ_CKBB 1.8151e-17
* device instance cc_XD1_XDFFQ_CKBB_XD4_XDFFQ_CLKB r0 *1 0,0
Ccc_XD1_XDFFQ_CKBB_XD4_XDFFQ_CLKB XD1_XDFFQ_CKBB XD4_XDFFQ_CLKB 2.4201e-17
* device instance cc_XD1_XDFFQ_CKBB_XD4_XDFFQ_M r0 *1 0,0
Ccc_XD1_XDFFQ_CKBB_XD4_XDFFQ_M XD1_XDFFQ_CKBB XD4_XDFFQ_M 2.4201e-17
* device instance cc_XD1_XDFFQ_CKBB_XD4_XDFFQ_MB r0 *1 0,0
Ccc_XD1_XDFFQ_CKBB_XD4_XDFFQ_MB XD1_XDFFQ_CKBB XD4_XDFFQ_MB 1.21e-17
* device instance cc_XD1_XDFFQ_CKBB_XD4_XDFFQ_MFB r0 *1 0,0
Ccc_XD1_XDFFQ_CKBB_XD4_XDFFQ_MFB XD1_XDFFQ_CKBB XD4_XDFFQ_MFB 1.21e-17
* device instance cc_XD1_XDFFQ_CKBB_XD4_XDFFQ_S r0 *1 0,0
Ccc_XD1_XDFFQ_CKBB_XD4_XDFFQ_S XD1_XDFFQ_CKBB XD4_XDFFQ_S 1.8151e-17
* device instance cc_XD1_XDFFQ_CKBB_XD4_XDFFQ_SB r0 *1 0,0
Ccc_XD1_XDFFQ_CKBB_XD4_XDFFQ_SB XD1_XDFFQ_CKBB XD4_XDFFQ_SB 1.8151e-17
* device instance cc_XD1_XDFFQ_CKBB_XD4_XDFFQ_SFB r0 *1 0,0
Ccc_XD1_XDFFQ_CKBB_XD4_XDFFQ_SFB XD1_XDFFQ_CKBB XD4_XDFFQ_SFB 1.21e-17
* device instance cc_XD1_XDFFQ_CKBB_XD4_XN2_mid1 r0 *1 0,0
Ccc_XD1_XDFFQ_CKBB_XD4_XN2_mid1 XD1_XDFFQ_CKBB XD4_XN2_mid1 1.21e-17
* device instance cc_XD1_XDFFQ_CKBB_XD4_XN3_mid1 r0 *1 0,0
Ccc_XD1_XDFFQ_CKBB_XD4_XN3_mid1 XD1_XDFFQ_CKBB XD4_XN3_mid1 1.21e-17
* device instance cc_XD1_XDFFQ_CKBB_XD4_XN3_mid2 r0 *1 0,0
Ccc_XD1_XDFFQ_CKBB_XD4_XN3_mid2 XD1_XDFFQ_CKBB XD4_XN3_mid2 1.21e-17
* device instance cc_XD1_XDFFQ_CKBB_XD4_dmodout r0 *1 0,0
Ccc_XD1_XDFFQ_CKBB_XD4_dmodout XD1_XDFFQ_CKBB XD4_dmodout 1.21e-17
* device instance cc_XD1_XDFFQ_CKBB_XD4_dq r0 *1 0,0
Ccc_XD1_XDFFQ_CKBB_XD4_dq XD1_XDFFQ_CKBB XD4_dq 1.8151e-17
* device instance cc_XD1_XDFFQ_CKBB_XD4_nm r0 *1 0,0
Ccc_XD1_XDFFQ_CKBB_XD4_nm XD1_XDFFQ_CKBB XD4_nm 1.21e-17
* device instance cc_XD1_XDFFQ_CKBB_XD4_nt r0 *1 0,0
Ccc_XD1_XDFFQ_CKBB_XD4_nt XD1_XDFFQ_CKBB XD4_nt 1.21e-17
* device instance cc_XD1_XDFFQ_CKBB_XD4_t1 r0 *1 0,0
Ccc_XD1_XDFFQ_CKBB_XD4_t1 XD1_XDFFQ_CKBB XD4_t1 1.21e-17
* device instance cc_XD1_XDFFQ_CKBB_XD5_XDFFM_CKBB r0 *1 0,0
Ccc_XD1_XDFFQ_CKBB_XD5_XDFFM_CKBB XD1_XDFFQ_CKBB XD5_XDFFM_CKBB 1.8151e-17
* device instance cc_XD1_XDFFQ_CKBB_XD5_XDFFM_CLKB r0 *1 0,0
Ccc_XD1_XDFFQ_CKBB_XD5_XDFFM_CLKB XD1_XDFFQ_CKBB XD5_XDFFM_CLKB 2.4201e-17
* device instance cc_XD1_XDFFQ_CKBB_XD5_XDFFM_M r0 *1 0,0
Ccc_XD1_XDFFQ_CKBB_XD5_XDFFM_M XD1_XDFFQ_CKBB XD5_XDFFM_M 2.4201e-17
* device instance cc_XD1_XDFFQ_CKBB_XD5_XDFFM_MB r0 *1 0,0
Ccc_XD1_XDFFQ_CKBB_XD5_XDFFM_MB XD1_XDFFQ_CKBB XD5_XDFFM_MB 1.21e-17
* device instance cc_XD1_XDFFQ_CKBB_XD5_XDFFM_MFB r0 *1 0,0
Ccc_XD1_XDFFQ_CKBB_XD5_XDFFM_MFB XD1_XDFFQ_CKBB XD5_XDFFM_MFB 1.21e-17
* device instance cc_XD1_XDFFQ_CKBB_XD5_XDFFM_S r0 *1 0,0
Ccc_XD1_XDFFQ_CKBB_XD5_XDFFM_S XD1_XDFFQ_CKBB XD5_XDFFM_S 1.8151e-17
* device instance cc_XD1_XDFFQ_CKBB_XD5_XDFFM_SB r0 *1 0,0
Ccc_XD1_XDFFQ_CKBB_XD5_XDFFM_SB XD1_XDFFQ_CKBB XD5_XDFFM_SB 1.8151e-17
* device instance cc_XD1_XDFFQ_CKBB_XD5_XDFFM_SFB r0 *1 0,0
Ccc_XD1_XDFFQ_CKBB_XD5_XDFFM_SFB XD1_XDFFQ_CKBB XD5_XDFFM_SFB 1.21e-17
* device instance cc_XD1_XDFFQ_CKBB_XD5_XDFFQ_CKBB r0 *1 0,0
Ccc_XD1_XDFFQ_CKBB_XD5_XDFFQ_CKBB XD1_XDFFQ_CKBB XD5_XDFFQ_CKBB 1.8151e-17
* device instance cc_XD1_XDFFQ_CKBB_XD5_XDFFQ_CLKB r0 *1 0,0
Ccc_XD1_XDFFQ_CKBB_XD5_XDFFQ_CLKB XD1_XDFFQ_CKBB XD5_XDFFQ_CLKB 2.4201e-17
* device instance cc_XD1_XDFFQ_CKBB_XD5_XDFFQ_M r0 *1 0,0
Ccc_XD1_XDFFQ_CKBB_XD5_XDFFQ_M XD1_XDFFQ_CKBB XD5_XDFFQ_M 2.4201e-17
* device instance cc_XD1_XDFFQ_CKBB_XD5_XDFFQ_MB r0 *1 0,0
Ccc_XD1_XDFFQ_CKBB_XD5_XDFFQ_MB XD1_XDFFQ_CKBB XD5_XDFFQ_MB 1.21e-17
* device instance cc_XD1_XDFFQ_CKBB_XD5_XDFFQ_MFB r0 *1 0,0
Ccc_XD1_XDFFQ_CKBB_XD5_XDFFQ_MFB XD1_XDFFQ_CKBB XD5_XDFFQ_MFB 1.21e-17
* device instance cc_XD1_XDFFQ_CKBB_XD5_XDFFQ_S r0 *1 0,0
Ccc_XD1_XDFFQ_CKBB_XD5_XDFFQ_S XD1_XDFFQ_CKBB XD5_XDFFQ_S 1.8151e-17
* device instance cc_XD1_XDFFQ_CKBB_XD5_XDFFQ_SB r0 *1 0,0
Ccc_XD1_XDFFQ_CKBB_XD5_XDFFQ_SB XD1_XDFFQ_CKBB XD5_XDFFQ_SB 1.8151e-17
* device instance cc_XD1_XDFFQ_CKBB_XD5_XDFFQ_SFB r0 *1 0,0
Ccc_XD1_XDFFQ_CKBB_XD5_XDFFQ_SFB XD1_XDFFQ_CKBB XD5_XDFFQ_SFB 1.21e-17
* device instance cc_XD1_XDFFQ_CKBB_XD5_XN2_mid1 r0 *1 0,0
Ccc_XD1_XDFFQ_CKBB_XD5_XN2_mid1 XD1_XDFFQ_CKBB XD5_XN2_mid1 1.21e-17
* device instance cc_XD1_XDFFQ_CKBB_XD5_XN3_mid1 r0 *1 0,0
Ccc_XD1_XDFFQ_CKBB_XD5_XN3_mid1 XD1_XDFFQ_CKBB XD5_XN3_mid1 1.21e-17
* device instance cc_XD1_XDFFQ_CKBB_XD5_XN3_mid2 r0 *1 0,0
Ccc_XD1_XDFFQ_CKBB_XD5_XN3_mid2 XD1_XDFFQ_CKBB XD5_XN3_mid2 1.21e-17
* device instance cc_XD1_XDFFQ_CKBB_XD5_dmodout r0 *1 0,0
Ccc_XD1_XDFFQ_CKBB_XD5_dmodout XD1_XDFFQ_CKBB XD5_dmodout 1.21e-17
* device instance cc_XD1_XDFFQ_CKBB_XD5_dq r0 *1 0,0
Ccc_XD1_XDFFQ_CKBB_XD5_dq XD1_XDFFQ_CKBB XD5_dq 1.8151e-17
* device instance cc_XD1_XDFFQ_CKBB_XD5_nm r0 *1 0,0
Ccc_XD1_XDFFQ_CKBB_XD5_nm XD1_XDFFQ_CKBB XD5_nm 1.21e-17
* device instance cc_XD1_XDFFQ_CKBB_XD5_nt r0 *1 0,0
Ccc_XD1_XDFFQ_CKBB_XD5_nt XD1_XDFFQ_CKBB XD5_nt 1.21e-17
* device instance cc_XD1_XDFFQ_CKBB_XD5_t1 r0 *1 0,0
Ccc_XD1_XDFFQ_CKBB_XD5_t1 XD1_XDFFQ_CKBB XD5_t1 1.21e-17
* device instance cc_XD1_XDFFQ_CKBB_XFRT_CKBB r0 *1 0,0
Ccc_XD1_XDFFQ_CKBB_XFRT_CKBB XD1_XDFFQ_CKBB XFRT_CKBB 1.8151e-17
* device instance cc_XD1_XDFFQ_CKBB_XFRT_CLKB r0 *1 0,0
Ccc_XD1_XDFFQ_CKBB_XFRT_CLKB XD1_XDFFQ_CKBB XFRT_CLKB 2.4201e-17
* device instance cc_XD1_XDFFQ_CKBB_XFRT_M r0 *1 0,0
Ccc_XD1_XDFFQ_CKBB_XFRT_M XD1_XDFFQ_CKBB XFRT_M 2.4201e-17
* device instance cc_XD1_XDFFQ_CKBB_XFRT_MB r0 *1 0,0
Ccc_XD1_XDFFQ_CKBB_XFRT_MB XD1_XDFFQ_CKBB XFRT_MB 1.21e-17
* device instance cc_XD1_XDFFQ_CKBB_XFRT_MFB r0 *1 0,0
Ccc_XD1_XDFFQ_CKBB_XFRT_MFB XD1_XDFFQ_CKBB XFRT_MFB 1.21e-17
* device instance cc_XD1_XDFFQ_CKBB_XFRT_S r0 *1 0,0
Ccc_XD1_XDFFQ_CKBB_XFRT_S XD1_XDFFQ_CKBB XFRT_S 1.8151e-17
* device instance cc_XD1_XDFFQ_CKBB_XFRT_SB r0 *1 0,0
Ccc_XD1_XDFFQ_CKBB_XFRT_SB XD1_XDFFQ_CKBB XFRT_SB 1.8151e-17
* device instance cc_XD1_XDFFQ_CKBB_XFRT_SFB r0 *1 0,0
Ccc_XD1_XDFFQ_CKBB_XFRT_SFB XD1_XDFFQ_CKBB XFRT_SFB 1.21e-17
* device instance cc_XD1_XDFFQ_CKBB_ck1 r0 *1 0,0
Ccc_XD1_XDFFQ_CKBB_ck1 XD1_XDFFQ_CKBB ck1 3.0251e-17
* device instance cc_XD1_XDFFQ_CKBB_ck2 r0 *1 0,0
Ccc_XD1_XDFFQ_CKBB_ck2 XD1_XDFFQ_CKBB ck2 3.0251e-17
* device instance cc_XD1_XDFFQ_CKBB_ck3 r0 *1 0,0
Ccc_XD1_XDFFQ_CKBB_ck3 XD1_XDFFQ_CKBB ck3 3.0251e-17
* device instance cc_XD1_XDFFQ_CKBB_ck4 r0 *1 0,0
Ccc_XD1_XDFFQ_CKBB_ck4 XD1_XDFFQ_CKBB ck4 3.0251e-17
* device instance cc_XD1_XDFFQ_CKBB_ck5 r0 *1 0,0
Ccc_XD1_XDFFQ_CKBB_ck5 XD1_XDFFQ_CKBB ck5 3.0251e-17
* device instance cc_XD1_XDFFQ_CKBB_mod0 r0 *1 0,0
Ccc_XD1_XDFFQ_CKBB_mod0 XD1_XDFFQ_CKBB mod0 2.4201e-17
* device instance cc_XD1_XDFFQ_CKBB_mod1 r0 *1 0,0
Ccc_XD1_XDFFQ_CKBB_mod1 XD1_XDFFQ_CKBB mod1 2.4201e-17
* device instance cc_XD1_XDFFQ_CKBB_mod2 r0 *1 0,0
Ccc_XD1_XDFFQ_CKBB_mod2 XD1_XDFFQ_CKBB mod2 2.4201e-17
* device instance cc_XD1_XDFFQ_CKBB_mod3 r0 *1 0,0
Ccc_XD1_XDFFQ_CKBB_mod3 XD1_XDFFQ_CKBB mod3 2.4201e-17
* device instance cc_XD1_XDFFQ_CKBB_mod4 r0 *1 0,0
Ccc_XD1_XDFFQ_CKBB_mod4 XD1_XDFFQ_CKBB mod4 2.4201e-17
* device instance cc_XD1_XDFFQ_CKBB_net1 r0 *1 0,0
Ccc_XD1_XDFFQ_CKBB_net1 XD1_XDFFQ_CKBB net1 1.21e-17
* device instance cc_XD1_XDFFQ_CLKB_XD1_XDFFQ_M r0 *1 0,0
Ccc_XD1_XDFFQ_CLKB_XD1_XDFFQ_M XD1_XDFFQ_CLKB XD1_XDFFQ_M 4.2352e-17
* device instance cc_XD1_XDFFQ_CLKB_XD1_XDFFQ_MB r0 *1 0,0
Ccc_XD1_XDFFQ_CLKB_XD1_XDFFQ_MB XD1_XDFFQ_CLKB XD1_XDFFQ_MB 2.4201e-17
* device instance cc_XD1_XDFFQ_CLKB_XD1_XDFFQ_MFB r0 *1 0,0
Ccc_XD1_XDFFQ_CLKB_XD1_XDFFQ_MFB XD1_XDFFQ_CLKB XD1_XDFFQ_MFB 2.4201e-17
* device instance cc_XD1_XDFFQ_CLKB_XD1_XDFFQ_S r0 *1 0,0
Ccc_XD1_XDFFQ_CLKB_XD1_XDFFQ_S XD1_XDFFQ_CLKB XD1_XDFFQ_S 1.8151e-17
* device instance cc_XD1_XDFFQ_CLKB_XD1_XDFFQ_SB r0 *1 0,0
Ccc_XD1_XDFFQ_CLKB_XD1_XDFFQ_SB XD1_XDFFQ_CLKB XD1_XDFFQ_SB 1.8151e-17
* device instance cc_XD1_XDFFQ_CLKB_XD1_XDFFQ_SFB r0 *1 0,0
Ccc_XD1_XDFFQ_CLKB_XD1_XDFFQ_SFB XD1_XDFFQ_CLKB XD1_XDFFQ_SFB 1.21e-17
* device instance cc_XD1_XDFFQ_CLKB_XD1_XN2_mid1 r0 *1 0,0
Ccc_XD1_XDFFQ_CLKB_XD1_XN2_mid1 XD1_XDFFQ_CLKB XD1_XN2_mid1 1.21e-17
* device instance cc_XD1_XDFFQ_CLKB_XD1_XNOR_midp r0 *1 0,0
Ccc_XD1_XDFFQ_CLKB_XD1_XNOR_midp XD1_XDFFQ_CLKB XD1_XNOR_midp 1.21e-17
* device instance cc_XD1_XDFFQ_CLKB_XD1_dmodout r0 *1 0,0
Ccc_XD1_XDFFQ_CLKB_XD1_dmodout XD1_XDFFQ_CLKB XD1_dmodout 1.21e-17
* device instance cc_XD1_XDFFQ_CLKB_XD1_dq r0 *1 0,0
Ccc_XD1_XDFFQ_CLKB_XD1_dq XD1_XDFFQ_CLKB XD1_dq 1.8151e-17
* device instance cc_XD1_XDFFQ_CLKB_XD1_nm r0 *1 0,0
Ccc_XD1_XDFFQ_CLKB_XD1_nm XD1_XDFFQ_CLKB XD1_nm 1.21e-17
* device instance cc_XD1_XDFFQ_CLKB_XD1_nt r0 *1 0,0
Ccc_XD1_XDFFQ_CLKB_XD1_nt XD1_XDFFQ_CLKB XD1_nt 2.4201e-17
* device instance cc_XD1_XDFFQ_CLKB_XD1_t1 r0 *1 0,0
Ccc_XD1_XDFFQ_CLKB_XD1_t1 XD1_XDFFQ_CLKB XD1_t1 1.21e-17
* device instance cc_XD1_XDFFQ_CLKB_XD2_XDFFM_CKBB r0 *1 0,0
Ccc_XD1_XDFFQ_CLKB_XD2_XDFFM_CKBB XD1_XDFFQ_CLKB XD2_XDFFM_CKBB 1.8151e-17
* device instance cc_XD1_XDFFQ_CLKB_XD2_XDFFM_CLKB r0 *1 0,0
Ccc_XD1_XDFFQ_CLKB_XD2_XDFFM_CLKB XD1_XDFFQ_CLKB XD2_XDFFM_CLKB 2.4201e-17
* device instance cc_XD1_XDFFQ_CLKB_XD2_XDFFM_M r0 *1 0,0
Ccc_XD1_XDFFQ_CLKB_XD2_XDFFM_M XD1_XDFFQ_CLKB XD2_XDFFM_M 2.4201e-17
* device instance cc_XD1_XDFFQ_CLKB_XD2_XDFFM_MB r0 *1 0,0
Ccc_XD1_XDFFQ_CLKB_XD2_XDFFM_MB XD1_XDFFQ_CLKB XD2_XDFFM_MB 1.21e-17
* device instance cc_XD1_XDFFQ_CLKB_XD2_XDFFM_MFB r0 *1 0,0
Ccc_XD1_XDFFQ_CLKB_XD2_XDFFM_MFB XD1_XDFFQ_CLKB XD2_XDFFM_MFB 1.21e-17
* device instance cc_XD1_XDFFQ_CLKB_XD2_XDFFM_S r0 *1 0,0
Ccc_XD1_XDFFQ_CLKB_XD2_XDFFM_S XD1_XDFFQ_CLKB XD2_XDFFM_S 1.8151e-17
* device instance cc_XD1_XDFFQ_CLKB_XD2_XDFFM_SB r0 *1 0,0
Ccc_XD1_XDFFQ_CLKB_XD2_XDFFM_SB XD1_XDFFQ_CLKB XD2_XDFFM_SB 1.8151e-17
* device instance cc_XD1_XDFFQ_CLKB_XD2_XDFFM_SFB r0 *1 0,0
Ccc_XD1_XDFFQ_CLKB_XD2_XDFFM_SFB XD1_XDFFQ_CLKB XD2_XDFFM_SFB 1.21e-17
* device instance cc_XD1_XDFFQ_CLKB_XD2_XDFFQ_CKBB r0 *1 0,0
Ccc_XD1_XDFFQ_CLKB_XD2_XDFFQ_CKBB XD1_XDFFQ_CLKB XD2_XDFFQ_CKBB 1.8151e-17
* device instance cc_XD1_XDFFQ_CLKB_XD2_XDFFQ_CLKB r0 *1 0,0
Ccc_XD1_XDFFQ_CLKB_XD2_XDFFQ_CLKB XD1_XDFFQ_CLKB XD2_XDFFQ_CLKB 2.4201e-17
* device instance cc_XD1_XDFFQ_CLKB_XD2_XDFFQ_M r0 *1 0,0
Ccc_XD1_XDFFQ_CLKB_XD2_XDFFQ_M XD1_XDFFQ_CLKB XD2_XDFFQ_M 2.4201e-17
* device instance cc_XD1_XDFFQ_CLKB_XD2_XDFFQ_MB r0 *1 0,0
Ccc_XD1_XDFFQ_CLKB_XD2_XDFFQ_MB XD1_XDFFQ_CLKB XD2_XDFFQ_MB 1.21e-17
* device instance cc_XD1_XDFFQ_CLKB_XD2_XDFFQ_MFB r0 *1 0,0
Ccc_XD1_XDFFQ_CLKB_XD2_XDFFQ_MFB XD1_XDFFQ_CLKB XD2_XDFFQ_MFB 1.21e-17
* device instance cc_XD1_XDFFQ_CLKB_XD2_XDFFQ_S r0 *1 0,0
Ccc_XD1_XDFFQ_CLKB_XD2_XDFFQ_S XD1_XDFFQ_CLKB XD2_XDFFQ_S 1.8151e-17
* device instance cc_XD1_XDFFQ_CLKB_XD2_XDFFQ_SB r0 *1 0,0
Ccc_XD1_XDFFQ_CLKB_XD2_XDFFQ_SB XD1_XDFFQ_CLKB XD2_XDFFQ_SB 1.8151e-17
* device instance cc_XD1_XDFFQ_CLKB_XD2_XDFFQ_SFB r0 *1 0,0
Ccc_XD1_XDFFQ_CLKB_XD2_XDFFQ_SFB XD1_XDFFQ_CLKB XD2_XDFFQ_SFB 1.21e-17
* device instance cc_XD1_XDFFQ_CLKB_XD2_XN2_mid1 r0 *1 0,0
Ccc_XD1_XDFFQ_CLKB_XD2_XN2_mid1 XD1_XDFFQ_CLKB XD2_XN2_mid1 1.21e-17
* device instance cc_XD1_XDFFQ_CLKB_XD2_XN3_mid1 r0 *1 0,0
Ccc_XD1_XDFFQ_CLKB_XD2_XN3_mid1 XD1_XDFFQ_CLKB XD2_XN3_mid1 1.21e-17
* device instance cc_XD1_XDFFQ_CLKB_XD2_XN3_mid2 r0 *1 0,0
Ccc_XD1_XDFFQ_CLKB_XD2_XN3_mid2 XD1_XDFFQ_CLKB XD2_XN3_mid2 1.21e-17
* device instance cc_XD1_XDFFQ_CLKB_XD2_dmodout r0 *1 0,0
Ccc_XD1_XDFFQ_CLKB_XD2_dmodout XD1_XDFFQ_CLKB XD2_dmodout 1.21e-17
* device instance cc_XD1_XDFFQ_CLKB_XD2_dq r0 *1 0,0
Ccc_XD1_XDFFQ_CLKB_XD2_dq XD1_XDFFQ_CLKB XD2_dq 1.8151e-17
* device instance cc_XD1_XDFFQ_CLKB_XD2_nm r0 *1 0,0
Ccc_XD1_XDFFQ_CLKB_XD2_nm XD1_XDFFQ_CLKB XD2_nm 1.21e-17
* device instance cc_XD1_XDFFQ_CLKB_XD2_nt r0 *1 0,0
Ccc_XD1_XDFFQ_CLKB_XD2_nt XD1_XDFFQ_CLKB XD2_nt 1.21e-17
* device instance cc_XD1_XDFFQ_CLKB_XD2_t1 r0 *1 0,0
Ccc_XD1_XDFFQ_CLKB_XD2_t1 XD1_XDFFQ_CLKB XD2_t1 1.21e-17
* device instance cc_XD1_XDFFQ_CLKB_XD3_XDFFM_CKBB r0 *1 0,0
Ccc_XD1_XDFFQ_CLKB_XD3_XDFFM_CKBB XD1_XDFFQ_CLKB XD3_XDFFM_CKBB 1.8151e-17
* device instance cc_XD1_XDFFQ_CLKB_XD3_XDFFM_CLKB r0 *1 0,0
Ccc_XD1_XDFFQ_CLKB_XD3_XDFFM_CLKB XD1_XDFFQ_CLKB XD3_XDFFM_CLKB 2.4201e-17
* device instance cc_XD1_XDFFQ_CLKB_XD3_XDFFM_M r0 *1 0,0
Ccc_XD1_XDFFQ_CLKB_XD3_XDFFM_M XD1_XDFFQ_CLKB XD3_XDFFM_M 2.4201e-17
* device instance cc_XD1_XDFFQ_CLKB_XD3_XDFFM_MB r0 *1 0,0
Ccc_XD1_XDFFQ_CLKB_XD3_XDFFM_MB XD1_XDFFQ_CLKB XD3_XDFFM_MB 1.21e-17
* device instance cc_XD1_XDFFQ_CLKB_XD3_XDFFM_MFB r0 *1 0,0
Ccc_XD1_XDFFQ_CLKB_XD3_XDFFM_MFB XD1_XDFFQ_CLKB XD3_XDFFM_MFB 1.21e-17
* device instance cc_XD1_XDFFQ_CLKB_XD3_XDFFM_S r0 *1 0,0
Ccc_XD1_XDFFQ_CLKB_XD3_XDFFM_S XD1_XDFFQ_CLKB XD3_XDFFM_S 1.8151e-17
* device instance cc_XD1_XDFFQ_CLKB_XD3_XDFFM_SB r0 *1 0,0
Ccc_XD1_XDFFQ_CLKB_XD3_XDFFM_SB XD1_XDFFQ_CLKB XD3_XDFFM_SB 1.8151e-17
* device instance cc_XD1_XDFFQ_CLKB_XD3_XDFFM_SFB r0 *1 0,0
Ccc_XD1_XDFFQ_CLKB_XD3_XDFFM_SFB XD1_XDFFQ_CLKB XD3_XDFFM_SFB 1.21e-17
* device instance cc_XD1_XDFFQ_CLKB_XD3_XDFFQ_CKBB r0 *1 0,0
Ccc_XD1_XDFFQ_CLKB_XD3_XDFFQ_CKBB XD1_XDFFQ_CLKB XD3_XDFFQ_CKBB 1.8151e-17
* device instance cc_XD1_XDFFQ_CLKB_XD3_XDFFQ_CLKB r0 *1 0,0
Ccc_XD1_XDFFQ_CLKB_XD3_XDFFQ_CLKB XD1_XDFFQ_CLKB XD3_XDFFQ_CLKB 2.4201e-17
* device instance cc_XD1_XDFFQ_CLKB_XD3_XDFFQ_M r0 *1 0,0
Ccc_XD1_XDFFQ_CLKB_XD3_XDFFQ_M XD1_XDFFQ_CLKB XD3_XDFFQ_M 2.4201e-17
* device instance cc_XD1_XDFFQ_CLKB_XD3_XDFFQ_MB r0 *1 0,0
Ccc_XD1_XDFFQ_CLKB_XD3_XDFFQ_MB XD1_XDFFQ_CLKB XD3_XDFFQ_MB 1.21e-17
* device instance cc_XD1_XDFFQ_CLKB_XD3_XDFFQ_MFB r0 *1 0,0
Ccc_XD1_XDFFQ_CLKB_XD3_XDFFQ_MFB XD1_XDFFQ_CLKB XD3_XDFFQ_MFB 1.21e-17
* device instance cc_XD1_XDFFQ_CLKB_XD3_XDFFQ_S r0 *1 0,0
Ccc_XD1_XDFFQ_CLKB_XD3_XDFFQ_S XD1_XDFFQ_CLKB XD3_XDFFQ_S 1.8151e-17
* device instance cc_XD1_XDFFQ_CLKB_XD3_XDFFQ_SB r0 *1 0,0
Ccc_XD1_XDFFQ_CLKB_XD3_XDFFQ_SB XD1_XDFFQ_CLKB XD3_XDFFQ_SB 1.8151e-17
* device instance cc_XD1_XDFFQ_CLKB_XD3_XDFFQ_SFB r0 *1 0,0
Ccc_XD1_XDFFQ_CLKB_XD3_XDFFQ_SFB XD1_XDFFQ_CLKB XD3_XDFFQ_SFB 1.21e-17
* device instance cc_XD1_XDFFQ_CLKB_XD3_XN2_mid1 r0 *1 0,0
Ccc_XD1_XDFFQ_CLKB_XD3_XN2_mid1 XD1_XDFFQ_CLKB XD3_XN2_mid1 1.21e-17
* device instance cc_XD1_XDFFQ_CLKB_XD3_XN3_mid1 r0 *1 0,0
Ccc_XD1_XDFFQ_CLKB_XD3_XN3_mid1 XD1_XDFFQ_CLKB XD3_XN3_mid1 1.21e-17
* device instance cc_XD1_XDFFQ_CLKB_XD3_XN3_mid2 r0 *1 0,0
Ccc_XD1_XDFFQ_CLKB_XD3_XN3_mid2 XD1_XDFFQ_CLKB XD3_XN3_mid2 1.21e-17
* device instance cc_XD1_XDFFQ_CLKB_XD3_dmodout r0 *1 0,0
Ccc_XD1_XDFFQ_CLKB_XD3_dmodout XD1_XDFFQ_CLKB XD3_dmodout 1.21e-17
* device instance cc_XD1_XDFFQ_CLKB_XD3_dq r0 *1 0,0
Ccc_XD1_XDFFQ_CLKB_XD3_dq XD1_XDFFQ_CLKB XD3_dq 1.8151e-17
* device instance cc_XD1_XDFFQ_CLKB_XD3_nm r0 *1 0,0
Ccc_XD1_XDFFQ_CLKB_XD3_nm XD1_XDFFQ_CLKB XD3_nm 1.21e-17
* device instance cc_XD1_XDFFQ_CLKB_XD3_nt r0 *1 0,0
Ccc_XD1_XDFFQ_CLKB_XD3_nt XD1_XDFFQ_CLKB XD3_nt 1.21e-17
* device instance cc_XD1_XDFFQ_CLKB_XD3_t1 r0 *1 0,0
Ccc_XD1_XDFFQ_CLKB_XD3_t1 XD1_XDFFQ_CLKB XD3_t1 1.21e-17
* device instance cc_XD1_XDFFQ_CLKB_XD4_XDFFM_CKBB r0 *1 0,0
Ccc_XD1_XDFFQ_CLKB_XD4_XDFFM_CKBB XD1_XDFFQ_CLKB XD4_XDFFM_CKBB 1.8151e-17
* device instance cc_XD1_XDFFQ_CLKB_XD4_XDFFM_CLKB r0 *1 0,0
Ccc_XD1_XDFFQ_CLKB_XD4_XDFFM_CLKB XD1_XDFFQ_CLKB XD4_XDFFM_CLKB 2.4201e-17
* device instance cc_XD1_XDFFQ_CLKB_XD4_XDFFM_M r0 *1 0,0
Ccc_XD1_XDFFQ_CLKB_XD4_XDFFM_M XD1_XDFFQ_CLKB XD4_XDFFM_M 2.4201e-17
* device instance cc_XD1_XDFFQ_CLKB_XD4_XDFFM_MB r0 *1 0,0
Ccc_XD1_XDFFQ_CLKB_XD4_XDFFM_MB XD1_XDFFQ_CLKB XD4_XDFFM_MB 1.21e-17
* device instance cc_XD1_XDFFQ_CLKB_XD4_XDFFM_MFB r0 *1 0,0
Ccc_XD1_XDFFQ_CLKB_XD4_XDFFM_MFB XD1_XDFFQ_CLKB XD4_XDFFM_MFB 1.21e-17
* device instance cc_XD1_XDFFQ_CLKB_XD4_XDFFM_S r0 *1 0,0
Ccc_XD1_XDFFQ_CLKB_XD4_XDFFM_S XD1_XDFFQ_CLKB XD4_XDFFM_S 1.8151e-17
* device instance cc_XD1_XDFFQ_CLKB_XD4_XDFFM_SB r0 *1 0,0
Ccc_XD1_XDFFQ_CLKB_XD4_XDFFM_SB XD1_XDFFQ_CLKB XD4_XDFFM_SB 1.8151e-17
* device instance cc_XD1_XDFFQ_CLKB_XD4_XDFFM_SFB r0 *1 0,0
Ccc_XD1_XDFFQ_CLKB_XD4_XDFFM_SFB XD1_XDFFQ_CLKB XD4_XDFFM_SFB 1.21e-17
* device instance cc_XD1_XDFFQ_CLKB_XD4_XDFFQ_CKBB r0 *1 0,0
Ccc_XD1_XDFFQ_CLKB_XD4_XDFFQ_CKBB XD1_XDFFQ_CLKB XD4_XDFFQ_CKBB 1.8151e-17
* device instance cc_XD1_XDFFQ_CLKB_XD4_XDFFQ_CLKB r0 *1 0,0
Ccc_XD1_XDFFQ_CLKB_XD4_XDFFQ_CLKB XD1_XDFFQ_CLKB XD4_XDFFQ_CLKB 2.4201e-17
* device instance cc_XD1_XDFFQ_CLKB_XD4_XDFFQ_M r0 *1 0,0
Ccc_XD1_XDFFQ_CLKB_XD4_XDFFQ_M XD1_XDFFQ_CLKB XD4_XDFFQ_M 2.4201e-17
* device instance cc_XD1_XDFFQ_CLKB_XD4_XDFFQ_MB r0 *1 0,0
Ccc_XD1_XDFFQ_CLKB_XD4_XDFFQ_MB XD1_XDFFQ_CLKB XD4_XDFFQ_MB 1.21e-17
* device instance cc_XD1_XDFFQ_CLKB_XD4_XDFFQ_MFB r0 *1 0,0
Ccc_XD1_XDFFQ_CLKB_XD4_XDFFQ_MFB XD1_XDFFQ_CLKB XD4_XDFFQ_MFB 1.21e-17
* device instance cc_XD1_XDFFQ_CLKB_XD4_XDFFQ_S r0 *1 0,0
Ccc_XD1_XDFFQ_CLKB_XD4_XDFFQ_S XD1_XDFFQ_CLKB XD4_XDFFQ_S 1.8151e-17
* device instance cc_XD1_XDFFQ_CLKB_XD4_XDFFQ_SB r0 *1 0,0
Ccc_XD1_XDFFQ_CLKB_XD4_XDFFQ_SB XD1_XDFFQ_CLKB XD4_XDFFQ_SB 1.8151e-17
* device instance cc_XD1_XDFFQ_CLKB_XD4_XDFFQ_SFB r0 *1 0,0
Ccc_XD1_XDFFQ_CLKB_XD4_XDFFQ_SFB XD1_XDFFQ_CLKB XD4_XDFFQ_SFB 1.21e-17
* device instance cc_XD1_XDFFQ_CLKB_XD4_XN2_mid1 r0 *1 0,0
Ccc_XD1_XDFFQ_CLKB_XD4_XN2_mid1 XD1_XDFFQ_CLKB XD4_XN2_mid1 1.21e-17
* device instance cc_XD1_XDFFQ_CLKB_XD4_XN3_mid1 r0 *1 0,0
Ccc_XD1_XDFFQ_CLKB_XD4_XN3_mid1 XD1_XDFFQ_CLKB XD4_XN3_mid1 1.21e-17
* device instance cc_XD1_XDFFQ_CLKB_XD4_XN3_mid2 r0 *1 0,0
Ccc_XD1_XDFFQ_CLKB_XD4_XN3_mid2 XD1_XDFFQ_CLKB XD4_XN3_mid2 1.21e-17
* device instance cc_XD1_XDFFQ_CLKB_XD4_dmodout r0 *1 0,0
Ccc_XD1_XDFFQ_CLKB_XD4_dmodout XD1_XDFFQ_CLKB XD4_dmodout 1.21e-17
* device instance cc_XD1_XDFFQ_CLKB_XD4_dq r0 *1 0,0
Ccc_XD1_XDFFQ_CLKB_XD4_dq XD1_XDFFQ_CLKB XD4_dq 1.8151e-17
* device instance cc_XD1_XDFFQ_CLKB_XD4_nm r0 *1 0,0
Ccc_XD1_XDFFQ_CLKB_XD4_nm XD1_XDFFQ_CLKB XD4_nm 1.21e-17
* device instance cc_XD1_XDFFQ_CLKB_XD4_nt r0 *1 0,0
Ccc_XD1_XDFFQ_CLKB_XD4_nt XD1_XDFFQ_CLKB XD4_nt 1.21e-17
* device instance cc_XD1_XDFFQ_CLKB_XD4_t1 r0 *1 0,0
Ccc_XD1_XDFFQ_CLKB_XD4_t1 XD1_XDFFQ_CLKB XD4_t1 1.21e-17
* device instance cc_XD1_XDFFQ_CLKB_XD5_XDFFM_CKBB r0 *1 0,0
Ccc_XD1_XDFFQ_CLKB_XD5_XDFFM_CKBB XD1_XDFFQ_CLKB XD5_XDFFM_CKBB 1.8151e-17
* device instance cc_XD1_XDFFQ_CLKB_XD5_XDFFM_CLKB r0 *1 0,0
Ccc_XD1_XDFFQ_CLKB_XD5_XDFFM_CLKB XD1_XDFFQ_CLKB XD5_XDFFM_CLKB 2.4201e-17
* device instance cc_XD1_XDFFQ_CLKB_XD5_XDFFM_M r0 *1 0,0
Ccc_XD1_XDFFQ_CLKB_XD5_XDFFM_M XD1_XDFFQ_CLKB XD5_XDFFM_M 2.4201e-17
* device instance cc_XD1_XDFFQ_CLKB_XD5_XDFFM_MB r0 *1 0,0
Ccc_XD1_XDFFQ_CLKB_XD5_XDFFM_MB XD1_XDFFQ_CLKB XD5_XDFFM_MB 1.21e-17
* device instance cc_XD1_XDFFQ_CLKB_XD5_XDFFM_MFB r0 *1 0,0
Ccc_XD1_XDFFQ_CLKB_XD5_XDFFM_MFB XD1_XDFFQ_CLKB XD5_XDFFM_MFB 1.21e-17
* device instance cc_XD1_XDFFQ_CLKB_XD5_XDFFM_S r0 *1 0,0
Ccc_XD1_XDFFQ_CLKB_XD5_XDFFM_S XD1_XDFFQ_CLKB XD5_XDFFM_S 1.8151e-17
* device instance cc_XD1_XDFFQ_CLKB_XD5_XDFFM_SB r0 *1 0,0
Ccc_XD1_XDFFQ_CLKB_XD5_XDFFM_SB XD1_XDFFQ_CLKB XD5_XDFFM_SB 1.8151e-17
* device instance cc_XD1_XDFFQ_CLKB_XD5_XDFFM_SFB r0 *1 0,0
Ccc_XD1_XDFFQ_CLKB_XD5_XDFFM_SFB XD1_XDFFQ_CLKB XD5_XDFFM_SFB 1.21e-17
* device instance cc_XD1_XDFFQ_CLKB_XD5_XDFFQ_CKBB r0 *1 0,0
Ccc_XD1_XDFFQ_CLKB_XD5_XDFFQ_CKBB XD1_XDFFQ_CLKB XD5_XDFFQ_CKBB 1.8151e-17
* device instance cc_XD1_XDFFQ_CLKB_XD5_XDFFQ_CLKB r0 *1 0,0
Ccc_XD1_XDFFQ_CLKB_XD5_XDFFQ_CLKB XD1_XDFFQ_CLKB XD5_XDFFQ_CLKB 2.4201e-17
* device instance cc_XD1_XDFFQ_CLKB_XD5_XDFFQ_M r0 *1 0,0
Ccc_XD1_XDFFQ_CLKB_XD5_XDFFQ_M XD1_XDFFQ_CLKB XD5_XDFFQ_M 2.4201e-17
* device instance cc_XD1_XDFFQ_CLKB_XD5_XDFFQ_MB r0 *1 0,0
Ccc_XD1_XDFFQ_CLKB_XD5_XDFFQ_MB XD1_XDFFQ_CLKB XD5_XDFFQ_MB 1.21e-17
* device instance cc_XD1_XDFFQ_CLKB_XD5_XDFFQ_MFB r0 *1 0,0
Ccc_XD1_XDFFQ_CLKB_XD5_XDFFQ_MFB XD1_XDFFQ_CLKB XD5_XDFFQ_MFB 1.21e-17
* device instance cc_XD1_XDFFQ_CLKB_XD5_XDFFQ_S r0 *1 0,0
Ccc_XD1_XDFFQ_CLKB_XD5_XDFFQ_S XD1_XDFFQ_CLKB XD5_XDFFQ_S 1.8151e-17
* device instance cc_XD1_XDFFQ_CLKB_XD5_XDFFQ_SB r0 *1 0,0
Ccc_XD1_XDFFQ_CLKB_XD5_XDFFQ_SB XD1_XDFFQ_CLKB XD5_XDFFQ_SB 1.8151e-17
* device instance cc_XD1_XDFFQ_CLKB_XD5_XDFFQ_SFB r0 *1 0,0
Ccc_XD1_XDFFQ_CLKB_XD5_XDFFQ_SFB XD1_XDFFQ_CLKB XD5_XDFFQ_SFB 1.21e-17
* device instance cc_XD1_XDFFQ_CLKB_XD5_XN2_mid1 r0 *1 0,0
Ccc_XD1_XDFFQ_CLKB_XD5_XN2_mid1 XD1_XDFFQ_CLKB XD5_XN2_mid1 1.21e-17
* device instance cc_XD1_XDFFQ_CLKB_XD5_XN3_mid1 r0 *1 0,0
Ccc_XD1_XDFFQ_CLKB_XD5_XN3_mid1 XD1_XDFFQ_CLKB XD5_XN3_mid1 1.21e-17
* device instance cc_XD1_XDFFQ_CLKB_XD5_XN3_mid2 r0 *1 0,0
Ccc_XD1_XDFFQ_CLKB_XD5_XN3_mid2 XD1_XDFFQ_CLKB XD5_XN3_mid2 1.21e-17
* device instance cc_XD1_XDFFQ_CLKB_XD5_dmodout r0 *1 0,0
Ccc_XD1_XDFFQ_CLKB_XD5_dmodout XD1_XDFFQ_CLKB XD5_dmodout 1.21e-17
* device instance cc_XD1_XDFFQ_CLKB_XD5_dq r0 *1 0,0
Ccc_XD1_XDFFQ_CLKB_XD5_dq XD1_XDFFQ_CLKB XD5_dq 1.8151e-17
* device instance cc_XD1_XDFFQ_CLKB_XD5_nm r0 *1 0,0
Ccc_XD1_XDFFQ_CLKB_XD5_nm XD1_XDFFQ_CLKB XD5_nm 1.21e-17
* device instance cc_XD1_XDFFQ_CLKB_XD5_nt r0 *1 0,0
Ccc_XD1_XDFFQ_CLKB_XD5_nt XD1_XDFFQ_CLKB XD5_nt 1.21e-17
* device instance cc_XD1_XDFFQ_CLKB_XD5_t1 r0 *1 0,0
Ccc_XD1_XDFFQ_CLKB_XD5_t1 XD1_XDFFQ_CLKB XD5_t1 1.21e-17
* device instance cc_XD1_XDFFQ_CLKB_XFRT_CKBB r0 *1 0,0
Ccc_XD1_XDFFQ_CLKB_XFRT_CKBB XD1_XDFFQ_CLKB XFRT_CKBB 1.8151e-17
* device instance cc_XD1_XDFFQ_CLKB_XFRT_CLKB r0 *1 0,0
Ccc_XD1_XDFFQ_CLKB_XFRT_CLKB XD1_XDFFQ_CLKB XFRT_CLKB 2.4201e-17
* device instance cc_XD1_XDFFQ_CLKB_XFRT_M r0 *1 0,0
Ccc_XD1_XDFFQ_CLKB_XFRT_M XD1_XDFFQ_CLKB XFRT_M 2.4201e-17
* device instance cc_XD1_XDFFQ_CLKB_XFRT_MB r0 *1 0,0
Ccc_XD1_XDFFQ_CLKB_XFRT_MB XD1_XDFFQ_CLKB XFRT_MB 1.21e-17
* device instance cc_XD1_XDFFQ_CLKB_XFRT_MFB r0 *1 0,0
Ccc_XD1_XDFFQ_CLKB_XFRT_MFB XD1_XDFFQ_CLKB XFRT_MFB 1.21e-17
* device instance cc_XD1_XDFFQ_CLKB_XFRT_S r0 *1 0,0
Ccc_XD1_XDFFQ_CLKB_XFRT_S XD1_XDFFQ_CLKB XFRT_S 1.8151e-17
* device instance cc_XD1_XDFFQ_CLKB_XFRT_SB r0 *1 0,0
Ccc_XD1_XDFFQ_CLKB_XFRT_SB XD1_XDFFQ_CLKB XFRT_SB 1.8151e-17
* device instance cc_XD1_XDFFQ_CLKB_XFRT_SFB r0 *1 0,0
Ccc_XD1_XDFFQ_CLKB_XFRT_SFB XD1_XDFFQ_CLKB XFRT_SFB 1.21e-17
* device instance cc_XD1_XDFFQ_CLKB_ck1 r0 *1 0,0
Ccc_XD1_XDFFQ_CLKB_ck1 XD1_XDFFQ_CLKB ck1 3.0251e-17
* device instance cc_XD1_XDFFQ_CLKB_ck2 r0 *1 0,0
Ccc_XD1_XDFFQ_CLKB_ck2 XD1_XDFFQ_CLKB ck2 3.0251e-17
* device instance cc_XD1_XDFFQ_CLKB_ck3 r0 *1 0,0
Ccc_XD1_XDFFQ_CLKB_ck3 XD1_XDFFQ_CLKB ck3 3.0251e-17
* device instance cc_XD1_XDFFQ_CLKB_ck4 r0 *1 0,0
Ccc_XD1_XDFFQ_CLKB_ck4 XD1_XDFFQ_CLKB ck4 3.0251e-17
* device instance cc_XD1_XDFFQ_CLKB_ck5 r0 *1 0,0
Ccc_XD1_XDFFQ_CLKB_ck5 XD1_XDFFQ_CLKB ck5 3.0251e-17
* device instance cc_XD1_XDFFQ_CLKB_mod0 r0 *1 0,0
Ccc_XD1_XDFFQ_CLKB_mod0 XD1_XDFFQ_CLKB mod0 2.4201e-17
* device instance cc_XD1_XDFFQ_CLKB_mod1 r0 *1 0,0
Ccc_XD1_XDFFQ_CLKB_mod1 XD1_XDFFQ_CLKB mod1 2.4201e-17
* device instance cc_XD1_XDFFQ_CLKB_mod2 r0 *1 0,0
Ccc_XD1_XDFFQ_CLKB_mod2 XD1_XDFFQ_CLKB mod2 2.4201e-17
* device instance cc_XD1_XDFFQ_CLKB_mod3 r0 *1 0,0
Ccc_XD1_XDFFQ_CLKB_mod3 XD1_XDFFQ_CLKB mod3 2.4201e-17
* device instance cc_XD1_XDFFQ_CLKB_mod4 r0 *1 0,0
Ccc_XD1_XDFFQ_CLKB_mod4 XD1_XDFFQ_CLKB mod4 2.4201e-17
* device instance cc_XD1_XDFFQ_CLKB_net1 r0 *1 0,0
Ccc_XD1_XDFFQ_CLKB_net1 XD1_XDFFQ_CLKB net1 1.21e-17
* device instance cc_XD1_XDFFQ_M_XD1_XDFFQ_MB r0 *1 0,0
Ccc_XD1_XDFFQ_M_XD1_XDFFQ_MB XD1_XDFFQ_M XD1_XDFFQ_MB 2.4201e-17
* device instance cc_XD1_XDFFQ_M_XD1_XDFFQ_MFB r0 *1 0,0
Ccc_XD1_XDFFQ_M_XD1_XDFFQ_MFB XD1_XDFFQ_M XD1_XDFFQ_MFB 3.4688e-17
* device instance cc_XD1_XDFFQ_M_XD1_XDFFQ_S r0 *1 0,0
Ccc_XD1_XDFFQ_M_XD1_XDFFQ_S XD1_XDFFQ_M XD1_XDFFQ_S 2.8638e-17
* device instance cc_XD1_XDFFQ_M_XD1_XDFFQ_SB r0 *1 0,0
Ccc_XD1_XDFFQ_M_XD1_XDFFQ_SB XD1_XDFFQ_M XD1_XDFFQ_SB 1.8151e-17
* device instance cc_XD1_XDFFQ_M_XD1_XDFFQ_SFB r0 *1 0,0
Ccc_XD1_XDFFQ_M_XD1_XDFFQ_SFB XD1_XDFFQ_M XD1_XDFFQ_SFB 1.21e-17
* device instance cc_XD1_XDFFQ_M_XD1_XN2_mid1 r0 *1 0,0
Ccc_XD1_XDFFQ_M_XD1_XN2_mid1 XD1_XDFFQ_M XD1_XN2_mid1 1.21e-17
* device instance cc_XD1_XDFFQ_M_XD1_XNOR_midp r0 *1 0,0
Ccc_XD1_XDFFQ_M_XD1_XNOR_midp XD1_XDFFQ_M XD1_XNOR_midp 1.21e-17
* device instance cc_XD1_XDFFQ_M_XD1_dmodout r0 *1 0,0
Ccc_XD1_XDFFQ_M_XD1_dmodout XD1_XDFFQ_M XD1_dmodout 1.21e-17
* device instance cc_XD1_XDFFQ_M_XD1_dq r0 *1 0,0
Ccc_XD1_XDFFQ_M_XD1_dq XD1_XDFFQ_M XD1_dq 2.8638e-17
* device instance cc_XD1_XDFFQ_M_XD1_nm r0 *1 0,0
Ccc_XD1_XDFFQ_M_XD1_nm XD1_XDFFQ_M XD1_nm 1.21e-17
* device instance cc_XD1_XDFFQ_M_XD1_nt r0 *1 0,0
Ccc_XD1_XDFFQ_M_XD1_nt XD1_XDFFQ_M XD1_nt 2.4201e-17
* device instance cc_XD1_XDFFQ_M_XD1_t1 r0 *1 0,0
Ccc_XD1_XDFFQ_M_XD1_t1 XD1_XDFFQ_M XD1_t1 1.21e-17
* device instance cc_XD1_XDFFQ_M_XD2_XDFFM_CKBB r0 *1 0,0
Ccc_XD1_XDFFQ_M_XD2_XDFFM_CKBB XD1_XDFFQ_M XD2_XDFFM_CKBB 1.8151e-17
* device instance cc_XD1_XDFFQ_M_XD2_XDFFM_CLKB r0 *1 0,0
Ccc_XD1_XDFFQ_M_XD2_XDFFM_CLKB XD1_XDFFQ_M XD2_XDFFM_CLKB 2.4201e-17
* device instance cc_XD1_XDFFQ_M_XD2_XDFFM_M r0 *1 0,0
Ccc_XD1_XDFFQ_M_XD2_XDFFM_M XD1_XDFFQ_M XD2_XDFFM_M 2.4201e-17
* device instance cc_XD1_XDFFQ_M_XD2_XDFFM_MB r0 *1 0,0
Ccc_XD1_XDFFQ_M_XD2_XDFFM_MB XD1_XDFFQ_M XD2_XDFFM_MB 1.21e-17
* device instance cc_XD1_XDFFQ_M_XD2_XDFFM_MFB r0 *1 0,0
Ccc_XD1_XDFFQ_M_XD2_XDFFM_MFB XD1_XDFFQ_M XD2_XDFFM_MFB 1.21e-17
* device instance cc_XD1_XDFFQ_M_XD2_XDFFM_S r0 *1 0,0
Ccc_XD1_XDFFQ_M_XD2_XDFFM_S XD1_XDFFQ_M XD2_XDFFM_S 1.8151e-17
* device instance cc_XD1_XDFFQ_M_XD2_XDFFM_SB r0 *1 0,0
Ccc_XD1_XDFFQ_M_XD2_XDFFM_SB XD1_XDFFQ_M XD2_XDFFM_SB 1.8151e-17
* device instance cc_XD1_XDFFQ_M_XD2_XDFFM_SFB r0 *1 0,0
Ccc_XD1_XDFFQ_M_XD2_XDFFM_SFB XD1_XDFFQ_M XD2_XDFFM_SFB 1.21e-17
* device instance cc_XD1_XDFFQ_M_XD2_XDFFQ_CKBB r0 *1 0,0
Ccc_XD1_XDFFQ_M_XD2_XDFFQ_CKBB XD1_XDFFQ_M XD2_XDFFQ_CKBB 1.8151e-17
* device instance cc_XD1_XDFFQ_M_XD2_XDFFQ_CLKB r0 *1 0,0
Ccc_XD1_XDFFQ_M_XD2_XDFFQ_CLKB XD1_XDFFQ_M XD2_XDFFQ_CLKB 2.4201e-17
* device instance cc_XD1_XDFFQ_M_XD2_XDFFQ_M r0 *1 0,0
Ccc_XD1_XDFFQ_M_XD2_XDFFQ_M XD1_XDFFQ_M XD2_XDFFQ_M 2.4201e-17
* device instance cc_XD1_XDFFQ_M_XD2_XDFFQ_MB r0 *1 0,0
Ccc_XD1_XDFFQ_M_XD2_XDFFQ_MB XD1_XDFFQ_M XD2_XDFFQ_MB 1.21e-17
* device instance cc_XD1_XDFFQ_M_XD2_XDFFQ_MFB r0 *1 0,0
Ccc_XD1_XDFFQ_M_XD2_XDFFQ_MFB XD1_XDFFQ_M XD2_XDFFQ_MFB 1.21e-17
* device instance cc_XD1_XDFFQ_M_XD2_XDFFQ_S r0 *1 0,0
Ccc_XD1_XDFFQ_M_XD2_XDFFQ_S XD1_XDFFQ_M XD2_XDFFQ_S 1.8151e-17
* device instance cc_XD1_XDFFQ_M_XD2_XDFFQ_SB r0 *1 0,0
Ccc_XD1_XDFFQ_M_XD2_XDFFQ_SB XD1_XDFFQ_M XD2_XDFFQ_SB 1.8151e-17
* device instance cc_XD1_XDFFQ_M_XD2_XDFFQ_SFB r0 *1 0,0
Ccc_XD1_XDFFQ_M_XD2_XDFFQ_SFB XD1_XDFFQ_M XD2_XDFFQ_SFB 1.21e-17
* device instance cc_XD1_XDFFQ_M_XD2_XN2_mid1 r0 *1 0,0
Ccc_XD1_XDFFQ_M_XD2_XN2_mid1 XD1_XDFFQ_M XD2_XN2_mid1 1.21e-17
* device instance cc_XD1_XDFFQ_M_XD2_XN3_mid1 r0 *1 0,0
Ccc_XD1_XDFFQ_M_XD2_XN3_mid1 XD1_XDFFQ_M XD2_XN3_mid1 1.21e-17
* device instance cc_XD1_XDFFQ_M_XD2_XN3_mid2 r0 *1 0,0
Ccc_XD1_XDFFQ_M_XD2_XN3_mid2 XD1_XDFFQ_M XD2_XN3_mid2 1.21e-17
* device instance cc_XD1_XDFFQ_M_XD2_dmodout r0 *1 0,0
Ccc_XD1_XDFFQ_M_XD2_dmodout XD1_XDFFQ_M XD2_dmodout 1.21e-17
* device instance cc_XD1_XDFFQ_M_XD2_dq r0 *1 0,0
Ccc_XD1_XDFFQ_M_XD2_dq XD1_XDFFQ_M XD2_dq 1.8151e-17
* device instance cc_XD1_XDFFQ_M_XD2_nm r0 *1 0,0
Ccc_XD1_XDFFQ_M_XD2_nm XD1_XDFFQ_M XD2_nm 1.21e-17
* device instance cc_XD1_XDFFQ_M_XD2_nt r0 *1 0,0
Ccc_XD1_XDFFQ_M_XD2_nt XD1_XDFFQ_M XD2_nt 1.21e-17
* device instance cc_XD1_XDFFQ_M_XD2_t1 r0 *1 0,0
Ccc_XD1_XDFFQ_M_XD2_t1 XD1_XDFFQ_M XD2_t1 1.21e-17
* device instance cc_XD1_XDFFQ_M_XD3_XDFFM_CKBB r0 *1 0,0
Ccc_XD1_XDFFQ_M_XD3_XDFFM_CKBB XD1_XDFFQ_M XD3_XDFFM_CKBB 1.8151e-17
* device instance cc_XD1_XDFFQ_M_XD3_XDFFM_CLKB r0 *1 0,0
Ccc_XD1_XDFFQ_M_XD3_XDFFM_CLKB XD1_XDFFQ_M XD3_XDFFM_CLKB 2.4201e-17
* device instance cc_XD1_XDFFQ_M_XD3_XDFFM_M r0 *1 0,0
Ccc_XD1_XDFFQ_M_XD3_XDFFM_M XD1_XDFFQ_M XD3_XDFFM_M 2.4201e-17
* device instance cc_XD1_XDFFQ_M_XD3_XDFFM_MB r0 *1 0,0
Ccc_XD1_XDFFQ_M_XD3_XDFFM_MB XD1_XDFFQ_M XD3_XDFFM_MB 1.21e-17
* device instance cc_XD1_XDFFQ_M_XD3_XDFFM_MFB r0 *1 0,0
Ccc_XD1_XDFFQ_M_XD3_XDFFM_MFB XD1_XDFFQ_M XD3_XDFFM_MFB 1.21e-17
* device instance cc_XD1_XDFFQ_M_XD3_XDFFM_S r0 *1 0,0
Ccc_XD1_XDFFQ_M_XD3_XDFFM_S XD1_XDFFQ_M XD3_XDFFM_S 1.8151e-17
* device instance cc_XD1_XDFFQ_M_XD3_XDFFM_SB r0 *1 0,0
Ccc_XD1_XDFFQ_M_XD3_XDFFM_SB XD1_XDFFQ_M XD3_XDFFM_SB 1.8151e-17
* device instance cc_XD1_XDFFQ_M_XD3_XDFFM_SFB r0 *1 0,0
Ccc_XD1_XDFFQ_M_XD3_XDFFM_SFB XD1_XDFFQ_M XD3_XDFFM_SFB 1.21e-17
* device instance cc_XD1_XDFFQ_M_XD3_XDFFQ_CKBB r0 *1 0,0
Ccc_XD1_XDFFQ_M_XD3_XDFFQ_CKBB XD1_XDFFQ_M XD3_XDFFQ_CKBB 1.8151e-17
* device instance cc_XD1_XDFFQ_M_XD3_XDFFQ_CLKB r0 *1 0,0
Ccc_XD1_XDFFQ_M_XD3_XDFFQ_CLKB XD1_XDFFQ_M XD3_XDFFQ_CLKB 2.4201e-17
* device instance cc_XD1_XDFFQ_M_XD3_XDFFQ_M r0 *1 0,0
Ccc_XD1_XDFFQ_M_XD3_XDFFQ_M XD1_XDFFQ_M XD3_XDFFQ_M 2.4201e-17
* device instance cc_XD1_XDFFQ_M_XD3_XDFFQ_MB r0 *1 0,0
Ccc_XD1_XDFFQ_M_XD3_XDFFQ_MB XD1_XDFFQ_M XD3_XDFFQ_MB 1.21e-17
* device instance cc_XD1_XDFFQ_M_XD3_XDFFQ_MFB r0 *1 0,0
Ccc_XD1_XDFFQ_M_XD3_XDFFQ_MFB XD1_XDFFQ_M XD3_XDFFQ_MFB 1.21e-17
* device instance cc_XD1_XDFFQ_M_XD3_XDFFQ_S r0 *1 0,0
Ccc_XD1_XDFFQ_M_XD3_XDFFQ_S XD1_XDFFQ_M XD3_XDFFQ_S 1.8151e-17
* device instance cc_XD1_XDFFQ_M_XD3_XDFFQ_SB r0 *1 0,0
Ccc_XD1_XDFFQ_M_XD3_XDFFQ_SB XD1_XDFFQ_M XD3_XDFFQ_SB 1.8151e-17
* device instance cc_XD1_XDFFQ_M_XD3_XDFFQ_SFB r0 *1 0,0
Ccc_XD1_XDFFQ_M_XD3_XDFFQ_SFB XD1_XDFFQ_M XD3_XDFFQ_SFB 1.21e-17
* device instance cc_XD1_XDFFQ_M_XD3_XN2_mid1 r0 *1 0,0
Ccc_XD1_XDFFQ_M_XD3_XN2_mid1 XD1_XDFFQ_M XD3_XN2_mid1 1.21e-17
* device instance cc_XD1_XDFFQ_M_XD3_XN3_mid1 r0 *1 0,0
Ccc_XD1_XDFFQ_M_XD3_XN3_mid1 XD1_XDFFQ_M XD3_XN3_mid1 1.21e-17
* device instance cc_XD1_XDFFQ_M_XD3_XN3_mid2 r0 *1 0,0
Ccc_XD1_XDFFQ_M_XD3_XN3_mid2 XD1_XDFFQ_M XD3_XN3_mid2 1.21e-17
* device instance cc_XD1_XDFFQ_M_XD3_dmodout r0 *1 0,0
Ccc_XD1_XDFFQ_M_XD3_dmodout XD1_XDFFQ_M XD3_dmodout 1.21e-17
* device instance cc_XD1_XDFFQ_M_XD3_dq r0 *1 0,0
Ccc_XD1_XDFFQ_M_XD3_dq XD1_XDFFQ_M XD3_dq 1.8151e-17
* device instance cc_XD1_XDFFQ_M_XD3_nm r0 *1 0,0
Ccc_XD1_XDFFQ_M_XD3_nm XD1_XDFFQ_M XD3_nm 1.21e-17
* device instance cc_XD1_XDFFQ_M_XD3_nt r0 *1 0,0
Ccc_XD1_XDFFQ_M_XD3_nt XD1_XDFFQ_M XD3_nt 1.21e-17
* device instance cc_XD1_XDFFQ_M_XD3_t1 r0 *1 0,0
Ccc_XD1_XDFFQ_M_XD3_t1 XD1_XDFFQ_M XD3_t1 1.21e-17
* device instance cc_XD1_XDFFQ_M_XD4_XDFFM_CKBB r0 *1 0,0
Ccc_XD1_XDFFQ_M_XD4_XDFFM_CKBB XD1_XDFFQ_M XD4_XDFFM_CKBB 1.8151e-17
* device instance cc_XD1_XDFFQ_M_XD4_XDFFM_CLKB r0 *1 0,0
Ccc_XD1_XDFFQ_M_XD4_XDFFM_CLKB XD1_XDFFQ_M XD4_XDFFM_CLKB 2.4201e-17
* device instance cc_XD1_XDFFQ_M_XD4_XDFFM_M r0 *1 0,0
Ccc_XD1_XDFFQ_M_XD4_XDFFM_M XD1_XDFFQ_M XD4_XDFFM_M 2.4201e-17
* device instance cc_XD1_XDFFQ_M_XD4_XDFFM_MB r0 *1 0,0
Ccc_XD1_XDFFQ_M_XD4_XDFFM_MB XD1_XDFFQ_M XD4_XDFFM_MB 1.21e-17
* device instance cc_XD1_XDFFQ_M_XD4_XDFFM_MFB r0 *1 0,0
Ccc_XD1_XDFFQ_M_XD4_XDFFM_MFB XD1_XDFFQ_M XD4_XDFFM_MFB 1.21e-17
* device instance cc_XD1_XDFFQ_M_XD4_XDFFM_S r0 *1 0,0
Ccc_XD1_XDFFQ_M_XD4_XDFFM_S XD1_XDFFQ_M XD4_XDFFM_S 1.8151e-17
* device instance cc_XD1_XDFFQ_M_XD4_XDFFM_SB r0 *1 0,0
Ccc_XD1_XDFFQ_M_XD4_XDFFM_SB XD1_XDFFQ_M XD4_XDFFM_SB 1.8151e-17
* device instance cc_XD1_XDFFQ_M_XD4_XDFFM_SFB r0 *1 0,0
Ccc_XD1_XDFFQ_M_XD4_XDFFM_SFB XD1_XDFFQ_M XD4_XDFFM_SFB 1.21e-17
* device instance cc_XD1_XDFFQ_M_XD4_XDFFQ_CKBB r0 *1 0,0
Ccc_XD1_XDFFQ_M_XD4_XDFFQ_CKBB XD1_XDFFQ_M XD4_XDFFQ_CKBB 1.8151e-17
* device instance cc_XD1_XDFFQ_M_XD4_XDFFQ_CLKB r0 *1 0,0
Ccc_XD1_XDFFQ_M_XD4_XDFFQ_CLKB XD1_XDFFQ_M XD4_XDFFQ_CLKB 2.4201e-17
* device instance cc_XD1_XDFFQ_M_XD4_XDFFQ_M r0 *1 0,0
Ccc_XD1_XDFFQ_M_XD4_XDFFQ_M XD1_XDFFQ_M XD4_XDFFQ_M 2.4201e-17
* device instance cc_XD1_XDFFQ_M_XD4_XDFFQ_MB r0 *1 0,0
Ccc_XD1_XDFFQ_M_XD4_XDFFQ_MB XD1_XDFFQ_M XD4_XDFFQ_MB 1.21e-17
* device instance cc_XD1_XDFFQ_M_XD4_XDFFQ_MFB r0 *1 0,0
Ccc_XD1_XDFFQ_M_XD4_XDFFQ_MFB XD1_XDFFQ_M XD4_XDFFQ_MFB 1.21e-17
* device instance cc_XD1_XDFFQ_M_XD4_XDFFQ_S r0 *1 0,0
Ccc_XD1_XDFFQ_M_XD4_XDFFQ_S XD1_XDFFQ_M XD4_XDFFQ_S 1.8151e-17
* device instance cc_XD1_XDFFQ_M_XD4_XDFFQ_SB r0 *1 0,0
Ccc_XD1_XDFFQ_M_XD4_XDFFQ_SB XD1_XDFFQ_M XD4_XDFFQ_SB 1.8151e-17
* device instance cc_XD1_XDFFQ_M_XD4_XDFFQ_SFB r0 *1 0,0
Ccc_XD1_XDFFQ_M_XD4_XDFFQ_SFB XD1_XDFFQ_M XD4_XDFFQ_SFB 1.21e-17
* device instance cc_XD1_XDFFQ_M_XD4_XN2_mid1 r0 *1 0,0
Ccc_XD1_XDFFQ_M_XD4_XN2_mid1 XD1_XDFFQ_M XD4_XN2_mid1 1.21e-17
* device instance cc_XD1_XDFFQ_M_XD4_XN3_mid1 r0 *1 0,0
Ccc_XD1_XDFFQ_M_XD4_XN3_mid1 XD1_XDFFQ_M XD4_XN3_mid1 1.21e-17
* device instance cc_XD1_XDFFQ_M_XD4_XN3_mid2 r0 *1 0,0
Ccc_XD1_XDFFQ_M_XD4_XN3_mid2 XD1_XDFFQ_M XD4_XN3_mid2 1.21e-17
* device instance cc_XD1_XDFFQ_M_XD4_dmodout r0 *1 0,0
Ccc_XD1_XDFFQ_M_XD4_dmodout XD1_XDFFQ_M XD4_dmodout 1.21e-17
* device instance cc_XD1_XDFFQ_M_XD4_dq r0 *1 0,0
Ccc_XD1_XDFFQ_M_XD4_dq XD1_XDFFQ_M XD4_dq 1.8151e-17
* device instance cc_XD1_XDFFQ_M_XD4_nm r0 *1 0,0
Ccc_XD1_XDFFQ_M_XD4_nm XD1_XDFFQ_M XD4_nm 1.21e-17
* device instance cc_XD1_XDFFQ_M_XD4_nt r0 *1 0,0
Ccc_XD1_XDFFQ_M_XD4_nt XD1_XDFFQ_M XD4_nt 1.21e-17
* device instance cc_XD1_XDFFQ_M_XD4_t1 r0 *1 0,0
Ccc_XD1_XDFFQ_M_XD4_t1 XD1_XDFFQ_M XD4_t1 1.21e-17
* device instance cc_XD1_XDFFQ_M_XD5_XDFFM_CKBB r0 *1 0,0
Ccc_XD1_XDFFQ_M_XD5_XDFFM_CKBB XD1_XDFFQ_M XD5_XDFFM_CKBB 1.8151e-17
* device instance cc_XD1_XDFFQ_M_XD5_XDFFM_CLKB r0 *1 0,0
Ccc_XD1_XDFFQ_M_XD5_XDFFM_CLKB XD1_XDFFQ_M XD5_XDFFM_CLKB 2.4201e-17
* device instance cc_XD1_XDFFQ_M_XD5_XDFFM_M r0 *1 0,0
Ccc_XD1_XDFFQ_M_XD5_XDFFM_M XD1_XDFFQ_M XD5_XDFFM_M 2.4201e-17
* device instance cc_XD1_XDFFQ_M_XD5_XDFFM_MB r0 *1 0,0
Ccc_XD1_XDFFQ_M_XD5_XDFFM_MB XD1_XDFFQ_M XD5_XDFFM_MB 1.21e-17
* device instance cc_XD1_XDFFQ_M_XD5_XDFFM_MFB r0 *1 0,0
Ccc_XD1_XDFFQ_M_XD5_XDFFM_MFB XD1_XDFFQ_M XD5_XDFFM_MFB 1.21e-17
* device instance cc_XD1_XDFFQ_M_XD5_XDFFM_S r0 *1 0,0
Ccc_XD1_XDFFQ_M_XD5_XDFFM_S XD1_XDFFQ_M XD5_XDFFM_S 1.8151e-17
* device instance cc_XD1_XDFFQ_M_XD5_XDFFM_SB r0 *1 0,0
Ccc_XD1_XDFFQ_M_XD5_XDFFM_SB XD1_XDFFQ_M XD5_XDFFM_SB 1.8151e-17
* device instance cc_XD1_XDFFQ_M_XD5_XDFFM_SFB r0 *1 0,0
Ccc_XD1_XDFFQ_M_XD5_XDFFM_SFB XD1_XDFFQ_M XD5_XDFFM_SFB 1.21e-17
* device instance cc_XD1_XDFFQ_M_XD5_XDFFQ_CKBB r0 *1 0,0
Ccc_XD1_XDFFQ_M_XD5_XDFFQ_CKBB XD1_XDFFQ_M XD5_XDFFQ_CKBB 1.8151e-17
* device instance cc_XD1_XDFFQ_M_XD5_XDFFQ_CLKB r0 *1 0,0
Ccc_XD1_XDFFQ_M_XD5_XDFFQ_CLKB XD1_XDFFQ_M XD5_XDFFQ_CLKB 2.4201e-17
* device instance cc_XD1_XDFFQ_M_XD5_XDFFQ_M r0 *1 0,0
Ccc_XD1_XDFFQ_M_XD5_XDFFQ_M XD1_XDFFQ_M XD5_XDFFQ_M 2.4201e-17
* device instance cc_XD1_XDFFQ_M_XD5_XDFFQ_MB r0 *1 0,0
Ccc_XD1_XDFFQ_M_XD5_XDFFQ_MB XD1_XDFFQ_M XD5_XDFFQ_MB 1.21e-17
* device instance cc_XD1_XDFFQ_M_XD5_XDFFQ_MFB r0 *1 0,0
Ccc_XD1_XDFFQ_M_XD5_XDFFQ_MFB XD1_XDFFQ_M XD5_XDFFQ_MFB 1.21e-17
* device instance cc_XD1_XDFFQ_M_XD5_XDFFQ_S r0 *1 0,0
Ccc_XD1_XDFFQ_M_XD5_XDFFQ_S XD1_XDFFQ_M XD5_XDFFQ_S 1.8151e-17
* device instance cc_XD1_XDFFQ_M_XD5_XDFFQ_SB r0 *1 0,0
Ccc_XD1_XDFFQ_M_XD5_XDFFQ_SB XD1_XDFFQ_M XD5_XDFFQ_SB 1.8151e-17
* device instance cc_XD1_XDFFQ_M_XD5_XDFFQ_SFB r0 *1 0,0
Ccc_XD1_XDFFQ_M_XD5_XDFFQ_SFB XD1_XDFFQ_M XD5_XDFFQ_SFB 1.21e-17
* device instance cc_XD1_XDFFQ_M_XD5_XN2_mid1 r0 *1 0,0
Ccc_XD1_XDFFQ_M_XD5_XN2_mid1 XD1_XDFFQ_M XD5_XN2_mid1 1.21e-17
* device instance cc_XD1_XDFFQ_M_XD5_XN3_mid1 r0 *1 0,0
Ccc_XD1_XDFFQ_M_XD5_XN3_mid1 XD1_XDFFQ_M XD5_XN3_mid1 1.21e-17
* device instance cc_XD1_XDFFQ_M_XD5_XN3_mid2 r0 *1 0,0
Ccc_XD1_XDFFQ_M_XD5_XN3_mid2 XD1_XDFFQ_M XD5_XN3_mid2 1.21e-17
* device instance cc_XD1_XDFFQ_M_XD5_dmodout r0 *1 0,0
Ccc_XD1_XDFFQ_M_XD5_dmodout XD1_XDFFQ_M XD5_dmodout 1.21e-17
* device instance cc_XD1_XDFFQ_M_XD5_dq r0 *1 0,0
Ccc_XD1_XDFFQ_M_XD5_dq XD1_XDFFQ_M XD5_dq 1.8151e-17
* device instance cc_XD1_XDFFQ_M_XD5_nm r0 *1 0,0
Ccc_XD1_XDFFQ_M_XD5_nm XD1_XDFFQ_M XD5_nm 1.21e-17
* device instance cc_XD1_XDFFQ_M_XD5_nt r0 *1 0,0
Ccc_XD1_XDFFQ_M_XD5_nt XD1_XDFFQ_M XD5_nt 1.21e-17
* device instance cc_XD1_XDFFQ_M_XD5_t1 r0 *1 0,0
Ccc_XD1_XDFFQ_M_XD5_t1 XD1_XDFFQ_M XD5_t1 1.21e-17
* device instance cc_XD1_XDFFQ_M_XFRT_CKBB r0 *1 0,0
Ccc_XD1_XDFFQ_M_XFRT_CKBB XD1_XDFFQ_M XFRT_CKBB 1.8151e-17
* device instance cc_XD1_XDFFQ_M_XFRT_CLKB r0 *1 0,0
Ccc_XD1_XDFFQ_M_XFRT_CLKB XD1_XDFFQ_M XFRT_CLKB 2.4201e-17
* device instance cc_XD1_XDFFQ_M_XFRT_M r0 *1 0,0
Ccc_XD1_XDFFQ_M_XFRT_M XD1_XDFFQ_M XFRT_M 2.4201e-17
* device instance cc_XD1_XDFFQ_M_XFRT_MB r0 *1 0,0
Ccc_XD1_XDFFQ_M_XFRT_MB XD1_XDFFQ_M XFRT_MB 1.21e-17
* device instance cc_XD1_XDFFQ_M_XFRT_MFB r0 *1 0,0
Ccc_XD1_XDFFQ_M_XFRT_MFB XD1_XDFFQ_M XFRT_MFB 1.21e-17
* device instance cc_XD1_XDFFQ_M_XFRT_S r0 *1 0,0
Ccc_XD1_XDFFQ_M_XFRT_S XD1_XDFFQ_M XFRT_S 1.8151e-17
* device instance cc_XD1_XDFFQ_M_XFRT_SB r0 *1 0,0
Ccc_XD1_XDFFQ_M_XFRT_SB XD1_XDFFQ_M XFRT_SB 1.8151e-17
* device instance cc_XD1_XDFFQ_M_XFRT_SFB r0 *1 0,0
Ccc_XD1_XDFFQ_M_XFRT_SFB XD1_XDFFQ_M XFRT_SFB 1.21e-17
* device instance cc_XD1_XDFFQ_M_ck1 r0 *1 0,0
Ccc_XD1_XDFFQ_M_ck1 XD1_XDFFQ_M ck1 3.0251e-17
* device instance cc_XD1_XDFFQ_M_ck2 r0 *1 0,0
Ccc_XD1_XDFFQ_M_ck2 XD1_XDFFQ_M ck2 3.0251e-17
* device instance cc_XD1_XDFFQ_M_ck3 r0 *1 0,0
Ccc_XD1_XDFFQ_M_ck3 XD1_XDFFQ_M ck3 3.0251e-17
* device instance cc_XD1_XDFFQ_M_ck4 r0 *1 0,0
Ccc_XD1_XDFFQ_M_ck4 XD1_XDFFQ_M ck4 3.0251e-17
* device instance cc_XD1_XDFFQ_M_ck5 r0 *1 0,0
Ccc_XD1_XDFFQ_M_ck5 XD1_XDFFQ_M ck5 3.0251e-17
* device instance cc_XD1_XDFFQ_M_mod0 r0 *1 0,0
Ccc_XD1_XDFFQ_M_mod0 XD1_XDFFQ_M mod0 2.4201e-17
* device instance cc_XD1_XDFFQ_M_mod1 r0 *1 0,0
Ccc_XD1_XDFFQ_M_mod1 XD1_XDFFQ_M mod1 2.4201e-17
* device instance cc_XD1_XDFFQ_M_mod2 r0 *1 0,0
Ccc_XD1_XDFFQ_M_mod2 XD1_XDFFQ_M mod2 2.4201e-17
* device instance cc_XD1_XDFFQ_M_mod3 r0 *1 0,0
Ccc_XD1_XDFFQ_M_mod3 XD1_XDFFQ_M mod3 2.4201e-17
* device instance cc_XD1_XDFFQ_M_mod4 r0 *1 0,0
Ccc_XD1_XDFFQ_M_mod4 XD1_XDFFQ_M mod4 2.4201e-17
* device instance cc_XD1_XDFFQ_M_net1 r0 *1 0,0
Ccc_XD1_XDFFQ_M_net1 XD1_XDFFQ_M net1 1.21e-17
* device instance cc_XD1_XDFFQ_MB_XD1_XDFFQ_MFB r0 *1 0,0
Ccc_XD1_XDFFQ_MB_XD1_XDFFQ_MFB XD1_XDFFQ_MB XD1_XDFFQ_MFB 1.21e-17
* device instance cc_XD1_XDFFQ_MB_XD1_XDFFQ_S r0 *1 0,0
Ccc_XD1_XDFFQ_MB_XD1_XDFFQ_S XD1_XDFFQ_MB XD1_XDFFQ_S 1.8151e-17
* device instance cc_XD1_XDFFQ_MB_XD1_XDFFQ_SB r0 *1 0,0
Ccc_XD1_XDFFQ_MB_XD1_XDFFQ_SB XD1_XDFFQ_MB XD1_XDFFQ_SB 1.8151e-17
* device instance cc_XD1_XDFFQ_MB_XD1_XDFFQ_SFB r0 *1 0,0
Ccc_XD1_XDFFQ_MB_XD1_XDFFQ_SFB XD1_XDFFQ_MB XD1_XDFFQ_SFB 1.21e-17
* device instance cc_XD1_XDFFQ_MB_XD1_XN2_mid1 r0 *1 0,0
Ccc_XD1_XDFFQ_MB_XD1_XN2_mid1 XD1_XDFFQ_MB XD1_XN2_mid1 1.21e-17
* device instance cc_XD1_XDFFQ_MB_XD1_XNOR_midp r0 *1 0,0
Ccc_XD1_XDFFQ_MB_XD1_XNOR_midp XD1_XDFFQ_MB XD1_XNOR_midp 1.21e-17
* device instance cc_XD1_XDFFQ_MB_XD1_dmodout r0 *1 0,0
Ccc_XD1_XDFFQ_MB_XD1_dmodout XD1_XDFFQ_MB XD1_dmodout 1.21e-17
* device instance cc_XD1_XDFFQ_MB_XD1_dq r0 *1 0,0
Ccc_XD1_XDFFQ_MB_XD1_dq XD1_XDFFQ_MB XD1_dq 1.21e-17
* device instance cc_XD1_XDFFQ_MB_XD1_nm r0 *1 0,0
Ccc_XD1_XDFFQ_MB_XD1_nm XD1_XDFFQ_MB XD1_nm 1.21e-17
* device instance cc_XD1_XDFFQ_MB_XD1_nt r0 *1 0,0
Ccc_XD1_XDFFQ_MB_XD1_nt XD1_XDFFQ_MB XD1_nt 2.4201e-17
* device instance cc_XD1_XDFFQ_MB_XD1_t1 r0 *1 0,0
Ccc_XD1_XDFFQ_MB_XD1_t1 XD1_XDFFQ_MB XD1_t1 1.21e-17
* device instance cc_XD1_XDFFQ_MB_XD2_XDFFM_CKBB r0 *1 0,0
Ccc_XD1_XDFFQ_MB_XD2_XDFFM_CKBB XD1_XDFFQ_MB XD2_XDFFM_CKBB 1.8151e-17
* device instance cc_XD1_XDFFQ_MB_XD2_XDFFM_CLKB r0 *1 0,0
Ccc_XD1_XDFFQ_MB_XD2_XDFFM_CLKB XD1_XDFFQ_MB XD2_XDFFM_CLKB 2.4201e-17
* device instance cc_XD1_XDFFQ_MB_XD2_XDFFM_M r0 *1 0,0
Ccc_XD1_XDFFQ_MB_XD2_XDFFM_M XD1_XDFFQ_MB XD2_XDFFM_M 2.4201e-17
* device instance cc_XD1_XDFFQ_MB_XD2_XDFFM_MB r0 *1 0,0
Ccc_XD1_XDFFQ_MB_XD2_XDFFM_MB XD1_XDFFQ_MB XD2_XDFFM_MB 1.21e-17
* device instance cc_XD1_XDFFQ_MB_XD2_XDFFM_MFB r0 *1 0,0
Ccc_XD1_XDFFQ_MB_XD2_XDFFM_MFB XD1_XDFFQ_MB XD2_XDFFM_MFB 1.21e-17
* device instance cc_XD1_XDFFQ_MB_XD2_XDFFM_S r0 *1 0,0
Ccc_XD1_XDFFQ_MB_XD2_XDFFM_S XD1_XDFFQ_MB XD2_XDFFM_S 1.8151e-17
* device instance cc_XD1_XDFFQ_MB_XD2_XDFFM_SB r0 *1 0,0
Ccc_XD1_XDFFQ_MB_XD2_XDFFM_SB XD1_XDFFQ_MB XD2_XDFFM_SB 1.8151e-17
* device instance cc_XD1_XDFFQ_MB_XD2_XDFFM_SFB r0 *1 0,0
Ccc_XD1_XDFFQ_MB_XD2_XDFFM_SFB XD1_XDFFQ_MB XD2_XDFFM_SFB 1.21e-17
* device instance cc_XD1_XDFFQ_MB_XD2_XDFFQ_CKBB r0 *1 0,0
Ccc_XD1_XDFFQ_MB_XD2_XDFFQ_CKBB XD1_XDFFQ_MB XD2_XDFFQ_CKBB 1.8151e-17
* device instance cc_XD1_XDFFQ_MB_XD2_XDFFQ_CLKB r0 *1 0,0
Ccc_XD1_XDFFQ_MB_XD2_XDFFQ_CLKB XD1_XDFFQ_MB XD2_XDFFQ_CLKB 2.4201e-17
* device instance cc_XD1_XDFFQ_MB_XD2_XDFFQ_M r0 *1 0,0
Ccc_XD1_XDFFQ_MB_XD2_XDFFQ_M XD1_XDFFQ_MB XD2_XDFFQ_M 2.4201e-17
* device instance cc_XD1_XDFFQ_MB_XD2_XDFFQ_MB r0 *1 0,0
Ccc_XD1_XDFFQ_MB_XD2_XDFFQ_MB XD1_XDFFQ_MB XD2_XDFFQ_MB 1.21e-17
* device instance cc_XD1_XDFFQ_MB_XD2_XDFFQ_MFB r0 *1 0,0
Ccc_XD1_XDFFQ_MB_XD2_XDFFQ_MFB XD1_XDFFQ_MB XD2_XDFFQ_MFB 1.21e-17
* device instance cc_XD1_XDFFQ_MB_XD2_XDFFQ_S r0 *1 0,0
Ccc_XD1_XDFFQ_MB_XD2_XDFFQ_S XD1_XDFFQ_MB XD2_XDFFQ_S 1.8151e-17
* device instance cc_XD1_XDFFQ_MB_XD2_XDFFQ_SB r0 *1 0,0
Ccc_XD1_XDFFQ_MB_XD2_XDFFQ_SB XD1_XDFFQ_MB XD2_XDFFQ_SB 1.8151e-17
* device instance cc_XD1_XDFFQ_MB_XD2_XDFFQ_SFB r0 *1 0,0
Ccc_XD1_XDFFQ_MB_XD2_XDFFQ_SFB XD1_XDFFQ_MB XD2_XDFFQ_SFB 1.21e-17
* device instance cc_XD1_XDFFQ_MB_XD2_XN2_mid1 r0 *1 0,0
Ccc_XD1_XDFFQ_MB_XD2_XN2_mid1 XD1_XDFFQ_MB XD2_XN2_mid1 1.21e-17
* device instance cc_XD1_XDFFQ_MB_XD2_XN3_mid1 r0 *1 0,0
Ccc_XD1_XDFFQ_MB_XD2_XN3_mid1 XD1_XDFFQ_MB XD2_XN3_mid1 1.21e-17
* device instance cc_XD1_XDFFQ_MB_XD2_XN3_mid2 r0 *1 0,0
Ccc_XD1_XDFFQ_MB_XD2_XN3_mid2 XD1_XDFFQ_MB XD2_XN3_mid2 1.21e-17
* device instance cc_XD1_XDFFQ_MB_XD2_dmodout r0 *1 0,0
Ccc_XD1_XDFFQ_MB_XD2_dmodout XD1_XDFFQ_MB XD2_dmodout 1.21e-17
* device instance cc_XD1_XDFFQ_MB_XD2_dq r0 *1 0,0
Ccc_XD1_XDFFQ_MB_XD2_dq XD1_XDFFQ_MB XD2_dq 1.8151e-17
* device instance cc_XD1_XDFFQ_MB_XD2_nm r0 *1 0,0
Ccc_XD1_XDFFQ_MB_XD2_nm XD1_XDFFQ_MB XD2_nm 1.21e-17
* device instance cc_XD1_XDFFQ_MB_XD2_nt r0 *1 0,0
Ccc_XD1_XDFFQ_MB_XD2_nt XD1_XDFFQ_MB XD2_nt 1.21e-17
* device instance cc_XD1_XDFFQ_MB_XD2_t1 r0 *1 0,0
Ccc_XD1_XDFFQ_MB_XD2_t1 XD1_XDFFQ_MB XD2_t1 1.21e-17
* device instance cc_XD1_XDFFQ_MB_XD3_XDFFM_CKBB r0 *1 0,0
Ccc_XD1_XDFFQ_MB_XD3_XDFFM_CKBB XD1_XDFFQ_MB XD3_XDFFM_CKBB 1.8151e-17
* device instance cc_XD1_XDFFQ_MB_XD3_XDFFM_CLKB r0 *1 0,0
Ccc_XD1_XDFFQ_MB_XD3_XDFFM_CLKB XD1_XDFFQ_MB XD3_XDFFM_CLKB 2.4201e-17
* device instance cc_XD1_XDFFQ_MB_XD3_XDFFM_M r0 *1 0,0
Ccc_XD1_XDFFQ_MB_XD3_XDFFM_M XD1_XDFFQ_MB XD3_XDFFM_M 2.4201e-17
* device instance cc_XD1_XDFFQ_MB_XD3_XDFFM_MB r0 *1 0,0
Ccc_XD1_XDFFQ_MB_XD3_XDFFM_MB XD1_XDFFQ_MB XD3_XDFFM_MB 1.21e-17
* device instance cc_XD1_XDFFQ_MB_XD3_XDFFM_MFB r0 *1 0,0
Ccc_XD1_XDFFQ_MB_XD3_XDFFM_MFB XD1_XDFFQ_MB XD3_XDFFM_MFB 1.21e-17
* device instance cc_XD1_XDFFQ_MB_XD3_XDFFM_S r0 *1 0,0
Ccc_XD1_XDFFQ_MB_XD3_XDFFM_S XD1_XDFFQ_MB XD3_XDFFM_S 1.8151e-17
* device instance cc_XD1_XDFFQ_MB_XD3_XDFFM_SB r0 *1 0,0
Ccc_XD1_XDFFQ_MB_XD3_XDFFM_SB XD1_XDFFQ_MB XD3_XDFFM_SB 1.8151e-17
* device instance cc_XD1_XDFFQ_MB_XD3_XDFFM_SFB r0 *1 0,0
Ccc_XD1_XDFFQ_MB_XD3_XDFFM_SFB XD1_XDFFQ_MB XD3_XDFFM_SFB 1.21e-17
* device instance cc_XD1_XDFFQ_MB_XD3_XDFFQ_CKBB r0 *1 0,0
Ccc_XD1_XDFFQ_MB_XD3_XDFFQ_CKBB XD1_XDFFQ_MB XD3_XDFFQ_CKBB 1.8151e-17
* device instance cc_XD1_XDFFQ_MB_XD3_XDFFQ_CLKB r0 *1 0,0
Ccc_XD1_XDFFQ_MB_XD3_XDFFQ_CLKB XD1_XDFFQ_MB XD3_XDFFQ_CLKB 2.4201e-17
* device instance cc_XD1_XDFFQ_MB_XD3_XDFFQ_M r0 *1 0,0
Ccc_XD1_XDFFQ_MB_XD3_XDFFQ_M XD1_XDFFQ_MB XD3_XDFFQ_M 2.4201e-17
* device instance cc_XD1_XDFFQ_MB_XD3_XDFFQ_MB r0 *1 0,0
Ccc_XD1_XDFFQ_MB_XD3_XDFFQ_MB XD1_XDFFQ_MB XD3_XDFFQ_MB 1.21e-17
* device instance cc_XD1_XDFFQ_MB_XD3_XDFFQ_MFB r0 *1 0,0
Ccc_XD1_XDFFQ_MB_XD3_XDFFQ_MFB XD1_XDFFQ_MB XD3_XDFFQ_MFB 1.21e-17
* device instance cc_XD1_XDFFQ_MB_XD3_XDFFQ_S r0 *1 0,0
Ccc_XD1_XDFFQ_MB_XD3_XDFFQ_S XD1_XDFFQ_MB XD3_XDFFQ_S 1.8151e-17
* device instance cc_XD1_XDFFQ_MB_XD3_XDFFQ_SB r0 *1 0,0
Ccc_XD1_XDFFQ_MB_XD3_XDFFQ_SB XD1_XDFFQ_MB XD3_XDFFQ_SB 1.8151e-17
* device instance cc_XD1_XDFFQ_MB_XD3_XDFFQ_SFB r0 *1 0,0
Ccc_XD1_XDFFQ_MB_XD3_XDFFQ_SFB XD1_XDFFQ_MB XD3_XDFFQ_SFB 1.21e-17
* device instance cc_XD1_XDFFQ_MB_XD3_XN2_mid1 r0 *1 0,0
Ccc_XD1_XDFFQ_MB_XD3_XN2_mid1 XD1_XDFFQ_MB XD3_XN2_mid1 1.21e-17
* device instance cc_XD1_XDFFQ_MB_XD3_XN3_mid1 r0 *1 0,0
Ccc_XD1_XDFFQ_MB_XD3_XN3_mid1 XD1_XDFFQ_MB XD3_XN3_mid1 1.21e-17
* device instance cc_XD1_XDFFQ_MB_XD3_XN3_mid2 r0 *1 0,0
Ccc_XD1_XDFFQ_MB_XD3_XN3_mid2 XD1_XDFFQ_MB XD3_XN3_mid2 1.21e-17
* device instance cc_XD1_XDFFQ_MB_XD3_dmodout r0 *1 0,0
Ccc_XD1_XDFFQ_MB_XD3_dmodout XD1_XDFFQ_MB XD3_dmodout 1.21e-17
* device instance cc_XD1_XDFFQ_MB_XD3_dq r0 *1 0,0
Ccc_XD1_XDFFQ_MB_XD3_dq XD1_XDFFQ_MB XD3_dq 1.8151e-17
* device instance cc_XD1_XDFFQ_MB_XD3_nm r0 *1 0,0
Ccc_XD1_XDFFQ_MB_XD3_nm XD1_XDFFQ_MB XD3_nm 1.21e-17
* device instance cc_XD1_XDFFQ_MB_XD3_nt r0 *1 0,0
Ccc_XD1_XDFFQ_MB_XD3_nt XD1_XDFFQ_MB XD3_nt 1.21e-17
* device instance cc_XD1_XDFFQ_MB_XD3_t1 r0 *1 0,0
Ccc_XD1_XDFFQ_MB_XD3_t1 XD1_XDFFQ_MB XD3_t1 1.21e-17
* device instance cc_XD1_XDFFQ_MB_XD4_XDFFM_CKBB r0 *1 0,0
Ccc_XD1_XDFFQ_MB_XD4_XDFFM_CKBB XD1_XDFFQ_MB XD4_XDFFM_CKBB 1.8151e-17
* device instance cc_XD1_XDFFQ_MB_XD4_XDFFM_CLKB r0 *1 0,0
Ccc_XD1_XDFFQ_MB_XD4_XDFFM_CLKB XD1_XDFFQ_MB XD4_XDFFM_CLKB 2.4201e-17
* device instance cc_XD1_XDFFQ_MB_XD4_XDFFM_M r0 *1 0,0
Ccc_XD1_XDFFQ_MB_XD4_XDFFM_M XD1_XDFFQ_MB XD4_XDFFM_M 2.4201e-17
* device instance cc_XD1_XDFFQ_MB_XD4_XDFFM_MB r0 *1 0,0
Ccc_XD1_XDFFQ_MB_XD4_XDFFM_MB XD1_XDFFQ_MB XD4_XDFFM_MB 1.21e-17
* device instance cc_XD1_XDFFQ_MB_XD4_XDFFM_MFB r0 *1 0,0
Ccc_XD1_XDFFQ_MB_XD4_XDFFM_MFB XD1_XDFFQ_MB XD4_XDFFM_MFB 1.21e-17
* device instance cc_XD1_XDFFQ_MB_XD4_XDFFM_S r0 *1 0,0
Ccc_XD1_XDFFQ_MB_XD4_XDFFM_S XD1_XDFFQ_MB XD4_XDFFM_S 1.8151e-17
* device instance cc_XD1_XDFFQ_MB_XD4_XDFFM_SB r0 *1 0,0
Ccc_XD1_XDFFQ_MB_XD4_XDFFM_SB XD1_XDFFQ_MB XD4_XDFFM_SB 1.8151e-17
* device instance cc_XD1_XDFFQ_MB_XD4_XDFFM_SFB r0 *1 0,0
Ccc_XD1_XDFFQ_MB_XD4_XDFFM_SFB XD1_XDFFQ_MB XD4_XDFFM_SFB 1.21e-17
* device instance cc_XD1_XDFFQ_MB_XD4_XDFFQ_CKBB r0 *1 0,0
Ccc_XD1_XDFFQ_MB_XD4_XDFFQ_CKBB XD1_XDFFQ_MB XD4_XDFFQ_CKBB 1.8151e-17
* device instance cc_XD1_XDFFQ_MB_XD4_XDFFQ_CLKB r0 *1 0,0
Ccc_XD1_XDFFQ_MB_XD4_XDFFQ_CLKB XD1_XDFFQ_MB XD4_XDFFQ_CLKB 2.4201e-17
* device instance cc_XD1_XDFFQ_MB_XD4_XDFFQ_M r0 *1 0,0
Ccc_XD1_XDFFQ_MB_XD4_XDFFQ_M XD1_XDFFQ_MB XD4_XDFFQ_M 2.4201e-17
* device instance cc_XD1_XDFFQ_MB_XD4_XDFFQ_MB r0 *1 0,0
Ccc_XD1_XDFFQ_MB_XD4_XDFFQ_MB XD1_XDFFQ_MB XD4_XDFFQ_MB 1.21e-17
* device instance cc_XD1_XDFFQ_MB_XD4_XDFFQ_MFB r0 *1 0,0
Ccc_XD1_XDFFQ_MB_XD4_XDFFQ_MFB XD1_XDFFQ_MB XD4_XDFFQ_MFB 1.21e-17
* device instance cc_XD1_XDFFQ_MB_XD4_XDFFQ_S r0 *1 0,0
Ccc_XD1_XDFFQ_MB_XD4_XDFFQ_S XD1_XDFFQ_MB XD4_XDFFQ_S 1.8151e-17
* device instance cc_XD1_XDFFQ_MB_XD4_XDFFQ_SB r0 *1 0,0
Ccc_XD1_XDFFQ_MB_XD4_XDFFQ_SB XD1_XDFFQ_MB XD4_XDFFQ_SB 1.8151e-17
* device instance cc_XD1_XDFFQ_MB_XD4_XDFFQ_SFB r0 *1 0,0
Ccc_XD1_XDFFQ_MB_XD4_XDFFQ_SFB XD1_XDFFQ_MB XD4_XDFFQ_SFB 1.21e-17
* device instance cc_XD1_XDFFQ_MB_XD4_XN2_mid1 r0 *1 0,0
Ccc_XD1_XDFFQ_MB_XD4_XN2_mid1 XD1_XDFFQ_MB XD4_XN2_mid1 1.21e-17
* device instance cc_XD1_XDFFQ_MB_XD4_XN3_mid1 r0 *1 0,0
Ccc_XD1_XDFFQ_MB_XD4_XN3_mid1 XD1_XDFFQ_MB XD4_XN3_mid1 1.21e-17
* device instance cc_XD1_XDFFQ_MB_XD4_XN3_mid2 r0 *1 0,0
Ccc_XD1_XDFFQ_MB_XD4_XN3_mid2 XD1_XDFFQ_MB XD4_XN3_mid2 1.21e-17
* device instance cc_XD1_XDFFQ_MB_XD4_dmodout r0 *1 0,0
Ccc_XD1_XDFFQ_MB_XD4_dmodout XD1_XDFFQ_MB XD4_dmodout 1.21e-17
* device instance cc_XD1_XDFFQ_MB_XD4_dq r0 *1 0,0
Ccc_XD1_XDFFQ_MB_XD4_dq XD1_XDFFQ_MB XD4_dq 1.8151e-17
* device instance cc_XD1_XDFFQ_MB_XD4_nm r0 *1 0,0
Ccc_XD1_XDFFQ_MB_XD4_nm XD1_XDFFQ_MB XD4_nm 1.21e-17
* device instance cc_XD1_XDFFQ_MB_XD4_nt r0 *1 0,0
Ccc_XD1_XDFFQ_MB_XD4_nt XD1_XDFFQ_MB XD4_nt 1.21e-17
* device instance cc_XD1_XDFFQ_MB_XD4_t1 r0 *1 0,0
Ccc_XD1_XDFFQ_MB_XD4_t1 XD1_XDFFQ_MB XD4_t1 1.21e-17
* device instance cc_XD1_XDFFQ_MB_XD5_XDFFM_CKBB r0 *1 0,0
Ccc_XD1_XDFFQ_MB_XD5_XDFFM_CKBB XD1_XDFFQ_MB XD5_XDFFM_CKBB 1.8151e-17
* device instance cc_XD1_XDFFQ_MB_XD5_XDFFM_CLKB r0 *1 0,0
Ccc_XD1_XDFFQ_MB_XD5_XDFFM_CLKB XD1_XDFFQ_MB XD5_XDFFM_CLKB 2.4201e-17
* device instance cc_XD1_XDFFQ_MB_XD5_XDFFM_M r0 *1 0,0
Ccc_XD1_XDFFQ_MB_XD5_XDFFM_M XD1_XDFFQ_MB XD5_XDFFM_M 2.4201e-17
* device instance cc_XD1_XDFFQ_MB_XD5_XDFFM_MB r0 *1 0,0
Ccc_XD1_XDFFQ_MB_XD5_XDFFM_MB XD1_XDFFQ_MB XD5_XDFFM_MB 1.21e-17
* device instance cc_XD1_XDFFQ_MB_XD5_XDFFM_MFB r0 *1 0,0
Ccc_XD1_XDFFQ_MB_XD5_XDFFM_MFB XD1_XDFFQ_MB XD5_XDFFM_MFB 1.21e-17
* device instance cc_XD1_XDFFQ_MB_XD5_XDFFM_S r0 *1 0,0
Ccc_XD1_XDFFQ_MB_XD5_XDFFM_S XD1_XDFFQ_MB XD5_XDFFM_S 1.8151e-17
* device instance cc_XD1_XDFFQ_MB_XD5_XDFFM_SB r0 *1 0,0
Ccc_XD1_XDFFQ_MB_XD5_XDFFM_SB XD1_XDFFQ_MB XD5_XDFFM_SB 1.8151e-17
* device instance cc_XD1_XDFFQ_MB_XD5_XDFFM_SFB r0 *1 0,0
Ccc_XD1_XDFFQ_MB_XD5_XDFFM_SFB XD1_XDFFQ_MB XD5_XDFFM_SFB 1.21e-17
* device instance cc_XD1_XDFFQ_MB_XD5_XDFFQ_CKBB r0 *1 0,0
Ccc_XD1_XDFFQ_MB_XD5_XDFFQ_CKBB XD1_XDFFQ_MB XD5_XDFFQ_CKBB 1.8151e-17
* device instance cc_XD1_XDFFQ_MB_XD5_XDFFQ_CLKB r0 *1 0,0
Ccc_XD1_XDFFQ_MB_XD5_XDFFQ_CLKB XD1_XDFFQ_MB XD5_XDFFQ_CLKB 2.4201e-17
* device instance cc_XD1_XDFFQ_MB_XD5_XDFFQ_M r0 *1 0,0
Ccc_XD1_XDFFQ_MB_XD5_XDFFQ_M XD1_XDFFQ_MB XD5_XDFFQ_M 2.4201e-17
* device instance cc_XD1_XDFFQ_MB_XD5_XDFFQ_MB r0 *1 0,0
Ccc_XD1_XDFFQ_MB_XD5_XDFFQ_MB XD1_XDFFQ_MB XD5_XDFFQ_MB 1.21e-17
* device instance cc_XD1_XDFFQ_MB_XD5_XDFFQ_MFB r0 *1 0,0
Ccc_XD1_XDFFQ_MB_XD5_XDFFQ_MFB XD1_XDFFQ_MB XD5_XDFFQ_MFB 1.21e-17
* device instance cc_XD1_XDFFQ_MB_XD5_XDFFQ_S r0 *1 0,0
Ccc_XD1_XDFFQ_MB_XD5_XDFFQ_S XD1_XDFFQ_MB XD5_XDFFQ_S 1.8151e-17
* device instance cc_XD1_XDFFQ_MB_XD5_XDFFQ_SB r0 *1 0,0
Ccc_XD1_XDFFQ_MB_XD5_XDFFQ_SB XD1_XDFFQ_MB XD5_XDFFQ_SB 1.8151e-17
* device instance cc_XD1_XDFFQ_MB_XD5_XDFFQ_SFB r0 *1 0,0
Ccc_XD1_XDFFQ_MB_XD5_XDFFQ_SFB XD1_XDFFQ_MB XD5_XDFFQ_SFB 1.21e-17
* device instance cc_XD1_XDFFQ_MB_XD5_XN2_mid1 r0 *1 0,0
Ccc_XD1_XDFFQ_MB_XD5_XN2_mid1 XD1_XDFFQ_MB XD5_XN2_mid1 1.21e-17
* device instance cc_XD1_XDFFQ_MB_XD5_XN3_mid1 r0 *1 0,0
Ccc_XD1_XDFFQ_MB_XD5_XN3_mid1 XD1_XDFFQ_MB XD5_XN3_mid1 1.21e-17
* device instance cc_XD1_XDFFQ_MB_XD5_XN3_mid2 r0 *1 0,0
Ccc_XD1_XDFFQ_MB_XD5_XN3_mid2 XD1_XDFFQ_MB XD5_XN3_mid2 1.21e-17
* device instance cc_XD1_XDFFQ_MB_XD5_dmodout r0 *1 0,0
Ccc_XD1_XDFFQ_MB_XD5_dmodout XD1_XDFFQ_MB XD5_dmodout 1.21e-17
* device instance cc_XD1_XDFFQ_MB_XD5_dq r0 *1 0,0
Ccc_XD1_XDFFQ_MB_XD5_dq XD1_XDFFQ_MB XD5_dq 1.8151e-17
* device instance cc_XD1_XDFFQ_MB_XD5_nm r0 *1 0,0
Ccc_XD1_XDFFQ_MB_XD5_nm XD1_XDFFQ_MB XD5_nm 1.21e-17
* device instance cc_XD1_XDFFQ_MB_XD5_nt r0 *1 0,0
Ccc_XD1_XDFFQ_MB_XD5_nt XD1_XDFFQ_MB XD5_nt 1.21e-17
* device instance cc_XD1_XDFFQ_MB_XD5_t1 r0 *1 0,0
Ccc_XD1_XDFFQ_MB_XD5_t1 XD1_XDFFQ_MB XD5_t1 1.21e-17
* device instance cc_XD1_XDFFQ_MB_XFRT_CKBB r0 *1 0,0
Ccc_XD1_XDFFQ_MB_XFRT_CKBB XD1_XDFFQ_MB XFRT_CKBB 1.8151e-17
* device instance cc_XD1_XDFFQ_MB_XFRT_CLKB r0 *1 0,0
Ccc_XD1_XDFFQ_MB_XFRT_CLKB XD1_XDFFQ_MB XFRT_CLKB 2.4201e-17
* device instance cc_XD1_XDFFQ_MB_XFRT_M r0 *1 0,0
Ccc_XD1_XDFFQ_MB_XFRT_M XD1_XDFFQ_MB XFRT_M 2.4201e-17
* device instance cc_XD1_XDFFQ_MB_XFRT_MB r0 *1 0,0
Ccc_XD1_XDFFQ_MB_XFRT_MB XD1_XDFFQ_MB XFRT_MB 1.21e-17
* device instance cc_XD1_XDFFQ_MB_XFRT_MFB r0 *1 0,0
Ccc_XD1_XDFFQ_MB_XFRT_MFB XD1_XDFFQ_MB XFRT_MFB 1.21e-17
* device instance cc_XD1_XDFFQ_MB_XFRT_S r0 *1 0,0
Ccc_XD1_XDFFQ_MB_XFRT_S XD1_XDFFQ_MB XFRT_S 1.8151e-17
* device instance cc_XD1_XDFFQ_MB_XFRT_SB r0 *1 0,0
Ccc_XD1_XDFFQ_MB_XFRT_SB XD1_XDFFQ_MB XFRT_SB 1.8151e-17
* device instance cc_XD1_XDFFQ_MB_XFRT_SFB r0 *1 0,0
Ccc_XD1_XDFFQ_MB_XFRT_SFB XD1_XDFFQ_MB XFRT_SFB 1.21e-17
* device instance cc_XD1_XDFFQ_MB_ck1 r0 *1 0,0
Ccc_XD1_XDFFQ_MB_ck1 XD1_XDFFQ_MB ck1 3.0251e-17
* device instance cc_XD1_XDFFQ_MB_ck2 r0 *1 0,0
Ccc_XD1_XDFFQ_MB_ck2 XD1_XDFFQ_MB ck2 3.0251e-17
* device instance cc_XD1_XDFFQ_MB_ck3 r0 *1 0,0
Ccc_XD1_XDFFQ_MB_ck3 XD1_XDFFQ_MB ck3 3.0251e-17
* device instance cc_XD1_XDFFQ_MB_ck4 r0 *1 0,0
Ccc_XD1_XDFFQ_MB_ck4 XD1_XDFFQ_MB ck4 3.0251e-17
* device instance cc_XD1_XDFFQ_MB_ck5 r0 *1 0,0
Ccc_XD1_XDFFQ_MB_ck5 XD1_XDFFQ_MB ck5 3.0251e-17
* device instance cc_XD1_XDFFQ_MB_mod0 r0 *1 0,0
Ccc_XD1_XDFFQ_MB_mod0 XD1_XDFFQ_MB mod0 2.4201e-17
* device instance cc_XD1_XDFFQ_MB_mod1 r0 *1 0,0
Ccc_XD1_XDFFQ_MB_mod1 XD1_XDFFQ_MB mod1 2.4201e-17
* device instance cc_XD1_XDFFQ_MB_mod2 r0 *1 0,0
Ccc_XD1_XDFFQ_MB_mod2 XD1_XDFFQ_MB mod2 2.4201e-17
* device instance cc_XD1_XDFFQ_MB_mod3 r0 *1 0,0
Ccc_XD1_XDFFQ_MB_mod3 XD1_XDFFQ_MB mod3 2.4201e-17
* device instance cc_XD1_XDFFQ_MB_mod4 r0 *1 0,0
Ccc_XD1_XDFFQ_MB_mod4 XD1_XDFFQ_MB mod4 2.4201e-17
* device instance cc_XD1_XDFFQ_MB_net1 r0 *1 0,0
Ccc_XD1_XDFFQ_MB_net1 XD1_XDFFQ_MB net1 1.21e-17
* device instance cc_XD1_XDFFQ_MFB_XD1_XDFFQ_S r0 *1 0,0
Ccc_XD1_XDFFQ_MFB_XD1_XDFFQ_S XD1_XDFFQ_MFB XD1_XDFFQ_S 1.8151e-17
* device instance cc_XD1_XDFFQ_MFB_XD1_XDFFQ_SB r0 *1 0,0
Ccc_XD1_XDFFQ_MFB_XD1_XDFFQ_SB XD1_XDFFQ_MFB XD1_XDFFQ_SB 1.8151e-17
* device instance cc_XD1_XDFFQ_MFB_XD1_XDFFQ_SFB r0 *1 0,0
Ccc_XD1_XDFFQ_MFB_XD1_XDFFQ_SFB XD1_XDFFQ_MFB XD1_XDFFQ_SFB 1.21e-17
* device instance cc_XD1_XDFFQ_MFB_XD1_XN2_mid1 r0 *1 0,0
Ccc_XD1_XDFFQ_MFB_XD1_XN2_mid1 XD1_XDFFQ_MFB XD1_XN2_mid1 1.21e-17
* device instance cc_XD1_XDFFQ_MFB_XD1_XNOR_midp r0 *1 0,0
Ccc_XD1_XDFFQ_MFB_XD1_XNOR_midp XD1_XDFFQ_MFB XD1_XNOR_midp 1.21e-17
* device instance cc_XD1_XDFFQ_MFB_XD1_dmodout r0 *1 0,0
Ccc_XD1_XDFFQ_MFB_XD1_dmodout XD1_XDFFQ_MFB XD1_dmodout 1.21e-17
* device instance cc_XD1_XDFFQ_MFB_XD1_dq r0 *1 0,0
Ccc_XD1_XDFFQ_MFB_XD1_dq XD1_XDFFQ_MFB XD1_dq 1.21e-17
* device instance cc_XD1_XDFFQ_MFB_XD1_nm r0 *1 0,0
Ccc_XD1_XDFFQ_MFB_XD1_nm XD1_XDFFQ_MFB XD1_nm 1.21e-17
* device instance cc_XD1_XDFFQ_MFB_XD1_nt r0 *1 0,0
Ccc_XD1_XDFFQ_MFB_XD1_nt XD1_XDFFQ_MFB XD1_nt 2.4201e-17
* device instance cc_XD1_XDFFQ_MFB_XD1_t1 r0 *1 0,0
Ccc_XD1_XDFFQ_MFB_XD1_t1 XD1_XDFFQ_MFB XD1_t1 1.21e-17
* device instance cc_XD1_XDFFQ_MFB_XD2_XDFFM_CKBB r0 *1 0,0
Ccc_XD1_XDFFQ_MFB_XD2_XDFFM_CKBB XD1_XDFFQ_MFB XD2_XDFFM_CKBB 1.8151e-17
* device instance cc_XD1_XDFFQ_MFB_XD2_XDFFM_CLKB r0 *1 0,0
Ccc_XD1_XDFFQ_MFB_XD2_XDFFM_CLKB XD1_XDFFQ_MFB XD2_XDFFM_CLKB 2.4201e-17
* device instance cc_XD1_XDFFQ_MFB_XD2_XDFFM_M r0 *1 0,0
Ccc_XD1_XDFFQ_MFB_XD2_XDFFM_M XD1_XDFFQ_MFB XD2_XDFFM_M 2.4201e-17
* device instance cc_XD1_XDFFQ_MFB_XD2_XDFFM_MB r0 *1 0,0
Ccc_XD1_XDFFQ_MFB_XD2_XDFFM_MB XD1_XDFFQ_MFB XD2_XDFFM_MB 1.21e-17
* device instance cc_XD1_XDFFQ_MFB_XD2_XDFFM_MFB r0 *1 0,0
Ccc_XD1_XDFFQ_MFB_XD2_XDFFM_MFB XD1_XDFFQ_MFB XD2_XDFFM_MFB 1.21e-17
* device instance cc_XD1_XDFFQ_MFB_XD2_XDFFM_S r0 *1 0,0
Ccc_XD1_XDFFQ_MFB_XD2_XDFFM_S XD1_XDFFQ_MFB XD2_XDFFM_S 1.8151e-17
* device instance cc_XD1_XDFFQ_MFB_XD2_XDFFM_SB r0 *1 0,0
Ccc_XD1_XDFFQ_MFB_XD2_XDFFM_SB XD1_XDFFQ_MFB XD2_XDFFM_SB 1.8151e-17
* device instance cc_XD1_XDFFQ_MFB_XD2_XDFFM_SFB r0 *1 0,0
Ccc_XD1_XDFFQ_MFB_XD2_XDFFM_SFB XD1_XDFFQ_MFB XD2_XDFFM_SFB 1.21e-17
* device instance cc_XD1_XDFFQ_MFB_XD2_XDFFQ_CKBB r0 *1 0,0
Ccc_XD1_XDFFQ_MFB_XD2_XDFFQ_CKBB XD1_XDFFQ_MFB XD2_XDFFQ_CKBB 1.8151e-17
* device instance cc_XD1_XDFFQ_MFB_XD2_XDFFQ_CLKB r0 *1 0,0
Ccc_XD1_XDFFQ_MFB_XD2_XDFFQ_CLKB XD1_XDFFQ_MFB XD2_XDFFQ_CLKB 2.4201e-17
* device instance cc_XD1_XDFFQ_MFB_XD2_XDFFQ_M r0 *1 0,0
Ccc_XD1_XDFFQ_MFB_XD2_XDFFQ_M XD1_XDFFQ_MFB XD2_XDFFQ_M 2.4201e-17
* device instance cc_XD1_XDFFQ_MFB_XD2_XDFFQ_MB r0 *1 0,0
Ccc_XD1_XDFFQ_MFB_XD2_XDFFQ_MB XD1_XDFFQ_MFB XD2_XDFFQ_MB 1.21e-17
* device instance cc_XD1_XDFFQ_MFB_XD2_XDFFQ_MFB r0 *1 0,0
Ccc_XD1_XDFFQ_MFB_XD2_XDFFQ_MFB XD1_XDFFQ_MFB XD2_XDFFQ_MFB 1.21e-17
* device instance cc_XD1_XDFFQ_MFB_XD2_XDFFQ_S r0 *1 0,0
Ccc_XD1_XDFFQ_MFB_XD2_XDFFQ_S XD1_XDFFQ_MFB XD2_XDFFQ_S 1.8151e-17
* device instance cc_XD1_XDFFQ_MFB_XD2_XDFFQ_SB r0 *1 0,0
Ccc_XD1_XDFFQ_MFB_XD2_XDFFQ_SB XD1_XDFFQ_MFB XD2_XDFFQ_SB 1.8151e-17
* device instance cc_XD1_XDFFQ_MFB_XD2_XDFFQ_SFB r0 *1 0,0
Ccc_XD1_XDFFQ_MFB_XD2_XDFFQ_SFB XD1_XDFFQ_MFB XD2_XDFFQ_SFB 1.21e-17
* device instance cc_XD1_XDFFQ_MFB_XD2_XN2_mid1 r0 *1 0,0
Ccc_XD1_XDFFQ_MFB_XD2_XN2_mid1 XD1_XDFFQ_MFB XD2_XN2_mid1 1.21e-17
* device instance cc_XD1_XDFFQ_MFB_XD2_XN3_mid1 r0 *1 0,0
Ccc_XD1_XDFFQ_MFB_XD2_XN3_mid1 XD1_XDFFQ_MFB XD2_XN3_mid1 1.21e-17
* device instance cc_XD1_XDFFQ_MFB_XD2_XN3_mid2 r0 *1 0,0
Ccc_XD1_XDFFQ_MFB_XD2_XN3_mid2 XD1_XDFFQ_MFB XD2_XN3_mid2 1.21e-17
* device instance cc_XD1_XDFFQ_MFB_XD2_dmodout r0 *1 0,0
Ccc_XD1_XDFFQ_MFB_XD2_dmodout XD1_XDFFQ_MFB XD2_dmodout 1.21e-17
* device instance cc_XD1_XDFFQ_MFB_XD2_dq r0 *1 0,0
Ccc_XD1_XDFFQ_MFB_XD2_dq XD1_XDFFQ_MFB XD2_dq 1.8151e-17
* device instance cc_XD1_XDFFQ_MFB_XD2_nm r0 *1 0,0
Ccc_XD1_XDFFQ_MFB_XD2_nm XD1_XDFFQ_MFB XD2_nm 1.21e-17
* device instance cc_XD1_XDFFQ_MFB_XD2_nt r0 *1 0,0
Ccc_XD1_XDFFQ_MFB_XD2_nt XD1_XDFFQ_MFB XD2_nt 1.21e-17
* device instance cc_XD1_XDFFQ_MFB_XD2_t1 r0 *1 0,0
Ccc_XD1_XDFFQ_MFB_XD2_t1 XD1_XDFFQ_MFB XD2_t1 1.21e-17
* device instance cc_XD1_XDFFQ_MFB_XD3_XDFFM_CKBB r0 *1 0,0
Ccc_XD1_XDFFQ_MFB_XD3_XDFFM_CKBB XD1_XDFFQ_MFB XD3_XDFFM_CKBB 1.8151e-17
* device instance cc_XD1_XDFFQ_MFB_XD3_XDFFM_CLKB r0 *1 0,0
Ccc_XD1_XDFFQ_MFB_XD3_XDFFM_CLKB XD1_XDFFQ_MFB XD3_XDFFM_CLKB 2.4201e-17
* device instance cc_XD1_XDFFQ_MFB_XD3_XDFFM_M r0 *1 0,0
Ccc_XD1_XDFFQ_MFB_XD3_XDFFM_M XD1_XDFFQ_MFB XD3_XDFFM_M 2.4201e-17
* device instance cc_XD1_XDFFQ_MFB_XD3_XDFFM_MB r0 *1 0,0
Ccc_XD1_XDFFQ_MFB_XD3_XDFFM_MB XD1_XDFFQ_MFB XD3_XDFFM_MB 1.21e-17
* device instance cc_XD1_XDFFQ_MFB_XD3_XDFFM_MFB r0 *1 0,0
Ccc_XD1_XDFFQ_MFB_XD3_XDFFM_MFB XD1_XDFFQ_MFB XD3_XDFFM_MFB 1.21e-17
* device instance cc_XD1_XDFFQ_MFB_XD3_XDFFM_S r0 *1 0,0
Ccc_XD1_XDFFQ_MFB_XD3_XDFFM_S XD1_XDFFQ_MFB XD3_XDFFM_S 1.8151e-17
* device instance cc_XD1_XDFFQ_MFB_XD3_XDFFM_SB r0 *1 0,0
Ccc_XD1_XDFFQ_MFB_XD3_XDFFM_SB XD1_XDFFQ_MFB XD3_XDFFM_SB 1.8151e-17
* device instance cc_XD1_XDFFQ_MFB_XD3_XDFFM_SFB r0 *1 0,0
Ccc_XD1_XDFFQ_MFB_XD3_XDFFM_SFB XD1_XDFFQ_MFB XD3_XDFFM_SFB 1.21e-17
* device instance cc_XD1_XDFFQ_MFB_XD3_XDFFQ_CKBB r0 *1 0,0
Ccc_XD1_XDFFQ_MFB_XD3_XDFFQ_CKBB XD1_XDFFQ_MFB XD3_XDFFQ_CKBB 1.8151e-17
* device instance cc_XD1_XDFFQ_MFB_XD3_XDFFQ_CLKB r0 *1 0,0
Ccc_XD1_XDFFQ_MFB_XD3_XDFFQ_CLKB XD1_XDFFQ_MFB XD3_XDFFQ_CLKB 2.4201e-17
* device instance cc_XD1_XDFFQ_MFB_XD3_XDFFQ_M r0 *1 0,0
Ccc_XD1_XDFFQ_MFB_XD3_XDFFQ_M XD1_XDFFQ_MFB XD3_XDFFQ_M 2.4201e-17
* device instance cc_XD1_XDFFQ_MFB_XD3_XDFFQ_MB r0 *1 0,0
Ccc_XD1_XDFFQ_MFB_XD3_XDFFQ_MB XD1_XDFFQ_MFB XD3_XDFFQ_MB 1.21e-17
* device instance cc_XD1_XDFFQ_MFB_XD3_XDFFQ_MFB r0 *1 0,0
Ccc_XD1_XDFFQ_MFB_XD3_XDFFQ_MFB XD1_XDFFQ_MFB XD3_XDFFQ_MFB 1.21e-17
* device instance cc_XD1_XDFFQ_MFB_XD3_XDFFQ_S r0 *1 0,0
Ccc_XD1_XDFFQ_MFB_XD3_XDFFQ_S XD1_XDFFQ_MFB XD3_XDFFQ_S 1.8151e-17
* device instance cc_XD1_XDFFQ_MFB_XD3_XDFFQ_SB r0 *1 0,0
Ccc_XD1_XDFFQ_MFB_XD3_XDFFQ_SB XD1_XDFFQ_MFB XD3_XDFFQ_SB 1.8151e-17
* device instance cc_XD1_XDFFQ_MFB_XD3_XDFFQ_SFB r0 *1 0,0
Ccc_XD1_XDFFQ_MFB_XD3_XDFFQ_SFB XD1_XDFFQ_MFB XD3_XDFFQ_SFB 1.21e-17
* device instance cc_XD1_XDFFQ_MFB_XD3_XN2_mid1 r0 *1 0,0
Ccc_XD1_XDFFQ_MFB_XD3_XN2_mid1 XD1_XDFFQ_MFB XD3_XN2_mid1 1.21e-17
* device instance cc_XD1_XDFFQ_MFB_XD3_XN3_mid1 r0 *1 0,0
Ccc_XD1_XDFFQ_MFB_XD3_XN3_mid1 XD1_XDFFQ_MFB XD3_XN3_mid1 1.21e-17
* device instance cc_XD1_XDFFQ_MFB_XD3_XN3_mid2 r0 *1 0,0
Ccc_XD1_XDFFQ_MFB_XD3_XN3_mid2 XD1_XDFFQ_MFB XD3_XN3_mid2 1.21e-17
* device instance cc_XD1_XDFFQ_MFB_XD3_dmodout r0 *1 0,0
Ccc_XD1_XDFFQ_MFB_XD3_dmodout XD1_XDFFQ_MFB XD3_dmodout 1.21e-17
* device instance cc_XD1_XDFFQ_MFB_XD3_dq r0 *1 0,0
Ccc_XD1_XDFFQ_MFB_XD3_dq XD1_XDFFQ_MFB XD3_dq 1.8151e-17
* device instance cc_XD1_XDFFQ_MFB_XD3_nm r0 *1 0,0
Ccc_XD1_XDFFQ_MFB_XD3_nm XD1_XDFFQ_MFB XD3_nm 1.21e-17
* device instance cc_XD1_XDFFQ_MFB_XD3_nt r0 *1 0,0
Ccc_XD1_XDFFQ_MFB_XD3_nt XD1_XDFFQ_MFB XD3_nt 1.21e-17
* device instance cc_XD1_XDFFQ_MFB_XD3_t1 r0 *1 0,0
Ccc_XD1_XDFFQ_MFB_XD3_t1 XD1_XDFFQ_MFB XD3_t1 1.21e-17
* device instance cc_XD1_XDFFQ_MFB_XD4_XDFFM_CKBB r0 *1 0,0
Ccc_XD1_XDFFQ_MFB_XD4_XDFFM_CKBB XD1_XDFFQ_MFB XD4_XDFFM_CKBB 1.8151e-17
* device instance cc_XD1_XDFFQ_MFB_XD4_XDFFM_CLKB r0 *1 0,0
Ccc_XD1_XDFFQ_MFB_XD4_XDFFM_CLKB XD1_XDFFQ_MFB XD4_XDFFM_CLKB 2.4201e-17
* device instance cc_XD1_XDFFQ_MFB_XD4_XDFFM_M r0 *1 0,0
Ccc_XD1_XDFFQ_MFB_XD4_XDFFM_M XD1_XDFFQ_MFB XD4_XDFFM_M 2.4201e-17
* device instance cc_XD1_XDFFQ_MFB_XD4_XDFFM_MB r0 *1 0,0
Ccc_XD1_XDFFQ_MFB_XD4_XDFFM_MB XD1_XDFFQ_MFB XD4_XDFFM_MB 1.21e-17
* device instance cc_XD1_XDFFQ_MFB_XD4_XDFFM_MFB r0 *1 0,0
Ccc_XD1_XDFFQ_MFB_XD4_XDFFM_MFB XD1_XDFFQ_MFB XD4_XDFFM_MFB 1.21e-17
* device instance cc_XD1_XDFFQ_MFB_XD4_XDFFM_S r0 *1 0,0
Ccc_XD1_XDFFQ_MFB_XD4_XDFFM_S XD1_XDFFQ_MFB XD4_XDFFM_S 1.8151e-17
* device instance cc_XD1_XDFFQ_MFB_XD4_XDFFM_SB r0 *1 0,0
Ccc_XD1_XDFFQ_MFB_XD4_XDFFM_SB XD1_XDFFQ_MFB XD4_XDFFM_SB 1.8151e-17
* device instance cc_XD1_XDFFQ_MFB_XD4_XDFFM_SFB r0 *1 0,0
Ccc_XD1_XDFFQ_MFB_XD4_XDFFM_SFB XD1_XDFFQ_MFB XD4_XDFFM_SFB 1.21e-17
* device instance cc_XD1_XDFFQ_MFB_XD4_XDFFQ_CKBB r0 *1 0,0
Ccc_XD1_XDFFQ_MFB_XD4_XDFFQ_CKBB XD1_XDFFQ_MFB XD4_XDFFQ_CKBB 1.8151e-17
* device instance cc_XD1_XDFFQ_MFB_XD4_XDFFQ_CLKB r0 *1 0,0
Ccc_XD1_XDFFQ_MFB_XD4_XDFFQ_CLKB XD1_XDFFQ_MFB XD4_XDFFQ_CLKB 2.4201e-17
* device instance cc_XD1_XDFFQ_MFB_XD4_XDFFQ_M r0 *1 0,0
Ccc_XD1_XDFFQ_MFB_XD4_XDFFQ_M XD1_XDFFQ_MFB XD4_XDFFQ_M 2.4201e-17
* device instance cc_XD1_XDFFQ_MFB_XD4_XDFFQ_MB r0 *1 0,0
Ccc_XD1_XDFFQ_MFB_XD4_XDFFQ_MB XD1_XDFFQ_MFB XD4_XDFFQ_MB 1.21e-17
* device instance cc_XD1_XDFFQ_MFB_XD4_XDFFQ_MFB r0 *1 0,0
Ccc_XD1_XDFFQ_MFB_XD4_XDFFQ_MFB XD1_XDFFQ_MFB XD4_XDFFQ_MFB 1.21e-17
* device instance cc_XD1_XDFFQ_MFB_XD4_XDFFQ_S r0 *1 0,0
Ccc_XD1_XDFFQ_MFB_XD4_XDFFQ_S XD1_XDFFQ_MFB XD4_XDFFQ_S 1.8151e-17
* device instance cc_XD1_XDFFQ_MFB_XD4_XDFFQ_SB r0 *1 0,0
Ccc_XD1_XDFFQ_MFB_XD4_XDFFQ_SB XD1_XDFFQ_MFB XD4_XDFFQ_SB 1.8151e-17
* device instance cc_XD1_XDFFQ_MFB_XD4_XDFFQ_SFB r0 *1 0,0
Ccc_XD1_XDFFQ_MFB_XD4_XDFFQ_SFB XD1_XDFFQ_MFB XD4_XDFFQ_SFB 1.21e-17
* device instance cc_XD1_XDFFQ_MFB_XD4_XN2_mid1 r0 *1 0,0
Ccc_XD1_XDFFQ_MFB_XD4_XN2_mid1 XD1_XDFFQ_MFB XD4_XN2_mid1 1.21e-17
* device instance cc_XD1_XDFFQ_MFB_XD4_XN3_mid1 r0 *1 0,0
Ccc_XD1_XDFFQ_MFB_XD4_XN3_mid1 XD1_XDFFQ_MFB XD4_XN3_mid1 1.21e-17
* device instance cc_XD1_XDFFQ_MFB_XD4_XN3_mid2 r0 *1 0,0
Ccc_XD1_XDFFQ_MFB_XD4_XN3_mid2 XD1_XDFFQ_MFB XD4_XN3_mid2 1.21e-17
* device instance cc_XD1_XDFFQ_MFB_XD4_dmodout r0 *1 0,0
Ccc_XD1_XDFFQ_MFB_XD4_dmodout XD1_XDFFQ_MFB XD4_dmodout 1.21e-17
* device instance cc_XD1_XDFFQ_MFB_XD4_dq r0 *1 0,0
Ccc_XD1_XDFFQ_MFB_XD4_dq XD1_XDFFQ_MFB XD4_dq 1.8151e-17
* device instance cc_XD1_XDFFQ_MFB_XD4_nm r0 *1 0,0
Ccc_XD1_XDFFQ_MFB_XD4_nm XD1_XDFFQ_MFB XD4_nm 1.21e-17
* device instance cc_XD1_XDFFQ_MFB_XD4_nt r0 *1 0,0
Ccc_XD1_XDFFQ_MFB_XD4_nt XD1_XDFFQ_MFB XD4_nt 1.21e-17
* device instance cc_XD1_XDFFQ_MFB_XD4_t1 r0 *1 0,0
Ccc_XD1_XDFFQ_MFB_XD4_t1 XD1_XDFFQ_MFB XD4_t1 1.21e-17
* device instance cc_XD1_XDFFQ_MFB_XD5_XDFFM_CKBB r0 *1 0,0
Ccc_XD1_XDFFQ_MFB_XD5_XDFFM_CKBB XD1_XDFFQ_MFB XD5_XDFFM_CKBB 1.8151e-17
* device instance cc_XD1_XDFFQ_MFB_XD5_XDFFM_CLKB r0 *1 0,0
Ccc_XD1_XDFFQ_MFB_XD5_XDFFM_CLKB XD1_XDFFQ_MFB XD5_XDFFM_CLKB 2.4201e-17
* device instance cc_XD1_XDFFQ_MFB_XD5_XDFFM_M r0 *1 0,0
Ccc_XD1_XDFFQ_MFB_XD5_XDFFM_M XD1_XDFFQ_MFB XD5_XDFFM_M 2.4201e-17
* device instance cc_XD1_XDFFQ_MFB_XD5_XDFFM_MB r0 *1 0,0
Ccc_XD1_XDFFQ_MFB_XD5_XDFFM_MB XD1_XDFFQ_MFB XD5_XDFFM_MB 1.21e-17
* device instance cc_XD1_XDFFQ_MFB_XD5_XDFFM_MFB r0 *1 0,0
Ccc_XD1_XDFFQ_MFB_XD5_XDFFM_MFB XD1_XDFFQ_MFB XD5_XDFFM_MFB 1.21e-17
* device instance cc_XD1_XDFFQ_MFB_XD5_XDFFM_S r0 *1 0,0
Ccc_XD1_XDFFQ_MFB_XD5_XDFFM_S XD1_XDFFQ_MFB XD5_XDFFM_S 1.8151e-17
* device instance cc_XD1_XDFFQ_MFB_XD5_XDFFM_SB r0 *1 0,0
Ccc_XD1_XDFFQ_MFB_XD5_XDFFM_SB XD1_XDFFQ_MFB XD5_XDFFM_SB 1.8151e-17
* device instance cc_XD1_XDFFQ_MFB_XD5_XDFFM_SFB r0 *1 0,0
Ccc_XD1_XDFFQ_MFB_XD5_XDFFM_SFB XD1_XDFFQ_MFB XD5_XDFFM_SFB 1.21e-17
* device instance cc_XD1_XDFFQ_MFB_XD5_XDFFQ_CKBB r0 *1 0,0
Ccc_XD1_XDFFQ_MFB_XD5_XDFFQ_CKBB XD1_XDFFQ_MFB XD5_XDFFQ_CKBB 1.8151e-17
* device instance cc_XD1_XDFFQ_MFB_XD5_XDFFQ_CLKB r0 *1 0,0
Ccc_XD1_XDFFQ_MFB_XD5_XDFFQ_CLKB XD1_XDFFQ_MFB XD5_XDFFQ_CLKB 2.4201e-17
* device instance cc_XD1_XDFFQ_MFB_XD5_XDFFQ_M r0 *1 0,0
Ccc_XD1_XDFFQ_MFB_XD5_XDFFQ_M XD1_XDFFQ_MFB XD5_XDFFQ_M 2.4201e-17
* device instance cc_XD1_XDFFQ_MFB_XD5_XDFFQ_MB r0 *1 0,0
Ccc_XD1_XDFFQ_MFB_XD5_XDFFQ_MB XD1_XDFFQ_MFB XD5_XDFFQ_MB 1.21e-17
* device instance cc_XD1_XDFFQ_MFB_XD5_XDFFQ_MFB r0 *1 0,0
Ccc_XD1_XDFFQ_MFB_XD5_XDFFQ_MFB XD1_XDFFQ_MFB XD5_XDFFQ_MFB 1.21e-17
* device instance cc_XD1_XDFFQ_MFB_XD5_XDFFQ_S r0 *1 0,0
Ccc_XD1_XDFFQ_MFB_XD5_XDFFQ_S XD1_XDFFQ_MFB XD5_XDFFQ_S 1.8151e-17
* device instance cc_XD1_XDFFQ_MFB_XD5_XDFFQ_SB r0 *1 0,0
Ccc_XD1_XDFFQ_MFB_XD5_XDFFQ_SB XD1_XDFFQ_MFB XD5_XDFFQ_SB 1.8151e-17
* device instance cc_XD1_XDFFQ_MFB_XD5_XDFFQ_SFB r0 *1 0,0
Ccc_XD1_XDFFQ_MFB_XD5_XDFFQ_SFB XD1_XDFFQ_MFB XD5_XDFFQ_SFB 1.21e-17
* device instance cc_XD1_XDFFQ_MFB_XD5_XN2_mid1 r0 *1 0,0
Ccc_XD1_XDFFQ_MFB_XD5_XN2_mid1 XD1_XDFFQ_MFB XD5_XN2_mid1 1.21e-17
* device instance cc_XD1_XDFFQ_MFB_XD5_XN3_mid1 r0 *1 0,0
Ccc_XD1_XDFFQ_MFB_XD5_XN3_mid1 XD1_XDFFQ_MFB XD5_XN3_mid1 1.21e-17
* device instance cc_XD1_XDFFQ_MFB_XD5_XN3_mid2 r0 *1 0,0
Ccc_XD1_XDFFQ_MFB_XD5_XN3_mid2 XD1_XDFFQ_MFB XD5_XN3_mid2 1.21e-17
* device instance cc_XD1_XDFFQ_MFB_XD5_dmodout r0 *1 0,0
Ccc_XD1_XDFFQ_MFB_XD5_dmodout XD1_XDFFQ_MFB XD5_dmodout 1.21e-17
* device instance cc_XD1_XDFFQ_MFB_XD5_dq r0 *1 0,0
Ccc_XD1_XDFFQ_MFB_XD5_dq XD1_XDFFQ_MFB XD5_dq 1.8151e-17
* device instance cc_XD1_XDFFQ_MFB_XD5_nm r0 *1 0,0
Ccc_XD1_XDFFQ_MFB_XD5_nm XD1_XDFFQ_MFB XD5_nm 1.21e-17
* device instance cc_XD1_XDFFQ_MFB_XD5_nt r0 *1 0,0
Ccc_XD1_XDFFQ_MFB_XD5_nt XD1_XDFFQ_MFB XD5_nt 1.21e-17
* device instance cc_XD1_XDFFQ_MFB_XD5_t1 r0 *1 0,0
Ccc_XD1_XDFFQ_MFB_XD5_t1 XD1_XDFFQ_MFB XD5_t1 1.21e-17
* device instance cc_XD1_XDFFQ_MFB_XFRT_CKBB r0 *1 0,0
Ccc_XD1_XDFFQ_MFB_XFRT_CKBB XD1_XDFFQ_MFB XFRT_CKBB 1.8151e-17
* device instance cc_XD1_XDFFQ_MFB_XFRT_CLKB r0 *1 0,0
Ccc_XD1_XDFFQ_MFB_XFRT_CLKB XD1_XDFFQ_MFB XFRT_CLKB 2.4201e-17
* device instance cc_XD1_XDFFQ_MFB_XFRT_M r0 *1 0,0
Ccc_XD1_XDFFQ_MFB_XFRT_M XD1_XDFFQ_MFB XFRT_M 2.4201e-17
* device instance cc_XD1_XDFFQ_MFB_XFRT_MB r0 *1 0,0
Ccc_XD1_XDFFQ_MFB_XFRT_MB XD1_XDFFQ_MFB XFRT_MB 1.21e-17
* device instance cc_XD1_XDFFQ_MFB_XFRT_MFB r0 *1 0,0
Ccc_XD1_XDFFQ_MFB_XFRT_MFB XD1_XDFFQ_MFB XFRT_MFB 1.21e-17
* device instance cc_XD1_XDFFQ_MFB_XFRT_S r0 *1 0,0
Ccc_XD1_XDFFQ_MFB_XFRT_S XD1_XDFFQ_MFB XFRT_S 1.8151e-17
* device instance cc_XD1_XDFFQ_MFB_XFRT_SB r0 *1 0,0
Ccc_XD1_XDFFQ_MFB_XFRT_SB XD1_XDFFQ_MFB XFRT_SB 1.8151e-17
* device instance cc_XD1_XDFFQ_MFB_XFRT_SFB r0 *1 0,0
Ccc_XD1_XDFFQ_MFB_XFRT_SFB XD1_XDFFQ_MFB XFRT_SFB 1.21e-17
* device instance cc_XD1_XDFFQ_MFB_ck1 r0 *1 0,0
Ccc_XD1_XDFFQ_MFB_ck1 XD1_XDFFQ_MFB ck1 3.0251e-17
* device instance cc_XD1_XDFFQ_MFB_ck2 r0 *1 0,0
Ccc_XD1_XDFFQ_MFB_ck2 XD1_XDFFQ_MFB ck2 3.0251e-17
* device instance cc_XD1_XDFFQ_MFB_ck3 r0 *1 0,0
Ccc_XD1_XDFFQ_MFB_ck3 XD1_XDFFQ_MFB ck3 3.0251e-17
* device instance cc_XD1_XDFFQ_MFB_ck4 r0 *1 0,0
Ccc_XD1_XDFFQ_MFB_ck4 XD1_XDFFQ_MFB ck4 3.0251e-17
* device instance cc_XD1_XDFFQ_MFB_ck5 r0 *1 0,0
Ccc_XD1_XDFFQ_MFB_ck5 XD1_XDFFQ_MFB ck5 3.0251e-17
* device instance cc_XD1_XDFFQ_MFB_mod0 r0 *1 0,0
Ccc_XD1_XDFFQ_MFB_mod0 XD1_XDFFQ_MFB mod0 2.4201e-17
* device instance cc_XD1_XDFFQ_MFB_mod1 r0 *1 0,0
Ccc_XD1_XDFFQ_MFB_mod1 XD1_XDFFQ_MFB mod1 2.4201e-17
* device instance cc_XD1_XDFFQ_MFB_mod2 r0 *1 0,0
Ccc_XD1_XDFFQ_MFB_mod2 XD1_XDFFQ_MFB mod2 2.4201e-17
* device instance cc_XD1_XDFFQ_MFB_mod3 r0 *1 0,0
Ccc_XD1_XDFFQ_MFB_mod3 XD1_XDFFQ_MFB mod3 2.4201e-17
* device instance cc_XD1_XDFFQ_MFB_mod4 r0 *1 0,0
Ccc_XD1_XDFFQ_MFB_mod4 XD1_XDFFQ_MFB mod4 2.4201e-17
* device instance cc_XD1_XDFFQ_MFB_net1 r0 *1 0,0
Ccc_XD1_XDFFQ_MFB_net1 XD1_XDFFQ_MFB net1 1.21e-17
* device instance cc_XD1_XDFFQ_S_XD1_XDFFQ_SB r0 *1 0,0
Ccc_XD1_XDFFQ_S_XD1_XDFFQ_SB XD1_XDFFQ_S XD1_XDFFQ_SB 3.0251e-17
* device instance cc_XD1_XDFFQ_S_XD1_XDFFQ_SFB r0 *1 0,0
Ccc_XD1_XDFFQ_S_XD1_XDFFQ_SFB XD1_XDFFQ_S XD1_XDFFQ_SFB 3.4688e-17
* device instance cc_XD1_XDFFQ_S_XD1_XN2_mid1 r0 *1 0,0
Ccc_XD1_XDFFQ_S_XD1_XN2_mid1 XD1_XDFFQ_S XD1_XN2_mid1 1.21e-17
* device instance cc_XD1_XDFFQ_S_XD1_XNOR_midp r0 *1 0,0
Ccc_XD1_XDFFQ_S_XD1_XNOR_midp XD1_XDFFQ_S XD1_XNOR_midp 1.21e-17
* device instance cc_XD1_XDFFQ_S_XD1_dmodout r0 *1 0,0
Ccc_XD1_XDFFQ_S_XD1_dmodout XD1_XDFFQ_S XD1_dmodout 1.21e-17
* device instance cc_XD1_XDFFQ_S_XD1_dq r0 *1 0,0
Ccc_XD1_XDFFQ_S_XD1_dq XD1_XDFFQ_S XD1_dq 1.21e-17
* device instance cc_XD1_XDFFQ_S_XD1_nm r0 *1 0,0
Ccc_XD1_XDFFQ_S_XD1_nm XD1_XDFFQ_S XD1_nm 1.21e-17
* device instance cc_XD1_XDFFQ_S_XD1_nt r0 *1 0,0
Ccc_XD1_XDFFQ_S_XD1_nt XD1_XDFFQ_S XD1_nt 2.4201e-17
* device instance cc_XD1_XDFFQ_S_XD1_t1 r0 *1 0,0
Ccc_XD1_XDFFQ_S_XD1_t1 XD1_XDFFQ_S XD1_t1 1.21e-17
* device instance cc_XD1_XDFFQ_S_XD2_XDFFM_CKBB r0 *1 0,0
Ccc_XD1_XDFFQ_S_XD2_XDFFM_CKBB XD1_XDFFQ_S XD2_XDFFM_CKBB 1.8151e-17
* device instance cc_XD1_XDFFQ_S_XD2_XDFFM_CLKB r0 *1 0,0
Ccc_XD1_XDFFQ_S_XD2_XDFFM_CLKB XD1_XDFFQ_S XD2_XDFFM_CLKB 2.4201e-17
* device instance cc_XD1_XDFFQ_S_XD2_XDFFM_M r0 *1 0,0
Ccc_XD1_XDFFQ_S_XD2_XDFFM_M XD1_XDFFQ_S XD2_XDFFM_M 2.4201e-17
* device instance cc_XD1_XDFFQ_S_XD2_XDFFM_MB r0 *1 0,0
Ccc_XD1_XDFFQ_S_XD2_XDFFM_MB XD1_XDFFQ_S XD2_XDFFM_MB 1.21e-17
* device instance cc_XD1_XDFFQ_S_XD2_XDFFM_MFB r0 *1 0,0
Ccc_XD1_XDFFQ_S_XD2_XDFFM_MFB XD1_XDFFQ_S XD2_XDFFM_MFB 1.21e-17
* device instance cc_XD1_XDFFQ_S_XD2_XDFFM_S r0 *1 0,0
Ccc_XD1_XDFFQ_S_XD2_XDFFM_S XD1_XDFFQ_S XD2_XDFFM_S 1.8151e-17
* device instance cc_XD1_XDFFQ_S_XD2_XDFFM_SB r0 *1 0,0
Ccc_XD1_XDFFQ_S_XD2_XDFFM_SB XD1_XDFFQ_S XD2_XDFFM_SB 1.8151e-17
* device instance cc_XD1_XDFFQ_S_XD2_XDFFM_SFB r0 *1 0,0
Ccc_XD1_XDFFQ_S_XD2_XDFFM_SFB XD1_XDFFQ_S XD2_XDFFM_SFB 1.21e-17
* device instance cc_XD1_XDFFQ_S_XD2_XDFFQ_CKBB r0 *1 0,0
Ccc_XD1_XDFFQ_S_XD2_XDFFQ_CKBB XD1_XDFFQ_S XD2_XDFFQ_CKBB 1.8151e-17
* device instance cc_XD1_XDFFQ_S_XD2_XDFFQ_CLKB r0 *1 0,0
Ccc_XD1_XDFFQ_S_XD2_XDFFQ_CLKB XD1_XDFFQ_S XD2_XDFFQ_CLKB 2.4201e-17
* device instance cc_XD1_XDFFQ_S_XD2_XDFFQ_M r0 *1 0,0
Ccc_XD1_XDFFQ_S_XD2_XDFFQ_M XD1_XDFFQ_S XD2_XDFFQ_M 2.4201e-17
* device instance cc_XD1_XDFFQ_S_XD2_XDFFQ_MB r0 *1 0,0
Ccc_XD1_XDFFQ_S_XD2_XDFFQ_MB XD1_XDFFQ_S XD2_XDFFQ_MB 1.21e-17
* device instance cc_XD1_XDFFQ_S_XD2_XDFFQ_MFB r0 *1 0,0
Ccc_XD1_XDFFQ_S_XD2_XDFFQ_MFB XD1_XDFFQ_S XD2_XDFFQ_MFB 1.21e-17
* device instance cc_XD1_XDFFQ_S_XD2_XDFFQ_S r0 *1 0,0
Ccc_XD1_XDFFQ_S_XD2_XDFFQ_S XD1_XDFFQ_S XD2_XDFFQ_S 1.8151e-17
* device instance cc_XD1_XDFFQ_S_XD2_XDFFQ_SB r0 *1 0,0
Ccc_XD1_XDFFQ_S_XD2_XDFFQ_SB XD1_XDFFQ_S XD2_XDFFQ_SB 1.8151e-17
* device instance cc_XD1_XDFFQ_S_XD2_XDFFQ_SFB r0 *1 0,0
Ccc_XD1_XDFFQ_S_XD2_XDFFQ_SFB XD1_XDFFQ_S XD2_XDFFQ_SFB 1.21e-17
* device instance cc_XD1_XDFFQ_S_XD2_XN2_mid1 r0 *1 0,0
Ccc_XD1_XDFFQ_S_XD2_XN2_mid1 XD1_XDFFQ_S XD2_XN2_mid1 1.21e-17
* device instance cc_XD1_XDFFQ_S_XD2_XN3_mid1 r0 *1 0,0
Ccc_XD1_XDFFQ_S_XD2_XN3_mid1 XD1_XDFFQ_S XD2_XN3_mid1 1.21e-17
* device instance cc_XD1_XDFFQ_S_XD2_XN3_mid2 r0 *1 0,0
Ccc_XD1_XDFFQ_S_XD2_XN3_mid2 XD1_XDFFQ_S XD2_XN3_mid2 1.21e-17
* device instance cc_XD1_XDFFQ_S_XD2_dmodout r0 *1 0,0
Ccc_XD1_XDFFQ_S_XD2_dmodout XD1_XDFFQ_S XD2_dmodout 1.21e-17
* device instance cc_XD1_XDFFQ_S_XD2_dq r0 *1 0,0
Ccc_XD1_XDFFQ_S_XD2_dq XD1_XDFFQ_S XD2_dq 1.8151e-17
* device instance cc_XD1_XDFFQ_S_XD2_nm r0 *1 0,0
Ccc_XD1_XDFFQ_S_XD2_nm XD1_XDFFQ_S XD2_nm 1.21e-17
* device instance cc_XD1_XDFFQ_S_XD2_nt r0 *1 0,0
Ccc_XD1_XDFFQ_S_XD2_nt XD1_XDFFQ_S XD2_nt 1.21e-17
* device instance cc_XD1_XDFFQ_S_XD2_t1 r0 *1 0,0
Ccc_XD1_XDFFQ_S_XD2_t1 XD1_XDFFQ_S XD2_t1 1.21e-17
* device instance cc_XD1_XDFFQ_S_XD3_XDFFM_CKBB r0 *1 0,0
Ccc_XD1_XDFFQ_S_XD3_XDFFM_CKBB XD1_XDFFQ_S XD3_XDFFM_CKBB 1.8151e-17
* device instance cc_XD1_XDFFQ_S_XD3_XDFFM_CLKB r0 *1 0,0
Ccc_XD1_XDFFQ_S_XD3_XDFFM_CLKB XD1_XDFFQ_S XD3_XDFFM_CLKB 2.4201e-17
* device instance cc_XD1_XDFFQ_S_XD3_XDFFM_M r0 *1 0,0
Ccc_XD1_XDFFQ_S_XD3_XDFFM_M XD1_XDFFQ_S XD3_XDFFM_M 2.4201e-17
* device instance cc_XD1_XDFFQ_S_XD3_XDFFM_MB r0 *1 0,0
Ccc_XD1_XDFFQ_S_XD3_XDFFM_MB XD1_XDFFQ_S XD3_XDFFM_MB 1.21e-17
* device instance cc_XD1_XDFFQ_S_XD3_XDFFM_MFB r0 *1 0,0
Ccc_XD1_XDFFQ_S_XD3_XDFFM_MFB XD1_XDFFQ_S XD3_XDFFM_MFB 1.21e-17
* device instance cc_XD1_XDFFQ_S_XD3_XDFFM_S r0 *1 0,0
Ccc_XD1_XDFFQ_S_XD3_XDFFM_S XD1_XDFFQ_S XD3_XDFFM_S 1.8151e-17
* device instance cc_XD1_XDFFQ_S_XD3_XDFFM_SB r0 *1 0,0
Ccc_XD1_XDFFQ_S_XD3_XDFFM_SB XD1_XDFFQ_S XD3_XDFFM_SB 1.8151e-17
* device instance cc_XD1_XDFFQ_S_XD3_XDFFM_SFB r0 *1 0,0
Ccc_XD1_XDFFQ_S_XD3_XDFFM_SFB XD1_XDFFQ_S XD3_XDFFM_SFB 1.21e-17
* device instance cc_XD1_XDFFQ_S_XD3_XDFFQ_CKBB r0 *1 0,0
Ccc_XD1_XDFFQ_S_XD3_XDFFQ_CKBB XD1_XDFFQ_S XD3_XDFFQ_CKBB 1.8151e-17
* device instance cc_XD1_XDFFQ_S_XD3_XDFFQ_CLKB r0 *1 0,0
Ccc_XD1_XDFFQ_S_XD3_XDFFQ_CLKB XD1_XDFFQ_S XD3_XDFFQ_CLKB 2.4201e-17
* device instance cc_XD1_XDFFQ_S_XD3_XDFFQ_M r0 *1 0,0
Ccc_XD1_XDFFQ_S_XD3_XDFFQ_M XD1_XDFFQ_S XD3_XDFFQ_M 2.4201e-17
* device instance cc_XD1_XDFFQ_S_XD3_XDFFQ_MB r0 *1 0,0
Ccc_XD1_XDFFQ_S_XD3_XDFFQ_MB XD1_XDFFQ_S XD3_XDFFQ_MB 1.21e-17
* device instance cc_XD1_XDFFQ_S_XD3_XDFFQ_MFB r0 *1 0,0
Ccc_XD1_XDFFQ_S_XD3_XDFFQ_MFB XD1_XDFFQ_S XD3_XDFFQ_MFB 1.21e-17
* device instance cc_XD1_XDFFQ_S_XD3_XDFFQ_S r0 *1 0,0
Ccc_XD1_XDFFQ_S_XD3_XDFFQ_S XD1_XDFFQ_S XD3_XDFFQ_S 1.8151e-17
* device instance cc_XD1_XDFFQ_S_XD3_XDFFQ_SB r0 *1 0,0
Ccc_XD1_XDFFQ_S_XD3_XDFFQ_SB XD1_XDFFQ_S XD3_XDFFQ_SB 1.8151e-17
* device instance cc_XD1_XDFFQ_S_XD3_XDFFQ_SFB r0 *1 0,0
Ccc_XD1_XDFFQ_S_XD3_XDFFQ_SFB XD1_XDFFQ_S XD3_XDFFQ_SFB 1.21e-17
* device instance cc_XD1_XDFFQ_S_XD3_XN2_mid1 r0 *1 0,0
Ccc_XD1_XDFFQ_S_XD3_XN2_mid1 XD1_XDFFQ_S XD3_XN2_mid1 1.21e-17
* device instance cc_XD1_XDFFQ_S_XD3_XN3_mid1 r0 *1 0,0
Ccc_XD1_XDFFQ_S_XD3_XN3_mid1 XD1_XDFFQ_S XD3_XN3_mid1 1.21e-17
* device instance cc_XD1_XDFFQ_S_XD3_XN3_mid2 r0 *1 0,0
Ccc_XD1_XDFFQ_S_XD3_XN3_mid2 XD1_XDFFQ_S XD3_XN3_mid2 1.21e-17
* device instance cc_XD1_XDFFQ_S_XD3_dmodout r0 *1 0,0
Ccc_XD1_XDFFQ_S_XD3_dmodout XD1_XDFFQ_S XD3_dmodout 1.21e-17
* device instance cc_XD1_XDFFQ_S_XD3_dq r0 *1 0,0
Ccc_XD1_XDFFQ_S_XD3_dq XD1_XDFFQ_S XD3_dq 1.8151e-17
* device instance cc_XD1_XDFFQ_S_XD3_nm r0 *1 0,0
Ccc_XD1_XDFFQ_S_XD3_nm XD1_XDFFQ_S XD3_nm 1.21e-17
* device instance cc_XD1_XDFFQ_S_XD3_nt r0 *1 0,0
Ccc_XD1_XDFFQ_S_XD3_nt XD1_XDFFQ_S XD3_nt 1.21e-17
* device instance cc_XD1_XDFFQ_S_XD3_t1 r0 *1 0,0
Ccc_XD1_XDFFQ_S_XD3_t1 XD1_XDFFQ_S XD3_t1 1.21e-17
* device instance cc_XD1_XDFFQ_S_XD4_XDFFM_CKBB r0 *1 0,0
Ccc_XD1_XDFFQ_S_XD4_XDFFM_CKBB XD1_XDFFQ_S XD4_XDFFM_CKBB 1.8151e-17
* device instance cc_XD1_XDFFQ_S_XD4_XDFFM_CLKB r0 *1 0,0
Ccc_XD1_XDFFQ_S_XD4_XDFFM_CLKB XD1_XDFFQ_S XD4_XDFFM_CLKB 2.4201e-17
* device instance cc_XD1_XDFFQ_S_XD4_XDFFM_M r0 *1 0,0
Ccc_XD1_XDFFQ_S_XD4_XDFFM_M XD1_XDFFQ_S XD4_XDFFM_M 2.4201e-17
* device instance cc_XD1_XDFFQ_S_XD4_XDFFM_MB r0 *1 0,0
Ccc_XD1_XDFFQ_S_XD4_XDFFM_MB XD1_XDFFQ_S XD4_XDFFM_MB 1.21e-17
* device instance cc_XD1_XDFFQ_S_XD4_XDFFM_MFB r0 *1 0,0
Ccc_XD1_XDFFQ_S_XD4_XDFFM_MFB XD1_XDFFQ_S XD4_XDFFM_MFB 1.21e-17
* device instance cc_XD1_XDFFQ_S_XD4_XDFFM_S r0 *1 0,0
Ccc_XD1_XDFFQ_S_XD4_XDFFM_S XD1_XDFFQ_S XD4_XDFFM_S 1.8151e-17
* device instance cc_XD1_XDFFQ_S_XD4_XDFFM_SB r0 *1 0,0
Ccc_XD1_XDFFQ_S_XD4_XDFFM_SB XD1_XDFFQ_S XD4_XDFFM_SB 1.8151e-17
* device instance cc_XD1_XDFFQ_S_XD4_XDFFM_SFB r0 *1 0,0
Ccc_XD1_XDFFQ_S_XD4_XDFFM_SFB XD1_XDFFQ_S XD4_XDFFM_SFB 1.21e-17
* device instance cc_XD1_XDFFQ_S_XD4_XDFFQ_CKBB r0 *1 0,0
Ccc_XD1_XDFFQ_S_XD4_XDFFQ_CKBB XD1_XDFFQ_S XD4_XDFFQ_CKBB 1.8151e-17
* device instance cc_XD1_XDFFQ_S_XD4_XDFFQ_CLKB r0 *1 0,0
Ccc_XD1_XDFFQ_S_XD4_XDFFQ_CLKB XD1_XDFFQ_S XD4_XDFFQ_CLKB 2.4201e-17
* device instance cc_XD1_XDFFQ_S_XD4_XDFFQ_M r0 *1 0,0
Ccc_XD1_XDFFQ_S_XD4_XDFFQ_M XD1_XDFFQ_S XD4_XDFFQ_M 2.4201e-17
* device instance cc_XD1_XDFFQ_S_XD4_XDFFQ_MB r0 *1 0,0
Ccc_XD1_XDFFQ_S_XD4_XDFFQ_MB XD1_XDFFQ_S XD4_XDFFQ_MB 1.21e-17
* device instance cc_XD1_XDFFQ_S_XD4_XDFFQ_MFB r0 *1 0,0
Ccc_XD1_XDFFQ_S_XD4_XDFFQ_MFB XD1_XDFFQ_S XD4_XDFFQ_MFB 1.21e-17
* device instance cc_XD1_XDFFQ_S_XD4_XDFFQ_S r0 *1 0,0
Ccc_XD1_XDFFQ_S_XD4_XDFFQ_S XD1_XDFFQ_S XD4_XDFFQ_S 1.8151e-17
* device instance cc_XD1_XDFFQ_S_XD4_XDFFQ_SB r0 *1 0,0
Ccc_XD1_XDFFQ_S_XD4_XDFFQ_SB XD1_XDFFQ_S XD4_XDFFQ_SB 1.8151e-17
* device instance cc_XD1_XDFFQ_S_XD4_XDFFQ_SFB r0 *1 0,0
Ccc_XD1_XDFFQ_S_XD4_XDFFQ_SFB XD1_XDFFQ_S XD4_XDFFQ_SFB 1.21e-17
* device instance cc_XD1_XDFFQ_S_XD4_XN2_mid1 r0 *1 0,0
Ccc_XD1_XDFFQ_S_XD4_XN2_mid1 XD1_XDFFQ_S XD4_XN2_mid1 1.21e-17
* device instance cc_XD1_XDFFQ_S_XD4_XN3_mid1 r0 *1 0,0
Ccc_XD1_XDFFQ_S_XD4_XN3_mid1 XD1_XDFFQ_S XD4_XN3_mid1 1.21e-17
* device instance cc_XD1_XDFFQ_S_XD4_XN3_mid2 r0 *1 0,0
Ccc_XD1_XDFFQ_S_XD4_XN3_mid2 XD1_XDFFQ_S XD4_XN3_mid2 1.21e-17
* device instance cc_XD1_XDFFQ_S_XD4_dmodout r0 *1 0,0
Ccc_XD1_XDFFQ_S_XD4_dmodout XD1_XDFFQ_S XD4_dmodout 1.21e-17
* device instance cc_XD1_XDFFQ_S_XD4_dq r0 *1 0,0
Ccc_XD1_XDFFQ_S_XD4_dq XD1_XDFFQ_S XD4_dq 1.8151e-17
* device instance cc_XD1_XDFFQ_S_XD4_nm r0 *1 0,0
Ccc_XD1_XDFFQ_S_XD4_nm XD1_XDFFQ_S XD4_nm 1.21e-17
* device instance cc_XD1_XDFFQ_S_XD4_nt r0 *1 0,0
Ccc_XD1_XDFFQ_S_XD4_nt XD1_XDFFQ_S XD4_nt 1.21e-17
* device instance cc_XD1_XDFFQ_S_XD4_t1 r0 *1 0,0
Ccc_XD1_XDFFQ_S_XD4_t1 XD1_XDFFQ_S XD4_t1 1.21e-17
* device instance cc_XD1_XDFFQ_S_XD5_XDFFM_CKBB r0 *1 0,0
Ccc_XD1_XDFFQ_S_XD5_XDFFM_CKBB XD1_XDFFQ_S XD5_XDFFM_CKBB 1.8151e-17
* device instance cc_XD1_XDFFQ_S_XD5_XDFFM_CLKB r0 *1 0,0
Ccc_XD1_XDFFQ_S_XD5_XDFFM_CLKB XD1_XDFFQ_S XD5_XDFFM_CLKB 2.4201e-17
* device instance cc_XD1_XDFFQ_S_XD5_XDFFM_M r0 *1 0,0
Ccc_XD1_XDFFQ_S_XD5_XDFFM_M XD1_XDFFQ_S XD5_XDFFM_M 2.4201e-17
* device instance cc_XD1_XDFFQ_S_XD5_XDFFM_MB r0 *1 0,0
Ccc_XD1_XDFFQ_S_XD5_XDFFM_MB XD1_XDFFQ_S XD5_XDFFM_MB 1.21e-17
* device instance cc_XD1_XDFFQ_S_XD5_XDFFM_MFB r0 *1 0,0
Ccc_XD1_XDFFQ_S_XD5_XDFFM_MFB XD1_XDFFQ_S XD5_XDFFM_MFB 1.21e-17
* device instance cc_XD1_XDFFQ_S_XD5_XDFFM_S r0 *1 0,0
Ccc_XD1_XDFFQ_S_XD5_XDFFM_S XD1_XDFFQ_S XD5_XDFFM_S 1.8151e-17
* device instance cc_XD1_XDFFQ_S_XD5_XDFFM_SB r0 *1 0,0
Ccc_XD1_XDFFQ_S_XD5_XDFFM_SB XD1_XDFFQ_S XD5_XDFFM_SB 1.8151e-17
* device instance cc_XD1_XDFFQ_S_XD5_XDFFM_SFB r0 *1 0,0
Ccc_XD1_XDFFQ_S_XD5_XDFFM_SFB XD1_XDFFQ_S XD5_XDFFM_SFB 1.21e-17
* device instance cc_XD1_XDFFQ_S_XD5_XDFFQ_CKBB r0 *1 0,0
Ccc_XD1_XDFFQ_S_XD5_XDFFQ_CKBB XD1_XDFFQ_S XD5_XDFFQ_CKBB 1.8151e-17
* device instance cc_XD1_XDFFQ_S_XD5_XDFFQ_CLKB r0 *1 0,0
Ccc_XD1_XDFFQ_S_XD5_XDFFQ_CLKB XD1_XDFFQ_S XD5_XDFFQ_CLKB 2.4201e-17
* device instance cc_XD1_XDFFQ_S_XD5_XDFFQ_M r0 *1 0,0
Ccc_XD1_XDFFQ_S_XD5_XDFFQ_M XD1_XDFFQ_S XD5_XDFFQ_M 2.4201e-17
* device instance cc_XD1_XDFFQ_S_XD5_XDFFQ_MB r0 *1 0,0
Ccc_XD1_XDFFQ_S_XD5_XDFFQ_MB XD1_XDFFQ_S XD5_XDFFQ_MB 1.21e-17
* device instance cc_XD1_XDFFQ_S_XD5_XDFFQ_MFB r0 *1 0,0
Ccc_XD1_XDFFQ_S_XD5_XDFFQ_MFB XD1_XDFFQ_S XD5_XDFFQ_MFB 1.21e-17
* device instance cc_XD1_XDFFQ_S_XD5_XDFFQ_S r0 *1 0,0
Ccc_XD1_XDFFQ_S_XD5_XDFFQ_S XD1_XDFFQ_S XD5_XDFFQ_S 1.8151e-17
* device instance cc_XD1_XDFFQ_S_XD5_XDFFQ_SB r0 *1 0,0
Ccc_XD1_XDFFQ_S_XD5_XDFFQ_SB XD1_XDFFQ_S XD5_XDFFQ_SB 1.8151e-17
* device instance cc_XD1_XDFFQ_S_XD5_XDFFQ_SFB r0 *1 0,0
Ccc_XD1_XDFFQ_S_XD5_XDFFQ_SFB XD1_XDFFQ_S XD5_XDFFQ_SFB 1.21e-17
* device instance cc_XD1_XDFFQ_S_XD5_XN2_mid1 r0 *1 0,0
Ccc_XD1_XDFFQ_S_XD5_XN2_mid1 XD1_XDFFQ_S XD5_XN2_mid1 1.21e-17
* device instance cc_XD1_XDFFQ_S_XD5_XN3_mid1 r0 *1 0,0
Ccc_XD1_XDFFQ_S_XD5_XN3_mid1 XD1_XDFFQ_S XD5_XN3_mid1 1.21e-17
* device instance cc_XD1_XDFFQ_S_XD5_XN3_mid2 r0 *1 0,0
Ccc_XD1_XDFFQ_S_XD5_XN3_mid2 XD1_XDFFQ_S XD5_XN3_mid2 1.21e-17
* device instance cc_XD1_XDFFQ_S_XD5_dmodout r0 *1 0,0
Ccc_XD1_XDFFQ_S_XD5_dmodout XD1_XDFFQ_S XD5_dmodout 1.21e-17
* device instance cc_XD1_XDFFQ_S_XD5_dq r0 *1 0,0
Ccc_XD1_XDFFQ_S_XD5_dq XD1_XDFFQ_S XD5_dq 1.8151e-17
* device instance cc_XD1_XDFFQ_S_XD5_nm r0 *1 0,0
Ccc_XD1_XDFFQ_S_XD5_nm XD1_XDFFQ_S XD5_nm 1.21e-17
* device instance cc_XD1_XDFFQ_S_XD5_nt r0 *1 0,0
Ccc_XD1_XDFFQ_S_XD5_nt XD1_XDFFQ_S XD5_nt 1.21e-17
* device instance cc_XD1_XDFFQ_S_XD5_t1 r0 *1 0,0
Ccc_XD1_XDFFQ_S_XD5_t1 XD1_XDFFQ_S XD5_t1 1.21e-17
* device instance cc_XD1_XDFFQ_S_XFRT_CKBB r0 *1 0,0
Ccc_XD1_XDFFQ_S_XFRT_CKBB XD1_XDFFQ_S XFRT_CKBB 1.8151e-17
* device instance cc_XD1_XDFFQ_S_XFRT_CLKB r0 *1 0,0
Ccc_XD1_XDFFQ_S_XFRT_CLKB XD1_XDFFQ_S XFRT_CLKB 2.4201e-17
* device instance cc_XD1_XDFFQ_S_XFRT_M r0 *1 0,0
Ccc_XD1_XDFFQ_S_XFRT_M XD1_XDFFQ_S XFRT_M 2.4201e-17
* device instance cc_XD1_XDFFQ_S_XFRT_MB r0 *1 0,0
Ccc_XD1_XDFFQ_S_XFRT_MB XD1_XDFFQ_S XFRT_MB 1.21e-17
* device instance cc_XD1_XDFFQ_S_XFRT_MFB r0 *1 0,0
Ccc_XD1_XDFFQ_S_XFRT_MFB XD1_XDFFQ_S XFRT_MFB 1.21e-17
* device instance cc_XD1_XDFFQ_S_XFRT_S r0 *1 0,0
Ccc_XD1_XDFFQ_S_XFRT_S XD1_XDFFQ_S XFRT_S 1.8151e-17
* device instance cc_XD1_XDFFQ_S_XFRT_SB r0 *1 0,0
Ccc_XD1_XDFFQ_S_XFRT_SB XD1_XDFFQ_S XFRT_SB 1.8151e-17
* device instance cc_XD1_XDFFQ_S_XFRT_SFB r0 *1 0,0
Ccc_XD1_XDFFQ_S_XFRT_SFB XD1_XDFFQ_S XFRT_SFB 1.21e-17
* device instance cc_XD1_XDFFQ_S_ck1 r0 *1 0,0
Ccc_XD1_XDFFQ_S_ck1 XD1_XDFFQ_S ck1 3.0251e-17
* device instance cc_XD1_XDFFQ_S_ck2 r0 *1 0,0
Ccc_XD1_XDFFQ_S_ck2 XD1_XDFFQ_S ck2 3.0251e-17
* device instance cc_XD1_XDFFQ_S_ck3 r0 *1 0,0
Ccc_XD1_XDFFQ_S_ck3 XD1_XDFFQ_S ck3 3.0251e-17
* device instance cc_XD1_XDFFQ_S_ck4 r0 *1 0,0
Ccc_XD1_XDFFQ_S_ck4 XD1_XDFFQ_S ck4 3.0251e-17
* device instance cc_XD1_XDFFQ_S_ck5 r0 *1 0,0
Ccc_XD1_XDFFQ_S_ck5 XD1_XDFFQ_S ck5 3.0251e-17
* device instance cc_XD1_XDFFQ_S_mod0 r0 *1 0,0
Ccc_XD1_XDFFQ_S_mod0 XD1_XDFFQ_S mod0 2.4201e-17
* device instance cc_XD1_XDFFQ_S_mod1 r0 *1 0,0
Ccc_XD1_XDFFQ_S_mod1 XD1_XDFFQ_S mod1 2.4201e-17
* device instance cc_XD1_XDFFQ_S_mod2 r0 *1 0,0
Ccc_XD1_XDFFQ_S_mod2 XD1_XDFFQ_S mod2 2.4201e-17
* device instance cc_XD1_XDFFQ_S_mod3 r0 *1 0,0
Ccc_XD1_XDFFQ_S_mod3 XD1_XDFFQ_S mod3 2.4201e-17
* device instance cc_XD1_XDFFQ_S_mod4 r0 *1 0,0
Ccc_XD1_XDFFQ_S_mod4 XD1_XDFFQ_S mod4 2.4201e-17
* device instance cc_XD1_XDFFQ_S_net1 r0 *1 0,0
Ccc_XD1_XDFFQ_S_net1 XD1_XDFFQ_S net1 1.21e-17
* device instance cc_XD1_XDFFQ_SB_XD1_XDFFQ_SFB r0 *1 0,0
Ccc_XD1_XDFFQ_SB_XD1_XDFFQ_SFB XD1_XDFFQ_SB XD1_XDFFQ_SFB 2.4201e-17
* device instance cc_XD1_XDFFQ_SB_XD1_XN2_mid1 r0 *1 0,0
Ccc_XD1_XDFFQ_SB_XD1_XN2_mid1 XD1_XDFFQ_SB XD1_XN2_mid1 1.21e-17
* device instance cc_XD1_XDFFQ_SB_XD1_XNOR_midp r0 *1 0,0
Ccc_XD1_XDFFQ_SB_XD1_XNOR_midp XD1_XDFFQ_SB XD1_XNOR_midp 1.21e-17
* device instance cc_XD1_XDFFQ_SB_XD1_dmodout r0 *1 0,0
Ccc_XD1_XDFFQ_SB_XD1_dmodout XD1_XDFFQ_SB XD1_dmodout 1.21e-17
* device instance cc_XD1_XDFFQ_SB_XD1_dq r0 *1 0,0
Ccc_XD1_XDFFQ_SB_XD1_dq XD1_XDFFQ_SB XD1_dq 1.21e-17
* device instance cc_XD1_XDFFQ_SB_XD1_nm r0 *1 0,0
Ccc_XD1_XDFFQ_SB_XD1_nm XD1_XDFFQ_SB XD1_nm 1.21e-17
* device instance cc_XD1_XDFFQ_SB_XD1_nt r0 *1 0,0
Ccc_XD1_XDFFQ_SB_XD1_nt XD1_XDFFQ_SB XD1_nt 2.4201e-17
* device instance cc_XD1_XDFFQ_SB_XD1_t1 r0 *1 0,0
Ccc_XD1_XDFFQ_SB_XD1_t1 XD1_XDFFQ_SB XD1_t1 1.21e-17
* device instance cc_XD1_XDFFQ_SB_XD2_XDFFM_CKBB r0 *1 0,0
Ccc_XD1_XDFFQ_SB_XD2_XDFFM_CKBB XD1_XDFFQ_SB XD2_XDFFM_CKBB 1.8151e-17
* device instance cc_XD1_XDFFQ_SB_XD2_XDFFM_CLKB r0 *1 0,0
Ccc_XD1_XDFFQ_SB_XD2_XDFFM_CLKB XD1_XDFFQ_SB XD2_XDFFM_CLKB 2.4201e-17
* device instance cc_XD1_XDFFQ_SB_XD2_XDFFM_M r0 *1 0,0
Ccc_XD1_XDFFQ_SB_XD2_XDFFM_M XD1_XDFFQ_SB XD2_XDFFM_M 2.4201e-17
* device instance cc_XD1_XDFFQ_SB_XD2_XDFFM_MB r0 *1 0,0
Ccc_XD1_XDFFQ_SB_XD2_XDFFM_MB XD1_XDFFQ_SB XD2_XDFFM_MB 1.21e-17
* device instance cc_XD1_XDFFQ_SB_XD2_XDFFM_MFB r0 *1 0,0
Ccc_XD1_XDFFQ_SB_XD2_XDFFM_MFB XD1_XDFFQ_SB XD2_XDFFM_MFB 1.21e-17
* device instance cc_XD1_XDFFQ_SB_XD2_XDFFM_S r0 *1 0,0
Ccc_XD1_XDFFQ_SB_XD2_XDFFM_S XD1_XDFFQ_SB XD2_XDFFM_S 1.8151e-17
* device instance cc_XD1_XDFFQ_SB_XD2_XDFFM_SB r0 *1 0,0
Ccc_XD1_XDFFQ_SB_XD2_XDFFM_SB XD1_XDFFQ_SB XD2_XDFFM_SB 1.8151e-17
* device instance cc_XD1_XDFFQ_SB_XD2_XDFFM_SFB r0 *1 0,0
Ccc_XD1_XDFFQ_SB_XD2_XDFFM_SFB XD1_XDFFQ_SB XD2_XDFFM_SFB 1.21e-17
* device instance cc_XD1_XDFFQ_SB_XD2_XDFFQ_CKBB r0 *1 0,0
Ccc_XD1_XDFFQ_SB_XD2_XDFFQ_CKBB XD1_XDFFQ_SB XD2_XDFFQ_CKBB 1.8151e-17
* device instance cc_XD1_XDFFQ_SB_XD2_XDFFQ_CLKB r0 *1 0,0
Ccc_XD1_XDFFQ_SB_XD2_XDFFQ_CLKB XD1_XDFFQ_SB XD2_XDFFQ_CLKB 2.4201e-17
* device instance cc_XD1_XDFFQ_SB_XD2_XDFFQ_M r0 *1 0,0
Ccc_XD1_XDFFQ_SB_XD2_XDFFQ_M XD1_XDFFQ_SB XD2_XDFFQ_M 2.4201e-17
* device instance cc_XD1_XDFFQ_SB_XD2_XDFFQ_MB r0 *1 0,0
Ccc_XD1_XDFFQ_SB_XD2_XDFFQ_MB XD1_XDFFQ_SB XD2_XDFFQ_MB 1.21e-17
* device instance cc_XD1_XDFFQ_SB_XD2_XDFFQ_MFB r0 *1 0,0
Ccc_XD1_XDFFQ_SB_XD2_XDFFQ_MFB XD1_XDFFQ_SB XD2_XDFFQ_MFB 1.21e-17
* device instance cc_XD1_XDFFQ_SB_XD2_XDFFQ_S r0 *1 0,0
Ccc_XD1_XDFFQ_SB_XD2_XDFFQ_S XD1_XDFFQ_SB XD2_XDFFQ_S 1.8151e-17
* device instance cc_XD1_XDFFQ_SB_XD2_XDFFQ_SB r0 *1 0,0
Ccc_XD1_XDFFQ_SB_XD2_XDFFQ_SB XD1_XDFFQ_SB XD2_XDFFQ_SB 1.8151e-17
* device instance cc_XD1_XDFFQ_SB_XD2_XDFFQ_SFB r0 *1 0,0
Ccc_XD1_XDFFQ_SB_XD2_XDFFQ_SFB XD1_XDFFQ_SB XD2_XDFFQ_SFB 1.21e-17
* device instance cc_XD1_XDFFQ_SB_XD2_XN2_mid1 r0 *1 0,0
Ccc_XD1_XDFFQ_SB_XD2_XN2_mid1 XD1_XDFFQ_SB XD2_XN2_mid1 1.21e-17
* device instance cc_XD1_XDFFQ_SB_XD2_XN3_mid1 r0 *1 0,0
Ccc_XD1_XDFFQ_SB_XD2_XN3_mid1 XD1_XDFFQ_SB XD2_XN3_mid1 1.21e-17
* device instance cc_XD1_XDFFQ_SB_XD2_XN3_mid2 r0 *1 0,0
Ccc_XD1_XDFFQ_SB_XD2_XN3_mid2 XD1_XDFFQ_SB XD2_XN3_mid2 1.21e-17
* device instance cc_XD1_XDFFQ_SB_XD2_dmodout r0 *1 0,0
Ccc_XD1_XDFFQ_SB_XD2_dmodout XD1_XDFFQ_SB XD2_dmodout 1.21e-17
* device instance cc_XD1_XDFFQ_SB_XD2_dq r0 *1 0,0
Ccc_XD1_XDFFQ_SB_XD2_dq XD1_XDFFQ_SB XD2_dq 1.8151e-17
* device instance cc_XD1_XDFFQ_SB_XD2_nm r0 *1 0,0
Ccc_XD1_XDFFQ_SB_XD2_nm XD1_XDFFQ_SB XD2_nm 1.21e-17
* device instance cc_XD1_XDFFQ_SB_XD2_nt r0 *1 0,0
Ccc_XD1_XDFFQ_SB_XD2_nt XD1_XDFFQ_SB XD2_nt 1.21e-17
* device instance cc_XD1_XDFFQ_SB_XD2_t1 r0 *1 0,0
Ccc_XD1_XDFFQ_SB_XD2_t1 XD1_XDFFQ_SB XD2_t1 1.21e-17
* device instance cc_XD1_XDFFQ_SB_XD3_XDFFM_CKBB r0 *1 0,0
Ccc_XD1_XDFFQ_SB_XD3_XDFFM_CKBB XD1_XDFFQ_SB XD3_XDFFM_CKBB 1.8151e-17
* device instance cc_XD1_XDFFQ_SB_XD3_XDFFM_CLKB r0 *1 0,0
Ccc_XD1_XDFFQ_SB_XD3_XDFFM_CLKB XD1_XDFFQ_SB XD3_XDFFM_CLKB 2.4201e-17
* device instance cc_XD1_XDFFQ_SB_XD3_XDFFM_M r0 *1 0,0
Ccc_XD1_XDFFQ_SB_XD3_XDFFM_M XD1_XDFFQ_SB XD3_XDFFM_M 2.4201e-17
* device instance cc_XD1_XDFFQ_SB_XD3_XDFFM_MB r0 *1 0,0
Ccc_XD1_XDFFQ_SB_XD3_XDFFM_MB XD1_XDFFQ_SB XD3_XDFFM_MB 1.21e-17
* device instance cc_XD1_XDFFQ_SB_XD3_XDFFM_MFB r0 *1 0,0
Ccc_XD1_XDFFQ_SB_XD3_XDFFM_MFB XD1_XDFFQ_SB XD3_XDFFM_MFB 1.21e-17
* device instance cc_XD1_XDFFQ_SB_XD3_XDFFM_S r0 *1 0,0
Ccc_XD1_XDFFQ_SB_XD3_XDFFM_S XD1_XDFFQ_SB XD3_XDFFM_S 1.8151e-17
* device instance cc_XD1_XDFFQ_SB_XD3_XDFFM_SB r0 *1 0,0
Ccc_XD1_XDFFQ_SB_XD3_XDFFM_SB XD1_XDFFQ_SB XD3_XDFFM_SB 1.8151e-17
* device instance cc_XD1_XDFFQ_SB_XD3_XDFFM_SFB r0 *1 0,0
Ccc_XD1_XDFFQ_SB_XD3_XDFFM_SFB XD1_XDFFQ_SB XD3_XDFFM_SFB 1.21e-17
* device instance cc_XD1_XDFFQ_SB_XD3_XDFFQ_CKBB r0 *1 0,0
Ccc_XD1_XDFFQ_SB_XD3_XDFFQ_CKBB XD1_XDFFQ_SB XD3_XDFFQ_CKBB 1.8151e-17
* device instance cc_XD1_XDFFQ_SB_XD3_XDFFQ_CLKB r0 *1 0,0
Ccc_XD1_XDFFQ_SB_XD3_XDFFQ_CLKB XD1_XDFFQ_SB XD3_XDFFQ_CLKB 2.4201e-17
* device instance cc_XD1_XDFFQ_SB_XD3_XDFFQ_M r0 *1 0,0
Ccc_XD1_XDFFQ_SB_XD3_XDFFQ_M XD1_XDFFQ_SB XD3_XDFFQ_M 2.4201e-17
* device instance cc_XD1_XDFFQ_SB_XD3_XDFFQ_MB r0 *1 0,0
Ccc_XD1_XDFFQ_SB_XD3_XDFFQ_MB XD1_XDFFQ_SB XD3_XDFFQ_MB 1.21e-17
* device instance cc_XD1_XDFFQ_SB_XD3_XDFFQ_MFB r0 *1 0,0
Ccc_XD1_XDFFQ_SB_XD3_XDFFQ_MFB XD1_XDFFQ_SB XD3_XDFFQ_MFB 1.21e-17
* device instance cc_XD1_XDFFQ_SB_XD3_XDFFQ_S r0 *1 0,0
Ccc_XD1_XDFFQ_SB_XD3_XDFFQ_S XD1_XDFFQ_SB XD3_XDFFQ_S 1.8151e-17
* device instance cc_XD1_XDFFQ_SB_XD3_XDFFQ_SB r0 *1 0,0
Ccc_XD1_XDFFQ_SB_XD3_XDFFQ_SB XD1_XDFFQ_SB XD3_XDFFQ_SB 1.8151e-17
* device instance cc_XD1_XDFFQ_SB_XD3_XDFFQ_SFB r0 *1 0,0
Ccc_XD1_XDFFQ_SB_XD3_XDFFQ_SFB XD1_XDFFQ_SB XD3_XDFFQ_SFB 1.21e-17
* device instance cc_XD1_XDFFQ_SB_XD3_XN2_mid1 r0 *1 0,0
Ccc_XD1_XDFFQ_SB_XD3_XN2_mid1 XD1_XDFFQ_SB XD3_XN2_mid1 1.21e-17
* device instance cc_XD1_XDFFQ_SB_XD3_XN3_mid1 r0 *1 0,0
Ccc_XD1_XDFFQ_SB_XD3_XN3_mid1 XD1_XDFFQ_SB XD3_XN3_mid1 1.21e-17
* device instance cc_XD1_XDFFQ_SB_XD3_XN3_mid2 r0 *1 0,0
Ccc_XD1_XDFFQ_SB_XD3_XN3_mid2 XD1_XDFFQ_SB XD3_XN3_mid2 1.21e-17
* device instance cc_XD1_XDFFQ_SB_XD3_dmodout r0 *1 0,0
Ccc_XD1_XDFFQ_SB_XD3_dmodout XD1_XDFFQ_SB XD3_dmodout 1.21e-17
* device instance cc_XD1_XDFFQ_SB_XD3_dq r0 *1 0,0
Ccc_XD1_XDFFQ_SB_XD3_dq XD1_XDFFQ_SB XD3_dq 1.8151e-17
* device instance cc_XD1_XDFFQ_SB_XD3_nm r0 *1 0,0
Ccc_XD1_XDFFQ_SB_XD3_nm XD1_XDFFQ_SB XD3_nm 1.21e-17
* device instance cc_XD1_XDFFQ_SB_XD3_nt r0 *1 0,0
Ccc_XD1_XDFFQ_SB_XD3_nt XD1_XDFFQ_SB XD3_nt 1.21e-17
* device instance cc_XD1_XDFFQ_SB_XD3_t1 r0 *1 0,0
Ccc_XD1_XDFFQ_SB_XD3_t1 XD1_XDFFQ_SB XD3_t1 1.21e-17
* device instance cc_XD1_XDFFQ_SB_XD4_XDFFM_CKBB r0 *1 0,0
Ccc_XD1_XDFFQ_SB_XD4_XDFFM_CKBB XD1_XDFFQ_SB XD4_XDFFM_CKBB 1.8151e-17
* device instance cc_XD1_XDFFQ_SB_XD4_XDFFM_CLKB r0 *1 0,0
Ccc_XD1_XDFFQ_SB_XD4_XDFFM_CLKB XD1_XDFFQ_SB XD4_XDFFM_CLKB 2.4201e-17
* device instance cc_XD1_XDFFQ_SB_XD4_XDFFM_M r0 *1 0,0
Ccc_XD1_XDFFQ_SB_XD4_XDFFM_M XD1_XDFFQ_SB XD4_XDFFM_M 2.4201e-17
* device instance cc_XD1_XDFFQ_SB_XD4_XDFFM_MB r0 *1 0,0
Ccc_XD1_XDFFQ_SB_XD4_XDFFM_MB XD1_XDFFQ_SB XD4_XDFFM_MB 1.21e-17
* device instance cc_XD1_XDFFQ_SB_XD4_XDFFM_MFB r0 *1 0,0
Ccc_XD1_XDFFQ_SB_XD4_XDFFM_MFB XD1_XDFFQ_SB XD4_XDFFM_MFB 1.21e-17
* device instance cc_XD1_XDFFQ_SB_XD4_XDFFM_S r0 *1 0,0
Ccc_XD1_XDFFQ_SB_XD4_XDFFM_S XD1_XDFFQ_SB XD4_XDFFM_S 1.8151e-17
* device instance cc_XD1_XDFFQ_SB_XD4_XDFFM_SB r0 *1 0,0
Ccc_XD1_XDFFQ_SB_XD4_XDFFM_SB XD1_XDFFQ_SB XD4_XDFFM_SB 1.8151e-17
* device instance cc_XD1_XDFFQ_SB_XD4_XDFFM_SFB r0 *1 0,0
Ccc_XD1_XDFFQ_SB_XD4_XDFFM_SFB XD1_XDFFQ_SB XD4_XDFFM_SFB 1.21e-17
* device instance cc_XD1_XDFFQ_SB_XD4_XDFFQ_CKBB r0 *1 0,0
Ccc_XD1_XDFFQ_SB_XD4_XDFFQ_CKBB XD1_XDFFQ_SB XD4_XDFFQ_CKBB 1.8151e-17
* device instance cc_XD1_XDFFQ_SB_XD4_XDFFQ_CLKB r0 *1 0,0
Ccc_XD1_XDFFQ_SB_XD4_XDFFQ_CLKB XD1_XDFFQ_SB XD4_XDFFQ_CLKB 2.4201e-17
* device instance cc_XD1_XDFFQ_SB_XD4_XDFFQ_M r0 *1 0,0
Ccc_XD1_XDFFQ_SB_XD4_XDFFQ_M XD1_XDFFQ_SB XD4_XDFFQ_M 2.4201e-17
* device instance cc_XD1_XDFFQ_SB_XD4_XDFFQ_MB r0 *1 0,0
Ccc_XD1_XDFFQ_SB_XD4_XDFFQ_MB XD1_XDFFQ_SB XD4_XDFFQ_MB 1.21e-17
* device instance cc_XD1_XDFFQ_SB_XD4_XDFFQ_MFB r0 *1 0,0
Ccc_XD1_XDFFQ_SB_XD4_XDFFQ_MFB XD1_XDFFQ_SB XD4_XDFFQ_MFB 1.21e-17
* device instance cc_XD1_XDFFQ_SB_XD4_XDFFQ_S r0 *1 0,0
Ccc_XD1_XDFFQ_SB_XD4_XDFFQ_S XD1_XDFFQ_SB XD4_XDFFQ_S 1.8151e-17
* device instance cc_XD1_XDFFQ_SB_XD4_XDFFQ_SB r0 *1 0,0
Ccc_XD1_XDFFQ_SB_XD4_XDFFQ_SB XD1_XDFFQ_SB XD4_XDFFQ_SB 1.8151e-17
* device instance cc_XD1_XDFFQ_SB_XD4_XDFFQ_SFB r0 *1 0,0
Ccc_XD1_XDFFQ_SB_XD4_XDFFQ_SFB XD1_XDFFQ_SB XD4_XDFFQ_SFB 1.21e-17
* device instance cc_XD1_XDFFQ_SB_XD4_XN2_mid1 r0 *1 0,0
Ccc_XD1_XDFFQ_SB_XD4_XN2_mid1 XD1_XDFFQ_SB XD4_XN2_mid1 1.21e-17
* device instance cc_XD1_XDFFQ_SB_XD4_XN3_mid1 r0 *1 0,0
Ccc_XD1_XDFFQ_SB_XD4_XN3_mid1 XD1_XDFFQ_SB XD4_XN3_mid1 1.21e-17
* device instance cc_XD1_XDFFQ_SB_XD4_XN3_mid2 r0 *1 0,0
Ccc_XD1_XDFFQ_SB_XD4_XN3_mid2 XD1_XDFFQ_SB XD4_XN3_mid2 1.21e-17
* device instance cc_XD1_XDFFQ_SB_XD4_dmodout r0 *1 0,0
Ccc_XD1_XDFFQ_SB_XD4_dmodout XD1_XDFFQ_SB XD4_dmodout 1.21e-17
* device instance cc_XD1_XDFFQ_SB_XD4_dq r0 *1 0,0
Ccc_XD1_XDFFQ_SB_XD4_dq XD1_XDFFQ_SB XD4_dq 1.8151e-17
* device instance cc_XD1_XDFFQ_SB_XD4_nm r0 *1 0,0
Ccc_XD1_XDFFQ_SB_XD4_nm XD1_XDFFQ_SB XD4_nm 1.21e-17
* device instance cc_XD1_XDFFQ_SB_XD4_nt r0 *1 0,0
Ccc_XD1_XDFFQ_SB_XD4_nt XD1_XDFFQ_SB XD4_nt 1.21e-17
* device instance cc_XD1_XDFFQ_SB_XD4_t1 r0 *1 0,0
Ccc_XD1_XDFFQ_SB_XD4_t1 XD1_XDFFQ_SB XD4_t1 1.21e-17
* device instance cc_XD1_XDFFQ_SB_XD5_XDFFM_CKBB r0 *1 0,0
Ccc_XD1_XDFFQ_SB_XD5_XDFFM_CKBB XD1_XDFFQ_SB XD5_XDFFM_CKBB 1.8151e-17
* device instance cc_XD1_XDFFQ_SB_XD5_XDFFM_CLKB r0 *1 0,0
Ccc_XD1_XDFFQ_SB_XD5_XDFFM_CLKB XD1_XDFFQ_SB XD5_XDFFM_CLKB 2.4201e-17
* device instance cc_XD1_XDFFQ_SB_XD5_XDFFM_M r0 *1 0,0
Ccc_XD1_XDFFQ_SB_XD5_XDFFM_M XD1_XDFFQ_SB XD5_XDFFM_M 2.4201e-17
* device instance cc_XD1_XDFFQ_SB_XD5_XDFFM_MB r0 *1 0,0
Ccc_XD1_XDFFQ_SB_XD5_XDFFM_MB XD1_XDFFQ_SB XD5_XDFFM_MB 1.21e-17
* device instance cc_XD1_XDFFQ_SB_XD5_XDFFM_MFB r0 *1 0,0
Ccc_XD1_XDFFQ_SB_XD5_XDFFM_MFB XD1_XDFFQ_SB XD5_XDFFM_MFB 1.21e-17
* device instance cc_XD1_XDFFQ_SB_XD5_XDFFM_S r0 *1 0,0
Ccc_XD1_XDFFQ_SB_XD5_XDFFM_S XD1_XDFFQ_SB XD5_XDFFM_S 1.8151e-17
* device instance cc_XD1_XDFFQ_SB_XD5_XDFFM_SB r0 *1 0,0
Ccc_XD1_XDFFQ_SB_XD5_XDFFM_SB XD1_XDFFQ_SB XD5_XDFFM_SB 1.8151e-17
* device instance cc_XD1_XDFFQ_SB_XD5_XDFFM_SFB r0 *1 0,0
Ccc_XD1_XDFFQ_SB_XD5_XDFFM_SFB XD1_XDFFQ_SB XD5_XDFFM_SFB 1.21e-17
* device instance cc_XD1_XDFFQ_SB_XD5_XDFFQ_CKBB r0 *1 0,0
Ccc_XD1_XDFFQ_SB_XD5_XDFFQ_CKBB XD1_XDFFQ_SB XD5_XDFFQ_CKBB 1.8151e-17
* device instance cc_XD1_XDFFQ_SB_XD5_XDFFQ_CLKB r0 *1 0,0
Ccc_XD1_XDFFQ_SB_XD5_XDFFQ_CLKB XD1_XDFFQ_SB XD5_XDFFQ_CLKB 2.4201e-17
* device instance cc_XD1_XDFFQ_SB_XD5_XDFFQ_M r0 *1 0,0
Ccc_XD1_XDFFQ_SB_XD5_XDFFQ_M XD1_XDFFQ_SB XD5_XDFFQ_M 2.4201e-17
* device instance cc_XD1_XDFFQ_SB_XD5_XDFFQ_MB r0 *1 0,0
Ccc_XD1_XDFFQ_SB_XD5_XDFFQ_MB XD1_XDFFQ_SB XD5_XDFFQ_MB 1.21e-17
* device instance cc_XD1_XDFFQ_SB_XD5_XDFFQ_MFB r0 *1 0,0
Ccc_XD1_XDFFQ_SB_XD5_XDFFQ_MFB XD1_XDFFQ_SB XD5_XDFFQ_MFB 1.21e-17
* device instance cc_XD1_XDFFQ_SB_XD5_XDFFQ_S r0 *1 0,0
Ccc_XD1_XDFFQ_SB_XD5_XDFFQ_S XD1_XDFFQ_SB XD5_XDFFQ_S 1.8151e-17
* device instance cc_XD1_XDFFQ_SB_XD5_XDFFQ_SB r0 *1 0,0
Ccc_XD1_XDFFQ_SB_XD5_XDFFQ_SB XD1_XDFFQ_SB XD5_XDFFQ_SB 1.8151e-17
* device instance cc_XD1_XDFFQ_SB_XD5_XDFFQ_SFB r0 *1 0,0
Ccc_XD1_XDFFQ_SB_XD5_XDFFQ_SFB XD1_XDFFQ_SB XD5_XDFFQ_SFB 1.21e-17
* device instance cc_XD1_XDFFQ_SB_XD5_XN2_mid1 r0 *1 0,0
Ccc_XD1_XDFFQ_SB_XD5_XN2_mid1 XD1_XDFFQ_SB XD5_XN2_mid1 1.21e-17
* device instance cc_XD1_XDFFQ_SB_XD5_XN3_mid1 r0 *1 0,0
Ccc_XD1_XDFFQ_SB_XD5_XN3_mid1 XD1_XDFFQ_SB XD5_XN3_mid1 1.21e-17
* device instance cc_XD1_XDFFQ_SB_XD5_XN3_mid2 r0 *1 0,0
Ccc_XD1_XDFFQ_SB_XD5_XN3_mid2 XD1_XDFFQ_SB XD5_XN3_mid2 1.21e-17
* device instance cc_XD1_XDFFQ_SB_XD5_dmodout r0 *1 0,0
Ccc_XD1_XDFFQ_SB_XD5_dmodout XD1_XDFFQ_SB XD5_dmodout 1.21e-17
* device instance cc_XD1_XDFFQ_SB_XD5_dq r0 *1 0,0
Ccc_XD1_XDFFQ_SB_XD5_dq XD1_XDFFQ_SB XD5_dq 1.8151e-17
* device instance cc_XD1_XDFFQ_SB_XD5_nm r0 *1 0,0
Ccc_XD1_XDFFQ_SB_XD5_nm XD1_XDFFQ_SB XD5_nm 1.21e-17
* device instance cc_XD1_XDFFQ_SB_XD5_nt r0 *1 0,0
Ccc_XD1_XDFFQ_SB_XD5_nt XD1_XDFFQ_SB XD5_nt 1.21e-17
* device instance cc_XD1_XDFFQ_SB_XD5_t1 r0 *1 0,0
Ccc_XD1_XDFFQ_SB_XD5_t1 XD1_XDFFQ_SB XD5_t1 1.21e-17
* device instance cc_XD1_XDFFQ_SB_XFRT_CKBB r0 *1 0,0
Ccc_XD1_XDFFQ_SB_XFRT_CKBB XD1_XDFFQ_SB XFRT_CKBB 1.8151e-17
* device instance cc_XD1_XDFFQ_SB_XFRT_CLKB r0 *1 0,0
Ccc_XD1_XDFFQ_SB_XFRT_CLKB XD1_XDFFQ_SB XFRT_CLKB 2.4201e-17
* device instance cc_XD1_XDFFQ_SB_XFRT_M r0 *1 0,0
Ccc_XD1_XDFFQ_SB_XFRT_M XD1_XDFFQ_SB XFRT_M 2.4201e-17
* device instance cc_XD1_XDFFQ_SB_XFRT_MB r0 *1 0,0
Ccc_XD1_XDFFQ_SB_XFRT_MB XD1_XDFFQ_SB XFRT_MB 1.21e-17
* device instance cc_XD1_XDFFQ_SB_XFRT_MFB r0 *1 0,0
Ccc_XD1_XDFFQ_SB_XFRT_MFB XD1_XDFFQ_SB XFRT_MFB 1.21e-17
* device instance cc_XD1_XDFFQ_SB_XFRT_S r0 *1 0,0
Ccc_XD1_XDFFQ_SB_XFRT_S XD1_XDFFQ_SB XFRT_S 1.8151e-17
* device instance cc_XD1_XDFFQ_SB_XFRT_SB r0 *1 0,0
Ccc_XD1_XDFFQ_SB_XFRT_SB XD1_XDFFQ_SB XFRT_SB 1.8151e-17
* device instance cc_XD1_XDFFQ_SB_XFRT_SFB r0 *1 0,0
Ccc_XD1_XDFFQ_SB_XFRT_SFB XD1_XDFFQ_SB XFRT_SFB 1.21e-17
* device instance cc_XD1_XDFFQ_SB_ck1 r0 *1 0,0
Ccc_XD1_XDFFQ_SB_ck1 XD1_XDFFQ_SB ck1 3.0251e-17
* device instance cc_XD1_XDFFQ_SB_ck2 r0 *1 0,0
Ccc_XD1_XDFFQ_SB_ck2 XD1_XDFFQ_SB ck2 3.0251e-17
* device instance cc_XD1_XDFFQ_SB_ck3 r0 *1 0,0
Ccc_XD1_XDFFQ_SB_ck3 XD1_XDFFQ_SB ck3 3.0251e-17
* device instance cc_XD1_XDFFQ_SB_ck4 r0 *1 0,0
Ccc_XD1_XDFFQ_SB_ck4 XD1_XDFFQ_SB ck4 3.0251e-17
* device instance cc_XD1_XDFFQ_SB_ck5 r0 *1 0,0
Ccc_XD1_XDFFQ_SB_ck5 XD1_XDFFQ_SB ck5 3.0251e-17
* device instance cc_XD1_XDFFQ_SB_mod0 r0 *1 0,0
Ccc_XD1_XDFFQ_SB_mod0 XD1_XDFFQ_SB mod0 2.4201e-17
* device instance cc_XD1_XDFFQ_SB_mod1 r0 *1 0,0
Ccc_XD1_XDFFQ_SB_mod1 XD1_XDFFQ_SB mod1 2.4201e-17
* device instance cc_XD1_XDFFQ_SB_mod2 r0 *1 0,0
Ccc_XD1_XDFFQ_SB_mod2 XD1_XDFFQ_SB mod2 2.4201e-17
* device instance cc_XD1_XDFFQ_SB_mod3 r0 *1 0,0
Ccc_XD1_XDFFQ_SB_mod3 XD1_XDFFQ_SB mod3 2.4201e-17
* device instance cc_XD1_XDFFQ_SB_mod4 r0 *1 0,0
Ccc_XD1_XDFFQ_SB_mod4 XD1_XDFFQ_SB mod4 2.4201e-17
* device instance cc_XD1_XDFFQ_SB_net1 r0 *1 0,0
Ccc_XD1_XDFFQ_SB_net1 XD1_XDFFQ_SB net1 1.21e-17
* device instance cc_XD1_XDFFQ_SFB_XD1_XN2_mid1 r0 *1 0,0
Ccc_XD1_XDFFQ_SFB_XD1_XN2_mid1 XD1_XDFFQ_SFB XD1_XN2_mid1 1.21e-17
* device instance cc_XD1_XDFFQ_SFB_XD1_XNOR_midp r0 *1 0,0
Ccc_XD1_XDFFQ_SFB_XD1_XNOR_midp XD1_XDFFQ_SFB XD1_XNOR_midp 1.21e-17
* device instance cc_XD1_XDFFQ_SFB_XD1_dmodout r0 *1 0,0
Ccc_XD1_XDFFQ_SFB_XD1_dmodout XD1_XDFFQ_SFB XD1_dmodout 1.21e-17
* device instance cc_XD1_XDFFQ_SFB_XD1_dq r0 *1 0,0
Ccc_XD1_XDFFQ_SFB_XD1_dq XD1_XDFFQ_SFB XD1_dq 1.21e-17
* device instance cc_XD1_XDFFQ_SFB_XD1_nm r0 *1 0,0
Ccc_XD1_XDFFQ_SFB_XD1_nm XD1_XDFFQ_SFB XD1_nm 1.21e-17
* device instance cc_XD1_XDFFQ_SFB_XD1_nt r0 *1 0,0
Ccc_XD1_XDFFQ_SFB_XD1_nt XD1_XDFFQ_SFB XD1_nt 2.4201e-17
* device instance cc_XD1_XDFFQ_SFB_XD1_t1 r0 *1 0,0
Ccc_XD1_XDFFQ_SFB_XD1_t1 XD1_XDFFQ_SFB XD1_t1 1.21e-17
* device instance cc_XD1_XDFFQ_SFB_XD2_XDFFM_CKBB r0 *1 0,0
Ccc_XD1_XDFFQ_SFB_XD2_XDFFM_CKBB XD1_XDFFQ_SFB XD2_XDFFM_CKBB 1.8151e-17
* device instance cc_XD1_XDFFQ_SFB_XD2_XDFFM_CLKB r0 *1 0,0
Ccc_XD1_XDFFQ_SFB_XD2_XDFFM_CLKB XD1_XDFFQ_SFB XD2_XDFFM_CLKB 2.4201e-17
* device instance cc_XD1_XDFFQ_SFB_XD2_XDFFM_M r0 *1 0,0
Ccc_XD1_XDFFQ_SFB_XD2_XDFFM_M XD1_XDFFQ_SFB XD2_XDFFM_M 2.4201e-17
* device instance cc_XD1_XDFFQ_SFB_XD2_XDFFM_MB r0 *1 0,0
Ccc_XD1_XDFFQ_SFB_XD2_XDFFM_MB XD1_XDFFQ_SFB XD2_XDFFM_MB 1.21e-17
* device instance cc_XD1_XDFFQ_SFB_XD2_XDFFM_MFB r0 *1 0,0
Ccc_XD1_XDFFQ_SFB_XD2_XDFFM_MFB XD1_XDFFQ_SFB XD2_XDFFM_MFB 1.21e-17
* device instance cc_XD1_XDFFQ_SFB_XD2_XDFFM_S r0 *1 0,0
Ccc_XD1_XDFFQ_SFB_XD2_XDFFM_S XD1_XDFFQ_SFB XD2_XDFFM_S 1.8151e-17
* device instance cc_XD1_XDFFQ_SFB_XD2_XDFFM_SB r0 *1 0,0
Ccc_XD1_XDFFQ_SFB_XD2_XDFFM_SB XD1_XDFFQ_SFB XD2_XDFFM_SB 1.8151e-17
* device instance cc_XD1_XDFFQ_SFB_XD2_XDFFM_SFB r0 *1 0,0
Ccc_XD1_XDFFQ_SFB_XD2_XDFFM_SFB XD1_XDFFQ_SFB XD2_XDFFM_SFB 1.21e-17
* device instance cc_XD1_XDFFQ_SFB_XD2_XDFFQ_CKBB r0 *1 0,0
Ccc_XD1_XDFFQ_SFB_XD2_XDFFQ_CKBB XD1_XDFFQ_SFB XD2_XDFFQ_CKBB 1.8151e-17
* device instance cc_XD1_XDFFQ_SFB_XD2_XDFFQ_CLKB r0 *1 0,0
Ccc_XD1_XDFFQ_SFB_XD2_XDFFQ_CLKB XD1_XDFFQ_SFB XD2_XDFFQ_CLKB 2.4201e-17
* device instance cc_XD1_XDFFQ_SFB_XD2_XDFFQ_M r0 *1 0,0
Ccc_XD1_XDFFQ_SFB_XD2_XDFFQ_M XD1_XDFFQ_SFB XD2_XDFFQ_M 2.4201e-17
* device instance cc_XD1_XDFFQ_SFB_XD2_XDFFQ_MB r0 *1 0,0
Ccc_XD1_XDFFQ_SFB_XD2_XDFFQ_MB XD1_XDFFQ_SFB XD2_XDFFQ_MB 1.21e-17
* device instance cc_XD1_XDFFQ_SFB_XD2_XDFFQ_MFB r0 *1 0,0
Ccc_XD1_XDFFQ_SFB_XD2_XDFFQ_MFB XD1_XDFFQ_SFB XD2_XDFFQ_MFB 1.21e-17
* device instance cc_XD1_XDFFQ_SFB_XD2_XDFFQ_S r0 *1 0,0
Ccc_XD1_XDFFQ_SFB_XD2_XDFFQ_S XD1_XDFFQ_SFB XD2_XDFFQ_S 1.8151e-17
* device instance cc_XD1_XDFFQ_SFB_XD2_XDFFQ_SB r0 *1 0,0
Ccc_XD1_XDFFQ_SFB_XD2_XDFFQ_SB XD1_XDFFQ_SFB XD2_XDFFQ_SB 1.8151e-17
* device instance cc_XD1_XDFFQ_SFB_XD2_XDFFQ_SFB r0 *1 0,0
Ccc_XD1_XDFFQ_SFB_XD2_XDFFQ_SFB XD1_XDFFQ_SFB XD2_XDFFQ_SFB 1.21e-17
* device instance cc_XD1_XDFFQ_SFB_XD2_XN2_mid1 r0 *1 0,0
Ccc_XD1_XDFFQ_SFB_XD2_XN2_mid1 XD1_XDFFQ_SFB XD2_XN2_mid1 1.21e-17
* device instance cc_XD1_XDFFQ_SFB_XD2_XN3_mid1 r0 *1 0,0
Ccc_XD1_XDFFQ_SFB_XD2_XN3_mid1 XD1_XDFFQ_SFB XD2_XN3_mid1 1.21e-17
* device instance cc_XD1_XDFFQ_SFB_XD2_XN3_mid2 r0 *1 0,0
Ccc_XD1_XDFFQ_SFB_XD2_XN3_mid2 XD1_XDFFQ_SFB XD2_XN3_mid2 1.21e-17
* device instance cc_XD1_XDFFQ_SFB_XD2_dmodout r0 *1 0,0
Ccc_XD1_XDFFQ_SFB_XD2_dmodout XD1_XDFFQ_SFB XD2_dmodout 1.21e-17
* device instance cc_XD1_XDFFQ_SFB_XD2_dq r0 *1 0,0
Ccc_XD1_XDFFQ_SFB_XD2_dq XD1_XDFFQ_SFB XD2_dq 1.8151e-17
* device instance cc_XD1_XDFFQ_SFB_XD2_nm r0 *1 0,0
Ccc_XD1_XDFFQ_SFB_XD2_nm XD1_XDFFQ_SFB XD2_nm 1.21e-17
* device instance cc_XD1_XDFFQ_SFB_XD2_nt r0 *1 0,0
Ccc_XD1_XDFFQ_SFB_XD2_nt XD1_XDFFQ_SFB XD2_nt 1.21e-17
* device instance cc_XD1_XDFFQ_SFB_XD2_t1 r0 *1 0,0
Ccc_XD1_XDFFQ_SFB_XD2_t1 XD1_XDFFQ_SFB XD2_t1 1.21e-17
* device instance cc_XD1_XDFFQ_SFB_XD3_XDFFM_CKBB r0 *1 0,0
Ccc_XD1_XDFFQ_SFB_XD3_XDFFM_CKBB XD1_XDFFQ_SFB XD3_XDFFM_CKBB 1.8151e-17
* device instance cc_XD1_XDFFQ_SFB_XD3_XDFFM_CLKB r0 *1 0,0
Ccc_XD1_XDFFQ_SFB_XD3_XDFFM_CLKB XD1_XDFFQ_SFB XD3_XDFFM_CLKB 2.4201e-17
* device instance cc_XD1_XDFFQ_SFB_XD3_XDFFM_M r0 *1 0,0
Ccc_XD1_XDFFQ_SFB_XD3_XDFFM_M XD1_XDFFQ_SFB XD3_XDFFM_M 2.4201e-17
* device instance cc_XD1_XDFFQ_SFB_XD3_XDFFM_MB r0 *1 0,0
Ccc_XD1_XDFFQ_SFB_XD3_XDFFM_MB XD1_XDFFQ_SFB XD3_XDFFM_MB 1.21e-17
* device instance cc_XD1_XDFFQ_SFB_XD3_XDFFM_MFB r0 *1 0,0
Ccc_XD1_XDFFQ_SFB_XD3_XDFFM_MFB XD1_XDFFQ_SFB XD3_XDFFM_MFB 1.21e-17
* device instance cc_XD1_XDFFQ_SFB_XD3_XDFFM_S r0 *1 0,0
Ccc_XD1_XDFFQ_SFB_XD3_XDFFM_S XD1_XDFFQ_SFB XD3_XDFFM_S 1.8151e-17
* device instance cc_XD1_XDFFQ_SFB_XD3_XDFFM_SB r0 *1 0,0
Ccc_XD1_XDFFQ_SFB_XD3_XDFFM_SB XD1_XDFFQ_SFB XD3_XDFFM_SB 1.8151e-17
* device instance cc_XD1_XDFFQ_SFB_XD3_XDFFM_SFB r0 *1 0,0
Ccc_XD1_XDFFQ_SFB_XD3_XDFFM_SFB XD1_XDFFQ_SFB XD3_XDFFM_SFB 1.21e-17
* device instance cc_XD1_XDFFQ_SFB_XD3_XDFFQ_CKBB r0 *1 0,0
Ccc_XD1_XDFFQ_SFB_XD3_XDFFQ_CKBB XD1_XDFFQ_SFB XD3_XDFFQ_CKBB 1.8151e-17
* device instance cc_XD1_XDFFQ_SFB_XD3_XDFFQ_CLKB r0 *1 0,0
Ccc_XD1_XDFFQ_SFB_XD3_XDFFQ_CLKB XD1_XDFFQ_SFB XD3_XDFFQ_CLKB 2.4201e-17
* device instance cc_XD1_XDFFQ_SFB_XD3_XDFFQ_M r0 *1 0,0
Ccc_XD1_XDFFQ_SFB_XD3_XDFFQ_M XD1_XDFFQ_SFB XD3_XDFFQ_M 2.4201e-17
* device instance cc_XD1_XDFFQ_SFB_XD3_XDFFQ_MB r0 *1 0,0
Ccc_XD1_XDFFQ_SFB_XD3_XDFFQ_MB XD1_XDFFQ_SFB XD3_XDFFQ_MB 1.21e-17
* device instance cc_XD1_XDFFQ_SFB_XD3_XDFFQ_MFB r0 *1 0,0
Ccc_XD1_XDFFQ_SFB_XD3_XDFFQ_MFB XD1_XDFFQ_SFB XD3_XDFFQ_MFB 1.21e-17
* device instance cc_XD1_XDFFQ_SFB_XD3_XDFFQ_S r0 *1 0,0
Ccc_XD1_XDFFQ_SFB_XD3_XDFFQ_S XD1_XDFFQ_SFB XD3_XDFFQ_S 1.8151e-17
* device instance cc_XD1_XDFFQ_SFB_XD3_XDFFQ_SB r0 *1 0,0
Ccc_XD1_XDFFQ_SFB_XD3_XDFFQ_SB XD1_XDFFQ_SFB XD3_XDFFQ_SB 1.8151e-17
* device instance cc_XD1_XDFFQ_SFB_XD3_XDFFQ_SFB r0 *1 0,0
Ccc_XD1_XDFFQ_SFB_XD3_XDFFQ_SFB XD1_XDFFQ_SFB XD3_XDFFQ_SFB 1.21e-17
* device instance cc_XD1_XDFFQ_SFB_XD3_XN2_mid1 r0 *1 0,0
Ccc_XD1_XDFFQ_SFB_XD3_XN2_mid1 XD1_XDFFQ_SFB XD3_XN2_mid1 1.21e-17
* device instance cc_XD1_XDFFQ_SFB_XD3_XN3_mid1 r0 *1 0,0
Ccc_XD1_XDFFQ_SFB_XD3_XN3_mid1 XD1_XDFFQ_SFB XD3_XN3_mid1 1.21e-17
* device instance cc_XD1_XDFFQ_SFB_XD3_XN3_mid2 r0 *1 0,0
Ccc_XD1_XDFFQ_SFB_XD3_XN3_mid2 XD1_XDFFQ_SFB XD3_XN3_mid2 1.21e-17
* device instance cc_XD1_XDFFQ_SFB_XD3_dmodout r0 *1 0,0
Ccc_XD1_XDFFQ_SFB_XD3_dmodout XD1_XDFFQ_SFB XD3_dmodout 1.21e-17
* device instance cc_XD1_XDFFQ_SFB_XD3_dq r0 *1 0,0
Ccc_XD1_XDFFQ_SFB_XD3_dq XD1_XDFFQ_SFB XD3_dq 1.8151e-17
* device instance cc_XD1_XDFFQ_SFB_XD3_nm r0 *1 0,0
Ccc_XD1_XDFFQ_SFB_XD3_nm XD1_XDFFQ_SFB XD3_nm 1.21e-17
* device instance cc_XD1_XDFFQ_SFB_XD3_nt r0 *1 0,0
Ccc_XD1_XDFFQ_SFB_XD3_nt XD1_XDFFQ_SFB XD3_nt 1.21e-17
* device instance cc_XD1_XDFFQ_SFB_XD3_t1 r0 *1 0,0
Ccc_XD1_XDFFQ_SFB_XD3_t1 XD1_XDFFQ_SFB XD3_t1 1.21e-17
* device instance cc_XD1_XDFFQ_SFB_XD4_XDFFM_CKBB r0 *1 0,0
Ccc_XD1_XDFFQ_SFB_XD4_XDFFM_CKBB XD1_XDFFQ_SFB XD4_XDFFM_CKBB 1.8151e-17
* device instance cc_XD1_XDFFQ_SFB_XD4_XDFFM_CLKB r0 *1 0,0
Ccc_XD1_XDFFQ_SFB_XD4_XDFFM_CLKB XD1_XDFFQ_SFB XD4_XDFFM_CLKB 2.4201e-17
* device instance cc_XD1_XDFFQ_SFB_XD4_XDFFM_M r0 *1 0,0
Ccc_XD1_XDFFQ_SFB_XD4_XDFFM_M XD1_XDFFQ_SFB XD4_XDFFM_M 2.4201e-17
* device instance cc_XD1_XDFFQ_SFB_XD4_XDFFM_MB r0 *1 0,0
Ccc_XD1_XDFFQ_SFB_XD4_XDFFM_MB XD1_XDFFQ_SFB XD4_XDFFM_MB 1.21e-17
* device instance cc_XD1_XDFFQ_SFB_XD4_XDFFM_MFB r0 *1 0,0
Ccc_XD1_XDFFQ_SFB_XD4_XDFFM_MFB XD1_XDFFQ_SFB XD4_XDFFM_MFB 1.21e-17
* device instance cc_XD1_XDFFQ_SFB_XD4_XDFFM_S r0 *1 0,0
Ccc_XD1_XDFFQ_SFB_XD4_XDFFM_S XD1_XDFFQ_SFB XD4_XDFFM_S 1.8151e-17
* device instance cc_XD1_XDFFQ_SFB_XD4_XDFFM_SB r0 *1 0,0
Ccc_XD1_XDFFQ_SFB_XD4_XDFFM_SB XD1_XDFFQ_SFB XD4_XDFFM_SB 1.8151e-17
* device instance cc_XD1_XDFFQ_SFB_XD4_XDFFM_SFB r0 *1 0,0
Ccc_XD1_XDFFQ_SFB_XD4_XDFFM_SFB XD1_XDFFQ_SFB XD4_XDFFM_SFB 1.21e-17
* device instance cc_XD1_XDFFQ_SFB_XD4_XDFFQ_CKBB r0 *1 0,0
Ccc_XD1_XDFFQ_SFB_XD4_XDFFQ_CKBB XD1_XDFFQ_SFB XD4_XDFFQ_CKBB 1.8151e-17
* device instance cc_XD1_XDFFQ_SFB_XD4_XDFFQ_CLKB r0 *1 0,0
Ccc_XD1_XDFFQ_SFB_XD4_XDFFQ_CLKB XD1_XDFFQ_SFB XD4_XDFFQ_CLKB 2.4201e-17
* device instance cc_XD1_XDFFQ_SFB_XD4_XDFFQ_M r0 *1 0,0
Ccc_XD1_XDFFQ_SFB_XD4_XDFFQ_M XD1_XDFFQ_SFB XD4_XDFFQ_M 2.4201e-17
* device instance cc_XD1_XDFFQ_SFB_XD4_XDFFQ_MB r0 *1 0,0
Ccc_XD1_XDFFQ_SFB_XD4_XDFFQ_MB XD1_XDFFQ_SFB XD4_XDFFQ_MB 1.21e-17
* device instance cc_XD1_XDFFQ_SFB_XD4_XDFFQ_MFB r0 *1 0,0
Ccc_XD1_XDFFQ_SFB_XD4_XDFFQ_MFB XD1_XDFFQ_SFB XD4_XDFFQ_MFB 1.21e-17
* device instance cc_XD1_XDFFQ_SFB_XD4_XDFFQ_S r0 *1 0,0
Ccc_XD1_XDFFQ_SFB_XD4_XDFFQ_S XD1_XDFFQ_SFB XD4_XDFFQ_S 1.8151e-17
* device instance cc_XD1_XDFFQ_SFB_XD4_XDFFQ_SB r0 *1 0,0
Ccc_XD1_XDFFQ_SFB_XD4_XDFFQ_SB XD1_XDFFQ_SFB XD4_XDFFQ_SB 1.8151e-17
* device instance cc_XD1_XDFFQ_SFB_XD4_XDFFQ_SFB r0 *1 0,0
Ccc_XD1_XDFFQ_SFB_XD4_XDFFQ_SFB XD1_XDFFQ_SFB XD4_XDFFQ_SFB 1.21e-17
* device instance cc_XD1_XDFFQ_SFB_XD4_XN2_mid1 r0 *1 0,0
Ccc_XD1_XDFFQ_SFB_XD4_XN2_mid1 XD1_XDFFQ_SFB XD4_XN2_mid1 1.21e-17
* device instance cc_XD1_XDFFQ_SFB_XD4_XN3_mid1 r0 *1 0,0
Ccc_XD1_XDFFQ_SFB_XD4_XN3_mid1 XD1_XDFFQ_SFB XD4_XN3_mid1 1.21e-17
* device instance cc_XD1_XDFFQ_SFB_XD4_XN3_mid2 r0 *1 0,0
Ccc_XD1_XDFFQ_SFB_XD4_XN3_mid2 XD1_XDFFQ_SFB XD4_XN3_mid2 1.21e-17
* device instance cc_XD1_XDFFQ_SFB_XD4_dmodout r0 *1 0,0
Ccc_XD1_XDFFQ_SFB_XD4_dmodout XD1_XDFFQ_SFB XD4_dmodout 1.21e-17
* device instance cc_XD1_XDFFQ_SFB_XD4_dq r0 *1 0,0
Ccc_XD1_XDFFQ_SFB_XD4_dq XD1_XDFFQ_SFB XD4_dq 1.8151e-17
* device instance cc_XD1_XDFFQ_SFB_XD4_nm r0 *1 0,0
Ccc_XD1_XDFFQ_SFB_XD4_nm XD1_XDFFQ_SFB XD4_nm 1.21e-17
* device instance cc_XD1_XDFFQ_SFB_XD4_nt r0 *1 0,0
Ccc_XD1_XDFFQ_SFB_XD4_nt XD1_XDFFQ_SFB XD4_nt 1.21e-17
* device instance cc_XD1_XDFFQ_SFB_XD4_t1 r0 *1 0,0
Ccc_XD1_XDFFQ_SFB_XD4_t1 XD1_XDFFQ_SFB XD4_t1 1.21e-17
* device instance cc_XD1_XDFFQ_SFB_XD5_XDFFM_CKBB r0 *1 0,0
Ccc_XD1_XDFFQ_SFB_XD5_XDFFM_CKBB XD1_XDFFQ_SFB XD5_XDFFM_CKBB 1.8151e-17
* device instance cc_XD1_XDFFQ_SFB_XD5_XDFFM_CLKB r0 *1 0,0
Ccc_XD1_XDFFQ_SFB_XD5_XDFFM_CLKB XD1_XDFFQ_SFB XD5_XDFFM_CLKB 2.4201e-17
* device instance cc_XD1_XDFFQ_SFB_XD5_XDFFM_M r0 *1 0,0
Ccc_XD1_XDFFQ_SFB_XD5_XDFFM_M XD1_XDFFQ_SFB XD5_XDFFM_M 2.4201e-17
* device instance cc_XD1_XDFFQ_SFB_XD5_XDFFM_MB r0 *1 0,0
Ccc_XD1_XDFFQ_SFB_XD5_XDFFM_MB XD1_XDFFQ_SFB XD5_XDFFM_MB 1.21e-17
* device instance cc_XD1_XDFFQ_SFB_XD5_XDFFM_MFB r0 *1 0,0
Ccc_XD1_XDFFQ_SFB_XD5_XDFFM_MFB XD1_XDFFQ_SFB XD5_XDFFM_MFB 1.21e-17
* device instance cc_XD1_XDFFQ_SFB_XD5_XDFFM_S r0 *1 0,0
Ccc_XD1_XDFFQ_SFB_XD5_XDFFM_S XD1_XDFFQ_SFB XD5_XDFFM_S 1.8151e-17
* device instance cc_XD1_XDFFQ_SFB_XD5_XDFFM_SB r0 *1 0,0
Ccc_XD1_XDFFQ_SFB_XD5_XDFFM_SB XD1_XDFFQ_SFB XD5_XDFFM_SB 1.8151e-17
* device instance cc_XD1_XDFFQ_SFB_XD5_XDFFM_SFB r0 *1 0,0
Ccc_XD1_XDFFQ_SFB_XD5_XDFFM_SFB XD1_XDFFQ_SFB XD5_XDFFM_SFB 1.21e-17
* device instance cc_XD1_XDFFQ_SFB_XD5_XDFFQ_CKBB r0 *1 0,0
Ccc_XD1_XDFFQ_SFB_XD5_XDFFQ_CKBB XD1_XDFFQ_SFB XD5_XDFFQ_CKBB 1.8151e-17
* device instance cc_XD1_XDFFQ_SFB_XD5_XDFFQ_CLKB r0 *1 0,0
Ccc_XD1_XDFFQ_SFB_XD5_XDFFQ_CLKB XD1_XDFFQ_SFB XD5_XDFFQ_CLKB 2.4201e-17
* device instance cc_XD1_XDFFQ_SFB_XD5_XDFFQ_M r0 *1 0,0
Ccc_XD1_XDFFQ_SFB_XD5_XDFFQ_M XD1_XDFFQ_SFB XD5_XDFFQ_M 2.4201e-17
* device instance cc_XD1_XDFFQ_SFB_XD5_XDFFQ_MB r0 *1 0,0
Ccc_XD1_XDFFQ_SFB_XD5_XDFFQ_MB XD1_XDFFQ_SFB XD5_XDFFQ_MB 1.21e-17
* device instance cc_XD1_XDFFQ_SFB_XD5_XDFFQ_MFB r0 *1 0,0
Ccc_XD1_XDFFQ_SFB_XD5_XDFFQ_MFB XD1_XDFFQ_SFB XD5_XDFFQ_MFB 1.21e-17
* device instance cc_XD1_XDFFQ_SFB_XD5_XDFFQ_S r0 *1 0,0
Ccc_XD1_XDFFQ_SFB_XD5_XDFFQ_S XD1_XDFFQ_SFB XD5_XDFFQ_S 1.8151e-17
* device instance cc_XD1_XDFFQ_SFB_XD5_XDFFQ_SB r0 *1 0,0
Ccc_XD1_XDFFQ_SFB_XD5_XDFFQ_SB XD1_XDFFQ_SFB XD5_XDFFQ_SB 1.8151e-17
* device instance cc_XD1_XDFFQ_SFB_XD5_XDFFQ_SFB r0 *1 0,0
Ccc_XD1_XDFFQ_SFB_XD5_XDFFQ_SFB XD1_XDFFQ_SFB XD5_XDFFQ_SFB 1.21e-17
* device instance cc_XD1_XDFFQ_SFB_XD5_XN2_mid1 r0 *1 0,0
Ccc_XD1_XDFFQ_SFB_XD5_XN2_mid1 XD1_XDFFQ_SFB XD5_XN2_mid1 1.21e-17
* device instance cc_XD1_XDFFQ_SFB_XD5_XN3_mid1 r0 *1 0,0
Ccc_XD1_XDFFQ_SFB_XD5_XN3_mid1 XD1_XDFFQ_SFB XD5_XN3_mid1 1.21e-17
* device instance cc_XD1_XDFFQ_SFB_XD5_XN3_mid2 r0 *1 0,0
Ccc_XD1_XDFFQ_SFB_XD5_XN3_mid2 XD1_XDFFQ_SFB XD5_XN3_mid2 1.21e-17
* device instance cc_XD1_XDFFQ_SFB_XD5_dmodout r0 *1 0,0
Ccc_XD1_XDFFQ_SFB_XD5_dmodout XD1_XDFFQ_SFB XD5_dmodout 1.21e-17
* device instance cc_XD1_XDFFQ_SFB_XD5_dq r0 *1 0,0
Ccc_XD1_XDFFQ_SFB_XD5_dq XD1_XDFFQ_SFB XD5_dq 1.8151e-17
* device instance cc_XD1_XDFFQ_SFB_XD5_nm r0 *1 0,0
Ccc_XD1_XDFFQ_SFB_XD5_nm XD1_XDFFQ_SFB XD5_nm 1.21e-17
* device instance cc_XD1_XDFFQ_SFB_XD5_nt r0 *1 0,0
Ccc_XD1_XDFFQ_SFB_XD5_nt XD1_XDFFQ_SFB XD5_nt 1.21e-17
* device instance cc_XD1_XDFFQ_SFB_XD5_t1 r0 *1 0,0
Ccc_XD1_XDFFQ_SFB_XD5_t1 XD1_XDFFQ_SFB XD5_t1 1.21e-17
* device instance cc_XD1_XDFFQ_SFB_XFRT_CKBB r0 *1 0,0
Ccc_XD1_XDFFQ_SFB_XFRT_CKBB XD1_XDFFQ_SFB XFRT_CKBB 1.8151e-17
* device instance cc_XD1_XDFFQ_SFB_XFRT_CLKB r0 *1 0,0
Ccc_XD1_XDFFQ_SFB_XFRT_CLKB XD1_XDFFQ_SFB XFRT_CLKB 2.4201e-17
* device instance cc_XD1_XDFFQ_SFB_XFRT_M r0 *1 0,0
Ccc_XD1_XDFFQ_SFB_XFRT_M XD1_XDFFQ_SFB XFRT_M 2.4201e-17
* device instance cc_XD1_XDFFQ_SFB_XFRT_MB r0 *1 0,0
Ccc_XD1_XDFFQ_SFB_XFRT_MB XD1_XDFFQ_SFB XFRT_MB 1.21e-17
* device instance cc_XD1_XDFFQ_SFB_XFRT_MFB r0 *1 0,0
Ccc_XD1_XDFFQ_SFB_XFRT_MFB XD1_XDFFQ_SFB XFRT_MFB 1.21e-17
* device instance cc_XD1_XDFFQ_SFB_XFRT_S r0 *1 0,0
Ccc_XD1_XDFFQ_SFB_XFRT_S XD1_XDFFQ_SFB XFRT_S 1.8151e-17
* device instance cc_XD1_XDFFQ_SFB_XFRT_SB r0 *1 0,0
Ccc_XD1_XDFFQ_SFB_XFRT_SB XD1_XDFFQ_SFB XFRT_SB 1.8151e-17
* device instance cc_XD1_XDFFQ_SFB_XFRT_SFB r0 *1 0,0
Ccc_XD1_XDFFQ_SFB_XFRT_SFB XD1_XDFFQ_SFB XFRT_SFB 1.21e-17
* device instance cc_XD1_XDFFQ_SFB_ck1 r0 *1 0,0
Ccc_XD1_XDFFQ_SFB_ck1 XD1_XDFFQ_SFB ck1 3.0251e-17
* device instance cc_XD1_XDFFQ_SFB_ck2 r0 *1 0,0
Ccc_XD1_XDFFQ_SFB_ck2 XD1_XDFFQ_SFB ck2 3.0251e-17
* device instance cc_XD1_XDFFQ_SFB_ck3 r0 *1 0,0
Ccc_XD1_XDFFQ_SFB_ck3 XD1_XDFFQ_SFB ck3 3.0251e-17
* device instance cc_XD1_XDFFQ_SFB_ck4 r0 *1 0,0
Ccc_XD1_XDFFQ_SFB_ck4 XD1_XDFFQ_SFB ck4 3.0251e-17
* device instance cc_XD1_XDFFQ_SFB_ck5 r0 *1 0,0
Ccc_XD1_XDFFQ_SFB_ck5 XD1_XDFFQ_SFB ck5 3.0251e-17
* device instance cc_XD1_XDFFQ_SFB_mod0 r0 *1 0,0
Ccc_XD1_XDFFQ_SFB_mod0 XD1_XDFFQ_SFB mod0 2.4201e-17
* device instance cc_XD1_XDFFQ_SFB_mod1 r0 *1 0,0
Ccc_XD1_XDFFQ_SFB_mod1 XD1_XDFFQ_SFB mod1 2.4201e-17
* device instance cc_XD1_XDFFQ_SFB_mod2 r0 *1 0,0
Ccc_XD1_XDFFQ_SFB_mod2 XD1_XDFFQ_SFB mod2 2.4201e-17
* device instance cc_XD1_XDFFQ_SFB_mod3 r0 *1 0,0
Ccc_XD1_XDFFQ_SFB_mod3 XD1_XDFFQ_SFB mod3 2.4201e-17
* device instance cc_XD1_XDFFQ_SFB_mod4 r0 *1 0,0
Ccc_XD1_XDFFQ_SFB_mod4 XD1_XDFFQ_SFB mod4 2.4201e-17
* device instance cc_XD1_XDFFQ_SFB_net1 r0 *1 0,0
Ccc_XD1_XDFFQ_SFB_net1 XD1_XDFFQ_SFB net1 1.21e-17
* device instance cc_XD1_XN2_mid1_XD1_nm r0 *1 0,0
Ccc_XD1_XN2_mid1_XD1_nm XD1_XN2_mid1 XD1_nm 1.1294e-17
* device instance cc_XD1_XN2_mid1_ck2 r0 *1 0,0
Ccc_XD1_XN2_mid1_ck2 XD1_XN2_mid1 ck2 6.05e-18
* device instance cc_XD1_XN3_mid1_XD1_XN3_mid2 r0 *1 0,0
Ccc_XD1_XN3_mid1_XD1_XN3_mid2 XD1_XN3_mid1 XD1_XN3_mid2 1.1294e-17
* device instance cc_XD1_XN3_mid1_XD1_nt r0 *1 0,0
Ccc_XD1_XN3_mid1_XD1_nt XD1_XN3_mid1 XD1_nt 1.1294e-17
* device instance cc_XD1_XN3_mid2_mod0 r0 *1 0,0
Ccc_XD1_XN3_mid2_mod0 XD1_XN3_mid2 mod0 6.05e-18
* device instance cc_XD1_XNOR_midp_XD1_dq r0 *1 0,0
Ccc_XD1_XNOR_midp_XD1_dq XD1_XNOR_midp XD1_dq 5.244e-18
* device instance cc_XD1_XNOR_midp_XD1_t1 r0 *1 0,0
Ccc_XD1_XNOR_midp_XD1_t1 XD1_XNOR_midp XD1_t1 6.05e-18
* device instance cc_XD1_dmodout_XD1_dq r0 *1 0,0
Ccc_XD1_dmodout_XD1_dq XD1_dmodout XD1_dq 1.21e-17
* device instance cc_XD1_dmodout_XD1_nm r0 *1 0,0
Ccc_XD1_dmodout_XD1_nm XD1_dmodout XD1_nm 1.8151e-17
* device instance cc_XD1_dmodout_XD1_nt r0 *1 0,0
Ccc_XD1_dmodout_XD1_nt XD1_dmodout XD1_nt 2.4201e-17
* device instance cc_XD1_dmodout_XD1_t1 r0 *1 0,0
Ccc_XD1_dmodout_XD1_t1 XD1_dmodout XD1_t1 1.21e-17
* device instance cc_XD1_dmodout_XD2_XDFFM_CKBB r0 *1 0,0
Ccc_XD1_dmodout_XD2_XDFFM_CKBB XD1_dmodout XD2_XDFFM_CKBB 1.8151e-17
* device instance cc_XD1_dmodout_XD2_XDFFM_CLKB r0 *1 0,0
Ccc_XD1_dmodout_XD2_XDFFM_CLKB XD1_dmodout XD2_XDFFM_CLKB 2.4201e-17
* device instance cc_XD1_dmodout_XD2_XDFFM_M r0 *1 0,0
Ccc_XD1_dmodout_XD2_XDFFM_M XD1_dmodout XD2_XDFFM_M 2.4201e-17
* device instance cc_XD1_dmodout_XD2_XDFFM_MB r0 *1 0,0
Ccc_XD1_dmodout_XD2_XDFFM_MB XD1_dmodout XD2_XDFFM_MB 1.21e-17
* device instance cc_XD1_dmodout_XD2_XDFFM_MFB r0 *1 0,0
Ccc_XD1_dmodout_XD2_XDFFM_MFB XD1_dmodout XD2_XDFFM_MFB 1.21e-17
* device instance cc_XD1_dmodout_XD2_XDFFM_S r0 *1 0,0
Ccc_XD1_dmodout_XD2_XDFFM_S XD1_dmodout XD2_XDFFM_S 1.8151e-17
* device instance cc_XD1_dmodout_XD2_XDFFM_SB r0 *1 0,0
Ccc_XD1_dmodout_XD2_XDFFM_SB XD1_dmodout XD2_XDFFM_SB 1.8151e-17
* device instance cc_XD1_dmodout_XD2_XDFFM_SFB r0 *1 0,0
Ccc_XD1_dmodout_XD2_XDFFM_SFB XD1_dmodout XD2_XDFFM_SFB 1.21e-17
* device instance cc_XD1_dmodout_XD2_XDFFQ_CKBB r0 *1 0,0
Ccc_XD1_dmodout_XD2_XDFFQ_CKBB XD1_dmodout XD2_XDFFQ_CKBB 1.8151e-17
* device instance cc_XD1_dmodout_XD2_XDFFQ_CLKB r0 *1 0,0
Ccc_XD1_dmodout_XD2_XDFFQ_CLKB XD1_dmodout XD2_XDFFQ_CLKB 2.4201e-17
* device instance cc_XD1_dmodout_XD2_XDFFQ_M r0 *1 0,0
Ccc_XD1_dmodout_XD2_XDFFQ_M XD1_dmodout XD2_XDFFQ_M 2.4201e-17
* device instance cc_XD1_dmodout_XD2_XDFFQ_MB r0 *1 0,0
Ccc_XD1_dmodout_XD2_XDFFQ_MB XD1_dmodout XD2_XDFFQ_MB 1.21e-17
* device instance cc_XD1_dmodout_XD2_XDFFQ_MFB r0 *1 0,0
Ccc_XD1_dmodout_XD2_XDFFQ_MFB XD1_dmodout XD2_XDFFQ_MFB 1.21e-17
* device instance cc_XD1_dmodout_XD2_XDFFQ_S r0 *1 0,0
Ccc_XD1_dmodout_XD2_XDFFQ_S XD1_dmodout XD2_XDFFQ_S 1.8151e-17
* device instance cc_XD1_dmodout_XD2_XDFFQ_SB r0 *1 0,0
Ccc_XD1_dmodout_XD2_XDFFQ_SB XD1_dmodout XD2_XDFFQ_SB 1.8151e-17
* device instance cc_XD1_dmodout_XD2_XDFFQ_SFB r0 *1 0,0
Ccc_XD1_dmodout_XD2_XDFFQ_SFB XD1_dmodout XD2_XDFFQ_SFB 1.21e-17
* device instance cc_XD1_dmodout_XD2_XN2_mid1 r0 *1 0,0
Ccc_XD1_dmodout_XD2_XN2_mid1 XD1_dmodout XD2_XN2_mid1 1.21e-17
* device instance cc_XD1_dmodout_XD2_XN3_mid1 r0 *1 0,0
Ccc_XD1_dmodout_XD2_XN3_mid1 XD1_dmodout XD2_XN3_mid1 1.21e-17
* device instance cc_XD1_dmodout_XD2_XN3_mid2 r0 *1 0,0
Ccc_XD1_dmodout_XD2_XN3_mid2 XD1_dmodout XD2_XN3_mid2 1.21e-17
* device instance cc_XD1_dmodout_XD2_dmodout r0 *1 0,0
Ccc_XD1_dmodout_XD2_dmodout XD1_dmodout XD2_dmodout 1.21e-17
* device instance cc_XD1_dmodout_XD2_dq r0 *1 0,0
Ccc_XD1_dmodout_XD2_dq XD1_dmodout XD2_dq 1.8151e-17
* device instance cc_XD1_dmodout_XD2_nm r0 *1 0,0
Ccc_XD1_dmodout_XD2_nm XD1_dmodout XD2_nm 1.21e-17
* device instance cc_XD1_dmodout_XD2_nt r0 *1 0,0
Ccc_XD1_dmodout_XD2_nt XD1_dmodout XD2_nt 1.21e-17
* device instance cc_XD1_dmodout_XD2_t1 r0 *1 0,0
Ccc_XD1_dmodout_XD2_t1 XD1_dmodout XD2_t1 1.21e-17
* device instance cc_XD1_dmodout_XD3_XDFFM_CKBB r0 *1 0,0
Ccc_XD1_dmodout_XD3_XDFFM_CKBB XD1_dmodout XD3_XDFFM_CKBB 1.8151e-17
* device instance cc_XD1_dmodout_XD3_XDFFM_CLKB r0 *1 0,0
Ccc_XD1_dmodout_XD3_XDFFM_CLKB XD1_dmodout XD3_XDFFM_CLKB 2.4201e-17
* device instance cc_XD1_dmodout_XD3_XDFFM_M r0 *1 0,0
Ccc_XD1_dmodout_XD3_XDFFM_M XD1_dmodout XD3_XDFFM_M 2.4201e-17
* device instance cc_XD1_dmodout_XD3_XDFFM_MB r0 *1 0,0
Ccc_XD1_dmodout_XD3_XDFFM_MB XD1_dmodout XD3_XDFFM_MB 1.21e-17
* device instance cc_XD1_dmodout_XD3_XDFFM_MFB r0 *1 0,0
Ccc_XD1_dmodout_XD3_XDFFM_MFB XD1_dmodout XD3_XDFFM_MFB 1.21e-17
* device instance cc_XD1_dmodout_XD3_XDFFM_S r0 *1 0,0
Ccc_XD1_dmodout_XD3_XDFFM_S XD1_dmodout XD3_XDFFM_S 1.8151e-17
* device instance cc_XD1_dmodout_XD3_XDFFM_SB r0 *1 0,0
Ccc_XD1_dmodout_XD3_XDFFM_SB XD1_dmodout XD3_XDFFM_SB 1.8151e-17
* device instance cc_XD1_dmodout_XD3_XDFFM_SFB r0 *1 0,0
Ccc_XD1_dmodout_XD3_XDFFM_SFB XD1_dmodout XD3_XDFFM_SFB 1.21e-17
* device instance cc_XD1_dmodout_XD3_XDFFQ_CKBB r0 *1 0,0
Ccc_XD1_dmodout_XD3_XDFFQ_CKBB XD1_dmodout XD3_XDFFQ_CKBB 1.8151e-17
* device instance cc_XD1_dmodout_XD3_XDFFQ_CLKB r0 *1 0,0
Ccc_XD1_dmodout_XD3_XDFFQ_CLKB XD1_dmodout XD3_XDFFQ_CLKB 2.4201e-17
* device instance cc_XD1_dmodout_XD3_XDFFQ_M r0 *1 0,0
Ccc_XD1_dmodout_XD3_XDFFQ_M XD1_dmodout XD3_XDFFQ_M 2.4201e-17
* device instance cc_XD1_dmodout_XD3_XDFFQ_MB r0 *1 0,0
Ccc_XD1_dmodout_XD3_XDFFQ_MB XD1_dmodout XD3_XDFFQ_MB 1.21e-17
* device instance cc_XD1_dmodout_XD3_XDFFQ_MFB r0 *1 0,0
Ccc_XD1_dmodout_XD3_XDFFQ_MFB XD1_dmodout XD3_XDFFQ_MFB 1.21e-17
* device instance cc_XD1_dmodout_XD3_XDFFQ_S r0 *1 0,0
Ccc_XD1_dmodout_XD3_XDFFQ_S XD1_dmodout XD3_XDFFQ_S 1.8151e-17
* device instance cc_XD1_dmodout_XD3_XDFFQ_SB r0 *1 0,0
Ccc_XD1_dmodout_XD3_XDFFQ_SB XD1_dmodout XD3_XDFFQ_SB 1.8151e-17
* device instance cc_XD1_dmodout_XD3_XDFFQ_SFB r0 *1 0,0
Ccc_XD1_dmodout_XD3_XDFFQ_SFB XD1_dmodout XD3_XDFFQ_SFB 1.21e-17
* device instance cc_XD1_dmodout_XD3_XN2_mid1 r0 *1 0,0
Ccc_XD1_dmodout_XD3_XN2_mid1 XD1_dmodout XD3_XN2_mid1 1.21e-17
* device instance cc_XD1_dmodout_XD3_XN3_mid1 r0 *1 0,0
Ccc_XD1_dmodout_XD3_XN3_mid1 XD1_dmodout XD3_XN3_mid1 1.21e-17
* device instance cc_XD1_dmodout_XD3_XN3_mid2 r0 *1 0,0
Ccc_XD1_dmodout_XD3_XN3_mid2 XD1_dmodout XD3_XN3_mid2 1.21e-17
* device instance cc_XD1_dmodout_XD3_dmodout r0 *1 0,0
Ccc_XD1_dmodout_XD3_dmodout XD1_dmodout XD3_dmodout 1.21e-17
* device instance cc_XD1_dmodout_XD3_dq r0 *1 0,0
Ccc_XD1_dmodout_XD3_dq XD1_dmodout XD3_dq 1.8151e-17
* device instance cc_XD1_dmodout_XD3_nm r0 *1 0,0
Ccc_XD1_dmodout_XD3_nm XD1_dmodout XD3_nm 1.21e-17
* device instance cc_XD1_dmodout_XD3_nt r0 *1 0,0
Ccc_XD1_dmodout_XD3_nt XD1_dmodout XD3_nt 1.21e-17
* device instance cc_XD1_dmodout_XD3_t1 r0 *1 0,0
Ccc_XD1_dmodout_XD3_t1 XD1_dmodout XD3_t1 1.21e-17
* device instance cc_XD1_dmodout_XD4_XDFFM_CKBB r0 *1 0,0
Ccc_XD1_dmodout_XD4_XDFFM_CKBB XD1_dmodout XD4_XDFFM_CKBB 1.8151e-17
* device instance cc_XD1_dmodout_XD4_XDFFM_CLKB r0 *1 0,0
Ccc_XD1_dmodout_XD4_XDFFM_CLKB XD1_dmodout XD4_XDFFM_CLKB 2.4201e-17
* device instance cc_XD1_dmodout_XD4_XDFFM_M r0 *1 0,0
Ccc_XD1_dmodout_XD4_XDFFM_M XD1_dmodout XD4_XDFFM_M 2.4201e-17
* device instance cc_XD1_dmodout_XD4_XDFFM_MB r0 *1 0,0
Ccc_XD1_dmodout_XD4_XDFFM_MB XD1_dmodout XD4_XDFFM_MB 1.21e-17
* device instance cc_XD1_dmodout_XD4_XDFFM_MFB r0 *1 0,0
Ccc_XD1_dmodout_XD4_XDFFM_MFB XD1_dmodout XD4_XDFFM_MFB 1.21e-17
* device instance cc_XD1_dmodout_XD4_XDFFM_S r0 *1 0,0
Ccc_XD1_dmodout_XD4_XDFFM_S XD1_dmodout XD4_XDFFM_S 1.8151e-17
* device instance cc_XD1_dmodout_XD4_XDFFM_SB r0 *1 0,0
Ccc_XD1_dmodout_XD4_XDFFM_SB XD1_dmodout XD4_XDFFM_SB 1.8151e-17
* device instance cc_XD1_dmodout_XD4_XDFFM_SFB r0 *1 0,0
Ccc_XD1_dmodout_XD4_XDFFM_SFB XD1_dmodout XD4_XDFFM_SFB 1.21e-17
* device instance cc_XD1_dmodout_XD4_XDFFQ_CKBB r0 *1 0,0
Ccc_XD1_dmodout_XD4_XDFFQ_CKBB XD1_dmodout XD4_XDFFQ_CKBB 1.8151e-17
* device instance cc_XD1_dmodout_XD4_XDFFQ_CLKB r0 *1 0,0
Ccc_XD1_dmodout_XD4_XDFFQ_CLKB XD1_dmodout XD4_XDFFQ_CLKB 2.4201e-17
* device instance cc_XD1_dmodout_XD4_XDFFQ_M r0 *1 0,0
Ccc_XD1_dmodout_XD4_XDFFQ_M XD1_dmodout XD4_XDFFQ_M 2.4201e-17
* device instance cc_XD1_dmodout_XD4_XDFFQ_MB r0 *1 0,0
Ccc_XD1_dmodout_XD4_XDFFQ_MB XD1_dmodout XD4_XDFFQ_MB 1.21e-17
* device instance cc_XD1_dmodout_XD4_XDFFQ_MFB r0 *1 0,0
Ccc_XD1_dmodout_XD4_XDFFQ_MFB XD1_dmodout XD4_XDFFQ_MFB 1.21e-17
* device instance cc_XD1_dmodout_XD4_XDFFQ_S r0 *1 0,0
Ccc_XD1_dmodout_XD4_XDFFQ_S XD1_dmodout XD4_XDFFQ_S 1.8151e-17
* device instance cc_XD1_dmodout_XD4_XDFFQ_SB r0 *1 0,0
Ccc_XD1_dmodout_XD4_XDFFQ_SB XD1_dmodout XD4_XDFFQ_SB 1.8151e-17
* device instance cc_XD1_dmodout_XD4_XDFFQ_SFB r0 *1 0,0
Ccc_XD1_dmodout_XD4_XDFFQ_SFB XD1_dmodout XD4_XDFFQ_SFB 1.21e-17
* device instance cc_XD1_dmodout_XD4_XN2_mid1 r0 *1 0,0
Ccc_XD1_dmodout_XD4_XN2_mid1 XD1_dmodout XD4_XN2_mid1 1.21e-17
* device instance cc_XD1_dmodout_XD4_XN3_mid1 r0 *1 0,0
Ccc_XD1_dmodout_XD4_XN3_mid1 XD1_dmodout XD4_XN3_mid1 1.21e-17
* device instance cc_XD1_dmodout_XD4_XN3_mid2 r0 *1 0,0
Ccc_XD1_dmodout_XD4_XN3_mid2 XD1_dmodout XD4_XN3_mid2 1.21e-17
* device instance cc_XD1_dmodout_XD4_dmodout r0 *1 0,0
Ccc_XD1_dmodout_XD4_dmodout XD1_dmodout XD4_dmodout 1.21e-17
* device instance cc_XD1_dmodout_XD4_dq r0 *1 0,0
Ccc_XD1_dmodout_XD4_dq XD1_dmodout XD4_dq 1.8151e-17
* device instance cc_XD1_dmodout_XD4_nm r0 *1 0,0
Ccc_XD1_dmodout_XD4_nm XD1_dmodout XD4_nm 1.21e-17
* device instance cc_XD1_dmodout_XD4_nt r0 *1 0,0
Ccc_XD1_dmodout_XD4_nt XD1_dmodout XD4_nt 1.21e-17
* device instance cc_XD1_dmodout_XD4_t1 r0 *1 0,0
Ccc_XD1_dmodout_XD4_t1 XD1_dmodout XD4_t1 1.21e-17
* device instance cc_XD1_dmodout_XD5_XDFFM_CKBB r0 *1 0,0
Ccc_XD1_dmodout_XD5_XDFFM_CKBB XD1_dmodout XD5_XDFFM_CKBB 1.8151e-17
* device instance cc_XD1_dmodout_XD5_XDFFM_CLKB r0 *1 0,0
Ccc_XD1_dmodout_XD5_XDFFM_CLKB XD1_dmodout XD5_XDFFM_CLKB 2.4201e-17
* device instance cc_XD1_dmodout_XD5_XDFFM_M r0 *1 0,0
Ccc_XD1_dmodout_XD5_XDFFM_M XD1_dmodout XD5_XDFFM_M 2.4201e-17
* device instance cc_XD1_dmodout_XD5_XDFFM_MB r0 *1 0,0
Ccc_XD1_dmodout_XD5_XDFFM_MB XD1_dmodout XD5_XDFFM_MB 1.21e-17
* device instance cc_XD1_dmodout_XD5_XDFFM_MFB r0 *1 0,0
Ccc_XD1_dmodout_XD5_XDFFM_MFB XD1_dmodout XD5_XDFFM_MFB 1.21e-17
* device instance cc_XD1_dmodout_XD5_XDFFM_S r0 *1 0,0
Ccc_XD1_dmodout_XD5_XDFFM_S XD1_dmodout XD5_XDFFM_S 1.8151e-17
* device instance cc_XD1_dmodout_XD5_XDFFM_SB r0 *1 0,0
Ccc_XD1_dmodout_XD5_XDFFM_SB XD1_dmodout XD5_XDFFM_SB 1.8151e-17
* device instance cc_XD1_dmodout_XD5_XDFFM_SFB r0 *1 0,0
Ccc_XD1_dmodout_XD5_XDFFM_SFB XD1_dmodout XD5_XDFFM_SFB 1.21e-17
* device instance cc_XD1_dmodout_XD5_XDFFQ_CKBB r0 *1 0,0
Ccc_XD1_dmodout_XD5_XDFFQ_CKBB XD1_dmodout XD5_XDFFQ_CKBB 1.8151e-17
* device instance cc_XD1_dmodout_XD5_XDFFQ_CLKB r0 *1 0,0
Ccc_XD1_dmodout_XD5_XDFFQ_CLKB XD1_dmodout XD5_XDFFQ_CLKB 2.4201e-17
* device instance cc_XD1_dmodout_XD5_XDFFQ_M r0 *1 0,0
Ccc_XD1_dmodout_XD5_XDFFQ_M XD1_dmodout XD5_XDFFQ_M 2.4201e-17
* device instance cc_XD1_dmodout_XD5_XDFFQ_MB r0 *1 0,0
Ccc_XD1_dmodout_XD5_XDFFQ_MB XD1_dmodout XD5_XDFFQ_MB 1.21e-17
* device instance cc_XD1_dmodout_XD5_XDFFQ_MFB r0 *1 0,0
Ccc_XD1_dmodout_XD5_XDFFQ_MFB XD1_dmodout XD5_XDFFQ_MFB 1.21e-17
* device instance cc_XD1_dmodout_XD5_XDFFQ_S r0 *1 0,0
Ccc_XD1_dmodout_XD5_XDFFQ_S XD1_dmodout XD5_XDFFQ_S 1.8151e-17
* device instance cc_XD1_dmodout_XD5_XDFFQ_SB r0 *1 0,0
Ccc_XD1_dmodout_XD5_XDFFQ_SB XD1_dmodout XD5_XDFFQ_SB 1.8151e-17
* device instance cc_XD1_dmodout_XD5_XDFFQ_SFB r0 *1 0,0
Ccc_XD1_dmodout_XD5_XDFFQ_SFB XD1_dmodout XD5_XDFFQ_SFB 1.21e-17
* device instance cc_XD1_dmodout_XD5_XN2_mid1 r0 *1 0,0
Ccc_XD1_dmodout_XD5_XN2_mid1 XD1_dmodout XD5_XN2_mid1 1.21e-17
* device instance cc_XD1_dmodout_XD5_XN3_mid1 r0 *1 0,0
Ccc_XD1_dmodout_XD5_XN3_mid1 XD1_dmodout XD5_XN3_mid1 1.21e-17
* device instance cc_XD1_dmodout_XD5_XN3_mid2 r0 *1 0,0
Ccc_XD1_dmodout_XD5_XN3_mid2 XD1_dmodout XD5_XN3_mid2 1.21e-17
* device instance cc_XD1_dmodout_XD5_dmodout r0 *1 0,0
Ccc_XD1_dmodout_XD5_dmodout XD1_dmodout XD5_dmodout 1.21e-17
* device instance cc_XD1_dmodout_XD5_dq r0 *1 0,0
Ccc_XD1_dmodout_XD5_dq XD1_dmodout XD5_dq 1.8151e-17
* device instance cc_XD1_dmodout_XD5_nm r0 *1 0,0
Ccc_XD1_dmodout_XD5_nm XD1_dmodout XD5_nm 1.21e-17
* device instance cc_XD1_dmodout_XD5_nt r0 *1 0,0
Ccc_XD1_dmodout_XD5_nt XD1_dmodout XD5_nt 1.21e-17
* device instance cc_XD1_dmodout_XD5_t1 r0 *1 0,0
Ccc_XD1_dmodout_XD5_t1 XD1_dmodout XD5_t1 1.21e-17
* device instance cc_XD1_dmodout_XFRT_CKBB r0 *1 0,0
Ccc_XD1_dmodout_XFRT_CKBB XD1_dmodout XFRT_CKBB 1.8151e-17
* device instance cc_XD1_dmodout_XFRT_CLKB r0 *1 0,0
Ccc_XD1_dmodout_XFRT_CLKB XD1_dmodout XFRT_CLKB 2.4201e-17
* device instance cc_XD1_dmodout_XFRT_M r0 *1 0,0
Ccc_XD1_dmodout_XFRT_M XD1_dmodout XFRT_M 2.4201e-17
* device instance cc_XD1_dmodout_XFRT_MB r0 *1 0,0
Ccc_XD1_dmodout_XFRT_MB XD1_dmodout XFRT_MB 1.21e-17
* device instance cc_XD1_dmodout_XFRT_MFB r0 *1 0,0
Ccc_XD1_dmodout_XFRT_MFB XD1_dmodout XFRT_MFB 1.21e-17
* device instance cc_XD1_dmodout_XFRT_S r0 *1 0,0
Ccc_XD1_dmodout_XFRT_S XD1_dmodout XFRT_S 1.8151e-17
* device instance cc_XD1_dmodout_XFRT_SB r0 *1 0,0
Ccc_XD1_dmodout_XFRT_SB XD1_dmodout XFRT_SB 1.8151e-17
* device instance cc_XD1_dmodout_XFRT_SFB r0 *1 0,0
Ccc_XD1_dmodout_XFRT_SFB XD1_dmodout XFRT_SFB 1.21e-17
* device instance cc_XD1_dmodout_ck1 r0 *1 0,0
Ccc_XD1_dmodout_ck1 XD1_dmodout ck1 3.6302e-17
* device instance cc_XD1_dmodout_ck2 r0 *1 0,0
Ccc_XD1_dmodout_ck2 XD1_dmodout ck2 3.0251e-17
* device instance cc_XD1_dmodout_ck3 r0 *1 0,0
Ccc_XD1_dmodout_ck3 XD1_dmodout ck3 3.0251e-17
* device instance cc_XD1_dmodout_ck4 r0 *1 0,0
Ccc_XD1_dmodout_ck4 XD1_dmodout ck4 3.0251e-17
* device instance cc_XD1_dmodout_ck5 r0 *1 0,0
Ccc_XD1_dmodout_ck5 XD1_dmodout ck5 3.0251e-17
* device instance cc_XD1_dmodout_mod0 r0 *1 0,0
Ccc_XD1_dmodout_mod0 XD1_dmodout mod0 2.4201e-17
* device instance cc_XD1_dmodout_mod1 r0 *1 0,0
Ccc_XD1_dmodout_mod1 XD1_dmodout mod1 2.4201e-17
* device instance cc_XD1_dmodout_mod2 r0 *1 0,0
Ccc_XD1_dmodout_mod2 XD1_dmodout mod2 2.4201e-17
* device instance cc_XD1_dmodout_mod3 r0 *1 0,0
Ccc_XD1_dmodout_mod3 XD1_dmodout mod3 2.4201e-17
* device instance cc_XD1_dmodout_mod4 r0 *1 0,0
Ccc_XD1_dmodout_mod4 XD1_dmodout mod4 2.4201e-17
* device instance cc_XD1_dmodout_net1 r0 *1 0,0
Ccc_XD1_dmodout_net1 XD1_dmodout net1 1.21e-17
* device instance cc_XD1_dq_XD1_nm r0 *1 0,0
Ccc_XD1_dq_XD1_nm XD1_dq XD1_nm 1.21e-17
* device instance cc_XD1_dq_XD1_nt r0 *1 0,0
Ccc_XD1_dq_XD1_nt XD1_dq XD1_nt 2.4201e-17
* device instance cc_XD1_dq_XD1_t1 r0 *1 0,0
Ccc_XD1_dq_XD1_t1 XD1_dq XD1_t1 1.8151e-17
* device instance cc_XD1_dq_XD2_XDFFM_CKBB r0 *1 0,0
Ccc_XD1_dq_XD2_XDFFM_CKBB XD1_dq XD2_XDFFM_CKBB 1.8151e-17
* device instance cc_XD1_dq_XD2_XDFFM_CLKB r0 *1 0,0
Ccc_XD1_dq_XD2_XDFFM_CLKB XD1_dq XD2_XDFFM_CLKB 2.4201e-17
* device instance cc_XD1_dq_XD2_XDFFM_M r0 *1 0,0
Ccc_XD1_dq_XD2_XDFFM_M XD1_dq XD2_XDFFM_M 2.4201e-17
* device instance cc_XD1_dq_XD2_XDFFM_MB r0 *1 0,0
Ccc_XD1_dq_XD2_XDFFM_MB XD1_dq XD2_XDFFM_MB 1.21e-17
* device instance cc_XD1_dq_XD2_XDFFM_MFB r0 *1 0,0
Ccc_XD1_dq_XD2_XDFFM_MFB XD1_dq XD2_XDFFM_MFB 1.21e-17
* device instance cc_XD1_dq_XD2_XDFFM_S r0 *1 0,0
Ccc_XD1_dq_XD2_XDFFM_S XD1_dq XD2_XDFFM_S 1.8151e-17
* device instance cc_XD1_dq_XD2_XDFFM_SB r0 *1 0,0
Ccc_XD1_dq_XD2_XDFFM_SB XD1_dq XD2_XDFFM_SB 1.8151e-17
* device instance cc_XD1_dq_XD2_XDFFM_SFB r0 *1 0,0
Ccc_XD1_dq_XD2_XDFFM_SFB XD1_dq XD2_XDFFM_SFB 1.21e-17
* device instance cc_XD1_dq_XD2_XDFFQ_CKBB r0 *1 0,0
Ccc_XD1_dq_XD2_XDFFQ_CKBB XD1_dq XD2_XDFFQ_CKBB 1.8151e-17
* device instance cc_XD1_dq_XD2_XDFFQ_CLKB r0 *1 0,0
Ccc_XD1_dq_XD2_XDFFQ_CLKB XD1_dq XD2_XDFFQ_CLKB 2.4201e-17
* device instance cc_XD1_dq_XD2_XDFFQ_M r0 *1 0,0
Ccc_XD1_dq_XD2_XDFFQ_M XD1_dq XD2_XDFFQ_M 2.4201e-17
* device instance cc_XD1_dq_XD2_XDFFQ_MB r0 *1 0,0
Ccc_XD1_dq_XD2_XDFFQ_MB XD1_dq XD2_XDFFQ_MB 1.21e-17
* device instance cc_XD1_dq_XD2_XDFFQ_MFB r0 *1 0,0
Ccc_XD1_dq_XD2_XDFFQ_MFB XD1_dq XD2_XDFFQ_MFB 1.21e-17
* device instance cc_XD1_dq_XD2_XDFFQ_S r0 *1 0,0
Ccc_XD1_dq_XD2_XDFFQ_S XD1_dq XD2_XDFFQ_S 1.8151e-17
* device instance cc_XD1_dq_XD2_XDFFQ_SB r0 *1 0,0
Ccc_XD1_dq_XD2_XDFFQ_SB XD1_dq XD2_XDFFQ_SB 1.8151e-17
* device instance cc_XD1_dq_XD2_XDFFQ_SFB r0 *1 0,0
Ccc_XD1_dq_XD2_XDFFQ_SFB XD1_dq XD2_XDFFQ_SFB 1.21e-17
* device instance cc_XD1_dq_XD2_XN2_mid1 r0 *1 0,0
Ccc_XD1_dq_XD2_XN2_mid1 XD1_dq XD2_XN2_mid1 1.21e-17
* device instance cc_XD1_dq_XD2_XN3_mid1 r0 *1 0,0
Ccc_XD1_dq_XD2_XN3_mid1 XD1_dq XD2_XN3_mid1 1.21e-17
* device instance cc_XD1_dq_XD2_XN3_mid2 r0 *1 0,0
Ccc_XD1_dq_XD2_XN3_mid2 XD1_dq XD2_XN3_mid2 1.21e-17
* device instance cc_XD1_dq_XD2_dmodout r0 *1 0,0
Ccc_XD1_dq_XD2_dmodout XD1_dq XD2_dmodout 1.21e-17
* device instance cc_XD1_dq_XD2_dq r0 *1 0,0
Ccc_XD1_dq_XD2_dq XD1_dq XD2_dq 1.8151e-17
* device instance cc_XD1_dq_XD2_nm r0 *1 0,0
Ccc_XD1_dq_XD2_nm XD1_dq XD2_nm 1.21e-17
* device instance cc_XD1_dq_XD2_nt r0 *1 0,0
Ccc_XD1_dq_XD2_nt XD1_dq XD2_nt 1.21e-17
* device instance cc_XD1_dq_XD2_t1 r0 *1 0,0
Ccc_XD1_dq_XD2_t1 XD1_dq XD2_t1 1.21e-17
* device instance cc_XD1_dq_XD3_XDFFM_CKBB r0 *1 0,0
Ccc_XD1_dq_XD3_XDFFM_CKBB XD1_dq XD3_XDFFM_CKBB 1.8151e-17
* device instance cc_XD1_dq_XD3_XDFFM_CLKB r0 *1 0,0
Ccc_XD1_dq_XD3_XDFFM_CLKB XD1_dq XD3_XDFFM_CLKB 2.4201e-17
* device instance cc_XD1_dq_XD3_XDFFM_M r0 *1 0,0
Ccc_XD1_dq_XD3_XDFFM_M XD1_dq XD3_XDFFM_M 2.4201e-17
* device instance cc_XD1_dq_XD3_XDFFM_MB r0 *1 0,0
Ccc_XD1_dq_XD3_XDFFM_MB XD1_dq XD3_XDFFM_MB 1.21e-17
* device instance cc_XD1_dq_XD3_XDFFM_MFB r0 *1 0,0
Ccc_XD1_dq_XD3_XDFFM_MFB XD1_dq XD3_XDFFM_MFB 1.21e-17
* device instance cc_XD1_dq_XD3_XDFFM_S r0 *1 0,0
Ccc_XD1_dq_XD3_XDFFM_S XD1_dq XD3_XDFFM_S 1.8151e-17
* device instance cc_XD1_dq_XD3_XDFFM_SB r0 *1 0,0
Ccc_XD1_dq_XD3_XDFFM_SB XD1_dq XD3_XDFFM_SB 1.8151e-17
* device instance cc_XD1_dq_XD3_XDFFM_SFB r0 *1 0,0
Ccc_XD1_dq_XD3_XDFFM_SFB XD1_dq XD3_XDFFM_SFB 1.21e-17
* device instance cc_XD1_dq_XD3_XDFFQ_CKBB r0 *1 0,0
Ccc_XD1_dq_XD3_XDFFQ_CKBB XD1_dq XD3_XDFFQ_CKBB 1.8151e-17
* device instance cc_XD1_dq_XD3_XDFFQ_CLKB r0 *1 0,0
Ccc_XD1_dq_XD3_XDFFQ_CLKB XD1_dq XD3_XDFFQ_CLKB 2.4201e-17
* device instance cc_XD1_dq_XD3_XDFFQ_M r0 *1 0,0
Ccc_XD1_dq_XD3_XDFFQ_M XD1_dq XD3_XDFFQ_M 2.4201e-17
* device instance cc_XD1_dq_XD3_XDFFQ_MB r0 *1 0,0
Ccc_XD1_dq_XD3_XDFFQ_MB XD1_dq XD3_XDFFQ_MB 1.21e-17
* device instance cc_XD1_dq_XD3_XDFFQ_MFB r0 *1 0,0
Ccc_XD1_dq_XD3_XDFFQ_MFB XD1_dq XD3_XDFFQ_MFB 1.21e-17
* device instance cc_XD1_dq_XD3_XDFFQ_S r0 *1 0,0
Ccc_XD1_dq_XD3_XDFFQ_S XD1_dq XD3_XDFFQ_S 1.8151e-17
* device instance cc_XD1_dq_XD3_XDFFQ_SB r0 *1 0,0
Ccc_XD1_dq_XD3_XDFFQ_SB XD1_dq XD3_XDFFQ_SB 1.8151e-17
* device instance cc_XD1_dq_XD3_XDFFQ_SFB r0 *1 0,0
Ccc_XD1_dq_XD3_XDFFQ_SFB XD1_dq XD3_XDFFQ_SFB 1.21e-17
* device instance cc_XD1_dq_XD3_XN2_mid1 r0 *1 0,0
Ccc_XD1_dq_XD3_XN2_mid1 XD1_dq XD3_XN2_mid1 1.21e-17
* device instance cc_XD1_dq_XD3_XN3_mid1 r0 *1 0,0
Ccc_XD1_dq_XD3_XN3_mid1 XD1_dq XD3_XN3_mid1 1.21e-17
* device instance cc_XD1_dq_XD3_XN3_mid2 r0 *1 0,0
Ccc_XD1_dq_XD3_XN3_mid2 XD1_dq XD3_XN3_mid2 1.21e-17
* device instance cc_XD1_dq_XD3_dmodout r0 *1 0,0
Ccc_XD1_dq_XD3_dmodout XD1_dq XD3_dmodout 1.21e-17
* device instance cc_XD1_dq_XD3_dq r0 *1 0,0
Ccc_XD1_dq_XD3_dq XD1_dq XD3_dq 1.8151e-17
* device instance cc_XD1_dq_XD3_nm r0 *1 0,0
Ccc_XD1_dq_XD3_nm XD1_dq XD3_nm 1.21e-17
* device instance cc_XD1_dq_XD3_nt r0 *1 0,0
Ccc_XD1_dq_XD3_nt XD1_dq XD3_nt 1.21e-17
* device instance cc_XD1_dq_XD3_t1 r0 *1 0,0
Ccc_XD1_dq_XD3_t1 XD1_dq XD3_t1 1.21e-17
* device instance cc_XD1_dq_XD4_XDFFM_CKBB r0 *1 0,0
Ccc_XD1_dq_XD4_XDFFM_CKBB XD1_dq XD4_XDFFM_CKBB 1.8151e-17
* device instance cc_XD1_dq_XD4_XDFFM_CLKB r0 *1 0,0
Ccc_XD1_dq_XD4_XDFFM_CLKB XD1_dq XD4_XDFFM_CLKB 2.4201e-17
* device instance cc_XD1_dq_XD4_XDFFM_M r0 *1 0,0
Ccc_XD1_dq_XD4_XDFFM_M XD1_dq XD4_XDFFM_M 2.4201e-17
* device instance cc_XD1_dq_XD4_XDFFM_MB r0 *1 0,0
Ccc_XD1_dq_XD4_XDFFM_MB XD1_dq XD4_XDFFM_MB 1.21e-17
* device instance cc_XD1_dq_XD4_XDFFM_MFB r0 *1 0,0
Ccc_XD1_dq_XD4_XDFFM_MFB XD1_dq XD4_XDFFM_MFB 1.21e-17
* device instance cc_XD1_dq_XD4_XDFFM_S r0 *1 0,0
Ccc_XD1_dq_XD4_XDFFM_S XD1_dq XD4_XDFFM_S 1.8151e-17
* device instance cc_XD1_dq_XD4_XDFFM_SB r0 *1 0,0
Ccc_XD1_dq_XD4_XDFFM_SB XD1_dq XD4_XDFFM_SB 1.8151e-17
* device instance cc_XD1_dq_XD4_XDFFM_SFB r0 *1 0,0
Ccc_XD1_dq_XD4_XDFFM_SFB XD1_dq XD4_XDFFM_SFB 1.21e-17
* device instance cc_XD1_dq_XD4_XDFFQ_CKBB r0 *1 0,0
Ccc_XD1_dq_XD4_XDFFQ_CKBB XD1_dq XD4_XDFFQ_CKBB 1.8151e-17
* device instance cc_XD1_dq_XD4_XDFFQ_CLKB r0 *1 0,0
Ccc_XD1_dq_XD4_XDFFQ_CLKB XD1_dq XD4_XDFFQ_CLKB 2.4201e-17
* device instance cc_XD1_dq_XD4_XDFFQ_M r0 *1 0,0
Ccc_XD1_dq_XD4_XDFFQ_M XD1_dq XD4_XDFFQ_M 2.4201e-17
* device instance cc_XD1_dq_XD4_XDFFQ_MB r0 *1 0,0
Ccc_XD1_dq_XD4_XDFFQ_MB XD1_dq XD4_XDFFQ_MB 1.21e-17
* device instance cc_XD1_dq_XD4_XDFFQ_MFB r0 *1 0,0
Ccc_XD1_dq_XD4_XDFFQ_MFB XD1_dq XD4_XDFFQ_MFB 1.21e-17
* device instance cc_XD1_dq_XD4_XDFFQ_S r0 *1 0,0
Ccc_XD1_dq_XD4_XDFFQ_S XD1_dq XD4_XDFFQ_S 1.8151e-17
* device instance cc_XD1_dq_XD4_XDFFQ_SB r0 *1 0,0
Ccc_XD1_dq_XD4_XDFFQ_SB XD1_dq XD4_XDFFQ_SB 1.8151e-17
* device instance cc_XD1_dq_XD4_XDFFQ_SFB r0 *1 0,0
Ccc_XD1_dq_XD4_XDFFQ_SFB XD1_dq XD4_XDFFQ_SFB 1.21e-17
* device instance cc_XD1_dq_XD4_XN2_mid1 r0 *1 0,0
Ccc_XD1_dq_XD4_XN2_mid1 XD1_dq XD4_XN2_mid1 1.21e-17
* device instance cc_XD1_dq_XD4_XN3_mid1 r0 *1 0,0
Ccc_XD1_dq_XD4_XN3_mid1 XD1_dq XD4_XN3_mid1 1.21e-17
* device instance cc_XD1_dq_XD4_XN3_mid2 r0 *1 0,0
Ccc_XD1_dq_XD4_XN3_mid2 XD1_dq XD4_XN3_mid2 1.21e-17
* device instance cc_XD1_dq_XD4_dmodout r0 *1 0,0
Ccc_XD1_dq_XD4_dmodout XD1_dq XD4_dmodout 1.21e-17
* device instance cc_XD1_dq_XD4_dq r0 *1 0,0
Ccc_XD1_dq_XD4_dq XD1_dq XD4_dq 1.8151e-17
* device instance cc_XD1_dq_XD4_nm r0 *1 0,0
Ccc_XD1_dq_XD4_nm XD1_dq XD4_nm 1.21e-17
* device instance cc_XD1_dq_XD4_nt r0 *1 0,0
Ccc_XD1_dq_XD4_nt XD1_dq XD4_nt 1.21e-17
* device instance cc_XD1_dq_XD4_t1 r0 *1 0,0
Ccc_XD1_dq_XD4_t1 XD1_dq XD4_t1 1.21e-17
* device instance cc_XD1_dq_XD5_XDFFM_CKBB r0 *1 0,0
Ccc_XD1_dq_XD5_XDFFM_CKBB XD1_dq XD5_XDFFM_CKBB 1.8151e-17
* device instance cc_XD1_dq_XD5_XDFFM_CLKB r0 *1 0,0
Ccc_XD1_dq_XD5_XDFFM_CLKB XD1_dq XD5_XDFFM_CLKB 2.4201e-17
* device instance cc_XD1_dq_XD5_XDFFM_M r0 *1 0,0
Ccc_XD1_dq_XD5_XDFFM_M XD1_dq XD5_XDFFM_M 2.4201e-17
* device instance cc_XD1_dq_XD5_XDFFM_MB r0 *1 0,0
Ccc_XD1_dq_XD5_XDFFM_MB XD1_dq XD5_XDFFM_MB 1.21e-17
* device instance cc_XD1_dq_XD5_XDFFM_MFB r0 *1 0,0
Ccc_XD1_dq_XD5_XDFFM_MFB XD1_dq XD5_XDFFM_MFB 1.21e-17
* device instance cc_XD1_dq_XD5_XDFFM_S r0 *1 0,0
Ccc_XD1_dq_XD5_XDFFM_S XD1_dq XD5_XDFFM_S 1.8151e-17
* device instance cc_XD1_dq_XD5_XDFFM_SB r0 *1 0,0
Ccc_XD1_dq_XD5_XDFFM_SB XD1_dq XD5_XDFFM_SB 1.8151e-17
* device instance cc_XD1_dq_XD5_XDFFM_SFB r0 *1 0,0
Ccc_XD1_dq_XD5_XDFFM_SFB XD1_dq XD5_XDFFM_SFB 1.21e-17
* device instance cc_XD1_dq_XD5_XDFFQ_CKBB r0 *1 0,0
Ccc_XD1_dq_XD5_XDFFQ_CKBB XD1_dq XD5_XDFFQ_CKBB 1.8151e-17
* device instance cc_XD1_dq_XD5_XDFFQ_CLKB r0 *1 0,0
Ccc_XD1_dq_XD5_XDFFQ_CLKB XD1_dq XD5_XDFFQ_CLKB 2.4201e-17
* device instance cc_XD1_dq_XD5_XDFFQ_M r0 *1 0,0
Ccc_XD1_dq_XD5_XDFFQ_M XD1_dq XD5_XDFFQ_M 2.4201e-17
* device instance cc_XD1_dq_XD5_XDFFQ_MB r0 *1 0,0
Ccc_XD1_dq_XD5_XDFFQ_MB XD1_dq XD5_XDFFQ_MB 1.21e-17
* device instance cc_XD1_dq_XD5_XDFFQ_MFB r0 *1 0,0
Ccc_XD1_dq_XD5_XDFFQ_MFB XD1_dq XD5_XDFFQ_MFB 1.21e-17
* device instance cc_XD1_dq_XD5_XDFFQ_S r0 *1 0,0
Ccc_XD1_dq_XD5_XDFFQ_S XD1_dq XD5_XDFFQ_S 1.8151e-17
* device instance cc_XD1_dq_XD5_XDFFQ_SB r0 *1 0,0
Ccc_XD1_dq_XD5_XDFFQ_SB XD1_dq XD5_XDFFQ_SB 1.8151e-17
* device instance cc_XD1_dq_XD5_XDFFQ_SFB r0 *1 0,0
Ccc_XD1_dq_XD5_XDFFQ_SFB XD1_dq XD5_XDFFQ_SFB 1.21e-17
* device instance cc_XD1_dq_XD5_XN2_mid1 r0 *1 0,0
Ccc_XD1_dq_XD5_XN2_mid1 XD1_dq XD5_XN2_mid1 1.21e-17
* device instance cc_XD1_dq_XD5_XN3_mid1 r0 *1 0,0
Ccc_XD1_dq_XD5_XN3_mid1 XD1_dq XD5_XN3_mid1 1.21e-17
* device instance cc_XD1_dq_XD5_XN3_mid2 r0 *1 0,0
Ccc_XD1_dq_XD5_XN3_mid2 XD1_dq XD5_XN3_mid2 1.21e-17
* device instance cc_XD1_dq_XD5_dmodout r0 *1 0,0
Ccc_XD1_dq_XD5_dmodout XD1_dq XD5_dmodout 1.21e-17
* device instance cc_XD1_dq_XD5_dq r0 *1 0,0
Ccc_XD1_dq_XD5_dq XD1_dq XD5_dq 1.8151e-17
* device instance cc_XD1_dq_XD5_nm r0 *1 0,0
Ccc_XD1_dq_XD5_nm XD1_dq XD5_nm 1.21e-17
* device instance cc_XD1_dq_XD5_nt r0 *1 0,0
Ccc_XD1_dq_XD5_nt XD1_dq XD5_nt 1.21e-17
* device instance cc_XD1_dq_XD5_t1 r0 *1 0,0
Ccc_XD1_dq_XD5_t1 XD1_dq XD5_t1 1.21e-17
* device instance cc_XD1_dq_XFRT_CKBB r0 *1 0,0
Ccc_XD1_dq_XFRT_CKBB XD1_dq XFRT_CKBB 1.8151e-17
* device instance cc_XD1_dq_XFRT_CLKB r0 *1 0,0
Ccc_XD1_dq_XFRT_CLKB XD1_dq XFRT_CLKB 2.4201e-17
* device instance cc_XD1_dq_XFRT_M r0 *1 0,0
Ccc_XD1_dq_XFRT_M XD1_dq XFRT_M 2.4201e-17
* device instance cc_XD1_dq_XFRT_MB r0 *1 0,0
Ccc_XD1_dq_XFRT_MB XD1_dq XFRT_MB 1.21e-17
* device instance cc_XD1_dq_XFRT_MFB r0 *1 0,0
Ccc_XD1_dq_XFRT_MFB XD1_dq XFRT_MFB 1.21e-17
* device instance cc_XD1_dq_XFRT_S r0 *1 0,0
Ccc_XD1_dq_XFRT_S XD1_dq XFRT_S 1.8151e-17
* device instance cc_XD1_dq_XFRT_SB r0 *1 0,0
Ccc_XD1_dq_XFRT_SB XD1_dq XFRT_SB 1.8151e-17
* device instance cc_XD1_dq_XFRT_SFB r0 *1 0,0
Ccc_XD1_dq_XFRT_SFB XD1_dq XFRT_SFB 1.21e-17
* device instance cc_XD1_dq_ck1 r0 *1 0,0
Ccc_XD1_dq_ck1 XD1_dq ck1 3.6302e-17
* device instance cc_XD1_dq_ck2 r0 *1 0,0
Ccc_XD1_dq_ck2 XD1_dq ck2 3.0251e-17
* device instance cc_XD1_dq_ck3 r0 *1 0,0
Ccc_XD1_dq_ck3 XD1_dq ck3 3.0251e-17
* device instance cc_XD1_dq_ck4 r0 *1 0,0
Ccc_XD1_dq_ck4 XD1_dq ck4 3.0251e-17
* device instance cc_XD1_dq_ck5 r0 *1 0,0
Ccc_XD1_dq_ck5 XD1_dq ck5 3.0251e-17
* device instance cc_XD1_dq_mod0 r0 *1 0,0
Ccc_XD1_dq_mod0 XD1_dq mod0 2.4201e-17
* device instance cc_XD1_dq_mod1 r0 *1 0,0
Ccc_XD1_dq_mod1 XD1_dq mod1 2.4201e-17
* device instance cc_XD1_dq_mod2 r0 *1 0,0
Ccc_XD1_dq_mod2 XD1_dq mod2 2.4201e-17
* device instance cc_XD1_dq_mod3 r0 *1 0,0
Ccc_XD1_dq_mod3 XD1_dq mod3 2.4201e-17
* device instance cc_XD1_dq_mod4 r0 *1 0,0
Ccc_XD1_dq_mod4 XD1_dq mod4 2.4201e-17
* device instance cc_XD1_dq_net1 r0 *1 0,0
Ccc_XD1_dq_net1 XD1_dq net1 1.21e-17
* device instance cc_XD1_nm_XD1_nt r0 *1 0,0
Ccc_XD1_nm_XD1_nt XD1_nm XD1_nt 2.4201e-17
* device instance cc_XD1_nm_XD1_t1 r0 *1 0,0
Ccc_XD1_nm_XD1_t1 XD1_nm XD1_t1 1.21e-17
* device instance cc_XD1_nm_XD2_XDFFM_CKBB r0 *1 0,0
Ccc_XD1_nm_XD2_XDFFM_CKBB XD1_nm XD2_XDFFM_CKBB 1.8151e-17
* device instance cc_XD1_nm_XD2_XDFFM_CLKB r0 *1 0,0
Ccc_XD1_nm_XD2_XDFFM_CLKB XD1_nm XD2_XDFFM_CLKB 2.4201e-17
* device instance cc_XD1_nm_XD2_XDFFM_M r0 *1 0,0
Ccc_XD1_nm_XD2_XDFFM_M XD1_nm XD2_XDFFM_M 2.4201e-17
* device instance cc_XD1_nm_XD2_XDFFM_MB r0 *1 0,0
Ccc_XD1_nm_XD2_XDFFM_MB XD1_nm XD2_XDFFM_MB 1.21e-17
* device instance cc_XD1_nm_XD2_XDFFM_MFB r0 *1 0,0
Ccc_XD1_nm_XD2_XDFFM_MFB XD1_nm XD2_XDFFM_MFB 1.21e-17
* device instance cc_XD1_nm_XD2_XDFFM_S r0 *1 0,0
Ccc_XD1_nm_XD2_XDFFM_S XD1_nm XD2_XDFFM_S 1.8151e-17
* device instance cc_XD1_nm_XD2_XDFFM_SB r0 *1 0,0
Ccc_XD1_nm_XD2_XDFFM_SB XD1_nm XD2_XDFFM_SB 1.8151e-17
* device instance cc_XD1_nm_XD2_XDFFM_SFB r0 *1 0,0
Ccc_XD1_nm_XD2_XDFFM_SFB XD1_nm XD2_XDFFM_SFB 1.21e-17
* device instance cc_XD1_nm_XD2_XDFFQ_CKBB r0 *1 0,0
Ccc_XD1_nm_XD2_XDFFQ_CKBB XD1_nm XD2_XDFFQ_CKBB 1.8151e-17
* device instance cc_XD1_nm_XD2_XDFFQ_CLKB r0 *1 0,0
Ccc_XD1_nm_XD2_XDFFQ_CLKB XD1_nm XD2_XDFFQ_CLKB 2.4201e-17
* device instance cc_XD1_nm_XD2_XDFFQ_M r0 *1 0,0
Ccc_XD1_nm_XD2_XDFFQ_M XD1_nm XD2_XDFFQ_M 2.4201e-17
* device instance cc_XD1_nm_XD2_XDFFQ_MB r0 *1 0,0
Ccc_XD1_nm_XD2_XDFFQ_MB XD1_nm XD2_XDFFQ_MB 1.21e-17
* device instance cc_XD1_nm_XD2_XDFFQ_MFB r0 *1 0,0
Ccc_XD1_nm_XD2_XDFFQ_MFB XD1_nm XD2_XDFFQ_MFB 1.21e-17
* device instance cc_XD1_nm_XD2_XDFFQ_S r0 *1 0,0
Ccc_XD1_nm_XD2_XDFFQ_S XD1_nm XD2_XDFFQ_S 1.8151e-17
* device instance cc_XD1_nm_XD2_XDFFQ_SB r0 *1 0,0
Ccc_XD1_nm_XD2_XDFFQ_SB XD1_nm XD2_XDFFQ_SB 1.8151e-17
* device instance cc_XD1_nm_XD2_XDFFQ_SFB r0 *1 0,0
Ccc_XD1_nm_XD2_XDFFQ_SFB XD1_nm XD2_XDFFQ_SFB 1.21e-17
* device instance cc_XD1_nm_XD2_XN2_mid1 r0 *1 0,0
Ccc_XD1_nm_XD2_XN2_mid1 XD1_nm XD2_XN2_mid1 1.21e-17
* device instance cc_XD1_nm_XD2_XN3_mid1 r0 *1 0,0
Ccc_XD1_nm_XD2_XN3_mid1 XD1_nm XD2_XN3_mid1 1.21e-17
* device instance cc_XD1_nm_XD2_XN3_mid2 r0 *1 0,0
Ccc_XD1_nm_XD2_XN3_mid2 XD1_nm XD2_XN3_mid2 1.21e-17
* device instance cc_XD1_nm_XD2_dmodout r0 *1 0,0
Ccc_XD1_nm_XD2_dmodout XD1_nm XD2_dmodout 1.21e-17
* device instance cc_XD1_nm_XD2_dq r0 *1 0,0
Ccc_XD1_nm_XD2_dq XD1_nm XD2_dq 1.8151e-17
* device instance cc_XD1_nm_XD2_nm r0 *1 0,0
Ccc_XD1_nm_XD2_nm XD1_nm XD2_nm 1.21e-17
* device instance cc_XD1_nm_XD2_nt r0 *1 0,0
Ccc_XD1_nm_XD2_nt XD1_nm XD2_nt 1.21e-17
* device instance cc_XD1_nm_XD2_t1 r0 *1 0,0
Ccc_XD1_nm_XD2_t1 XD1_nm XD2_t1 1.21e-17
* device instance cc_XD1_nm_XD3_XDFFM_CKBB r0 *1 0,0
Ccc_XD1_nm_XD3_XDFFM_CKBB XD1_nm XD3_XDFFM_CKBB 1.8151e-17
* device instance cc_XD1_nm_XD3_XDFFM_CLKB r0 *1 0,0
Ccc_XD1_nm_XD3_XDFFM_CLKB XD1_nm XD3_XDFFM_CLKB 2.4201e-17
* device instance cc_XD1_nm_XD3_XDFFM_M r0 *1 0,0
Ccc_XD1_nm_XD3_XDFFM_M XD1_nm XD3_XDFFM_M 2.4201e-17
* device instance cc_XD1_nm_XD3_XDFFM_MB r0 *1 0,0
Ccc_XD1_nm_XD3_XDFFM_MB XD1_nm XD3_XDFFM_MB 1.21e-17
* device instance cc_XD1_nm_XD3_XDFFM_MFB r0 *1 0,0
Ccc_XD1_nm_XD3_XDFFM_MFB XD1_nm XD3_XDFFM_MFB 1.21e-17
* device instance cc_XD1_nm_XD3_XDFFM_S r0 *1 0,0
Ccc_XD1_nm_XD3_XDFFM_S XD1_nm XD3_XDFFM_S 1.8151e-17
* device instance cc_XD1_nm_XD3_XDFFM_SB r0 *1 0,0
Ccc_XD1_nm_XD3_XDFFM_SB XD1_nm XD3_XDFFM_SB 1.8151e-17
* device instance cc_XD1_nm_XD3_XDFFM_SFB r0 *1 0,0
Ccc_XD1_nm_XD3_XDFFM_SFB XD1_nm XD3_XDFFM_SFB 1.21e-17
* device instance cc_XD1_nm_XD3_XDFFQ_CKBB r0 *1 0,0
Ccc_XD1_nm_XD3_XDFFQ_CKBB XD1_nm XD3_XDFFQ_CKBB 1.8151e-17
* device instance cc_XD1_nm_XD3_XDFFQ_CLKB r0 *1 0,0
Ccc_XD1_nm_XD3_XDFFQ_CLKB XD1_nm XD3_XDFFQ_CLKB 2.4201e-17
* device instance cc_XD1_nm_XD3_XDFFQ_M r0 *1 0,0
Ccc_XD1_nm_XD3_XDFFQ_M XD1_nm XD3_XDFFQ_M 2.4201e-17
* device instance cc_XD1_nm_XD3_XDFFQ_MB r0 *1 0,0
Ccc_XD1_nm_XD3_XDFFQ_MB XD1_nm XD3_XDFFQ_MB 1.21e-17
* device instance cc_XD1_nm_XD3_XDFFQ_MFB r0 *1 0,0
Ccc_XD1_nm_XD3_XDFFQ_MFB XD1_nm XD3_XDFFQ_MFB 1.21e-17
* device instance cc_XD1_nm_XD3_XDFFQ_S r0 *1 0,0
Ccc_XD1_nm_XD3_XDFFQ_S XD1_nm XD3_XDFFQ_S 1.8151e-17
* device instance cc_XD1_nm_XD3_XDFFQ_SB r0 *1 0,0
Ccc_XD1_nm_XD3_XDFFQ_SB XD1_nm XD3_XDFFQ_SB 1.8151e-17
* device instance cc_XD1_nm_XD3_XDFFQ_SFB r0 *1 0,0
Ccc_XD1_nm_XD3_XDFFQ_SFB XD1_nm XD3_XDFFQ_SFB 1.21e-17
* device instance cc_XD1_nm_XD3_XN2_mid1 r0 *1 0,0
Ccc_XD1_nm_XD3_XN2_mid1 XD1_nm XD3_XN2_mid1 1.21e-17
* device instance cc_XD1_nm_XD3_XN3_mid1 r0 *1 0,0
Ccc_XD1_nm_XD3_XN3_mid1 XD1_nm XD3_XN3_mid1 1.21e-17
* device instance cc_XD1_nm_XD3_XN3_mid2 r0 *1 0,0
Ccc_XD1_nm_XD3_XN3_mid2 XD1_nm XD3_XN3_mid2 1.21e-17
* device instance cc_XD1_nm_XD3_dmodout r0 *1 0,0
Ccc_XD1_nm_XD3_dmodout XD1_nm XD3_dmodout 1.21e-17
* device instance cc_XD1_nm_XD3_dq r0 *1 0,0
Ccc_XD1_nm_XD3_dq XD1_nm XD3_dq 1.8151e-17
* device instance cc_XD1_nm_XD3_nm r0 *1 0,0
Ccc_XD1_nm_XD3_nm XD1_nm XD3_nm 1.21e-17
* device instance cc_XD1_nm_XD3_nt r0 *1 0,0
Ccc_XD1_nm_XD3_nt XD1_nm XD3_nt 1.21e-17
* device instance cc_XD1_nm_XD3_t1 r0 *1 0,0
Ccc_XD1_nm_XD3_t1 XD1_nm XD3_t1 1.21e-17
* device instance cc_XD1_nm_XD4_XDFFM_CKBB r0 *1 0,0
Ccc_XD1_nm_XD4_XDFFM_CKBB XD1_nm XD4_XDFFM_CKBB 1.8151e-17
* device instance cc_XD1_nm_XD4_XDFFM_CLKB r0 *1 0,0
Ccc_XD1_nm_XD4_XDFFM_CLKB XD1_nm XD4_XDFFM_CLKB 2.4201e-17
* device instance cc_XD1_nm_XD4_XDFFM_M r0 *1 0,0
Ccc_XD1_nm_XD4_XDFFM_M XD1_nm XD4_XDFFM_M 2.4201e-17
* device instance cc_XD1_nm_XD4_XDFFM_MB r0 *1 0,0
Ccc_XD1_nm_XD4_XDFFM_MB XD1_nm XD4_XDFFM_MB 1.21e-17
* device instance cc_XD1_nm_XD4_XDFFM_MFB r0 *1 0,0
Ccc_XD1_nm_XD4_XDFFM_MFB XD1_nm XD4_XDFFM_MFB 1.21e-17
* device instance cc_XD1_nm_XD4_XDFFM_S r0 *1 0,0
Ccc_XD1_nm_XD4_XDFFM_S XD1_nm XD4_XDFFM_S 1.8151e-17
* device instance cc_XD1_nm_XD4_XDFFM_SB r0 *1 0,0
Ccc_XD1_nm_XD4_XDFFM_SB XD1_nm XD4_XDFFM_SB 1.8151e-17
* device instance cc_XD1_nm_XD4_XDFFM_SFB r0 *1 0,0
Ccc_XD1_nm_XD4_XDFFM_SFB XD1_nm XD4_XDFFM_SFB 1.21e-17
* device instance cc_XD1_nm_XD4_XDFFQ_CKBB r0 *1 0,0
Ccc_XD1_nm_XD4_XDFFQ_CKBB XD1_nm XD4_XDFFQ_CKBB 1.8151e-17
* device instance cc_XD1_nm_XD4_XDFFQ_CLKB r0 *1 0,0
Ccc_XD1_nm_XD4_XDFFQ_CLKB XD1_nm XD4_XDFFQ_CLKB 2.4201e-17
* device instance cc_XD1_nm_XD4_XDFFQ_M r0 *1 0,0
Ccc_XD1_nm_XD4_XDFFQ_M XD1_nm XD4_XDFFQ_M 2.4201e-17
* device instance cc_XD1_nm_XD4_XDFFQ_MB r0 *1 0,0
Ccc_XD1_nm_XD4_XDFFQ_MB XD1_nm XD4_XDFFQ_MB 1.21e-17
* device instance cc_XD1_nm_XD4_XDFFQ_MFB r0 *1 0,0
Ccc_XD1_nm_XD4_XDFFQ_MFB XD1_nm XD4_XDFFQ_MFB 1.21e-17
* device instance cc_XD1_nm_XD4_XDFFQ_S r0 *1 0,0
Ccc_XD1_nm_XD4_XDFFQ_S XD1_nm XD4_XDFFQ_S 1.8151e-17
* device instance cc_XD1_nm_XD4_XDFFQ_SB r0 *1 0,0
Ccc_XD1_nm_XD4_XDFFQ_SB XD1_nm XD4_XDFFQ_SB 1.8151e-17
* device instance cc_XD1_nm_XD4_XDFFQ_SFB r0 *1 0,0
Ccc_XD1_nm_XD4_XDFFQ_SFB XD1_nm XD4_XDFFQ_SFB 1.21e-17
* device instance cc_XD1_nm_XD4_XN2_mid1 r0 *1 0,0
Ccc_XD1_nm_XD4_XN2_mid1 XD1_nm XD4_XN2_mid1 1.21e-17
* device instance cc_XD1_nm_XD4_XN3_mid1 r0 *1 0,0
Ccc_XD1_nm_XD4_XN3_mid1 XD1_nm XD4_XN3_mid1 1.21e-17
* device instance cc_XD1_nm_XD4_XN3_mid2 r0 *1 0,0
Ccc_XD1_nm_XD4_XN3_mid2 XD1_nm XD4_XN3_mid2 1.21e-17
* device instance cc_XD1_nm_XD4_dmodout r0 *1 0,0
Ccc_XD1_nm_XD4_dmodout XD1_nm XD4_dmodout 1.21e-17
* device instance cc_XD1_nm_XD4_dq r0 *1 0,0
Ccc_XD1_nm_XD4_dq XD1_nm XD4_dq 1.8151e-17
* device instance cc_XD1_nm_XD4_nm r0 *1 0,0
Ccc_XD1_nm_XD4_nm XD1_nm XD4_nm 1.21e-17
* device instance cc_XD1_nm_XD4_nt r0 *1 0,0
Ccc_XD1_nm_XD4_nt XD1_nm XD4_nt 1.21e-17
* device instance cc_XD1_nm_XD4_t1 r0 *1 0,0
Ccc_XD1_nm_XD4_t1 XD1_nm XD4_t1 1.21e-17
* device instance cc_XD1_nm_XD5_XDFFM_CKBB r0 *1 0,0
Ccc_XD1_nm_XD5_XDFFM_CKBB XD1_nm XD5_XDFFM_CKBB 1.8151e-17
* device instance cc_XD1_nm_XD5_XDFFM_CLKB r0 *1 0,0
Ccc_XD1_nm_XD5_XDFFM_CLKB XD1_nm XD5_XDFFM_CLKB 2.4201e-17
* device instance cc_XD1_nm_XD5_XDFFM_M r0 *1 0,0
Ccc_XD1_nm_XD5_XDFFM_M XD1_nm XD5_XDFFM_M 2.4201e-17
* device instance cc_XD1_nm_XD5_XDFFM_MB r0 *1 0,0
Ccc_XD1_nm_XD5_XDFFM_MB XD1_nm XD5_XDFFM_MB 1.21e-17
* device instance cc_XD1_nm_XD5_XDFFM_MFB r0 *1 0,0
Ccc_XD1_nm_XD5_XDFFM_MFB XD1_nm XD5_XDFFM_MFB 1.21e-17
* device instance cc_XD1_nm_XD5_XDFFM_S r0 *1 0,0
Ccc_XD1_nm_XD5_XDFFM_S XD1_nm XD5_XDFFM_S 1.8151e-17
* device instance cc_XD1_nm_XD5_XDFFM_SB r0 *1 0,0
Ccc_XD1_nm_XD5_XDFFM_SB XD1_nm XD5_XDFFM_SB 1.8151e-17
* device instance cc_XD1_nm_XD5_XDFFM_SFB r0 *1 0,0
Ccc_XD1_nm_XD5_XDFFM_SFB XD1_nm XD5_XDFFM_SFB 1.21e-17
* device instance cc_XD1_nm_XD5_XDFFQ_CKBB r0 *1 0,0
Ccc_XD1_nm_XD5_XDFFQ_CKBB XD1_nm XD5_XDFFQ_CKBB 1.8151e-17
* device instance cc_XD1_nm_XD5_XDFFQ_CLKB r0 *1 0,0
Ccc_XD1_nm_XD5_XDFFQ_CLKB XD1_nm XD5_XDFFQ_CLKB 2.4201e-17
* device instance cc_XD1_nm_XD5_XDFFQ_M r0 *1 0,0
Ccc_XD1_nm_XD5_XDFFQ_M XD1_nm XD5_XDFFQ_M 2.4201e-17
* device instance cc_XD1_nm_XD5_XDFFQ_MB r0 *1 0,0
Ccc_XD1_nm_XD5_XDFFQ_MB XD1_nm XD5_XDFFQ_MB 1.21e-17
* device instance cc_XD1_nm_XD5_XDFFQ_MFB r0 *1 0,0
Ccc_XD1_nm_XD5_XDFFQ_MFB XD1_nm XD5_XDFFQ_MFB 1.21e-17
* device instance cc_XD1_nm_XD5_XDFFQ_S r0 *1 0,0
Ccc_XD1_nm_XD5_XDFFQ_S XD1_nm XD5_XDFFQ_S 1.8151e-17
* device instance cc_XD1_nm_XD5_XDFFQ_SB r0 *1 0,0
Ccc_XD1_nm_XD5_XDFFQ_SB XD1_nm XD5_XDFFQ_SB 1.8151e-17
* device instance cc_XD1_nm_XD5_XDFFQ_SFB r0 *1 0,0
Ccc_XD1_nm_XD5_XDFFQ_SFB XD1_nm XD5_XDFFQ_SFB 1.21e-17
* device instance cc_XD1_nm_XD5_XN2_mid1 r0 *1 0,0
Ccc_XD1_nm_XD5_XN2_mid1 XD1_nm XD5_XN2_mid1 1.21e-17
* device instance cc_XD1_nm_XD5_XN3_mid1 r0 *1 0,0
Ccc_XD1_nm_XD5_XN3_mid1 XD1_nm XD5_XN3_mid1 1.21e-17
* device instance cc_XD1_nm_XD5_XN3_mid2 r0 *1 0,0
Ccc_XD1_nm_XD5_XN3_mid2 XD1_nm XD5_XN3_mid2 1.21e-17
* device instance cc_XD1_nm_XD5_dmodout r0 *1 0,0
Ccc_XD1_nm_XD5_dmodout XD1_nm XD5_dmodout 1.21e-17
* device instance cc_XD1_nm_XD5_dq r0 *1 0,0
Ccc_XD1_nm_XD5_dq XD1_nm XD5_dq 1.8151e-17
* device instance cc_XD1_nm_XD5_nm r0 *1 0,0
Ccc_XD1_nm_XD5_nm XD1_nm XD5_nm 1.21e-17
* device instance cc_XD1_nm_XD5_nt r0 *1 0,0
Ccc_XD1_nm_XD5_nt XD1_nm XD5_nt 1.21e-17
* device instance cc_XD1_nm_XD5_t1 r0 *1 0,0
Ccc_XD1_nm_XD5_t1 XD1_nm XD5_t1 1.21e-17
* device instance cc_XD1_nm_XFRT_CKBB r0 *1 0,0
Ccc_XD1_nm_XFRT_CKBB XD1_nm XFRT_CKBB 1.8151e-17
* device instance cc_XD1_nm_XFRT_CLKB r0 *1 0,0
Ccc_XD1_nm_XFRT_CLKB XD1_nm XFRT_CLKB 2.4201e-17
* device instance cc_XD1_nm_XFRT_M r0 *1 0,0
Ccc_XD1_nm_XFRT_M XD1_nm XFRT_M 2.4201e-17
* device instance cc_XD1_nm_XFRT_MB r0 *1 0,0
Ccc_XD1_nm_XFRT_MB XD1_nm XFRT_MB 1.21e-17
* device instance cc_XD1_nm_XFRT_MFB r0 *1 0,0
Ccc_XD1_nm_XFRT_MFB XD1_nm XFRT_MFB 1.21e-17
* device instance cc_XD1_nm_XFRT_S r0 *1 0,0
Ccc_XD1_nm_XFRT_S XD1_nm XFRT_S 1.8151e-17
* device instance cc_XD1_nm_XFRT_SB r0 *1 0,0
Ccc_XD1_nm_XFRT_SB XD1_nm XFRT_SB 1.8151e-17
* device instance cc_XD1_nm_XFRT_SFB r0 *1 0,0
Ccc_XD1_nm_XFRT_SFB XD1_nm XFRT_SFB 1.21e-17
* device instance cc_XD1_nm_ck1 r0 *1 0,0
Ccc_XD1_nm_ck1 XD1_nm ck1 3.0251e-17
* device instance cc_XD1_nm_ck2 r0 *1 0,0
Ccc_XD1_nm_ck2 XD1_nm ck2 3.6302e-17
* device instance cc_XD1_nm_ck3 r0 *1 0,0
Ccc_XD1_nm_ck3 XD1_nm ck3 3.0251e-17
* device instance cc_XD1_nm_ck4 r0 *1 0,0
Ccc_XD1_nm_ck4 XD1_nm ck4 3.0251e-17
* device instance cc_XD1_nm_ck5 r0 *1 0,0
Ccc_XD1_nm_ck5 XD1_nm ck5 3.0251e-17
* device instance cc_XD1_nm_mod0 r0 *1 0,0
Ccc_XD1_nm_mod0 XD1_nm mod0 2.4201e-17
* device instance cc_XD1_nm_mod1 r0 *1 0,0
Ccc_XD1_nm_mod1 XD1_nm mod1 2.4201e-17
* device instance cc_XD1_nm_mod2 r0 *1 0,0
Ccc_XD1_nm_mod2 XD1_nm mod2 2.4201e-17
* device instance cc_XD1_nm_mod3 r0 *1 0,0
Ccc_XD1_nm_mod3 XD1_nm mod3 2.4201e-17
* device instance cc_XD1_nm_mod4 r0 *1 0,0
Ccc_XD1_nm_mod4 XD1_nm mod4 2.4201e-17
* device instance cc_XD1_nm_net1 r0 *1 0,0
Ccc_XD1_nm_net1 XD1_nm net1 1.21e-17
* device instance cc_XD1_nt_XD1_t1 r0 *1 0,0
Ccc_XD1_nt_XD1_t1 XD1_nt XD1_t1 1.21e-17
* device instance cc_XD1_nt_XD2_XDFFM_CKBB r0 *1 0,0
Ccc_XD1_nt_XD2_XDFFM_CKBB XD1_nt XD2_XDFFM_CKBB 1.8151e-17
* device instance cc_XD1_nt_XD2_XDFFM_CLKB r0 *1 0,0
Ccc_XD1_nt_XD2_XDFFM_CLKB XD1_nt XD2_XDFFM_CLKB 2.4201e-17
* device instance cc_XD1_nt_XD2_XDFFM_M r0 *1 0,0
Ccc_XD1_nt_XD2_XDFFM_M XD1_nt XD2_XDFFM_M 2.4201e-17
* device instance cc_XD1_nt_XD2_XDFFM_MB r0 *1 0,0
Ccc_XD1_nt_XD2_XDFFM_MB XD1_nt XD2_XDFFM_MB 1.21e-17
* device instance cc_XD1_nt_XD2_XDFFM_MFB r0 *1 0,0
Ccc_XD1_nt_XD2_XDFFM_MFB XD1_nt XD2_XDFFM_MFB 1.21e-17
* device instance cc_XD1_nt_XD2_XDFFM_S r0 *1 0,0
Ccc_XD1_nt_XD2_XDFFM_S XD1_nt XD2_XDFFM_S 1.8151e-17
* device instance cc_XD1_nt_XD2_XDFFM_SB r0 *1 0,0
Ccc_XD1_nt_XD2_XDFFM_SB XD1_nt XD2_XDFFM_SB 1.8151e-17
* device instance cc_XD1_nt_XD2_XDFFM_SFB r0 *1 0,0
Ccc_XD1_nt_XD2_XDFFM_SFB XD1_nt XD2_XDFFM_SFB 1.21e-17
* device instance cc_XD1_nt_XD2_XDFFQ_CKBB r0 *1 0,0
Ccc_XD1_nt_XD2_XDFFQ_CKBB XD1_nt XD2_XDFFQ_CKBB 1.8151e-17
* device instance cc_XD1_nt_XD2_XDFFQ_CLKB r0 *1 0,0
Ccc_XD1_nt_XD2_XDFFQ_CLKB XD1_nt XD2_XDFFQ_CLKB 2.4201e-17
* device instance cc_XD1_nt_XD2_XDFFQ_M r0 *1 0,0
Ccc_XD1_nt_XD2_XDFFQ_M XD1_nt XD2_XDFFQ_M 2.4201e-17
* device instance cc_XD1_nt_XD2_XDFFQ_MB r0 *1 0,0
Ccc_XD1_nt_XD2_XDFFQ_MB XD1_nt XD2_XDFFQ_MB 1.21e-17
* device instance cc_XD1_nt_XD2_XDFFQ_MFB r0 *1 0,0
Ccc_XD1_nt_XD2_XDFFQ_MFB XD1_nt XD2_XDFFQ_MFB 1.21e-17
* device instance cc_XD1_nt_XD2_XDFFQ_S r0 *1 0,0
Ccc_XD1_nt_XD2_XDFFQ_S XD1_nt XD2_XDFFQ_S 1.8151e-17
* device instance cc_XD1_nt_XD2_XDFFQ_SB r0 *1 0,0
Ccc_XD1_nt_XD2_XDFFQ_SB XD1_nt XD2_XDFFQ_SB 1.8151e-17
* device instance cc_XD1_nt_XD2_XDFFQ_SFB r0 *1 0,0
Ccc_XD1_nt_XD2_XDFFQ_SFB XD1_nt XD2_XDFFQ_SFB 1.21e-17
* device instance cc_XD1_nt_XD2_XN2_mid1 r0 *1 0,0
Ccc_XD1_nt_XD2_XN2_mid1 XD1_nt XD2_XN2_mid1 1.21e-17
* device instance cc_XD1_nt_XD2_XN3_mid1 r0 *1 0,0
Ccc_XD1_nt_XD2_XN3_mid1 XD1_nt XD2_XN3_mid1 1.21e-17
* device instance cc_XD1_nt_XD2_XN3_mid2 r0 *1 0,0
Ccc_XD1_nt_XD2_XN3_mid2 XD1_nt XD2_XN3_mid2 1.21e-17
* device instance cc_XD1_nt_XD2_dmodout r0 *1 0,0
Ccc_XD1_nt_XD2_dmodout XD1_nt XD2_dmodout 1.21e-17
* device instance cc_XD1_nt_XD2_dq r0 *1 0,0
Ccc_XD1_nt_XD2_dq XD1_nt XD2_dq 1.8151e-17
* device instance cc_XD1_nt_XD2_nm r0 *1 0,0
Ccc_XD1_nt_XD2_nm XD1_nt XD2_nm 1.21e-17
* device instance cc_XD1_nt_XD2_nt r0 *1 0,0
Ccc_XD1_nt_XD2_nt XD1_nt XD2_nt 1.21e-17
* device instance cc_XD1_nt_XD2_t1 r0 *1 0,0
Ccc_XD1_nt_XD2_t1 XD1_nt XD2_t1 1.21e-17
* device instance cc_XD1_nt_XD3_XDFFM_CKBB r0 *1 0,0
Ccc_XD1_nt_XD3_XDFFM_CKBB XD1_nt XD3_XDFFM_CKBB 1.8151e-17
* device instance cc_XD1_nt_XD3_XDFFM_CLKB r0 *1 0,0
Ccc_XD1_nt_XD3_XDFFM_CLKB XD1_nt XD3_XDFFM_CLKB 2.4201e-17
* device instance cc_XD1_nt_XD3_XDFFM_M r0 *1 0,0
Ccc_XD1_nt_XD3_XDFFM_M XD1_nt XD3_XDFFM_M 2.4201e-17
* device instance cc_XD1_nt_XD3_XDFFM_MB r0 *1 0,0
Ccc_XD1_nt_XD3_XDFFM_MB XD1_nt XD3_XDFFM_MB 1.21e-17
* device instance cc_XD1_nt_XD3_XDFFM_MFB r0 *1 0,0
Ccc_XD1_nt_XD3_XDFFM_MFB XD1_nt XD3_XDFFM_MFB 1.21e-17
* device instance cc_XD1_nt_XD3_XDFFM_S r0 *1 0,0
Ccc_XD1_nt_XD3_XDFFM_S XD1_nt XD3_XDFFM_S 1.8151e-17
* device instance cc_XD1_nt_XD3_XDFFM_SB r0 *1 0,0
Ccc_XD1_nt_XD3_XDFFM_SB XD1_nt XD3_XDFFM_SB 1.8151e-17
* device instance cc_XD1_nt_XD3_XDFFM_SFB r0 *1 0,0
Ccc_XD1_nt_XD3_XDFFM_SFB XD1_nt XD3_XDFFM_SFB 1.21e-17
* device instance cc_XD1_nt_XD3_XDFFQ_CKBB r0 *1 0,0
Ccc_XD1_nt_XD3_XDFFQ_CKBB XD1_nt XD3_XDFFQ_CKBB 1.8151e-17
* device instance cc_XD1_nt_XD3_XDFFQ_CLKB r0 *1 0,0
Ccc_XD1_nt_XD3_XDFFQ_CLKB XD1_nt XD3_XDFFQ_CLKB 2.4201e-17
* device instance cc_XD1_nt_XD3_XDFFQ_M r0 *1 0,0
Ccc_XD1_nt_XD3_XDFFQ_M XD1_nt XD3_XDFFQ_M 2.4201e-17
* device instance cc_XD1_nt_XD3_XDFFQ_MB r0 *1 0,0
Ccc_XD1_nt_XD3_XDFFQ_MB XD1_nt XD3_XDFFQ_MB 1.21e-17
* device instance cc_XD1_nt_XD3_XDFFQ_MFB r0 *1 0,0
Ccc_XD1_nt_XD3_XDFFQ_MFB XD1_nt XD3_XDFFQ_MFB 1.21e-17
* device instance cc_XD1_nt_XD3_XDFFQ_S r0 *1 0,0
Ccc_XD1_nt_XD3_XDFFQ_S XD1_nt XD3_XDFFQ_S 1.8151e-17
* device instance cc_XD1_nt_XD3_XDFFQ_SB r0 *1 0,0
Ccc_XD1_nt_XD3_XDFFQ_SB XD1_nt XD3_XDFFQ_SB 1.8151e-17
* device instance cc_XD1_nt_XD3_XDFFQ_SFB r0 *1 0,0
Ccc_XD1_nt_XD3_XDFFQ_SFB XD1_nt XD3_XDFFQ_SFB 1.21e-17
* device instance cc_XD1_nt_XD3_XN2_mid1 r0 *1 0,0
Ccc_XD1_nt_XD3_XN2_mid1 XD1_nt XD3_XN2_mid1 1.21e-17
* device instance cc_XD1_nt_XD3_XN3_mid1 r0 *1 0,0
Ccc_XD1_nt_XD3_XN3_mid1 XD1_nt XD3_XN3_mid1 1.21e-17
* device instance cc_XD1_nt_XD3_XN3_mid2 r0 *1 0,0
Ccc_XD1_nt_XD3_XN3_mid2 XD1_nt XD3_XN3_mid2 1.21e-17
* device instance cc_XD1_nt_XD3_dmodout r0 *1 0,0
Ccc_XD1_nt_XD3_dmodout XD1_nt XD3_dmodout 1.21e-17
* device instance cc_XD1_nt_XD3_dq r0 *1 0,0
Ccc_XD1_nt_XD3_dq XD1_nt XD3_dq 1.8151e-17
* device instance cc_XD1_nt_XD3_nm r0 *1 0,0
Ccc_XD1_nt_XD3_nm XD1_nt XD3_nm 1.21e-17
* device instance cc_XD1_nt_XD3_nt r0 *1 0,0
Ccc_XD1_nt_XD3_nt XD1_nt XD3_nt 1.21e-17
* device instance cc_XD1_nt_XD3_t1 r0 *1 0,0
Ccc_XD1_nt_XD3_t1 XD1_nt XD3_t1 1.21e-17
* device instance cc_XD1_nt_XD4_XDFFM_CKBB r0 *1 0,0
Ccc_XD1_nt_XD4_XDFFM_CKBB XD1_nt XD4_XDFFM_CKBB 1.8151e-17
* device instance cc_XD1_nt_XD4_XDFFM_CLKB r0 *1 0,0
Ccc_XD1_nt_XD4_XDFFM_CLKB XD1_nt XD4_XDFFM_CLKB 2.4201e-17
* device instance cc_XD1_nt_XD4_XDFFM_M r0 *1 0,0
Ccc_XD1_nt_XD4_XDFFM_M XD1_nt XD4_XDFFM_M 2.4201e-17
* device instance cc_XD1_nt_XD4_XDFFM_MB r0 *1 0,0
Ccc_XD1_nt_XD4_XDFFM_MB XD1_nt XD4_XDFFM_MB 1.21e-17
* device instance cc_XD1_nt_XD4_XDFFM_MFB r0 *1 0,0
Ccc_XD1_nt_XD4_XDFFM_MFB XD1_nt XD4_XDFFM_MFB 1.21e-17
* device instance cc_XD1_nt_XD4_XDFFM_S r0 *1 0,0
Ccc_XD1_nt_XD4_XDFFM_S XD1_nt XD4_XDFFM_S 1.8151e-17
* device instance cc_XD1_nt_XD4_XDFFM_SB r0 *1 0,0
Ccc_XD1_nt_XD4_XDFFM_SB XD1_nt XD4_XDFFM_SB 1.8151e-17
* device instance cc_XD1_nt_XD4_XDFFM_SFB r0 *1 0,0
Ccc_XD1_nt_XD4_XDFFM_SFB XD1_nt XD4_XDFFM_SFB 1.21e-17
* device instance cc_XD1_nt_XD4_XDFFQ_CKBB r0 *1 0,0
Ccc_XD1_nt_XD4_XDFFQ_CKBB XD1_nt XD4_XDFFQ_CKBB 1.8151e-17
* device instance cc_XD1_nt_XD4_XDFFQ_CLKB r0 *1 0,0
Ccc_XD1_nt_XD4_XDFFQ_CLKB XD1_nt XD4_XDFFQ_CLKB 2.4201e-17
* device instance cc_XD1_nt_XD4_XDFFQ_M r0 *1 0,0
Ccc_XD1_nt_XD4_XDFFQ_M XD1_nt XD4_XDFFQ_M 2.4201e-17
* device instance cc_XD1_nt_XD4_XDFFQ_MB r0 *1 0,0
Ccc_XD1_nt_XD4_XDFFQ_MB XD1_nt XD4_XDFFQ_MB 1.21e-17
* device instance cc_XD1_nt_XD4_XDFFQ_MFB r0 *1 0,0
Ccc_XD1_nt_XD4_XDFFQ_MFB XD1_nt XD4_XDFFQ_MFB 1.21e-17
* device instance cc_XD1_nt_XD4_XDFFQ_S r0 *1 0,0
Ccc_XD1_nt_XD4_XDFFQ_S XD1_nt XD4_XDFFQ_S 1.8151e-17
* device instance cc_XD1_nt_XD4_XDFFQ_SB r0 *1 0,0
Ccc_XD1_nt_XD4_XDFFQ_SB XD1_nt XD4_XDFFQ_SB 1.8151e-17
* device instance cc_XD1_nt_XD4_XDFFQ_SFB r0 *1 0,0
Ccc_XD1_nt_XD4_XDFFQ_SFB XD1_nt XD4_XDFFQ_SFB 1.21e-17
* device instance cc_XD1_nt_XD4_XN2_mid1 r0 *1 0,0
Ccc_XD1_nt_XD4_XN2_mid1 XD1_nt XD4_XN2_mid1 1.21e-17
* device instance cc_XD1_nt_XD4_XN3_mid1 r0 *1 0,0
Ccc_XD1_nt_XD4_XN3_mid1 XD1_nt XD4_XN3_mid1 1.21e-17
* device instance cc_XD1_nt_XD4_XN3_mid2 r0 *1 0,0
Ccc_XD1_nt_XD4_XN3_mid2 XD1_nt XD4_XN3_mid2 1.21e-17
* device instance cc_XD1_nt_XD4_dmodout r0 *1 0,0
Ccc_XD1_nt_XD4_dmodout XD1_nt XD4_dmodout 1.21e-17
* device instance cc_XD1_nt_XD4_dq r0 *1 0,0
Ccc_XD1_nt_XD4_dq XD1_nt XD4_dq 1.8151e-17
* device instance cc_XD1_nt_XD4_nm r0 *1 0,0
Ccc_XD1_nt_XD4_nm XD1_nt XD4_nm 1.21e-17
* device instance cc_XD1_nt_XD4_nt r0 *1 0,0
Ccc_XD1_nt_XD4_nt XD1_nt XD4_nt 1.21e-17
* device instance cc_XD1_nt_XD4_t1 r0 *1 0,0
Ccc_XD1_nt_XD4_t1 XD1_nt XD4_t1 1.21e-17
* device instance cc_XD1_nt_XD5_XDFFM_CKBB r0 *1 0,0
Ccc_XD1_nt_XD5_XDFFM_CKBB XD1_nt XD5_XDFFM_CKBB 1.8151e-17
* device instance cc_XD1_nt_XD5_XDFFM_CLKB r0 *1 0,0
Ccc_XD1_nt_XD5_XDFFM_CLKB XD1_nt XD5_XDFFM_CLKB 2.4201e-17
* device instance cc_XD1_nt_XD5_XDFFM_M r0 *1 0,0
Ccc_XD1_nt_XD5_XDFFM_M XD1_nt XD5_XDFFM_M 2.4201e-17
* device instance cc_XD1_nt_XD5_XDFFM_MB r0 *1 0,0
Ccc_XD1_nt_XD5_XDFFM_MB XD1_nt XD5_XDFFM_MB 1.21e-17
* device instance cc_XD1_nt_XD5_XDFFM_MFB r0 *1 0,0
Ccc_XD1_nt_XD5_XDFFM_MFB XD1_nt XD5_XDFFM_MFB 1.21e-17
* device instance cc_XD1_nt_XD5_XDFFM_S r0 *1 0,0
Ccc_XD1_nt_XD5_XDFFM_S XD1_nt XD5_XDFFM_S 1.8151e-17
* device instance cc_XD1_nt_XD5_XDFFM_SB r0 *1 0,0
Ccc_XD1_nt_XD5_XDFFM_SB XD1_nt XD5_XDFFM_SB 1.8151e-17
* device instance cc_XD1_nt_XD5_XDFFM_SFB r0 *1 0,0
Ccc_XD1_nt_XD5_XDFFM_SFB XD1_nt XD5_XDFFM_SFB 1.21e-17
* device instance cc_XD1_nt_XD5_XDFFQ_CKBB r0 *1 0,0
Ccc_XD1_nt_XD5_XDFFQ_CKBB XD1_nt XD5_XDFFQ_CKBB 1.8151e-17
* device instance cc_XD1_nt_XD5_XDFFQ_CLKB r0 *1 0,0
Ccc_XD1_nt_XD5_XDFFQ_CLKB XD1_nt XD5_XDFFQ_CLKB 2.4201e-17
* device instance cc_XD1_nt_XD5_XDFFQ_M r0 *1 0,0
Ccc_XD1_nt_XD5_XDFFQ_M XD1_nt XD5_XDFFQ_M 2.4201e-17
* device instance cc_XD1_nt_XD5_XDFFQ_MB r0 *1 0,0
Ccc_XD1_nt_XD5_XDFFQ_MB XD1_nt XD5_XDFFQ_MB 1.21e-17
* device instance cc_XD1_nt_XD5_XDFFQ_MFB r0 *1 0,0
Ccc_XD1_nt_XD5_XDFFQ_MFB XD1_nt XD5_XDFFQ_MFB 1.21e-17
* device instance cc_XD1_nt_XD5_XDFFQ_S r0 *1 0,0
Ccc_XD1_nt_XD5_XDFFQ_S XD1_nt XD5_XDFFQ_S 1.8151e-17
* device instance cc_XD1_nt_XD5_XDFFQ_SB r0 *1 0,0
Ccc_XD1_nt_XD5_XDFFQ_SB XD1_nt XD5_XDFFQ_SB 1.8151e-17
* device instance cc_XD1_nt_XD5_XDFFQ_SFB r0 *1 0,0
Ccc_XD1_nt_XD5_XDFFQ_SFB XD1_nt XD5_XDFFQ_SFB 1.21e-17
* device instance cc_XD1_nt_XD5_XN2_mid1 r0 *1 0,0
Ccc_XD1_nt_XD5_XN2_mid1 XD1_nt XD5_XN2_mid1 1.21e-17
* device instance cc_XD1_nt_XD5_XN3_mid1 r0 *1 0,0
Ccc_XD1_nt_XD5_XN3_mid1 XD1_nt XD5_XN3_mid1 1.21e-17
* device instance cc_XD1_nt_XD5_XN3_mid2 r0 *1 0,0
Ccc_XD1_nt_XD5_XN3_mid2 XD1_nt XD5_XN3_mid2 1.21e-17
* device instance cc_XD1_nt_XD5_dmodout r0 *1 0,0
Ccc_XD1_nt_XD5_dmodout XD1_nt XD5_dmodout 1.21e-17
* device instance cc_XD1_nt_XD5_dq r0 *1 0,0
Ccc_XD1_nt_XD5_dq XD1_nt XD5_dq 1.8151e-17
* device instance cc_XD1_nt_XD5_nm r0 *1 0,0
Ccc_XD1_nt_XD5_nm XD1_nt XD5_nm 1.21e-17
* device instance cc_XD1_nt_XD5_nt r0 *1 0,0
Ccc_XD1_nt_XD5_nt XD1_nt XD5_nt 1.21e-17
* device instance cc_XD1_nt_XD5_t1 r0 *1 0,0
Ccc_XD1_nt_XD5_t1 XD1_nt XD5_t1 1.21e-17
* device instance cc_XD1_nt_XFRT_CKBB r0 *1 0,0
Ccc_XD1_nt_XFRT_CKBB XD1_nt XFRT_CKBB 1.8151e-17
* device instance cc_XD1_nt_XFRT_CLKB r0 *1 0,0
Ccc_XD1_nt_XFRT_CLKB XD1_nt XFRT_CLKB 2.4201e-17
* device instance cc_XD1_nt_XFRT_M r0 *1 0,0
Ccc_XD1_nt_XFRT_M XD1_nt XFRT_M 2.4201e-17
* device instance cc_XD1_nt_XFRT_MB r0 *1 0,0
Ccc_XD1_nt_XFRT_MB XD1_nt XFRT_MB 1.21e-17
* device instance cc_XD1_nt_XFRT_MFB r0 *1 0,0
Ccc_XD1_nt_XFRT_MFB XD1_nt XFRT_MFB 1.21e-17
* device instance cc_XD1_nt_XFRT_S r0 *1 0,0
Ccc_XD1_nt_XFRT_S XD1_nt XFRT_S 1.8151e-17
* device instance cc_XD1_nt_XFRT_SB r0 *1 0,0
Ccc_XD1_nt_XFRT_SB XD1_nt XFRT_SB 1.8151e-17
* device instance cc_XD1_nt_XFRT_SFB r0 *1 0,0
Ccc_XD1_nt_XFRT_SFB XD1_nt XFRT_SFB 1.21e-17
* device instance cc_XD1_nt_ck1 r0 *1 0,0
Ccc_XD1_nt_ck1 XD1_nt ck1 3.0251e-17
* device instance cc_XD1_nt_ck2 r0 *1 0,0
Ccc_XD1_nt_ck2 XD1_nt ck2 3.0251e-17
* device instance cc_XD1_nt_ck3 r0 *1 0,0
Ccc_XD1_nt_ck3 XD1_nt ck3 3.0251e-17
* device instance cc_XD1_nt_ck4 r0 *1 0,0
Ccc_XD1_nt_ck4 XD1_nt ck4 3.0251e-17
* device instance cc_XD1_nt_ck5 r0 *1 0,0
Ccc_XD1_nt_ck5 XD1_nt ck5 3.0251e-17
* device instance cc_XD1_nt_mod0 r0 *1 0,0
Ccc_XD1_nt_mod0 XD1_nt mod0 3.0251e-17
* device instance cc_XD1_nt_mod1 r0 *1 0,0
Ccc_XD1_nt_mod1 XD1_nt mod1 2.4201e-17
* device instance cc_XD1_nt_mod2 r0 *1 0,0
Ccc_XD1_nt_mod2 XD1_nt mod2 2.4201e-17
* device instance cc_XD1_nt_mod3 r0 *1 0,0
Ccc_XD1_nt_mod3 XD1_nt mod3 2.4201e-17
* device instance cc_XD1_nt_mod4 r0 *1 0,0
Ccc_XD1_nt_mod4 XD1_nt mod4 2.4201e-17
* device instance cc_XD1_nt_net1 r0 *1 0,0
Ccc_XD1_nt_net1 XD1_nt net1 1.21e-17
* device instance cc_XD1_t1_XD2_XDFFM_CKBB r0 *1 0,0
Ccc_XD1_t1_XD2_XDFFM_CKBB XD1_t1 XD2_XDFFM_CKBB 1.8151e-17
* device instance cc_XD1_t1_XD2_XDFFM_CLKB r0 *1 0,0
Ccc_XD1_t1_XD2_XDFFM_CLKB XD1_t1 XD2_XDFFM_CLKB 2.4201e-17
* device instance cc_XD1_t1_XD2_XDFFM_M r0 *1 0,0
Ccc_XD1_t1_XD2_XDFFM_M XD1_t1 XD2_XDFFM_M 2.4201e-17
* device instance cc_XD1_t1_XD2_XDFFM_MB r0 *1 0,0
Ccc_XD1_t1_XD2_XDFFM_MB XD1_t1 XD2_XDFFM_MB 1.21e-17
* device instance cc_XD1_t1_XD2_XDFFM_MFB r0 *1 0,0
Ccc_XD1_t1_XD2_XDFFM_MFB XD1_t1 XD2_XDFFM_MFB 1.21e-17
* device instance cc_XD1_t1_XD2_XDFFM_S r0 *1 0,0
Ccc_XD1_t1_XD2_XDFFM_S XD1_t1 XD2_XDFFM_S 1.8151e-17
* device instance cc_XD1_t1_XD2_XDFFM_SB r0 *1 0,0
Ccc_XD1_t1_XD2_XDFFM_SB XD1_t1 XD2_XDFFM_SB 1.8151e-17
* device instance cc_XD1_t1_XD2_XDFFM_SFB r0 *1 0,0
Ccc_XD1_t1_XD2_XDFFM_SFB XD1_t1 XD2_XDFFM_SFB 1.21e-17
* device instance cc_XD1_t1_XD2_XDFFQ_CKBB r0 *1 0,0
Ccc_XD1_t1_XD2_XDFFQ_CKBB XD1_t1 XD2_XDFFQ_CKBB 1.8151e-17
* device instance cc_XD1_t1_XD2_XDFFQ_CLKB r0 *1 0,0
Ccc_XD1_t1_XD2_XDFFQ_CLKB XD1_t1 XD2_XDFFQ_CLKB 2.4201e-17
* device instance cc_XD1_t1_XD2_XDFFQ_M r0 *1 0,0
Ccc_XD1_t1_XD2_XDFFQ_M XD1_t1 XD2_XDFFQ_M 2.4201e-17
* device instance cc_XD1_t1_XD2_XDFFQ_MB r0 *1 0,0
Ccc_XD1_t1_XD2_XDFFQ_MB XD1_t1 XD2_XDFFQ_MB 1.21e-17
* device instance cc_XD1_t1_XD2_XDFFQ_MFB r0 *1 0,0
Ccc_XD1_t1_XD2_XDFFQ_MFB XD1_t1 XD2_XDFFQ_MFB 1.21e-17
* device instance cc_XD1_t1_XD2_XDFFQ_S r0 *1 0,0
Ccc_XD1_t1_XD2_XDFFQ_S XD1_t1 XD2_XDFFQ_S 1.8151e-17
* device instance cc_XD1_t1_XD2_XDFFQ_SB r0 *1 0,0
Ccc_XD1_t1_XD2_XDFFQ_SB XD1_t1 XD2_XDFFQ_SB 1.8151e-17
* device instance cc_XD1_t1_XD2_XDFFQ_SFB r0 *1 0,0
Ccc_XD1_t1_XD2_XDFFQ_SFB XD1_t1 XD2_XDFFQ_SFB 1.21e-17
* device instance cc_XD1_t1_XD2_XN2_mid1 r0 *1 0,0
Ccc_XD1_t1_XD2_XN2_mid1 XD1_t1 XD2_XN2_mid1 1.21e-17
* device instance cc_XD1_t1_XD2_XN3_mid1 r0 *1 0,0
Ccc_XD1_t1_XD2_XN3_mid1 XD1_t1 XD2_XN3_mid1 1.21e-17
* device instance cc_XD1_t1_XD2_XN3_mid2 r0 *1 0,0
Ccc_XD1_t1_XD2_XN3_mid2 XD1_t1 XD2_XN3_mid2 1.21e-17
* device instance cc_XD1_t1_XD2_dmodout r0 *1 0,0
Ccc_XD1_t1_XD2_dmodout XD1_t1 XD2_dmodout 1.21e-17
* device instance cc_XD1_t1_XD2_dq r0 *1 0,0
Ccc_XD1_t1_XD2_dq XD1_t1 XD2_dq 1.8151e-17
* device instance cc_XD1_t1_XD2_nm r0 *1 0,0
Ccc_XD1_t1_XD2_nm XD1_t1 XD2_nm 1.21e-17
* device instance cc_XD1_t1_XD2_nt r0 *1 0,0
Ccc_XD1_t1_XD2_nt XD1_t1 XD2_nt 1.21e-17
* device instance cc_XD1_t1_XD2_t1 r0 *1 0,0
Ccc_XD1_t1_XD2_t1 XD1_t1 XD2_t1 1.21e-17
* device instance cc_XD1_t1_XD3_XDFFM_CKBB r0 *1 0,0
Ccc_XD1_t1_XD3_XDFFM_CKBB XD1_t1 XD3_XDFFM_CKBB 1.8151e-17
* device instance cc_XD1_t1_XD3_XDFFM_CLKB r0 *1 0,0
Ccc_XD1_t1_XD3_XDFFM_CLKB XD1_t1 XD3_XDFFM_CLKB 2.4201e-17
* device instance cc_XD1_t1_XD3_XDFFM_M r0 *1 0,0
Ccc_XD1_t1_XD3_XDFFM_M XD1_t1 XD3_XDFFM_M 2.4201e-17
* device instance cc_XD1_t1_XD3_XDFFM_MB r0 *1 0,0
Ccc_XD1_t1_XD3_XDFFM_MB XD1_t1 XD3_XDFFM_MB 1.21e-17
* device instance cc_XD1_t1_XD3_XDFFM_MFB r0 *1 0,0
Ccc_XD1_t1_XD3_XDFFM_MFB XD1_t1 XD3_XDFFM_MFB 1.21e-17
* device instance cc_XD1_t1_XD3_XDFFM_S r0 *1 0,0
Ccc_XD1_t1_XD3_XDFFM_S XD1_t1 XD3_XDFFM_S 1.8151e-17
* device instance cc_XD1_t1_XD3_XDFFM_SB r0 *1 0,0
Ccc_XD1_t1_XD3_XDFFM_SB XD1_t1 XD3_XDFFM_SB 1.8151e-17
* device instance cc_XD1_t1_XD3_XDFFM_SFB r0 *1 0,0
Ccc_XD1_t1_XD3_XDFFM_SFB XD1_t1 XD3_XDFFM_SFB 1.21e-17
* device instance cc_XD1_t1_XD3_XDFFQ_CKBB r0 *1 0,0
Ccc_XD1_t1_XD3_XDFFQ_CKBB XD1_t1 XD3_XDFFQ_CKBB 1.8151e-17
* device instance cc_XD1_t1_XD3_XDFFQ_CLKB r0 *1 0,0
Ccc_XD1_t1_XD3_XDFFQ_CLKB XD1_t1 XD3_XDFFQ_CLKB 2.4201e-17
* device instance cc_XD1_t1_XD3_XDFFQ_M r0 *1 0,0
Ccc_XD1_t1_XD3_XDFFQ_M XD1_t1 XD3_XDFFQ_M 2.4201e-17
* device instance cc_XD1_t1_XD3_XDFFQ_MB r0 *1 0,0
Ccc_XD1_t1_XD3_XDFFQ_MB XD1_t1 XD3_XDFFQ_MB 1.21e-17
* device instance cc_XD1_t1_XD3_XDFFQ_MFB r0 *1 0,0
Ccc_XD1_t1_XD3_XDFFQ_MFB XD1_t1 XD3_XDFFQ_MFB 1.21e-17
* device instance cc_XD1_t1_XD3_XDFFQ_S r0 *1 0,0
Ccc_XD1_t1_XD3_XDFFQ_S XD1_t1 XD3_XDFFQ_S 1.8151e-17
* device instance cc_XD1_t1_XD3_XDFFQ_SB r0 *1 0,0
Ccc_XD1_t1_XD3_XDFFQ_SB XD1_t1 XD3_XDFFQ_SB 1.8151e-17
* device instance cc_XD1_t1_XD3_XDFFQ_SFB r0 *1 0,0
Ccc_XD1_t1_XD3_XDFFQ_SFB XD1_t1 XD3_XDFFQ_SFB 1.21e-17
* device instance cc_XD1_t1_XD3_XN2_mid1 r0 *1 0,0
Ccc_XD1_t1_XD3_XN2_mid1 XD1_t1 XD3_XN2_mid1 1.21e-17
* device instance cc_XD1_t1_XD3_XN3_mid1 r0 *1 0,0
Ccc_XD1_t1_XD3_XN3_mid1 XD1_t1 XD3_XN3_mid1 1.21e-17
* device instance cc_XD1_t1_XD3_XN3_mid2 r0 *1 0,0
Ccc_XD1_t1_XD3_XN3_mid2 XD1_t1 XD3_XN3_mid2 1.21e-17
* device instance cc_XD1_t1_XD3_dmodout r0 *1 0,0
Ccc_XD1_t1_XD3_dmodout XD1_t1 XD3_dmodout 1.21e-17
* device instance cc_XD1_t1_XD3_dq r0 *1 0,0
Ccc_XD1_t1_XD3_dq XD1_t1 XD3_dq 1.8151e-17
* device instance cc_XD1_t1_XD3_nm r0 *1 0,0
Ccc_XD1_t1_XD3_nm XD1_t1 XD3_nm 1.21e-17
* device instance cc_XD1_t1_XD3_nt r0 *1 0,0
Ccc_XD1_t1_XD3_nt XD1_t1 XD3_nt 1.21e-17
* device instance cc_XD1_t1_XD3_t1 r0 *1 0,0
Ccc_XD1_t1_XD3_t1 XD1_t1 XD3_t1 1.21e-17
* device instance cc_XD1_t1_XD4_XDFFM_CKBB r0 *1 0,0
Ccc_XD1_t1_XD4_XDFFM_CKBB XD1_t1 XD4_XDFFM_CKBB 1.8151e-17
* device instance cc_XD1_t1_XD4_XDFFM_CLKB r0 *1 0,0
Ccc_XD1_t1_XD4_XDFFM_CLKB XD1_t1 XD4_XDFFM_CLKB 2.4201e-17
* device instance cc_XD1_t1_XD4_XDFFM_M r0 *1 0,0
Ccc_XD1_t1_XD4_XDFFM_M XD1_t1 XD4_XDFFM_M 2.4201e-17
* device instance cc_XD1_t1_XD4_XDFFM_MB r0 *1 0,0
Ccc_XD1_t1_XD4_XDFFM_MB XD1_t1 XD4_XDFFM_MB 1.21e-17
* device instance cc_XD1_t1_XD4_XDFFM_MFB r0 *1 0,0
Ccc_XD1_t1_XD4_XDFFM_MFB XD1_t1 XD4_XDFFM_MFB 1.21e-17
* device instance cc_XD1_t1_XD4_XDFFM_S r0 *1 0,0
Ccc_XD1_t1_XD4_XDFFM_S XD1_t1 XD4_XDFFM_S 1.8151e-17
* device instance cc_XD1_t1_XD4_XDFFM_SB r0 *1 0,0
Ccc_XD1_t1_XD4_XDFFM_SB XD1_t1 XD4_XDFFM_SB 1.8151e-17
* device instance cc_XD1_t1_XD4_XDFFM_SFB r0 *1 0,0
Ccc_XD1_t1_XD4_XDFFM_SFB XD1_t1 XD4_XDFFM_SFB 1.21e-17
* device instance cc_XD1_t1_XD4_XDFFQ_CKBB r0 *1 0,0
Ccc_XD1_t1_XD4_XDFFQ_CKBB XD1_t1 XD4_XDFFQ_CKBB 1.8151e-17
* device instance cc_XD1_t1_XD4_XDFFQ_CLKB r0 *1 0,0
Ccc_XD1_t1_XD4_XDFFQ_CLKB XD1_t1 XD4_XDFFQ_CLKB 2.4201e-17
* device instance cc_XD1_t1_XD4_XDFFQ_M r0 *1 0,0
Ccc_XD1_t1_XD4_XDFFQ_M XD1_t1 XD4_XDFFQ_M 2.4201e-17
* device instance cc_XD1_t1_XD4_XDFFQ_MB r0 *1 0,0
Ccc_XD1_t1_XD4_XDFFQ_MB XD1_t1 XD4_XDFFQ_MB 1.21e-17
* device instance cc_XD1_t1_XD4_XDFFQ_MFB r0 *1 0,0
Ccc_XD1_t1_XD4_XDFFQ_MFB XD1_t1 XD4_XDFFQ_MFB 1.21e-17
* device instance cc_XD1_t1_XD4_XDFFQ_S r0 *1 0,0
Ccc_XD1_t1_XD4_XDFFQ_S XD1_t1 XD4_XDFFQ_S 1.8151e-17
* device instance cc_XD1_t1_XD4_XDFFQ_SB r0 *1 0,0
Ccc_XD1_t1_XD4_XDFFQ_SB XD1_t1 XD4_XDFFQ_SB 1.8151e-17
* device instance cc_XD1_t1_XD4_XDFFQ_SFB r0 *1 0,0
Ccc_XD1_t1_XD4_XDFFQ_SFB XD1_t1 XD4_XDFFQ_SFB 1.21e-17
* device instance cc_XD1_t1_XD4_XN2_mid1 r0 *1 0,0
Ccc_XD1_t1_XD4_XN2_mid1 XD1_t1 XD4_XN2_mid1 1.21e-17
* device instance cc_XD1_t1_XD4_XN3_mid1 r0 *1 0,0
Ccc_XD1_t1_XD4_XN3_mid1 XD1_t1 XD4_XN3_mid1 1.21e-17
* device instance cc_XD1_t1_XD4_XN3_mid2 r0 *1 0,0
Ccc_XD1_t1_XD4_XN3_mid2 XD1_t1 XD4_XN3_mid2 1.21e-17
* device instance cc_XD1_t1_XD4_dmodout r0 *1 0,0
Ccc_XD1_t1_XD4_dmodout XD1_t1 XD4_dmodout 1.21e-17
* device instance cc_XD1_t1_XD4_dq r0 *1 0,0
Ccc_XD1_t1_XD4_dq XD1_t1 XD4_dq 1.8151e-17
* device instance cc_XD1_t1_XD4_nm r0 *1 0,0
Ccc_XD1_t1_XD4_nm XD1_t1 XD4_nm 1.21e-17
* device instance cc_XD1_t1_XD4_nt r0 *1 0,0
Ccc_XD1_t1_XD4_nt XD1_t1 XD4_nt 1.21e-17
* device instance cc_XD1_t1_XD4_t1 r0 *1 0,0
Ccc_XD1_t1_XD4_t1 XD1_t1 XD4_t1 1.21e-17
* device instance cc_XD1_t1_XD5_XDFFM_CKBB r0 *1 0,0
Ccc_XD1_t1_XD5_XDFFM_CKBB XD1_t1 XD5_XDFFM_CKBB 1.8151e-17
* device instance cc_XD1_t1_XD5_XDFFM_CLKB r0 *1 0,0
Ccc_XD1_t1_XD5_XDFFM_CLKB XD1_t1 XD5_XDFFM_CLKB 2.4201e-17
* device instance cc_XD1_t1_XD5_XDFFM_M r0 *1 0,0
Ccc_XD1_t1_XD5_XDFFM_M XD1_t1 XD5_XDFFM_M 2.4201e-17
* device instance cc_XD1_t1_XD5_XDFFM_MB r0 *1 0,0
Ccc_XD1_t1_XD5_XDFFM_MB XD1_t1 XD5_XDFFM_MB 1.21e-17
* device instance cc_XD1_t1_XD5_XDFFM_MFB r0 *1 0,0
Ccc_XD1_t1_XD5_XDFFM_MFB XD1_t1 XD5_XDFFM_MFB 1.21e-17
* device instance cc_XD1_t1_XD5_XDFFM_S r0 *1 0,0
Ccc_XD1_t1_XD5_XDFFM_S XD1_t1 XD5_XDFFM_S 1.8151e-17
* device instance cc_XD1_t1_XD5_XDFFM_SB r0 *1 0,0
Ccc_XD1_t1_XD5_XDFFM_SB XD1_t1 XD5_XDFFM_SB 1.8151e-17
* device instance cc_XD1_t1_XD5_XDFFM_SFB r0 *1 0,0
Ccc_XD1_t1_XD5_XDFFM_SFB XD1_t1 XD5_XDFFM_SFB 1.21e-17
* device instance cc_XD1_t1_XD5_XDFFQ_CKBB r0 *1 0,0
Ccc_XD1_t1_XD5_XDFFQ_CKBB XD1_t1 XD5_XDFFQ_CKBB 1.8151e-17
* device instance cc_XD1_t1_XD5_XDFFQ_CLKB r0 *1 0,0
Ccc_XD1_t1_XD5_XDFFQ_CLKB XD1_t1 XD5_XDFFQ_CLKB 2.4201e-17
* device instance cc_XD1_t1_XD5_XDFFQ_M r0 *1 0,0
Ccc_XD1_t1_XD5_XDFFQ_M XD1_t1 XD5_XDFFQ_M 2.4201e-17
* device instance cc_XD1_t1_XD5_XDFFQ_MB r0 *1 0,0
Ccc_XD1_t1_XD5_XDFFQ_MB XD1_t1 XD5_XDFFQ_MB 1.21e-17
* device instance cc_XD1_t1_XD5_XDFFQ_MFB r0 *1 0,0
Ccc_XD1_t1_XD5_XDFFQ_MFB XD1_t1 XD5_XDFFQ_MFB 1.21e-17
* device instance cc_XD1_t1_XD5_XDFFQ_S r0 *1 0,0
Ccc_XD1_t1_XD5_XDFFQ_S XD1_t1 XD5_XDFFQ_S 1.8151e-17
* device instance cc_XD1_t1_XD5_XDFFQ_SB r0 *1 0,0
Ccc_XD1_t1_XD5_XDFFQ_SB XD1_t1 XD5_XDFFQ_SB 1.8151e-17
* device instance cc_XD1_t1_XD5_XDFFQ_SFB r0 *1 0,0
Ccc_XD1_t1_XD5_XDFFQ_SFB XD1_t1 XD5_XDFFQ_SFB 1.21e-17
* device instance cc_XD1_t1_XD5_XN2_mid1 r0 *1 0,0
Ccc_XD1_t1_XD5_XN2_mid1 XD1_t1 XD5_XN2_mid1 1.21e-17
* device instance cc_XD1_t1_XD5_XN3_mid1 r0 *1 0,0
Ccc_XD1_t1_XD5_XN3_mid1 XD1_t1 XD5_XN3_mid1 1.21e-17
* device instance cc_XD1_t1_XD5_XN3_mid2 r0 *1 0,0
Ccc_XD1_t1_XD5_XN3_mid2 XD1_t1 XD5_XN3_mid2 1.21e-17
* device instance cc_XD1_t1_XD5_dmodout r0 *1 0,0
Ccc_XD1_t1_XD5_dmodout XD1_t1 XD5_dmodout 1.21e-17
* device instance cc_XD1_t1_XD5_dq r0 *1 0,0
Ccc_XD1_t1_XD5_dq XD1_t1 XD5_dq 1.8151e-17
* device instance cc_XD1_t1_XD5_nm r0 *1 0,0
Ccc_XD1_t1_XD5_nm XD1_t1 XD5_nm 1.21e-17
* device instance cc_XD1_t1_XD5_nt r0 *1 0,0
Ccc_XD1_t1_XD5_nt XD1_t1 XD5_nt 1.21e-17
* device instance cc_XD1_t1_XD5_t1 r0 *1 0,0
Ccc_XD1_t1_XD5_t1 XD1_t1 XD5_t1 1.21e-17
* device instance cc_XD1_t1_XFRT_CKBB r0 *1 0,0
Ccc_XD1_t1_XFRT_CKBB XD1_t1 XFRT_CKBB 1.8151e-17
* device instance cc_XD1_t1_XFRT_CLKB r0 *1 0,0
Ccc_XD1_t1_XFRT_CLKB XD1_t1 XFRT_CLKB 2.4201e-17
* device instance cc_XD1_t1_XFRT_M r0 *1 0,0
Ccc_XD1_t1_XFRT_M XD1_t1 XFRT_M 2.4201e-17
* device instance cc_XD1_t1_XFRT_MB r0 *1 0,0
Ccc_XD1_t1_XFRT_MB XD1_t1 XFRT_MB 1.21e-17
* device instance cc_XD1_t1_XFRT_MFB r0 *1 0,0
Ccc_XD1_t1_XFRT_MFB XD1_t1 XFRT_MFB 1.21e-17
* device instance cc_XD1_t1_XFRT_S r0 *1 0,0
Ccc_XD1_t1_XFRT_S XD1_t1 XFRT_S 1.8151e-17
* device instance cc_XD1_t1_XFRT_SB r0 *1 0,0
Ccc_XD1_t1_XFRT_SB XD1_t1 XFRT_SB 1.8151e-17
* device instance cc_XD1_t1_XFRT_SFB r0 *1 0,0
Ccc_XD1_t1_XFRT_SFB XD1_t1 XFRT_SFB 1.21e-17
* device instance cc_XD1_t1_ck1 r0 *1 0,0
Ccc_XD1_t1_ck1 XD1_t1 ck1 3.0251e-17
* device instance cc_XD1_t1_ck2 r0 *1 0,0
Ccc_XD1_t1_ck2 XD1_t1 ck2 3.6302e-17
* device instance cc_XD1_t1_ck3 r0 *1 0,0
Ccc_XD1_t1_ck3 XD1_t1 ck3 3.0251e-17
* device instance cc_XD1_t1_ck4 r0 *1 0,0
Ccc_XD1_t1_ck4 XD1_t1 ck4 3.0251e-17
* device instance cc_XD1_t1_ck5 r0 *1 0,0
Ccc_XD1_t1_ck5 XD1_t1 ck5 3.0251e-17
* device instance cc_XD1_t1_mod0 r0 *1 0,0
Ccc_XD1_t1_mod0 XD1_t1 mod0 2.4201e-17
* device instance cc_XD1_t1_mod1 r0 *1 0,0
Ccc_XD1_t1_mod1 XD1_t1 mod1 2.4201e-17
* device instance cc_XD1_t1_mod2 r0 *1 0,0
Ccc_XD1_t1_mod2 XD1_t1 mod2 2.4201e-17
* device instance cc_XD1_t1_mod3 r0 *1 0,0
Ccc_XD1_t1_mod3 XD1_t1 mod3 2.4201e-17
* device instance cc_XD1_t1_mod4 r0 *1 0,0
Ccc_XD1_t1_mod4 XD1_t1 mod4 2.4201e-17
* device instance cc_XD1_t1_net1 r0 *1 0,0
Ccc_XD1_t1_net1 XD1_t1 net1 1.21e-17
* device instance cc_XD2_XDFFM_CKBB_XD2_XDFFM_CLKB r0 *1 0,0
Ccc_XD2_XDFFM_CKBB_XD2_XDFFM_CLKB XD2_XDFFM_CKBB XD2_XDFFM_CLKB 3.6302e-17
* device instance cc_XD2_XDFFM_CKBB_XD2_XDFFM_M r0 *1 0,0
Ccc_XD2_XDFFM_CKBB_XD2_XDFFM_M XD2_XDFFM_CKBB XD2_XDFFM_M 4.8402e-17
* device instance cc_XD2_XDFFM_CKBB_XD2_XDFFM_MB r0 *1 0,0
Ccc_XD2_XDFFM_CKBB_XD2_XDFFM_MB XD2_XDFFM_CKBB XD2_XDFFM_MB 2.4201e-17
* device instance cc_XD2_XDFFM_CKBB_XD2_XDFFM_MFB r0 *1 0,0
Ccc_XD2_XDFFM_CKBB_XD2_XDFFM_MFB XD2_XDFFM_CKBB XD2_XDFFM_MFB 2.4201e-17
* device instance cc_XD2_XDFFM_CKBB_XD2_XDFFM_S r0 *1 0,0
Ccc_XD2_XDFFM_CKBB_XD2_XDFFM_S XD2_XDFFM_CKBB XD2_XDFFM_S 3.0251e-17
* device instance cc_XD2_XDFFM_CKBB_XD2_XDFFM_SB r0 *1 0,0
Ccc_XD2_XDFFM_CKBB_XD2_XDFFM_SB XD2_XDFFM_CKBB XD2_XDFFM_SB 3.0251e-17
* device instance cc_XD2_XDFFM_CKBB_XD2_XDFFM_SFB r0 *1 0,0
Ccc_XD2_XDFFM_CKBB_XD2_XDFFM_SFB XD2_XDFFM_CKBB XD2_XDFFM_SFB 1.8151e-17
* device instance cc_XD2_XDFFM_CKBB_XD2_XDFFQ_CKBB r0 *1 0,0
Ccc_XD2_XDFFM_CKBB_XD2_XDFFQ_CKBB XD2_XDFFM_CKBB XD2_XDFFQ_CKBB 1.8151e-17
* device instance cc_XD2_XDFFM_CKBB_XD2_XDFFQ_CLKB r0 *1 0,0
Ccc_XD2_XDFFM_CKBB_XD2_XDFFQ_CLKB XD2_XDFFM_CKBB XD2_XDFFQ_CLKB 2.4201e-17
* device instance cc_XD2_XDFFM_CKBB_XD2_XDFFQ_M r0 *1 0,0
Ccc_XD2_XDFFM_CKBB_XD2_XDFFQ_M XD2_XDFFM_CKBB XD2_XDFFQ_M 2.4201e-17
* device instance cc_XD2_XDFFM_CKBB_XD2_XDFFQ_MB r0 *1 0,0
Ccc_XD2_XDFFM_CKBB_XD2_XDFFQ_MB XD2_XDFFM_CKBB XD2_XDFFQ_MB 1.21e-17
* device instance cc_XD2_XDFFM_CKBB_XD2_XDFFQ_MFB r0 *1 0,0
Ccc_XD2_XDFFM_CKBB_XD2_XDFFQ_MFB XD2_XDFFM_CKBB XD2_XDFFQ_MFB 1.21e-17
* device instance cc_XD2_XDFFM_CKBB_XD2_XDFFQ_S r0 *1 0,0
Ccc_XD2_XDFFM_CKBB_XD2_XDFFQ_S XD2_XDFFM_CKBB XD2_XDFFQ_S 1.8151e-17
* device instance cc_XD2_XDFFM_CKBB_XD2_XDFFQ_SB r0 *1 0,0
Ccc_XD2_XDFFM_CKBB_XD2_XDFFQ_SB XD2_XDFFM_CKBB XD2_XDFFQ_SB 1.8151e-17
* device instance cc_XD2_XDFFM_CKBB_XD2_XDFFQ_SFB r0 *1 0,0
Ccc_XD2_XDFFM_CKBB_XD2_XDFFQ_SFB XD2_XDFFM_CKBB XD2_XDFFQ_SFB 1.21e-17
* device instance cc_XD2_XDFFM_CKBB_XD2_XNOR_midp r0 *1 0,0
Ccc_XD2_XDFFM_CKBB_XD2_XNOR_midp XD2_XDFFM_CKBB XD2_XNOR_midp 1.21e-17
* device instance cc_XD2_XDFFM_CKBB_XD2_dmodout r0 *1 0,0
Ccc_XD2_XDFFM_CKBB_XD2_dmodout XD2_XDFFM_CKBB XD2_dmodout 1.8151e-17
* device instance cc_XD2_XDFFM_CKBB_XD2_dq r0 *1 0,0
Ccc_XD2_XDFFM_CKBB_XD2_dq XD2_XDFFM_CKBB XD2_dq 1.21e-17
* device instance cc_XD2_XDFFM_CKBB_XD2_nm r0 *1 0,0
Ccc_XD2_XDFFM_CKBB_XD2_nm XD2_XDFFM_CKBB XD2_nm 1.8151e-17
* device instance cc_XD2_XDFFM_CKBB_XD2_nt r0 *1 0,0
Ccc_XD2_XDFFM_CKBB_XD2_nt XD2_XDFFM_CKBB XD2_nt 2.4201e-17
* device instance cc_XD2_XDFFM_CKBB_XD2_t1 r0 *1 0,0
Ccc_XD2_XDFFM_CKBB_XD2_t1 XD2_XDFFM_CKBB XD2_t1 1.21e-17
* device instance cc_XD2_XDFFM_CKBB_XD3_XDFFM_CKBB r0 *1 0,0
Ccc_XD2_XDFFM_CKBB_XD3_XDFFM_CKBB XD2_XDFFM_CKBB XD3_XDFFM_CKBB 1.8151e-17
* device instance cc_XD2_XDFFM_CKBB_XD3_XDFFM_CLKB r0 *1 0,0
Ccc_XD2_XDFFM_CKBB_XD3_XDFFM_CLKB XD2_XDFFM_CKBB XD3_XDFFM_CLKB 2.4201e-17
* device instance cc_XD2_XDFFM_CKBB_XD3_XDFFM_M r0 *1 0,0
Ccc_XD2_XDFFM_CKBB_XD3_XDFFM_M XD2_XDFFM_CKBB XD3_XDFFM_M 2.4201e-17
* device instance cc_XD2_XDFFM_CKBB_XD3_XDFFM_MB r0 *1 0,0
Ccc_XD2_XDFFM_CKBB_XD3_XDFFM_MB XD2_XDFFM_CKBB XD3_XDFFM_MB 1.21e-17
* device instance cc_XD2_XDFFM_CKBB_XD3_XDFFM_MFB r0 *1 0,0
Ccc_XD2_XDFFM_CKBB_XD3_XDFFM_MFB XD2_XDFFM_CKBB XD3_XDFFM_MFB 1.21e-17
* device instance cc_XD2_XDFFM_CKBB_XD3_XDFFM_S r0 *1 0,0
Ccc_XD2_XDFFM_CKBB_XD3_XDFFM_S XD2_XDFFM_CKBB XD3_XDFFM_S 1.8151e-17
* device instance cc_XD2_XDFFM_CKBB_XD3_XDFFM_SB r0 *1 0,0
Ccc_XD2_XDFFM_CKBB_XD3_XDFFM_SB XD2_XDFFM_CKBB XD3_XDFFM_SB 1.8151e-17
* device instance cc_XD2_XDFFM_CKBB_XD3_XDFFM_SFB r0 *1 0,0
Ccc_XD2_XDFFM_CKBB_XD3_XDFFM_SFB XD2_XDFFM_CKBB XD3_XDFFM_SFB 1.21e-17
* device instance cc_XD2_XDFFM_CKBB_XD3_XDFFQ_CKBB r0 *1 0,0
Ccc_XD2_XDFFM_CKBB_XD3_XDFFQ_CKBB XD2_XDFFM_CKBB XD3_XDFFQ_CKBB 1.8151e-17
* device instance cc_XD2_XDFFM_CKBB_XD3_XDFFQ_CLKB r0 *1 0,0
Ccc_XD2_XDFFM_CKBB_XD3_XDFFQ_CLKB XD2_XDFFM_CKBB XD3_XDFFQ_CLKB 2.4201e-17
* device instance cc_XD2_XDFFM_CKBB_XD3_XDFFQ_M r0 *1 0,0
Ccc_XD2_XDFFM_CKBB_XD3_XDFFQ_M XD2_XDFFM_CKBB XD3_XDFFQ_M 2.4201e-17
* device instance cc_XD2_XDFFM_CKBB_XD3_XDFFQ_MB r0 *1 0,0
Ccc_XD2_XDFFM_CKBB_XD3_XDFFQ_MB XD2_XDFFM_CKBB XD3_XDFFQ_MB 1.21e-17
* device instance cc_XD2_XDFFM_CKBB_XD3_XDFFQ_MFB r0 *1 0,0
Ccc_XD2_XDFFM_CKBB_XD3_XDFFQ_MFB XD2_XDFFM_CKBB XD3_XDFFQ_MFB 1.21e-17
* device instance cc_XD2_XDFFM_CKBB_XD3_XDFFQ_S r0 *1 0,0
Ccc_XD2_XDFFM_CKBB_XD3_XDFFQ_S XD2_XDFFM_CKBB XD3_XDFFQ_S 1.8151e-17
* device instance cc_XD2_XDFFM_CKBB_XD3_XDFFQ_SB r0 *1 0,0
Ccc_XD2_XDFFM_CKBB_XD3_XDFFQ_SB XD2_XDFFM_CKBB XD3_XDFFQ_SB 1.8151e-17
* device instance cc_XD2_XDFFM_CKBB_XD3_XDFFQ_SFB r0 *1 0,0
Ccc_XD2_XDFFM_CKBB_XD3_XDFFQ_SFB XD2_XDFFM_CKBB XD3_XDFFQ_SFB 1.21e-17
* device instance cc_XD2_XDFFM_CKBB_XD3_XN2_mid1 r0 *1 0,0
Ccc_XD2_XDFFM_CKBB_XD3_XN2_mid1 XD2_XDFFM_CKBB XD3_XN2_mid1 1.21e-17
* device instance cc_XD2_XDFFM_CKBB_XD3_XN3_mid1 r0 *1 0,0
Ccc_XD2_XDFFM_CKBB_XD3_XN3_mid1 XD2_XDFFM_CKBB XD3_XN3_mid1 1.21e-17
* device instance cc_XD2_XDFFM_CKBB_XD3_XN3_mid2 r0 *1 0,0
Ccc_XD2_XDFFM_CKBB_XD3_XN3_mid2 XD2_XDFFM_CKBB XD3_XN3_mid2 1.21e-17
* device instance cc_XD2_XDFFM_CKBB_XD3_dmodout r0 *1 0,0
Ccc_XD2_XDFFM_CKBB_XD3_dmodout XD2_XDFFM_CKBB XD3_dmodout 1.21e-17
* device instance cc_XD2_XDFFM_CKBB_XD3_dq r0 *1 0,0
Ccc_XD2_XDFFM_CKBB_XD3_dq XD2_XDFFM_CKBB XD3_dq 1.8151e-17
* device instance cc_XD2_XDFFM_CKBB_XD3_nm r0 *1 0,0
Ccc_XD2_XDFFM_CKBB_XD3_nm XD2_XDFFM_CKBB XD3_nm 1.21e-17
* device instance cc_XD2_XDFFM_CKBB_XD3_nt r0 *1 0,0
Ccc_XD2_XDFFM_CKBB_XD3_nt XD2_XDFFM_CKBB XD3_nt 1.21e-17
* device instance cc_XD2_XDFFM_CKBB_XD3_t1 r0 *1 0,0
Ccc_XD2_XDFFM_CKBB_XD3_t1 XD2_XDFFM_CKBB XD3_t1 1.21e-17
* device instance cc_XD2_XDFFM_CKBB_XD4_XDFFM_CKBB r0 *1 0,0
Ccc_XD2_XDFFM_CKBB_XD4_XDFFM_CKBB XD2_XDFFM_CKBB XD4_XDFFM_CKBB 1.8151e-17
* device instance cc_XD2_XDFFM_CKBB_XD4_XDFFM_CLKB r0 *1 0,0
Ccc_XD2_XDFFM_CKBB_XD4_XDFFM_CLKB XD2_XDFFM_CKBB XD4_XDFFM_CLKB 2.4201e-17
* device instance cc_XD2_XDFFM_CKBB_XD4_XDFFM_M r0 *1 0,0
Ccc_XD2_XDFFM_CKBB_XD4_XDFFM_M XD2_XDFFM_CKBB XD4_XDFFM_M 2.4201e-17
* device instance cc_XD2_XDFFM_CKBB_XD4_XDFFM_MB r0 *1 0,0
Ccc_XD2_XDFFM_CKBB_XD4_XDFFM_MB XD2_XDFFM_CKBB XD4_XDFFM_MB 1.21e-17
* device instance cc_XD2_XDFFM_CKBB_XD4_XDFFM_MFB r0 *1 0,0
Ccc_XD2_XDFFM_CKBB_XD4_XDFFM_MFB XD2_XDFFM_CKBB XD4_XDFFM_MFB 1.21e-17
* device instance cc_XD2_XDFFM_CKBB_XD4_XDFFM_S r0 *1 0,0
Ccc_XD2_XDFFM_CKBB_XD4_XDFFM_S XD2_XDFFM_CKBB XD4_XDFFM_S 1.8151e-17
* device instance cc_XD2_XDFFM_CKBB_XD4_XDFFM_SB r0 *1 0,0
Ccc_XD2_XDFFM_CKBB_XD4_XDFFM_SB XD2_XDFFM_CKBB XD4_XDFFM_SB 1.8151e-17
* device instance cc_XD2_XDFFM_CKBB_XD4_XDFFM_SFB r0 *1 0,0
Ccc_XD2_XDFFM_CKBB_XD4_XDFFM_SFB XD2_XDFFM_CKBB XD4_XDFFM_SFB 1.21e-17
* device instance cc_XD2_XDFFM_CKBB_XD4_XDFFQ_CKBB r0 *1 0,0
Ccc_XD2_XDFFM_CKBB_XD4_XDFFQ_CKBB XD2_XDFFM_CKBB XD4_XDFFQ_CKBB 1.8151e-17
* device instance cc_XD2_XDFFM_CKBB_XD4_XDFFQ_CLKB r0 *1 0,0
Ccc_XD2_XDFFM_CKBB_XD4_XDFFQ_CLKB XD2_XDFFM_CKBB XD4_XDFFQ_CLKB 2.4201e-17
* device instance cc_XD2_XDFFM_CKBB_XD4_XDFFQ_M r0 *1 0,0
Ccc_XD2_XDFFM_CKBB_XD4_XDFFQ_M XD2_XDFFM_CKBB XD4_XDFFQ_M 2.4201e-17
* device instance cc_XD2_XDFFM_CKBB_XD4_XDFFQ_MB r0 *1 0,0
Ccc_XD2_XDFFM_CKBB_XD4_XDFFQ_MB XD2_XDFFM_CKBB XD4_XDFFQ_MB 1.21e-17
* device instance cc_XD2_XDFFM_CKBB_XD4_XDFFQ_MFB r0 *1 0,0
Ccc_XD2_XDFFM_CKBB_XD4_XDFFQ_MFB XD2_XDFFM_CKBB XD4_XDFFQ_MFB 1.21e-17
* device instance cc_XD2_XDFFM_CKBB_XD4_XDFFQ_S r0 *1 0,0
Ccc_XD2_XDFFM_CKBB_XD4_XDFFQ_S XD2_XDFFM_CKBB XD4_XDFFQ_S 1.8151e-17
* device instance cc_XD2_XDFFM_CKBB_XD4_XDFFQ_SB r0 *1 0,0
Ccc_XD2_XDFFM_CKBB_XD4_XDFFQ_SB XD2_XDFFM_CKBB XD4_XDFFQ_SB 1.8151e-17
* device instance cc_XD2_XDFFM_CKBB_XD4_XDFFQ_SFB r0 *1 0,0
Ccc_XD2_XDFFM_CKBB_XD4_XDFFQ_SFB XD2_XDFFM_CKBB XD4_XDFFQ_SFB 1.21e-17
* device instance cc_XD2_XDFFM_CKBB_XD4_XN2_mid1 r0 *1 0,0
Ccc_XD2_XDFFM_CKBB_XD4_XN2_mid1 XD2_XDFFM_CKBB XD4_XN2_mid1 1.21e-17
* device instance cc_XD2_XDFFM_CKBB_XD4_XN3_mid1 r0 *1 0,0
Ccc_XD2_XDFFM_CKBB_XD4_XN3_mid1 XD2_XDFFM_CKBB XD4_XN3_mid1 1.21e-17
* device instance cc_XD2_XDFFM_CKBB_XD4_XN3_mid2 r0 *1 0,0
Ccc_XD2_XDFFM_CKBB_XD4_XN3_mid2 XD2_XDFFM_CKBB XD4_XN3_mid2 1.21e-17
* device instance cc_XD2_XDFFM_CKBB_XD4_dmodout r0 *1 0,0
Ccc_XD2_XDFFM_CKBB_XD4_dmodout XD2_XDFFM_CKBB XD4_dmodout 1.21e-17
* device instance cc_XD2_XDFFM_CKBB_XD4_dq r0 *1 0,0
Ccc_XD2_XDFFM_CKBB_XD4_dq XD2_XDFFM_CKBB XD4_dq 1.8151e-17
* device instance cc_XD2_XDFFM_CKBB_XD4_nm r0 *1 0,0
Ccc_XD2_XDFFM_CKBB_XD4_nm XD2_XDFFM_CKBB XD4_nm 1.21e-17
* device instance cc_XD2_XDFFM_CKBB_XD4_nt r0 *1 0,0
Ccc_XD2_XDFFM_CKBB_XD4_nt XD2_XDFFM_CKBB XD4_nt 1.21e-17
* device instance cc_XD2_XDFFM_CKBB_XD4_t1 r0 *1 0,0
Ccc_XD2_XDFFM_CKBB_XD4_t1 XD2_XDFFM_CKBB XD4_t1 1.21e-17
* device instance cc_XD2_XDFFM_CKBB_XD5_XDFFM_CKBB r0 *1 0,0
Ccc_XD2_XDFFM_CKBB_XD5_XDFFM_CKBB XD2_XDFFM_CKBB XD5_XDFFM_CKBB 1.8151e-17
* device instance cc_XD2_XDFFM_CKBB_XD5_XDFFM_CLKB r0 *1 0,0
Ccc_XD2_XDFFM_CKBB_XD5_XDFFM_CLKB XD2_XDFFM_CKBB XD5_XDFFM_CLKB 2.4201e-17
* device instance cc_XD2_XDFFM_CKBB_XD5_XDFFM_M r0 *1 0,0
Ccc_XD2_XDFFM_CKBB_XD5_XDFFM_M XD2_XDFFM_CKBB XD5_XDFFM_M 2.4201e-17
* device instance cc_XD2_XDFFM_CKBB_XD5_XDFFM_MB r0 *1 0,0
Ccc_XD2_XDFFM_CKBB_XD5_XDFFM_MB XD2_XDFFM_CKBB XD5_XDFFM_MB 1.21e-17
* device instance cc_XD2_XDFFM_CKBB_XD5_XDFFM_MFB r0 *1 0,0
Ccc_XD2_XDFFM_CKBB_XD5_XDFFM_MFB XD2_XDFFM_CKBB XD5_XDFFM_MFB 1.21e-17
* device instance cc_XD2_XDFFM_CKBB_XD5_XDFFM_S r0 *1 0,0
Ccc_XD2_XDFFM_CKBB_XD5_XDFFM_S XD2_XDFFM_CKBB XD5_XDFFM_S 1.8151e-17
* device instance cc_XD2_XDFFM_CKBB_XD5_XDFFM_SB r0 *1 0,0
Ccc_XD2_XDFFM_CKBB_XD5_XDFFM_SB XD2_XDFFM_CKBB XD5_XDFFM_SB 1.8151e-17
* device instance cc_XD2_XDFFM_CKBB_XD5_XDFFM_SFB r0 *1 0,0
Ccc_XD2_XDFFM_CKBB_XD5_XDFFM_SFB XD2_XDFFM_CKBB XD5_XDFFM_SFB 1.21e-17
* device instance cc_XD2_XDFFM_CKBB_XD5_XDFFQ_CKBB r0 *1 0,0
Ccc_XD2_XDFFM_CKBB_XD5_XDFFQ_CKBB XD2_XDFFM_CKBB XD5_XDFFQ_CKBB 1.8151e-17
* device instance cc_XD2_XDFFM_CKBB_XD5_XDFFQ_CLKB r0 *1 0,0
Ccc_XD2_XDFFM_CKBB_XD5_XDFFQ_CLKB XD2_XDFFM_CKBB XD5_XDFFQ_CLKB 2.4201e-17
* device instance cc_XD2_XDFFM_CKBB_XD5_XDFFQ_M r0 *1 0,0
Ccc_XD2_XDFFM_CKBB_XD5_XDFFQ_M XD2_XDFFM_CKBB XD5_XDFFQ_M 2.4201e-17
* device instance cc_XD2_XDFFM_CKBB_XD5_XDFFQ_MB r0 *1 0,0
Ccc_XD2_XDFFM_CKBB_XD5_XDFFQ_MB XD2_XDFFM_CKBB XD5_XDFFQ_MB 1.21e-17
* device instance cc_XD2_XDFFM_CKBB_XD5_XDFFQ_MFB r0 *1 0,0
Ccc_XD2_XDFFM_CKBB_XD5_XDFFQ_MFB XD2_XDFFM_CKBB XD5_XDFFQ_MFB 1.21e-17
* device instance cc_XD2_XDFFM_CKBB_XD5_XDFFQ_S r0 *1 0,0
Ccc_XD2_XDFFM_CKBB_XD5_XDFFQ_S XD2_XDFFM_CKBB XD5_XDFFQ_S 1.8151e-17
* device instance cc_XD2_XDFFM_CKBB_XD5_XDFFQ_SB r0 *1 0,0
Ccc_XD2_XDFFM_CKBB_XD5_XDFFQ_SB XD2_XDFFM_CKBB XD5_XDFFQ_SB 1.8151e-17
* device instance cc_XD2_XDFFM_CKBB_XD5_XDFFQ_SFB r0 *1 0,0
Ccc_XD2_XDFFM_CKBB_XD5_XDFFQ_SFB XD2_XDFFM_CKBB XD5_XDFFQ_SFB 1.21e-17
* device instance cc_XD2_XDFFM_CKBB_XD5_XN2_mid1 r0 *1 0,0
Ccc_XD2_XDFFM_CKBB_XD5_XN2_mid1 XD2_XDFFM_CKBB XD5_XN2_mid1 1.21e-17
* device instance cc_XD2_XDFFM_CKBB_XD5_XN3_mid1 r0 *1 0,0
Ccc_XD2_XDFFM_CKBB_XD5_XN3_mid1 XD2_XDFFM_CKBB XD5_XN3_mid1 1.21e-17
* device instance cc_XD2_XDFFM_CKBB_XD5_XN3_mid2 r0 *1 0,0
Ccc_XD2_XDFFM_CKBB_XD5_XN3_mid2 XD2_XDFFM_CKBB XD5_XN3_mid2 1.21e-17
* device instance cc_XD2_XDFFM_CKBB_XD5_dmodout r0 *1 0,0
Ccc_XD2_XDFFM_CKBB_XD5_dmodout XD2_XDFFM_CKBB XD5_dmodout 1.21e-17
* device instance cc_XD2_XDFFM_CKBB_XD5_dq r0 *1 0,0
Ccc_XD2_XDFFM_CKBB_XD5_dq XD2_XDFFM_CKBB XD5_dq 1.8151e-17
* device instance cc_XD2_XDFFM_CKBB_XD5_nm r0 *1 0,0
Ccc_XD2_XDFFM_CKBB_XD5_nm XD2_XDFFM_CKBB XD5_nm 1.21e-17
* device instance cc_XD2_XDFFM_CKBB_XD5_nt r0 *1 0,0
Ccc_XD2_XDFFM_CKBB_XD5_nt XD2_XDFFM_CKBB XD5_nt 1.21e-17
* device instance cc_XD2_XDFFM_CKBB_XD5_t1 r0 *1 0,0
Ccc_XD2_XDFFM_CKBB_XD5_t1 XD2_XDFFM_CKBB XD5_t1 1.21e-17
* device instance cc_XD2_XDFFM_CKBB_XFRT_CKBB r0 *1 0,0
Ccc_XD2_XDFFM_CKBB_XFRT_CKBB XD2_XDFFM_CKBB XFRT_CKBB 1.8151e-17
* device instance cc_XD2_XDFFM_CKBB_XFRT_CLKB r0 *1 0,0
Ccc_XD2_XDFFM_CKBB_XFRT_CLKB XD2_XDFFM_CKBB XFRT_CLKB 2.4201e-17
* device instance cc_XD2_XDFFM_CKBB_XFRT_M r0 *1 0,0
Ccc_XD2_XDFFM_CKBB_XFRT_M XD2_XDFFM_CKBB XFRT_M 2.4201e-17
* device instance cc_XD2_XDFFM_CKBB_XFRT_MB r0 *1 0,0
Ccc_XD2_XDFFM_CKBB_XFRT_MB XD2_XDFFM_CKBB XFRT_MB 1.21e-17
* device instance cc_XD2_XDFFM_CKBB_XFRT_MFB r0 *1 0,0
Ccc_XD2_XDFFM_CKBB_XFRT_MFB XD2_XDFFM_CKBB XFRT_MFB 1.21e-17
* device instance cc_XD2_XDFFM_CKBB_XFRT_S r0 *1 0,0
Ccc_XD2_XDFFM_CKBB_XFRT_S XD2_XDFFM_CKBB XFRT_S 1.8151e-17
* device instance cc_XD2_XDFFM_CKBB_XFRT_SB r0 *1 0,0
Ccc_XD2_XDFFM_CKBB_XFRT_SB XD2_XDFFM_CKBB XFRT_SB 1.8151e-17
* device instance cc_XD2_XDFFM_CKBB_XFRT_SFB r0 *1 0,0
Ccc_XD2_XDFFM_CKBB_XFRT_SFB XD2_XDFFM_CKBB XFRT_SFB 1.21e-17
* device instance cc_XD2_XDFFM_CKBB_ck1 r0 *1 0,0
Ccc_XD2_XDFFM_CKBB_ck1 XD2_XDFFM_CKBB ck1 3.0251e-17
* device instance cc_XD2_XDFFM_CKBB_ck2 r0 *1 0,0
Ccc_XD2_XDFFM_CKBB_ck2 XD2_XDFFM_CKBB ck2 3.0251e-17
* device instance cc_XD2_XDFFM_CKBB_ck3 r0 *1 0,0
Ccc_XD2_XDFFM_CKBB_ck3 XD2_XDFFM_CKBB ck3 3.0251e-17
* device instance cc_XD2_XDFFM_CKBB_ck4 r0 *1 0,0
Ccc_XD2_XDFFM_CKBB_ck4 XD2_XDFFM_CKBB ck4 3.0251e-17
* device instance cc_XD2_XDFFM_CKBB_ck5 r0 *1 0,0
Ccc_XD2_XDFFM_CKBB_ck5 XD2_XDFFM_CKBB ck5 3.0251e-17
* device instance cc_XD2_XDFFM_CKBB_mod0 r0 *1 0,0
Ccc_XD2_XDFFM_CKBB_mod0 XD2_XDFFM_CKBB mod0 2.4201e-17
* device instance cc_XD2_XDFFM_CKBB_mod1 r0 *1 0,0
Ccc_XD2_XDFFM_CKBB_mod1 XD2_XDFFM_CKBB mod1 2.4201e-17
* device instance cc_XD2_XDFFM_CKBB_mod2 r0 *1 0,0
Ccc_XD2_XDFFM_CKBB_mod2 XD2_XDFFM_CKBB mod2 2.4201e-17
* device instance cc_XD2_XDFFM_CKBB_mod3 r0 *1 0,0
Ccc_XD2_XDFFM_CKBB_mod3 XD2_XDFFM_CKBB mod3 2.4201e-17
* device instance cc_XD2_XDFFM_CKBB_mod4 r0 *1 0,0
Ccc_XD2_XDFFM_CKBB_mod4 XD2_XDFFM_CKBB mod4 2.4201e-17
* device instance cc_XD2_XDFFM_CKBB_net1 r0 *1 0,0
Ccc_XD2_XDFFM_CKBB_net1 XD2_XDFFM_CKBB net1 1.21e-17
* device instance cc_XD2_XDFFM_CLKB_XD2_XDFFM_M r0 *1 0,0
Ccc_XD2_XDFFM_CLKB_XD2_XDFFM_M XD2_XDFFM_CLKB XD2_XDFFM_M 4.2352e-17
* device instance cc_XD2_XDFFM_CLKB_XD2_XDFFM_MB r0 *1 0,0
Ccc_XD2_XDFFM_CLKB_XD2_XDFFM_MB XD2_XDFFM_CLKB XD2_XDFFM_MB 2.4201e-17
* device instance cc_XD2_XDFFM_CLKB_XD2_XDFFM_MFB r0 *1 0,0
Ccc_XD2_XDFFM_CLKB_XD2_XDFFM_MFB XD2_XDFFM_CLKB XD2_XDFFM_MFB 2.4201e-17
* device instance cc_XD2_XDFFM_CLKB_XD2_XDFFM_S r0 *1 0,0
Ccc_XD2_XDFFM_CLKB_XD2_XDFFM_S XD2_XDFFM_CLKB XD2_XDFFM_S 1.8151e-17
* device instance cc_XD2_XDFFM_CLKB_XD2_XDFFM_SB r0 *1 0,0
Ccc_XD2_XDFFM_CLKB_XD2_XDFFM_SB XD2_XDFFM_CLKB XD2_XDFFM_SB 1.8151e-17
* device instance cc_XD2_XDFFM_CLKB_XD2_XDFFM_SFB r0 *1 0,0
Ccc_XD2_XDFFM_CLKB_XD2_XDFFM_SFB XD2_XDFFM_CLKB XD2_XDFFM_SFB 1.21e-17
* device instance cc_XD2_XDFFM_CLKB_XD2_XDFFQ_CKBB r0 *1 0,0
Ccc_XD2_XDFFM_CLKB_XD2_XDFFQ_CKBB XD2_XDFFM_CLKB XD2_XDFFQ_CKBB 1.8151e-17
* device instance cc_XD2_XDFFM_CLKB_XD2_XDFFQ_CLKB r0 *1 0,0
Ccc_XD2_XDFFM_CLKB_XD2_XDFFQ_CLKB XD2_XDFFM_CLKB XD2_XDFFQ_CLKB 2.4201e-17
* device instance cc_XD2_XDFFM_CLKB_XD2_XDFFQ_M r0 *1 0,0
Ccc_XD2_XDFFM_CLKB_XD2_XDFFQ_M XD2_XDFFM_CLKB XD2_XDFFQ_M 2.4201e-17
* device instance cc_XD2_XDFFM_CLKB_XD2_XDFFQ_MB r0 *1 0,0
Ccc_XD2_XDFFM_CLKB_XD2_XDFFQ_MB XD2_XDFFM_CLKB XD2_XDFFQ_MB 1.21e-17
* device instance cc_XD2_XDFFM_CLKB_XD2_XDFFQ_MFB r0 *1 0,0
Ccc_XD2_XDFFM_CLKB_XD2_XDFFQ_MFB XD2_XDFFM_CLKB XD2_XDFFQ_MFB 1.21e-17
* device instance cc_XD2_XDFFM_CLKB_XD2_XDFFQ_S r0 *1 0,0
Ccc_XD2_XDFFM_CLKB_XD2_XDFFQ_S XD2_XDFFM_CLKB XD2_XDFFQ_S 1.8151e-17
* device instance cc_XD2_XDFFM_CLKB_XD2_XDFFQ_SB r0 *1 0,0
Ccc_XD2_XDFFM_CLKB_XD2_XDFFQ_SB XD2_XDFFM_CLKB XD2_XDFFQ_SB 1.8151e-17
* device instance cc_XD2_XDFFM_CLKB_XD2_XDFFQ_SFB r0 *1 0,0
Ccc_XD2_XDFFM_CLKB_XD2_XDFFQ_SFB XD2_XDFFM_CLKB XD2_XDFFQ_SFB 1.21e-17
* device instance cc_XD2_XDFFM_CLKB_XD2_XNOR_midp r0 *1 0,0
Ccc_XD2_XDFFM_CLKB_XD2_XNOR_midp XD2_XDFFM_CLKB XD2_XNOR_midp 1.21e-17
* device instance cc_XD2_XDFFM_CLKB_XD2_dmodout r0 *1 0,0
Ccc_XD2_XDFFM_CLKB_XD2_dmodout XD2_XDFFM_CLKB XD2_dmodout 1.8151e-17
* device instance cc_XD2_XDFFM_CLKB_XD2_dq r0 *1 0,0
Ccc_XD2_XDFFM_CLKB_XD2_dq XD2_XDFFM_CLKB XD2_dq 1.21e-17
* device instance cc_XD2_XDFFM_CLKB_XD2_nm r0 *1 0,0
Ccc_XD2_XDFFM_CLKB_XD2_nm XD2_XDFFM_CLKB XD2_nm 1.8151e-17
* device instance cc_XD2_XDFFM_CLKB_XD2_nt r0 *1 0,0
Ccc_XD2_XDFFM_CLKB_XD2_nt XD2_XDFFM_CLKB XD2_nt 2.4201e-17
* device instance cc_XD2_XDFFM_CLKB_XD2_t1 r0 *1 0,0
Ccc_XD2_XDFFM_CLKB_XD2_t1 XD2_XDFFM_CLKB XD2_t1 1.21e-17
* device instance cc_XD2_XDFFM_CLKB_XD3_XDFFM_CKBB r0 *1 0,0
Ccc_XD2_XDFFM_CLKB_XD3_XDFFM_CKBB XD2_XDFFM_CLKB XD3_XDFFM_CKBB 1.8151e-17
* device instance cc_XD2_XDFFM_CLKB_XD3_XDFFM_CLKB r0 *1 0,0
Ccc_XD2_XDFFM_CLKB_XD3_XDFFM_CLKB XD2_XDFFM_CLKB XD3_XDFFM_CLKB 2.4201e-17
* device instance cc_XD2_XDFFM_CLKB_XD3_XDFFM_M r0 *1 0,0
Ccc_XD2_XDFFM_CLKB_XD3_XDFFM_M XD2_XDFFM_CLKB XD3_XDFFM_M 2.4201e-17
* device instance cc_XD2_XDFFM_CLKB_XD3_XDFFM_MB r0 *1 0,0
Ccc_XD2_XDFFM_CLKB_XD3_XDFFM_MB XD2_XDFFM_CLKB XD3_XDFFM_MB 1.21e-17
* device instance cc_XD2_XDFFM_CLKB_XD3_XDFFM_MFB r0 *1 0,0
Ccc_XD2_XDFFM_CLKB_XD3_XDFFM_MFB XD2_XDFFM_CLKB XD3_XDFFM_MFB 1.21e-17
* device instance cc_XD2_XDFFM_CLKB_XD3_XDFFM_S r0 *1 0,0
Ccc_XD2_XDFFM_CLKB_XD3_XDFFM_S XD2_XDFFM_CLKB XD3_XDFFM_S 1.8151e-17
* device instance cc_XD2_XDFFM_CLKB_XD3_XDFFM_SB r0 *1 0,0
Ccc_XD2_XDFFM_CLKB_XD3_XDFFM_SB XD2_XDFFM_CLKB XD3_XDFFM_SB 1.8151e-17
* device instance cc_XD2_XDFFM_CLKB_XD3_XDFFM_SFB r0 *1 0,0
Ccc_XD2_XDFFM_CLKB_XD3_XDFFM_SFB XD2_XDFFM_CLKB XD3_XDFFM_SFB 1.21e-17
* device instance cc_XD2_XDFFM_CLKB_XD3_XDFFQ_CKBB r0 *1 0,0
Ccc_XD2_XDFFM_CLKB_XD3_XDFFQ_CKBB XD2_XDFFM_CLKB XD3_XDFFQ_CKBB 1.8151e-17
* device instance cc_XD2_XDFFM_CLKB_XD3_XDFFQ_CLKB r0 *1 0,0
Ccc_XD2_XDFFM_CLKB_XD3_XDFFQ_CLKB XD2_XDFFM_CLKB XD3_XDFFQ_CLKB 2.4201e-17
* device instance cc_XD2_XDFFM_CLKB_XD3_XDFFQ_M r0 *1 0,0
Ccc_XD2_XDFFM_CLKB_XD3_XDFFQ_M XD2_XDFFM_CLKB XD3_XDFFQ_M 2.4201e-17
* device instance cc_XD2_XDFFM_CLKB_XD3_XDFFQ_MB r0 *1 0,0
Ccc_XD2_XDFFM_CLKB_XD3_XDFFQ_MB XD2_XDFFM_CLKB XD3_XDFFQ_MB 1.21e-17
* device instance cc_XD2_XDFFM_CLKB_XD3_XDFFQ_MFB r0 *1 0,0
Ccc_XD2_XDFFM_CLKB_XD3_XDFFQ_MFB XD2_XDFFM_CLKB XD3_XDFFQ_MFB 1.21e-17
* device instance cc_XD2_XDFFM_CLKB_XD3_XDFFQ_S r0 *1 0,0
Ccc_XD2_XDFFM_CLKB_XD3_XDFFQ_S XD2_XDFFM_CLKB XD3_XDFFQ_S 1.8151e-17
* device instance cc_XD2_XDFFM_CLKB_XD3_XDFFQ_SB r0 *1 0,0
Ccc_XD2_XDFFM_CLKB_XD3_XDFFQ_SB XD2_XDFFM_CLKB XD3_XDFFQ_SB 1.8151e-17
* device instance cc_XD2_XDFFM_CLKB_XD3_XDFFQ_SFB r0 *1 0,0
Ccc_XD2_XDFFM_CLKB_XD3_XDFFQ_SFB XD2_XDFFM_CLKB XD3_XDFFQ_SFB 1.21e-17
* device instance cc_XD2_XDFFM_CLKB_XD3_XN2_mid1 r0 *1 0,0
Ccc_XD2_XDFFM_CLKB_XD3_XN2_mid1 XD2_XDFFM_CLKB XD3_XN2_mid1 1.21e-17
* device instance cc_XD2_XDFFM_CLKB_XD3_XN3_mid1 r0 *1 0,0
Ccc_XD2_XDFFM_CLKB_XD3_XN3_mid1 XD2_XDFFM_CLKB XD3_XN3_mid1 1.21e-17
* device instance cc_XD2_XDFFM_CLKB_XD3_XN3_mid2 r0 *1 0,0
Ccc_XD2_XDFFM_CLKB_XD3_XN3_mid2 XD2_XDFFM_CLKB XD3_XN3_mid2 1.21e-17
* device instance cc_XD2_XDFFM_CLKB_XD3_dmodout r0 *1 0,0
Ccc_XD2_XDFFM_CLKB_XD3_dmodout XD2_XDFFM_CLKB XD3_dmodout 1.21e-17
* device instance cc_XD2_XDFFM_CLKB_XD3_dq r0 *1 0,0
Ccc_XD2_XDFFM_CLKB_XD3_dq XD2_XDFFM_CLKB XD3_dq 1.8151e-17
* device instance cc_XD2_XDFFM_CLKB_XD3_nm r0 *1 0,0
Ccc_XD2_XDFFM_CLKB_XD3_nm XD2_XDFFM_CLKB XD3_nm 1.21e-17
* device instance cc_XD2_XDFFM_CLKB_XD3_nt r0 *1 0,0
Ccc_XD2_XDFFM_CLKB_XD3_nt XD2_XDFFM_CLKB XD3_nt 1.21e-17
* device instance cc_XD2_XDFFM_CLKB_XD3_t1 r0 *1 0,0
Ccc_XD2_XDFFM_CLKB_XD3_t1 XD2_XDFFM_CLKB XD3_t1 1.21e-17
* device instance cc_XD2_XDFFM_CLKB_XD4_XDFFM_CKBB r0 *1 0,0
Ccc_XD2_XDFFM_CLKB_XD4_XDFFM_CKBB XD2_XDFFM_CLKB XD4_XDFFM_CKBB 1.8151e-17
* device instance cc_XD2_XDFFM_CLKB_XD4_XDFFM_CLKB r0 *1 0,0
Ccc_XD2_XDFFM_CLKB_XD4_XDFFM_CLKB XD2_XDFFM_CLKB XD4_XDFFM_CLKB 2.4201e-17
* device instance cc_XD2_XDFFM_CLKB_XD4_XDFFM_M r0 *1 0,0
Ccc_XD2_XDFFM_CLKB_XD4_XDFFM_M XD2_XDFFM_CLKB XD4_XDFFM_M 2.4201e-17
* device instance cc_XD2_XDFFM_CLKB_XD4_XDFFM_MB r0 *1 0,0
Ccc_XD2_XDFFM_CLKB_XD4_XDFFM_MB XD2_XDFFM_CLKB XD4_XDFFM_MB 1.21e-17
* device instance cc_XD2_XDFFM_CLKB_XD4_XDFFM_MFB r0 *1 0,0
Ccc_XD2_XDFFM_CLKB_XD4_XDFFM_MFB XD2_XDFFM_CLKB XD4_XDFFM_MFB 1.21e-17
* device instance cc_XD2_XDFFM_CLKB_XD4_XDFFM_S r0 *1 0,0
Ccc_XD2_XDFFM_CLKB_XD4_XDFFM_S XD2_XDFFM_CLKB XD4_XDFFM_S 1.8151e-17
* device instance cc_XD2_XDFFM_CLKB_XD4_XDFFM_SB r0 *1 0,0
Ccc_XD2_XDFFM_CLKB_XD4_XDFFM_SB XD2_XDFFM_CLKB XD4_XDFFM_SB 1.8151e-17
* device instance cc_XD2_XDFFM_CLKB_XD4_XDFFM_SFB r0 *1 0,0
Ccc_XD2_XDFFM_CLKB_XD4_XDFFM_SFB XD2_XDFFM_CLKB XD4_XDFFM_SFB 1.21e-17
* device instance cc_XD2_XDFFM_CLKB_XD4_XDFFQ_CKBB r0 *1 0,0
Ccc_XD2_XDFFM_CLKB_XD4_XDFFQ_CKBB XD2_XDFFM_CLKB XD4_XDFFQ_CKBB 1.8151e-17
* device instance cc_XD2_XDFFM_CLKB_XD4_XDFFQ_CLKB r0 *1 0,0
Ccc_XD2_XDFFM_CLKB_XD4_XDFFQ_CLKB XD2_XDFFM_CLKB XD4_XDFFQ_CLKB 2.4201e-17
* device instance cc_XD2_XDFFM_CLKB_XD4_XDFFQ_M r0 *1 0,0
Ccc_XD2_XDFFM_CLKB_XD4_XDFFQ_M XD2_XDFFM_CLKB XD4_XDFFQ_M 2.4201e-17
* device instance cc_XD2_XDFFM_CLKB_XD4_XDFFQ_MB r0 *1 0,0
Ccc_XD2_XDFFM_CLKB_XD4_XDFFQ_MB XD2_XDFFM_CLKB XD4_XDFFQ_MB 1.21e-17
* device instance cc_XD2_XDFFM_CLKB_XD4_XDFFQ_MFB r0 *1 0,0
Ccc_XD2_XDFFM_CLKB_XD4_XDFFQ_MFB XD2_XDFFM_CLKB XD4_XDFFQ_MFB 1.21e-17
* device instance cc_XD2_XDFFM_CLKB_XD4_XDFFQ_S r0 *1 0,0
Ccc_XD2_XDFFM_CLKB_XD4_XDFFQ_S XD2_XDFFM_CLKB XD4_XDFFQ_S 1.8151e-17
* device instance cc_XD2_XDFFM_CLKB_XD4_XDFFQ_SB r0 *1 0,0
Ccc_XD2_XDFFM_CLKB_XD4_XDFFQ_SB XD2_XDFFM_CLKB XD4_XDFFQ_SB 1.8151e-17
* device instance cc_XD2_XDFFM_CLKB_XD4_XDFFQ_SFB r0 *1 0,0
Ccc_XD2_XDFFM_CLKB_XD4_XDFFQ_SFB XD2_XDFFM_CLKB XD4_XDFFQ_SFB 1.21e-17
* device instance cc_XD2_XDFFM_CLKB_XD4_XN2_mid1 r0 *1 0,0
Ccc_XD2_XDFFM_CLKB_XD4_XN2_mid1 XD2_XDFFM_CLKB XD4_XN2_mid1 1.21e-17
* device instance cc_XD2_XDFFM_CLKB_XD4_XN3_mid1 r0 *1 0,0
Ccc_XD2_XDFFM_CLKB_XD4_XN3_mid1 XD2_XDFFM_CLKB XD4_XN3_mid1 1.21e-17
* device instance cc_XD2_XDFFM_CLKB_XD4_XN3_mid2 r0 *1 0,0
Ccc_XD2_XDFFM_CLKB_XD4_XN3_mid2 XD2_XDFFM_CLKB XD4_XN3_mid2 1.21e-17
* device instance cc_XD2_XDFFM_CLKB_XD4_dmodout r0 *1 0,0
Ccc_XD2_XDFFM_CLKB_XD4_dmodout XD2_XDFFM_CLKB XD4_dmodout 1.21e-17
* device instance cc_XD2_XDFFM_CLKB_XD4_dq r0 *1 0,0
Ccc_XD2_XDFFM_CLKB_XD4_dq XD2_XDFFM_CLKB XD4_dq 1.8151e-17
* device instance cc_XD2_XDFFM_CLKB_XD4_nm r0 *1 0,0
Ccc_XD2_XDFFM_CLKB_XD4_nm XD2_XDFFM_CLKB XD4_nm 1.21e-17
* device instance cc_XD2_XDFFM_CLKB_XD4_nt r0 *1 0,0
Ccc_XD2_XDFFM_CLKB_XD4_nt XD2_XDFFM_CLKB XD4_nt 1.21e-17
* device instance cc_XD2_XDFFM_CLKB_XD4_t1 r0 *1 0,0
Ccc_XD2_XDFFM_CLKB_XD4_t1 XD2_XDFFM_CLKB XD4_t1 1.21e-17
* device instance cc_XD2_XDFFM_CLKB_XD5_XDFFM_CKBB r0 *1 0,0
Ccc_XD2_XDFFM_CLKB_XD5_XDFFM_CKBB XD2_XDFFM_CLKB XD5_XDFFM_CKBB 1.8151e-17
* device instance cc_XD2_XDFFM_CLKB_XD5_XDFFM_CLKB r0 *1 0,0
Ccc_XD2_XDFFM_CLKB_XD5_XDFFM_CLKB XD2_XDFFM_CLKB XD5_XDFFM_CLKB 2.4201e-17
* device instance cc_XD2_XDFFM_CLKB_XD5_XDFFM_M r0 *1 0,0
Ccc_XD2_XDFFM_CLKB_XD5_XDFFM_M XD2_XDFFM_CLKB XD5_XDFFM_M 2.4201e-17
* device instance cc_XD2_XDFFM_CLKB_XD5_XDFFM_MB r0 *1 0,0
Ccc_XD2_XDFFM_CLKB_XD5_XDFFM_MB XD2_XDFFM_CLKB XD5_XDFFM_MB 1.21e-17
* device instance cc_XD2_XDFFM_CLKB_XD5_XDFFM_MFB r0 *1 0,0
Ccc_XD2_XDFFM_CLKB_XD5_XDFFM_MFB XD2_XDFFM_CLKB XD5_XDFFM_MFB 1.21e-17
* device instance cc_XD2_XDFFM_CLKB_XD5_XDFFM_S r0 *1 0,0
Ccc_XD2_XDFFM_CLKB_XD5_XDFFM_S XD2_XDFFM_CLKB XD5_XDFFM_S 1.8151e-17
* device instance cc_XD2_XDFFM_CLKB_XD5_XDFFM_SB r0 *1 0,0
Ccc_XD2_XDFFM_CLKB_XD5_XDFFM_SB XD2_XDFFM_CLKB XD5_XDFFM_SB 1.8151e-17
* device instance cc_XD2_XDFFM_CLKB_XD5_XDFFM_SFB r0 *1 0,0
Ccc_XD2_XDFFM_CLKB_XD5_XDFFM_SFB XD2_XDFFM_CLKB XD5_XDFFM_SFB 1.21e-17
* device instance cc_XD2_XDFFM_CLKB_XD5_XDFFQ_CKBB r0 *1 0,0
Ccc_XD2_XDFFM_CLKB_XD5_XDFFQ_CKBB XD2_XDFFM_CLKB XD5_XDFFQ_CKBB 1.8151e-17
* device instance cc_XD2_XDFFM_CLKB_XD5_XDFFQ_CLKB r0 *1 0,0
Ccc_XD2_XDFFM_CLKB_XD5_XDFFQ_CLKB XD2_XDFFM_CLKB XD5_XDFFQ_CLKB 2.4201e-17
* device instance cc_XD2_XDFFM_CLKB_XD5_XDFFQ_M r0 *1 0,0
Ccc_XD2_XDFFM_CLKB_XD5_XDFFQ_M XD2_XDFFM_CLKB XD5_XDFFQ_M 2.4201e-17
* device instance cc_XD2_XDFFM_CLKB_XD5_XDFFQ_MB r0 *1 0,0
Ccc_XD2_XDFFM_CLKB_XD5_XDFFQ_MB XD2_XDFFM_CLKB XD5_XDFFQ_MB 1.21e-17
* device instance cc_XD2_XDFFM_CLKB_XD5_XDFFQ_MFB r0 *1 0,0
Ccc_XD2_XDFFM_CLKB_XD5_XDFFQ_MFB XD2_XDFFM_CLKB XD5_XDFFQ_MFB 1.21e-17
* device instance cc_XD2_XDFFM_CLKB_XD5_XDFFQ_S r0 *1 0,0
Ccc_XD2_XDFFM_CLKB_XD5_XDFFQ_S XD2_XDFFM_CLKB XD5_XDFFQ_S 1.8151e-17
* device instance cc_XD2_XDFFM_CLKB_XD5_XDFFQ_SB r0 *1 0,0
Ccc_XD2_XDFFM_CLKB_XD5_XDFFQ_SB XD2_XDFFM_CLKB XD5_XDFFQ_SB 1.8151e-17
* device instance cc_XD2_XDFFM_CLKB_XD5_XDFFQ_SFB r0 *1 0,0
Ccc_XD2_XDFFM_CLKB_XD5_XDFFQ_SFB XD2_XDFFM_CLKB XD5_XDFFQ_SFB 1.21e-17
* device instance cc_XD2_XDFFM_CLKB_XD5_XN2_mid1 r0 *1 0,0
Ccc_XD2_XDFFM_CLKB_XD5_XN2_mid1 XD2_XDFFM_CLKB XD5_XN2_mid1 1.21e-17
* device instance cc_XD2_XDFFM_CLKB_XD5_XN3_mid1 r0 *1 0,0
Ccc_XD2_XDFFM_CLKB_XD5_XN3_mid1 XD2_XDFFM_CLKB XD5_XN3_mid1 1.21e-17
* device instance cc_XD2_XDFFM_CLKB_XD5_XN3_mid2 r0 *1 0,0
Ccc_XD2_XDFFM_CLKB_XD5_XN3_mid2 XD2_XDFFM_CLKB XD5_XN3_mid2 1.21e-17
* device instance cc_XD2_XDFFM_CLKB_XD5_dmodout r0 *1 0,0
Ccc_XD2_XDFFM_CLKB_XD5_dmodout XD2_XDFFM_CLKB XD5_dmodout 1.21e-17
* device instance cc_XD2_XDFFM_CLKB_XD5_dq r0 *1 0,0
Ccc_XD2_XDFFM_CLKB_XD5_dq XD2_XDFFM_CLKB XD5_dq 1.8151e-17
* device instance cc_XD2_XDFFM_CLKB_XD5_nm r0 *1 0,0
Ccc_XD2_XDFFM_CLKB_XD5_nm XD2_XDFFM_CLKB XD5_nm 1.21e-17
* device instance cc_XD2_XDFFM_CLKB_XD5_nt r0 *1 0,0
Ccc_XD2_XDFFM_CLKB_XD5_nt XD2_XDFFM_CLKB XD5_nt 1.21e-17
* device instance cc_XD2_XDFFM_CLKB_XD5_t1 r0 *1 0,0
Ccc_XD2_XDFFM_CLKB_XD5_t1 XD2_XDFFM_CLKB XD5_t1 1.21e-17
* device instance cc_XD2_XDFFM_CLKB_XFRT_CKBB r0 *1 0,0
Ccc_XD2_XDFFM_CLKB_XFRT_CKBB XD2_XDFFM_CLKB XFRT_CKBB 1.8151e-17
* device instance cc_XD2_XDFFM_CLKB_XFRT_CLKB r0 *1 0,0
Ccc_XD2_XDFFM_CLKB_XFRT_CLKB XD2_XDFFM_CLKB XFRT_CLKB 2.4201e-17
* device instance cc_XD2_XDFFM_CLKB_XFRT_M r0 *1 0,0
Ccc_XD2_XDFFM_CLKB_XFRT_M XD2_XDFFM_CLKB XFRT_M 2.4201e-17
* device instance cc_XD2_XDFFM_CLKB_XFRT_MB r0 *1 0,0
Ccc_XD2_XDFFM_CLKB_XFRT_MB XD2_XDFFM_CLKB XFRT_MB 1.21e-17
* device instance cc_XD2_XDFFM_CLKB_XFRT_MFB r0 *1 0,0
Ccc_XD2_XDFFM_CLKB_XFRT_MFB XD2_XDFFM_CLKB XFRT_MFB 1.21e-17
* device instance cc_XD2_XDFFM_CLKB_XFRT_S r0 *1 0,0
Ccc_XD2_XDFFM_CLKB_XFRT_S XD2_XDFFM_CLKB XFRT_S 1.8151e-17
* device instance cc_XD2_XDFFM_CLKB_XFRT_SB r0 *1 0,0
Ccc_XD2_XDFFM_CLKB_XFRT_SB XD2_XDFFM_CLKB XFRT_SB 1.8151e-17
* device instance cc_XD2_XDFFM_CLKB_XFRT_SFB r0 *1 0,0
Ccc_XD2_XDFFM_CLKB_XFRT_SFB XD2_XDFFM_CLKB XFRT_SFB 1.21e-17
* device instance cc_XD2_XDFFM_CLKB_ck1 r0 *1 0,0
Ccc_XD2_XDFFM_CLKB_ck1 XD2_XDFFM_CLKB ck1 3.0251e-17
* device instance cc_XD2_XDFFM_CLKB_ck2 r0 *1 0,0
Ccc_XD2_XDFFM_CLKB_ck2 XD2_XDFFM_CLKB ck2 3.0251e-17
* device instance cc_XD2_XDFFM_CLKB_ck3 r0 *1 0,0
Ccc_XD2_XDFFM_CLKB_ck3 XD2_XDFFM_CLKB ck3 3.0251e-17
* device instance cc_XD2_XDFFM_CLKB_ck4 r0 *1 0,0
Ccc_XD2_XDFFM_CLKB_ck4 XD2_XDFFM_CLKB ck4 3.0251e-17
* device instance cc_XD2_XDFFM_CLKB_ck5 r0 *1 0,0
Ccc_XD2_XDFFM_CLKB_ck5 XD2_XDFFM_CLKB ck5 3.0251e-17
* device instance cc_XD2_XDFFM_CLKB_mod0 r0 *1 0,0
Ccc_XD2_XDFFM_CLKB_mod0 XD2_XDFFM_CLKB mod0 2.4201e-17
* device instance cc_XD2_XDFFM_CLKB_mod1 r0 *1 0,0
Ccc_XD2_XDFFM_CLKB_mod1 XD2_XDFFM_CLKB mod1 2.4201e-17
* device instance cc_XD2_XDFFM_CLKB_mod2 r0 *1 0,0
Ccc_XD2_XDFFM_CLKB_mod2 XD2_XDFFM_CLKB mod2 2.4201e-17
* device instance cc_XD2_XDFFM_CLKB_mod3 r0 *1 0,0
Ccc_XD2_XDFFM_CLKB_mod3 XD2_XDFFM_CLKB mod3 2.4201e-17
* device instance cc_XD2_XDFFM_CLKB_mod4 r0 *1 0,0
Ccc_XD2_XDFFM_CLKB_mod4 XD2_XDFFM_CLKB mod4 2.4201e-17
* device instance cc_XD2_XDFFM_CLKB_net1 r0 *1 0,0
Ccc_XD2_XDFFM_CLKB_net1 XD2_XDFFM_CLKB net1 1.21e-17
* device instance cc_XD2_XDFFM_M_XD2_XDFFM_MB r0 *1 0,0
Ccc_XD2_XDFFM_M_XD2_XDFFM_MB XD2_XDFFM_M XD2_XDFFM_MB 2.4201e-17
* device instance cc_XD2_XDFFM_M_XD2_XDFFM_MFB r0 *1 0,0
Ccc_XD2_XDFFM_M_XD2_XDFFM_MFB XD2_XDFFM_M XD2_XDFFM_MFB 3.4688e-17
* device instance cc_XD2_XDFFM_M_XD2_XDFFM_S r0 *1 0,0
Ccc_XD2_XDFFM_M_XD2_XDFFM_S XD2_XDFFM_M XD2_XDFFM_S 2.8638e-17
* device instance cc_XD2_XDFFM_M_XD2_XDFFM_SB r0 *1 0,0
Ccc_XD2_XDFFM_M_XD2_XDFFM_SB XD2_XDFFM_M XD2_XDFFM_SB 1.8151e-17
* device instance cc_XD2_XDFFM_M_XD2_XDFFM_SFB r0 *1 0,0
Ccc_XD2_XDFFM_M_XD2_XDFFM_SFB XD2_XDFFM_M XD2_XDFFM_SFB 1.21e-17
* device instance cc_XD2_XDFFM_M_XD2_XDFFQ_CKBB r0 *1 0,0
Ccc_XD2_XDFFM_M_XD2_XDFFQ_CKBB XD2_XDFFM_M XD2_XDFFQ_CKBB 1.8151e-17
* device instance cc_XD2_XDFFM_M_XD2_XDFFQ_CLKB r0 *1 0,0
Ccc_XD2_XDFFM_M_XD2_XDFFQ_CLKB XD2_XDFFM_M XD2_XDFFQ_CLKB 2.4201e-17
* device instance cc_XD2_XDFFM_M_XD2_XDFFQ_M r0 *1 0,0
Ccc_XD2_XDFFM_M_XD2_XDFFQ_M XD2_XDFFM_M XD2_XDFFQ_M 2.4201e-17
* device instance cc_XD2_XDFFM_M_XD2_XDFFQ_MB r0 *1 0,0
Ccc_XD2_XDFFM_M_XD2_XDFFQ_MB XD2_XDFFM_M XD2_XDFFQ_MB 1.21e-17
* device instance cc_XD2_XDFFM_M_XD2_XDFFQ_MFB r0 *1 0,0
Ccc_XD2_XDFFM_M_XD2_XDFFQ_MFB XD2_XDFFM_M XD2_XDFFQ_MFB 1.21e-17
* device instance cc_XD2_XDFFM_M_XD2_XDFFQ_S r0 *1 0,0
Ccc_XD2_XDFFM_M_XD2_XDFFQ_S XD2_XDFFM_M XD2_XDFFQ_S 1.8151e-17
* device instance cc_XD2_XDFFM_M_XD2_XDFFQ_SB r0 *1 0,0
Ccc_XD2_XDFFM_M_XD2_XDFFQ_SB XD2_XDFFM_M XD2_XDFFQ_SB 1.8151e-17
* device instance cc_XD2_XDFFM_M_XD2_XDFFQ_SFB r0 *1 0,0
Ccc_XD2_XDFFM_M_XD2_XDFFQ_SFB XD2_XDFFM_M XD2_XDFFQ_SFB 1.21e-17
* device instance cc_XD2_XDFFM_M_XD2_XNOR_midp r0 *1 0,0
Ccc_XD2_XDFFM_M_XD2_XNOR_midp XD2_XDFFM_M XD2_XNOR_midp 1.21e-17
* device instance cc_XD2_XDFFM_M_XD2_dmodout r0 *1 0,0
Ccc_XD2_XDFFM_M_XD2_dmodout XD2_XDFFM_M XD2_dmodout 2.8638e-17
* device instance cc_XD2_XDFFM_M_XD2_dq r0 *1 0,0
Ccc_XD2_XDFFM_M_XD2_dq XD2_XDFFM_M XD2_dq 1.21e-17
* device instance cc_XD2_XDFFM_M_XD2_nm r0 *1 0,0
Ccc_XD2_XDFFM_M_XD2_nm XD2_XDFFM_M XD2_nm 1.8151e-17
* device instance cc_XD2_XDFFM_M_XD2_nt r0 *1 0,0
Ccc_XD2_XDFFM_M_XD2_nt XD2_XDFFM_M XD2_nt 2.4201e-17
* device instance cc_XD2_XDFFM_M_XD2_t1 r0 *1 0,0
Ccc_XD2_XDFFM_M_XD2_t1 XD2_XDFFM_M XD2_t1 1.21e-17
* device instance cc_XD2_XDFFM_M_XD3_XDFFM_CKBB r0 *1 0,0
Ccc_XD2_XDFFM_M_XD3_XDFFM_CKBB XD2_XDFFM_M XD3_XDFFM_CKBB 1.8151e-17
* device instance cc_XD2_XDFFM_M_XD3_XDFFM_CLKB r0 *1 0,0
Ccc_XD2_XDFFM_M_XD3_XDFFM_CLKB XD2_XDFFM_M XD3_XDFFM_CLKB 2.4201e-17
* device instance cc_XD2_XDFFM_M_XD3_XDFFM_M r0 *1 0,0
Ccc_XD2_XDFFM_M_XD3_XDFFM_M XD2_XDFFM_M XD3_XDFFM_M 2.4201e-17
* device instance cc_XD2_XDFFM_M_XD3_XDFFM_MB r0 *1 0,0
Ccc_XD2_XDFFM_M_XD3_XDFFM_MB XD2_XDFFM_M XD3_XDFFM_MB 1.21e-17
* device instance cc_XD2_XDFFM_M_XD3_XDFFM_MFB r0 *1 0,0
Ccc_XD2_XDFFM_M_XD3_XDFFM_MFB XD2_XDFFM_M XD3_XDFFM_MFB 1.21e-17
* device instance cc_XD2_XDFFM_M_XD3_XDFFM_S r0 *1 0,0
Ccc_XD2_XDFFM_M_XD3_XDFFM_S XD2_XDFFM_M XD3_XDFFM_S 1.8151e-17
* device instance cc_XD2_XDFFM_M_XD3_XDFFM_SB r0 *1 0,0
Ccc_XD2_XDFFM_M_XD3_XDFFM_SB XD2_XDFFM_M XD3_XDFFM_SB 1.8151e-17
* device instance cc_XD2_XDFFM_M_XD3_XDFFM_SFB r0 *1 0,0
Ccc_XD2_XDFFM_M_XD3_XDFFM_SFB XD2_XDFFM_M XD3_XDFFM_SFB 1.21e-17
* device instance cc_XD2_XDFFM_M_XD3_XDFFQ_CKBB r0 *1 0,0
Ccc_XD2_XDFFM_M_XD3_XDFFQ_CKBB XD2_XDFFM_M XD3_XDFFQ_CKBB 1.8151e-17
* device instance cc_XD2_XDFFM_M_XD3_XDFFQ_CLKB r0 *1 0,0
Ccc_XD2_XDFFM_M_XD3_XDFFQ_CLKB XD2_XDFFM_M XD3_XDFFQ_CLKB 2.4201e-17
* device instance cc_XD2_XDFFM_M_XD3_XDFFQ_M r0 *1 0,0
Ccc_XD2_XDFFM_M_XD3_XDFFQ_M XD2_XDFFM_M XD3_XDFFQ_M 2.4201e-17
* device instance cc_XD2_XDFFM_M_XD3_XDFFQ_MB r0 *1 0,0
Ccc_XD2_XDFFM_M_XD3_XDFFQ_MB XD2_XDFFM_M XD3_XDFFQ_MB 1.21e-17
* device instance cc_XD2_XDFFM_M_XD3_XDFFQ_MFB r0 *1 0,0
Ccc_XD2_XDFFM_M_XD3_XDFFQ_MFB XD2_XDFFM_M XD3_XDFFQ_MFB 1.21e-17
* device instance cc_XD2_XDFFM_M_XD3_XDFFQ_S r0 *1 0,0
Ccc_XD2_XDFFM_M_XD3_XDFFQ_S XD2_XDFFM_M XD3_XDFFQ_S 1.8151e-17
* device instance cc_XD2_XDFFM_M_XD3_XDFFQ_SB r0 *1 0,0
Ccc_XD2_XDFFM_M_XD3_XDFFQ_SB XD2_XDFFM_M XD3_XDFFQ_SB 1.8151e-17
* device instance cc_XD2_XDFFM_M_XD3_XDFFQ_SFB r0 *1 0,0
Ccc_XD2_XDFFM_M_XD3_XDFFQ_SFB XD2_XDFFM_M XD3_XDFFQ_SFB 1.21e-17
* device instance cc_XD2_XDFFM_M_XD3_XN2_mid1 r0 *1 0,0
Ccc_XD2_XDFFM_M_XD3_XN2_mid1 XD2_XDFFM_M XD3_XN2_mid1 1.21e-17
* device instance cc_XD2_XDFFM_M_XD3_XN3_mid1 r0 *1 0,0
Ccc_XD2_XDFFM_M_XD3_XN3_mid1 XD2_XDFFM_M XD3_XN3_mid1 1.21e-17
* device instance cc_XD2_XDFFM_M_XD3_XN3_mid2 r0 *1 0,0
Ccc_XD2_XDFFM_M_XD3_XN3_mid2 XD2_XDFFM_M XD3_XN3_mid2 1.21e-17
* device instance cc_XD2_XDFFM_M_XD3_dmodout r0 *1 0,0
Ccc_XD2_XDFFM_M_XD3_dmodout XD2_XDFFM_M XD3_dmodout 1.21e-17
* device instance cc_XD2_XDFFM_M_XD3_dq r0 *1 0,0
Ccc_XD2_XDFFM_M_XD3_dq XD2_XDFFM_M XD3_dq 1.8151e-17
* device instance cc_XD2_XDFFM_M_XD3_nm r0 *1 0,0
Ccc_XD2_XDFFM_M_XD3_nm XD2_XDFFM_M XD3_nm 1.21e-17
* device instance cc_XD2_XDFFM_M_XD3_nt r0 *1 0,0
Ccc_XD2_XDFFM_M_XD3_nt XD2_XDFFM_M XD3_nt 1.21e-17
* device instance cc_XD2_XDFFM_M_XD3_t1 r0 *1 0,0
Ccc_XD2_XDFFM_M_XD3_t1 XD2_XDFFM_M XD3_t1 1.21e-17
* device instance cc_XD2_XDFFM_M_XD4_XDFFM_CKBB r0 *1 0,0
Ccc_XD2_XDFFM_M_XD4_XDFFM_CKBB XD2_XDFFM_M XD4_XDFFM_CKBB 1.8151e-17
* device instance cc_XD2_XDFFM_M_XD4_XDFFM_CLKB r0 *1 0,0
Ccc_XD2_XDFFM_M_XD4_XDFFM_CLKB XD2_XDFFM_M XD4_XDFFM_CLKB 2.4201e-17
* device instance cc_XD2_XDFFM_M_XD4_XDFFM_M r0 *1 0,0
Ccc_XD2_XDFFM_M_XD4_XDFFM_M XD2_XDFFM_M XD4_XDFFM_M 2.4201e-17
* device instance cc_XD2_XDFFM_M_XD4_XDFFM_MB r0 *1 0,0
Ccc_XD2_XDFFM_M_XD4_XDFFM_MB XD2_XDFFM_M XD4_XDFFM_MB 1.21e-17
* device instance cc_XD2_XDFFM_M_XD4_XDFFM_MFB r0 *1 0,0
Ccc_XD2_XDFFM_M_XD4_XDFFM_MFB XD2_XDFFM_M XD4_XDFFM_MFB 1.21e-17
* device instance cc_XD2_XDFFM_M_XD4_XDFFM_S r0 *1 0,0
Ccc_XD2_XDFFM_M_XD4_XDFFM_S XD2_XDFFM_M XD4_XDFFM_S 1.8151e-17
* device instance cc_XD2_XDFFM_M_XD4_XDFFM_SB r0 *1 0,0
Ccc_XD2_XDFFM_M_XD4_XDFFM_SB XD2_XDFFM_M XD4_XDFFM_SB 1.8151e-17
* device instance cc_XD2_XDFFM_M_XD4_XDFFM_SFB r0 *1 0,0
Ccc_XD2_XDFFM_M_XD4_XDFFM_SFB XD2_XDFFM_M XD4_XDFFM_SFB 1.21e-17
* device instance cc_XD2_XDFFM_M_XD4_XDFFQ_CKBB r0 *1 0,0
Ccc_XD2_XDFFM_M_XD4_XDFFQ_CKBB XD2_XDFFM_M XD4_XDFFQ_CKBB 1.8151e-17
* device instance cc_XD2_XDFFM_M_XD4_XDFFQ_CLKB r0 *1 0,0
Ccc_XD2_XDFFM_M_XD4_XDFFQ_CLKB XD2_XDFFM_M XD4_XDFFQ_CLKB 2.4201e-17
* device instance cc_XD2_XDFFM_M_XD4_XDFFQ_M r0 *1 0,0
Ccc_XD2_XDFFM_M_XD4_XDFFQ_M XD2_XDFFM_M XD4_XDFFQ_M 2.4201e-17
* device instance cc_XD2_XDFFM_M_XD4_XDFFQ_MB r0 *1 0,0
Ccc_XD2_XDFFM_M_XD4_XDFFQ_MB XD2_XDFFM_M XD4_XDFFQ_MB 1.21e-17
* device instance cc_XD2_XDFFM_M_XD4_XDFFQ_MFB r0 *1 0,0
Ccc_XD2_XDFFM_M_XD4_XDFFQ_MFB XD2_XDFFM_M XD4_XDFFQ_MFB 1.21e-17
* device instance cc_XD2_XDFFM_M_XD4_XDFFQ_S r0 *1 0,0
Ccc_XD2_XDFFM_M_XD4_XDFFQ_S XD2_XDFFM_M XD4_XDFFQ_S 1.8151e-17
* device instance cc_XD2_XDFFM_M_XD4_XDFFQ_SB r0 *1 0,0
Ccc_XD2_XDFFM_M_XD4_XDFFQ_SB XD2_XDFFM_M XD4_XDFFQ_SB 1.8151e-17
* device instance cc_XD2_XDFFM_M_XD4_XDFFQ_SFB r0 *1 0,0
Ccc_XD2_XDFFM_M_XD4_XDFFQ_SFB XD2_XDFFM_M XD4_XDFFQ_SFB 1.21e-17
* device instance cc_XD2_XDFFM_M_XD4_XN2_mid1 r0 *1 0,0
Ccc_XD2_XDFFM_M_XD4_XN2_mid1 XD2_XDFFM_M XD4_XN2_mid1 1.21e-17
* device instance cc_XD2_XDFFM_M_XD4_XN3_mid1 r0 *1 0,0
Ccc_XD2_XDFFM_M_XD4_XN3_mid1 XD2_XDFFM_M XD4_XN3_mid1 1.21e-17
* device instance cc_XD2_XDFFM_M_XD4_XN3_mid2 r0 *1 0,0
Ccc_XD2_XDFFM_M_XD4_XN3_mid2 XD2_XDFFM_M XD4_XN3_mid2 1.21e-17
* device instance cc_XD2_XDFFM_M_XD4_dmodout r0 *1 0,0
Ccc_XD2_XDFFM_M_XD4_dmodout XD2_XDFFM_M XD4_dmodout 1.21e-17
* device instance cc_XD2_XDFFM_M_XD4_dq r0 *1 0,0
Ccc_XD2_XDFFM_M_XD4_dq XD2_XDFFM_M XD4_dq 1.8151e-17
* device instance cc_XD2_XDFFM_M_XD4_nm r0 *1 0,0
Ccc_XD2_XDFFM_M_XD4_nm XD2_XDFFM_M XD4_nm 1.21e-17
* device instance cc_XD2_XDFFM_M_XD4_nt r0 *1 0,0
Ccc_XD2_XDFFM_M_XD4_nt XD2_XDFFM_M XD4_nt 1.21e-17
* device instance cc_XD2_XDFFM_M_XD4_t1 r0 *1 0,0
Ccc_XD2_XDFFM_M_XD4_t1 XD2_XDFFM_M XD4_t1 1.21e-17
* device instance cc_XD2_XDFFM_M_XD5_XDFFM_CKBB r0 *1 0,0
Ccc_XD2_XDFFM_M_XD5_XDFFM_CKBB XD2_XDFFM_M XD5_XDFFM_CKBB 1.8151e-17
* device instance cc_XD2_XDFFM_M_XD5_XDFFM_CLKB r0 *1 0,0
Ccc_XD2_XDFFM_M_XD5_XDFFM_CLKB XD2_XDFFM_M XD5_XDFFM_CLKB 2.4201e-17
* device instance cc_XD2_XDFFM_M_XD5_XDFFM_M r0 *1 0,0
Ccc_XD2_XDFFM_M_XD5_XDFFM_M XD2_XDFFM_M XD5_XDFFM_M 2.4201e-17
* device instance cc_XD2_XDFFM_M_XD5_XDFFM_MB r0 *1 0,0
Ccc_XD2_XDFFM_M_XD5_XDFFM_MB XD2_XDFFM_M XD5_XDFFM_MB 1.21e-17
* device instance cc_XD2_XDFFM_M_XD5_XDFFM_MFB r0 *1 0,0
Ccc_XD2_XDFFM_M_XD5_XDFFM_MFB XD2_XDFFM_M XD5_XDFFM_MFB 1.21e-17
* device instance cc_XD2_XDFFM_M_XD5_XDFFM_S r0 *1 0,0
Ccc_XD2_XDFFM_M_XD5_XDFFM_S XD2_XDFFM_M XD5_XDFFM_S 1.8151e-17
* device instance cc_XD2_XDFFM_M_XD5_XDFFM_SB r0 *1 0,0
Ccc_XD2_XDFFM_M_XD5_XDFFM_SB XD2_XDFFM_M XD5_XDFFM_SB 1.8151e-17
* device instance cc_XD2_XDFFM_M_XD5_XDFFM_SFB r0 *1 0,0
Ccc_XD2_XDFFM_M_XD5_XDFFM_SFB XD2_XDFFM_M XD5_XDFFM_SFB 1.21e-17
* device instance cc_XD2_XDFFM_M_XD5_XDFFQ_CKBB r0 *1 0,0
Ccc_XD2_XDFFM_M_XD5_XDFFQ_CKBB XD2_XDFFM_M XD5_XDFFQ_CKBB 1.8151e-17
* device instance cc_XD2_XDFFM_M_XD5_XDFFQ_CLKB r0 *1 0,0
Ccc_XD2_XDFFM_M_XD5_XDFFQ_CLKB XD2_XDFFM_M XD5_XDFFQ_CLKB 2.4201e-17
* device instance cc_XD2_XDFFM_M_XD5_XDFFQ_M r0 *1 0,0
Ccc_XD2_XDFFM_M_XD5_XDFFQ_M XD2_XDFFM_M XD5_XDFFQ_M 2.4201e-17
* device instance cc_XD2_XDFFM_M_XD5_XDFFQ_MB r0 *1 0,0
Ccc_XD2_XDFFM_M_XD5_XDFFQ_MB XD2_XDFFM_M XD5_XDFFQ_MB 1.21e-17
* device instance cc_XD2_XDFFM_M_XD5_XDFFQ_MFB r0 *1 0,0
Ccc_XD2_XDFFM_M_XD5_XDFFQ_MFB XD2_XDFFM_M XD5_XDFFQ_MFB 1.21e-17
* device instance cc_XD2_XDFFM_M_XD5_XDFFQ_S r0 *1 0,0
Ccc_XD2_XDFFM_M_XD5_XDFFQ_S XD2_XDFFM_M XD5_XDFFQ_S 1.8151e-17
* device instance cc_XD2_XDFFM_M_XD5_XDFFQ_SB r0 *1 0,0
Ccc_XD2_XDFFM_M_XD5_XDFFQ_SB XD2_XDFFM_M XD5_XDFFQ_SB 1.8151e-17
* device instance cc_XD2_XDFFM_M_XD5_XDFFQ_SFB r0 *1 0,0
Ccc_XD2_XDFFM_M_XD5_XDFFQ_SFB XD2_XDFFM_M XD5_XDFFQ_SFB 1.21e-17
* device instance cc_XD2_XDFFM_M_XD5_XN2_mid1 r0 *1 0,0
Ccc_XD2_XDFFM_M_XD5_XN2_mid1 XD2_XDFFM_M XD5_XN2_mid1 1.21e-17
* device instance cc_XD2_XDFFM_M_XD5_XN3_mid1 r0 *1 0,0
Ccc_XD2_XDFFM_M_XD5_XN3_mid1 XD2_XDFFM_M XD5_XN3_mid1 1.21e-17
* device instance cc_XD2_XDFFM_M_XD5_XN3_mid2 r0 *1 0,0
Ccc_XD2_XDFFM_M_XD5_XN3_mid2 XD2_XDFFM_M XD5_XN3_mid2 1.21e-17
* device instance cc_XD2_XDFFM_M_XD5_dmodout r0 *1 0,0
Ccc_XD2_XDFFM_M_XD5_dmodout XD2_XDFFM_M XD5_dmodout 1.21e-17
* device instance cc_XD2_XDFFM_M_XD5_dq r0 *1 0,0
Ccc_XD2_XDFFM_M_XD5_dq XD2_XDFFM_M XD5_dq 1.8151e-17
* device instance cc_XD2_XDFFM_M_XD5_nm r0 *1 0,0
Ccc_XD2_XDFFM_M_XD5_nm XD2_XDFFM_M XD5_nm 1.21e-17
* device instance cc_XD2_XDFFM_M_XD5_nt r0 *1 0,0
Ccc_XD2_XDFFM_M_XD5_nt XD2_XDFFM_M XD5_nt 1.21e-17
* device instance cc_XD2_XDFFM_M_XD5_t1 r0 *1 0,0
Ccc_XD2_XDFFM_M_XD5_t1 XD2_XDFFM_M XD5_t1 1.21e-17
* device instance cc_XD2_XDFFM_M_XFRT_CKBB r0 *1 0,0
Ccc_XD2_XDFFM_M_XFRT_CKBB XD2_XDFFM_M XFRT_CKBB 1.8151e-17
* device instance cc_XD2_XDFFM_M_XFRT_CLKB r0 *1 0,0
Ccc_XD2_XDFFM_M_XFRT_CLKB XD2_XDFFM_M XFRT_CLKB 2.4201e-17
* device instance cc_XD2_XDFFM_M_XFRT_M r0 *1 0,0
Ccc_XD2_XDFFM_M_XFRT_M XD2_XDFFM_M XFRT_M 2.4201e-17
* device instance cc_XD2_XDFFM_M_XFRT_MB r0 *1 0,0
Ccc_XD2_XDFFM_M_XFRT_MB XD2_XDFFM_M XFRT_MB 1.21e-17
* device instance cc_XD2_XDFFM_M_XFRT_MFB r0 *1 0,0
Ccc_XD2_XDFFM_M_XFRT_MFB XD2_XDFFM_M XFRT_MFB 1.21e-17
* device instance cc_XD2_XDFFM_M_XFRT_S r0 *1 0,0
Ccc_XD2_XDFFM_M_XFRT_S XD2_XDFFM_M XFRT_S 1.8151e-17
* device instance cc_XD2_XDFFM_M_XFRT_SB r0 *1 0,0
Ccc_XD2_XDFFM_M_XFRT_SB XD2_XDFFM_M XFRT_SB 1.8151e-17
* device instance cc_XD2_XDFFM_M_XFRT_SFB r0 *1 0,0
Ccc_XD2_XDFFM_M_XFRT_SFB XD2_XDFFM_M XFRT_SFB 1.21e-17
* device instance cc_XD2_XDFFM_M_ck1 r0 *1 0,0
Ccc_XD2_XDFFM_M_ck1 XD2_XDFFM_M ck1 3.0251e-17
* device instance cc_XD2_XDFFM_M_ck2 r0 *1 0,0
Ccc_XD2_XDFFM_M_ck2 XD2_XDFFM_M ck2 3.0251e-17
* device instance cc_XD2_XDFFM_M_ck3 r0 *1 0,0
Ccc_XD2_XDFFM_M_ck3 XD2_XDFFM_M ck3 3.0251e-17
* device instance cc_XD2_XDFFM_M_ck4 r0 *1 0,0
Ccc_XD2_XDFFM_M_ck4 XD2_XDFFM_M ck4 3.0251e-17
* device instance cc_XD2_XDFFM_M_ck5 r0 *1 0,0
Ccc_XD2_XDFFM_M_ck5 XD2_XDFFM_M ck5 3.0251e-17
* device instance cc_XD2_XDFFM_M_mod0 r0 *1 0,0
Ccc_XD2_XDFFM_M_mod0 XD2_XDFFM_M mod0 2.4201e-17
* device instance cc_XD2_XDFFM_M_mod1 r0 *1 0,0
Ccc_XD2_XDFFM_M_mod1 XD2_XDFFM_M mod1 2.4201e-17
* device instance cc_XD2_XDFFM_M_mod2 r0 *1 0,0
Ccc_XD2_XDFFM_M_mod2 XD2_XDFFM_M mod2 2.4201e-17
* device instance cc_XD2_XDFFM_M_mod3 r0 *1 0,0
Ccc_XD2_XDFFM_M_mod3 XD2_XDFFM_M mod3 2.4201e-17
* device instance cc_XD2_XDFFM_M_mod4 r0 *1 0,0
Ccc_XD2_XDFFM_M_mod4 XD2_XDFFM_M mod4 2.4201e-17
* device instance cc_XD2_XDFFM_M_net1 r0 *1 0,0
Ccc_XD2_XDFFM_M_net1 XD2_XDFFM_M net1 1.21e-17
* device instance cc_XD2_XDFFM_MB_XD2_XDFFM_MFB r0 *1 0,0
Ccc_XD2_XDFFM_MB_XD2_XDFFM_MFB XD2_XDFFM_MB XD2_XDFFM_MFB 1.21e-17
* device instance cc_XD2_XDFFM_MB_XD2_XDFFM_S r0 *1 0,0
Ccc_XD2_XDFFM_MB_XD2_XDFFM_S XD2_XDFFM_MB XD2_XDFFM_S 1.8151e-17
* device instance cc_XD2_XDFFM_MB_XD2_XDFFM_SB r0 *1 0,0
Ccc_XD2_XDFFM_MB_XD2_XDFFM_SB XD2_XDFFM_MB XD2_XDFFM_SB 1.8151e-17
* device instance cc_XD2_XDFFM_MB_XD2_XDFFM_SFB r0 *1 0,0
Ccc_XD2_XDFFM_MB_XD2_XDFFM_SFB XD2_XDFFM_MB XD2_XDFFM_SFB 1.21e-17
* device instance cc_XD2_XDFFM_MB_XD2_XDFFQ_CKBB r0 *1 0,0
Ccc_XD2_XDFFM_MB_XD2_XDFFQ_CKBB XD2_XDFFM_MB XD2_XDFFQ_CKBB 1.8151e-17
* device instance cc_XD2_XDFFM_MB_XD2_XDFFQ_CLKB r0 *1 0,0
Ccc_XD2_XDFFM_MB_XD2_XDFFQ_CLKB XD2_XDFFM_MB XD2_XDFFQ_CLKB 2.4201e-17
* device instance cc_XD2_XDFFM_MB_XD2_XDFFQ_M r0 *1 0,0
Ccc_XD2_XDFFM_MB_XD2_XDFFQ_M XD2_XDFFM_MB XD2_XDFFQ_M 2.4201e-17
* device instance cc_XD2_XDFFM_MB_XD2_XDFFQ_MB r0 *1 0,0
Ccc_XD2_XDFFM_MB_XD2_XDFFQ_MB XD2_XDFFM_MB XD2_XDFFQ_MB 1.21e-17
* device instance cc_XD2_XDFFM_MB_XD2_XDFFQ_MFB r0 *1 0,0
Ccc_XD2_XDFFM_MB_XD2_XDFFQ_MFB XD2_XDFFM_MB XD2_XDFFQ_MFB 1.21e-17
* device instance cc_XD2_XDFFM_MB_XD2_XDFFQ_S r0 *1 0,0
Ccc_XD2_XDFFM_MB_XD2_XDFFQ_S XD2_XDFFM_MB XD2_XDFFQ_S 1.8151e-17
* device instance cc_XD2_XDFFM_MB_XD2_XDFFQ_SB r0 *1 0,0
Ccc_XD2_XDFFM_MB_XD2_XDFFQ_SB XD2_XDFFM_MB XD2_XDFFQ_SB 1.8151e-17
* device instance cc_XD2_XDFFM_MB_XD2_XDFFQ_SFB r0 *1 0,0
Ccc_XD2_XDFFM_MB_XD2_XDFFQ_SFB XD2_XDFFM_MB XD2_XDFFQ_SFB 1.21e-17
* device instance cc_XD2_XDFFM_MB_XD2_XNOR_midp r0 *1 0,0
Ccc_XD2_XDFFM_MB_XD2_XNOR_midp XD2_XDFFM_MB XD2_XNOR_midp 1.21e-17
* device instance cc_XD2_XDFFM_MB_XD2_dmodout r0 *1 0,0
Ccc_XD2_XDFFM_MB_XD2_dmodout XD2_XDFFM_MB XD2_dmodout 1.21e-17
* device instance cc_XD2_XDFFM_MB_XD2_dq r0 *1 0,0
Ccc_XD2_XDFFM_MB_XD2_dq XD2_XDFFM_MB XD2_dq 1.21e-17
* device instance cc_XD2_XDFFM_MB_XD2_nm r0 *1 0,0
Ccc_XD2_XDFFM_MB_XD2_nm XD2_XDFFM_MB XD2_nm 1.8151e-17
* device instance cc_XD2_XDFFM_MB_XD2_nt r0 *1 0,0
Ccc_XD2_XDFFM_MB_XD2_nt XD2_XDFFM_MB XD2_nt 2.4201e-17
* device instance cc_XD2_XDFFM_MB_XD2_t1 r0 *1 0,0
Ccc_XD2_XDFFM_MB_XD2_t1 XD2_XDFFM_MB XD2_t1 1.21e-17
* device instance cc_XD2_XDFFM_MB_XD3_XDFFM_CKBB r0 *1 0,0
Ccc_XD2_XDFFM_MB_XD3_XDFFM_CKBB XD2_XDFFM_MB XD3_XDFFM_CKBB 1.8151e-17
* device instance cc_XD2_XDFFM_MB_XD3_XDFFM_CLKB r0 *1 0,0
Ccc_XD2_XDFFM_MB_XD3_XDFFM_CLKB XD2_XDFFM_MB XD3_XDFFM_CLKB 2.4201e-17
* device instance cc_XD2_XDFFM_MB_XD3_XDFFM_M r0 *1 0,0
Ccc_XD2_XDFFM_MB_XD3_XDFFM_M XD2_XDFFM_MB XD3_XDFFM_M 2.4201e-17
* device instance cc_XD2_XDFFM_MB_XD3_XDFFM_MB r0 *1 0,0
Ccc_XD2_XDFFM_MB_XD3_XDFFM_MB XD2_XDFFM_MB XD3_XDFFM_MB 1.21e-17
* device instance cc_XD2_XDFFM_MB_XD3_XDFFM_MFB r0 *1 0,0
Ccc_XD2_XDFFM_MB_XD3_XDFFM_MFB XD2_XDFFM_MB XD3_XDFFM_MFB 1.21e-17
* device instance cc_XD2_XDFFM_MB_XD3_XDFFM_S r0 *1 0,0
Ccc_XD2_XDFFM_MB_XD3_XDFFM_S XD2_XDFFM_MB XD3_XDFFM_S 1.8151e-17
* device instance cc_XD2_XDFFM_MB_XD3_XDFFM_SB r0 *1 0,0
Ccc_XD2_XDFFM_MB_XD3_XDFFM_SB XD2_XDFFM_MB XD3_XDFFM_SB 1.8151e-17
* device instance cc_XD2_XDFFM_MB_XD3_XDFFM_SFB r0 *1 0,0
Ccc_XD2_XDFFM_MB_XD3_XDFFM_SFB XD2_XDFFM_MB XD3_XDFFM_SFB 1.21e-17
* device instance cc_XD2_XDFFM_MB_XD3_XDFFQ_CKBB r0 *1 0,0
Ccc_XD2_XDFFM_MB_XD3_XDFFQ_CKBB XD2_XDFFM_MB XD3_XDFFQ_CKBB 1.8151e-17
* device instance cc_XD2_XDFFM_MB_XD3_XDFFQ_CLKB r0 *1 0,0
Ccc_XD2_XDFFM_MB_XD3_XDFFQ_CLKB XD2_XDFFM_MB XD3_XDFFQ_CLKB 2.4201e-17
* device instance cc_XD2_XDFFM_MB_XD3_XDFFQ_M r0 *1 0,0
Ccc_XD2_XDFFM_MB_XD3_XDFFQ_M XD2_XDFFM_MB XD3_XDFFQ_M 2.4201e-17
* device instance cc_XD2_XDFFM_MB_XD3_XDFFQ_MB r0 *1 0,0
Ccc_XD2_XDFFM_MB_XD3_XDFFQ_MB XD2_XDFFM_MB XD3_XDFFQ_MB 1.21e-17
* device instance cc_XD2_XDFFM_MB_XD3_XDFFQ_MFB r0 *1 0,0
Ccc_XD2_XDFFM_MB_XD3_XDFFQ_MFB XD2_XDFFM_MB XD3_XDFFQ_MFB 1.21e-17
* device instance cc_XD2_XDFFM_MB_XD3_XDFFQ_S r0 *1 0,0
Ccc_XD2_XDFFM_MB_XD3_XDFFQ_S XD2_XDFFM_MB XD3_XDFFQ_S 1.8151e-17
* device instance cc_XD2_XDFFM_MB_XD3_XDFFQ_SB r0 *1 0,0
Ccc_XD2_XDFFM_MB_XD3_XDFFQ_SB XD2_XDFFM_MB XD3_XDFFQ_SB 1.8151e-17
* device instance cc_XD2_XDFFM_MB_XD3_XDFFQ_SFB r0 *1 0,0
Ccc_XD2_XDFFM_MB_XD3_XDFFQ_SFB XD2_XDFFM_MB XD3_XDFFQ_SFB 1.21e-17
* device instance cc_XD2_XDFFM_MB_XD3_XN2_mid1 r0 *1 0,0
Ccc_XD2_XDFFM_MB_XD3_XN2_mid1 XD2_XDFFM_MB XD3_XN2_mid1 1.21e-17
* device instance cc_XD2_XDFFM_MB_XD3_XN3_mid1 r0 *1 0,0
Ccc_XD2_XDFFM_MB_XD3_XN3_mid1 XD2_XDFFM_MB XD3_XN3_mid1 1.21e-17
* device instance cc_XD2_XDFFM_MB_XD3_XN3_mid2 r0 *1 0,0
Ccc_XD2_XDFFM_MB_XD3_XN3_mid2 XD2_XDFFM_MB XD3_XN3_mid2 1.21e-17
* device instance cc_XD2_XDFFM_MB_XD3_dmodout r0 *1 0,0
Ccc_XD2_XDFFM_MB_XD3_dmodout XD2_XDFFM_MB XD3_dmodout 1.21e-17
* device instance cc_XD2_XDFFM_MB_XD3_dq r0 *1 0,0
Ccc_XD2_XDFFM_MB_XD3_dq XD2_XDFFM_MB XD3_dq 1.8151e-17
* device instance cc_XD2_XDFFM_MB_XD3_nm r0 *1 0,0
Ccc_XD2_XDFFM_MB_XD3_nm XD2_XDFFM_MB XD3_nm 1.21e-17
* device instance cc_XD2_XDFFM_MB_XD3_nt r0 *1 0,0
Ccc_XD2_XDFFM_MB_XD3_nt XD2_XDFFM_MB XD3_nt 1.21e-17
* device instance cc_XD2_XDFFM_MB_XD3_t1 r0 *1 0,0
Ccc_XD2_XDFFM_MB_XD3_t1 XD2_XDFFM_MB XD3_t1 1.21e-17
* device instance cc_XD2_XDFFM_MB_XD4_XDFFM_CKBB r0 *1 0,0
Ccc_XD2_XDFFM_MB_XD4_XDFFM_CKBB XD2_XDFFM_MB XD4_XDFFM_CKBB 1.8151e-17
* device instance cc_XD2_XDFFM_MB_XD4_XDFFM_CLKB r0 *1 0,0
Ccc_XD2_XDFFM_MB_XD4_XDFFM_CLKB XD2_XDFFM_MB XD4_XDFFM_CLKB 2.4201e-17
* device instance cc_XD2_XDFFM_MB_XD4_XDFFM_M r0 *1 0,0
Ccc_XD2_XDFFM_MB_XD4_XDFFM_M XD2_XDFFM_MB XD4_XDFFM_M 2.4201e-17
* device instance cc_XD2_XDFFM_MB_XD4_XDFFM_MB r0 *1 0,0
Ccc_XD2_XDFFM_MB_XD4_XDFFM_MB XD2_XDFFM_MB XD4_XDFFM_MB 1.21e-17
* device instance cc_XD2_XDFFM_MB_XD4_XDFFM_MFB r0 *1 0,0
Ccc_XD2_XDFFM_MB_XD4_XDFFM_MFB XD2_XDFFM_MB XD4_XDFFM_MFB 1.21e-17
* device instance cc_XD2_XDFFM_MB_XD4_XDFFM_S r0 *1 0,0
Ccc_XD2_XDFFM_MB_XD4_XDFFM_S XD2_XDFFM_MB XD4_XDFFM_S 1.8151e-17
* device instance cc_XD2_XDFFM_MB_XD4_XDFFM_SB r0 *1 0,0
Ccc_XD2_XDFFM_MB_XD4_XDFFM_SB XD2_XDFFM_MB XD4_XDFFM_SB 1.8151e-17
* device instance cc_XD2_XDFFM_MB_XD4_XDFFM_SFB r0 *1 0,0
Ccc_XD2_XDFFM_MB_XD4_XDFFM_SFB XD2_XDFFM_MB XD4_XDFFM_SFB 1.21e-17
* device instance cc_XD2_XDFFM_MB_XD4_XDFFQ_CKBB r0 *1 0,0
Ccc_XD2_XDFFM_MB_XD4_XDFFQ_CKBB XD2_XDFFM_MB XD4_XDFFQ_CKBB 1.8151e-17
* device instance cc_XD2_XDFFM_MB_XD4_XDFFQ_CLKB r0 *1 0,0
Ccc_XD2_XDFFM_MB_XD4_XDFFQ_CLKB XD2_XDFFM_MB XD4_XDFFQ_CLKB 2.4201e-17
* device instance cc_XD2_XDFFM_MB_XD4_XDFFQ_M r0 *1 0,0
Ccc_XD2_XDFFM_MB_XD4_XDFFQ_M XD2_XDFFM_MB XD4_XDFFQ_M 2.4201e-17
* device instance cc_XD2_XDFFM_MB_XD4_XDFFQ_MB r0 *1 0,0
Ccc_XD2_XDFFM_MB_XD4_XDFFQ_MB XD2_XDFFM_MB XD4_XDFFQ_MB 1.21e-17
* device instance cc_XD2_XDFFM_MB_XD4_XDFFQ_MFB r0 *1 0,0
Ccc_XD2_XDFFM_MB_XD4_XDFFQ_MFB XD2_XDFFM_MB XD4_XDFFQ_MFB 1.21e-17
* device instance cc_XD2_XDFFM_MB_XD4_XDFFQ_S r0 *1 0,0
Ccc_XD2_XDFFM_MB_XD4_XDFFQ_S XD2_XDFFM_MB XD4_XDFFQ_S 1.8151e-17
* device instance cc_XD2_XDFFM_MB_XD4_XDFFQ_SB r0 *1 0,0
Ccc_XD2_XDFFM_MB_XD4_XDFFQ_SB XD2_XDFFM_MB XD4_XDFFQ_SB 1.8151e-17
* device instance cc_XD2_XDFFM_MB_XD4_XDFFQ_SFB r0 *1 0,0
Ccc_XD2_XDFFM_MB_XD4_XDFFQ_SFB XD2_XDFFM_MB XD4_XDFFQ_SFB 1.21e-17
* device instance cc_XD2_XDFFM_MB_XD4_XN2_mid1 r0 *1 0,0
Ccc_XD2_XDFFM_MB_XD4_XN2_mid1 XD2_XDFFM_MB XD4_XN2_mid1 1.21e-17
* device instance cc_XD2_XDFFM_MB_XD4_XN3_mid1 r0 *1 0,0
Ccc_XD2_XDFFM_MB_XD4_XN3_mid1 XD2_XDFFM_MB XD4_XN3_mid1 1.21e-17
* device instance cc_XD2_XDFFM_MB_XD4_XN3_mid2 r0 *1 0,0
Ccc_XD2_XDFFM_MB_XD4_XN3_mid2 XD2_XDFFM_MB XD4_XN3_mid2 1.21e-17
* device instance cc_XD2_XDFFM_MB_XD4_dmodout r0 *1 0,0
Ccc_XD2_XDFFM_MB_XD4_dmodout XD2_XDFFM_MB XD4_dmodout 1.21e-17
* device instance cc_XD2_XDFFM_MB_XD4_dq r0 *1 0,0
Ccc_XD2_XDFFM_MB_XD4_dq XD2_XDFFM_MB XD4_dq 1.8151e-17
* device instance cc_XD2_XDFFM_MB_XD4_nm r0 *1 0,0
Ccc_XD2_XDFFM_MB_XD4_nm XD2_XDFFM_MB XD4_nm 1.21e-17
* device instance cc_XD2_XDFFM_MB_XD4_nt r0 *1 0,0
Ccc_XD2_XDFFM_MB_XD4_nt XD2_XDFFM_MB XD4_nt 1.21e-17
* device instance cc_XD2_XDFFM_MB_XD4_t1 r0 *1 0,0
Ccc_XD2_XDFFM_MB_XD4_t1 XD2_XDFFM_MB XD4_t1 1.21e-17
* device instance cc_XD2_XDFFM_MB_XD5_XDFFM_CKBB r0 *1 0,0
Ccc_XD2_XDFFM_MB_XD5_XDFFM_CKBB XD2_XDFFM_MB XD5_XDFFM_CKBB 1.8151e-17
* device instance cc_XD2_XDFFM_MB_XD5_XDFFM_CLKB r0 *1 0,0
Ccc_XD2_XDFFM_MB_XD5_XDFFM_CLKB XD2_XDFFM_MB XD5_XDFFM_CLKB 2.4201e-17
* device instance cc_XD2_XDFFM_MB_XD5_XDFFM_M r0 *1 0,0
Ccc_XD2_XDFFM_MB_XD5_XDFFM_M XD2_XDFFM_MB XD5_XDFFM_M 2.4201e-17
* device instance cc_XD2_XDFFM_MB_XD5_XDFFM_MB r0 *1 0,0
Ccc_XD2_XDFFM_MB_XD5_XDFFM_MB XD2_XDFFM_MB XD5_XDFFM_MB 1.21e-17
* device instance cc_XD2_XDFFM_MB_XD5_XDFFM_MFB r0 *1 0,0
Ccc_XD2_XDFFM_MB_XD5_XDFFM_MFB XD2_XDFFM_MB XD5_XDFFM_MFB 1.21e-17
* device instance cc_XD2_XDFFM_MB_XD5_XDFFM_S r0 *1 0,0
Ccc_XD2_XDFFM_MB_XD5_XDFFM_S XD2_XDFFM_MB XD5_XDFFM_S 1.8151e-17
* device instance cc_XD2_XDFFM_MB_XD5_XDFFM_SB r0 *1 0,0
Ccc_XD2_XDFFM_MB_XD5_XDFFM_SB XD2_XDFFM_MB XD5_XDFFM_SB 1.8151e-17
* device instance cc_XD2_XDFFM_MB_XD5_XDFFM_SFB r0 *1 0,0
Ccc_XD2_XDFFM_MB_XD5_XDFFM_SFB XD2_XDFFM_MB XD5_XDFFM_SFB 1.21e-17
* device instance cc_XD2_XDFFM_MB_XD5_XDFFQ_CKBB r0 *1 0,0
Ccc_XD2_XDFFM_MB_XD5_XDFFQ_CKBB XD2_XDFFM_MB XD5_XDFFQ_CKBB 1.8151e-17
* device instance cc_XD2_XDFFM_MB_XD5_XDFFQ_CLKB r0 *1 0,0
Ccc_XD2_XDFFM_MB_XD5_XDFFQ_CLKB XD2_XDFFM_MB XD5_XDFFQ_CLKB 2.4201e-17
* device instance cc_XD2_XDFFM_MB_XD5_XDFFQ_M r0 *1 0,0
Ccc_XD2_XDFFM_MB_XD5_XDFFQ_M XD2_XDFFM_MB XD5_XDFFQ_M 2.4201e-17
* device instance cc_XD2_XDFFM_MB_XD5_XDFFQ_MB r0 *1 0,0
Ccc_XD2_XDFFM_MB_XD5_XDFFQ_MB XD2_XDFFM_MB XD5_XDFFQ_MB 1.21e-17
* device instance cc_XD2_XDFFM_MB_XD5_XDFFQ_MFB r0 *1 0,0
Ccc_XD2_XDFFM_MB_XD5_XDFFQ_MFB XD2_XDFFM_MB XD5_XDFFQ_MFB 1.21e-17
* device instance cc_XD2_XDFFM_MB_XD5_XDFFQ_S r0 *1 0,0
Ccc_XD2_XDFFM_MB_XD5_XDFFQ_S XD2_XDFFM_MB XD5_XDFFQ_S 1.8151e-17
* device instance cc_XD2_XDFFM_MB_XD5_XDFFQ_SB r0 *1 0,0
Ccc_XD2_XDFFM_MB_XD5_XDFFQ_SB XD2_XDFFM_MB XD5_XDFFQ_SB 1.8151e-17
* device instance cc_XD2_XDFFM_MB_XD5_XDFFQ_SFB r0 *1 0,0
Ccc_XD2_XDFFM_MB_XD5_XDFFQ_SFB XD2_XDFFM_MB XD5_XDFFQ_SFB 1.21e-17
* device instance cc_XD2_XDFFM_MB_XD5_XN2_mid1 r0 *1 0,0
Ccc_XD2_XDFFM_MB_XD5_XN2_mid1 XD2_XDFFM_MB XD5_XN2_mid1 1.21e-17
* device instance cc_XD2_XDFFM_MB_XD5_XN3_mid1 r0 *1 0,0
Ccc_XD2_XDFFM_MB_XD5_XN3_mid1 XD2_XDFFM_MB XD5_XN3_mid1 1.21e-17
* device instance cc_XD2_XDFFM_MB_XD5_XN3_mid2 r0 *1 0,0
Ccc_XD2_XDFFM_MB_XD5_XN3_mid2 XD2_XDFFM_MB XD5_XN3_mid2 1.21e-17
* device instance cc_XD2_XDFFM_MB_XD5_dmodout r0 *1 0,0
Ccc_XD2_XDFFM_MB_XD5_dmodout XD2_XDFFM_MB XD5_dmodout 1.21e-17
* device instance cc_XD2_XDFFM_MB_XD5_dq r0 *1 0,0
Ccc_XD2_XDFFM_MB_XD5_dq XD2_XDFFM_MB XD5_dq 1.8151e-17
* device instance cc_XD2_XDFFM_MB_XD5_nm r0 *1 0,0
Ccc_XD2_XDFFM_MB_XD5_nm XD2_XDFFM_MB XD5_nm 1.21e-17
* device instance cc_XD2_XDFFM_MB_XD5_nt r0 *1 0,0
Ccc_XD2_XDFFM_MB_XD5_nt XD2_XDFFM_MB XD5_nt 1.21e-17
* device instance cc_XD2_XDFFM_MB_XD5_t1 r0 *1 0,0
Ccc_XD2_XDFFM_MB_XD5_t1 XD2_XDFFM_MB XD5_t1 1.21e-17
* device instance cc_XD2_XDFFM_MB_XFRT_CKBB r0 *1 0,0
Ccc_XD2_XDFFM_MB_XFRT_CKBB XD2_XDFFM_MB XFRT_CKBB 1.8151e-17
* device instance cc_XD2_XDFFM_MB_XFRT_CLKB r0 *1 0,0
Ccc_XD2_XDFFM_MB_XFRT_CLKB XD2_XDFFM_MB XFRT_CLKB 2.4201e-17
* device instance cc_XD2_XDFFM_MB_XFRT_M r0 *1 0,0
Ccc_XD2_XDFFM_MB_XFRT_M XD2_XDFFM_MB XFRT_M 2.4201e-17
* device instance cc_XD2_XDFFM_MB_XFRT_MB r0 *1 0,0
Ccc_XD2_XDFFM_MB_XFRT_MB XD2_XDFFM_MB XFRT_MB 1.21e-17
* device instance cc_XD2_XDFFM_MB_XFRT_MFB r0 *1 0,0
Ccc_XD2_XDFFM_MB_XFRT_MFB XD2_XDFFM_MB XFRT_MFB 1.21e-17
* device instance cc_XD2_XDFFM_MB_XFRT_S r0 *1 0,0
Ccc_XD2_XDFFM_MB_XFRT_S XD2_XDFFM_MB XFRT_S 1.8151e-17
* device instance cc_XD2_XDFFM_MB_XFRT_SB r0 *1 0,0
Ccc_XD2_XDFFM_MB_XFRT_SB XD2_XDFFM_MB XFRT_SB 1.8151e-17
* device instance cc_XD2_XDFFM_MB_XFRT_SFB r0 *1 0,0
Ccc_XD2_XDFFM_MB_XFRT_SFB XD2_XDFFM_MB XFRT_SFB 1.21e-17
* device instance cc_XD2_XDFFM_MB_ck1 r0 *1 0,0
Ccc_XD2_XDFFM_MB_ck1 XD2_XDFFM_MB ck1 3.0251e-17
* device instance cc_XD2_XDFFM_MB_ck2 r0 *1 0,0
Ccc_XD2_XDFFM_MB_ck2 XD2_XDFFM_MB ck2 3.0251e-17
* device instance cc_XD2_XDFFM_MB_ck3 r0 *1 0,0
Ccc_XD2_XDFFM_MB_ck3 XD2_XDFFM_MB ck3 3.0251e-17
* device instance cc_XD2_XDFFM_MB_ck4 r0 *1 0,0
Ccc_XD2_XDFFM_MB_ck4 XD2_XDFFM_MB ck4 3.0251e-17
* device instance cc_XD2_XDFFM_MB_ck5 r0 *1 0,0
Ccc_XD2_XDFFM_MB_ck5 XD2_XDFFM_MB ck5 3.0251e-17
* device instance cc_XD2_XDFFM_MB_mod0 r0 *1 0,0
Ccc_XD2_XDFFM_MB_mod0 XD2_XDFFM_MB mod0 2.4201e-17
* device instance cc_XD2_XDFFM_MB_mod1 r0 *1 0,0
Ccc_XD2_XDFFM_MB_mod1 XD2_XDFFM_MB mod1 2.4201e-17
* device instance cc_XD2_XDFFM_MB_mod2 r0 *1 0,0
Ccc_XD2_XDFFM_MB_mod2 XD2_XDFFM_MB mod2 2.4201e-17
* device instance cc_XD2_XDFFM_MB_mod3 r0 *1 0,0
Ccc_XD2_XDFFM_MB_mod3 XD2_XDFFM_MB mod3 2.4201e-17
* device instance cc_XD2_XDFFM_MB_mod4 r0 *1 0,0
Ccc_XD2_XDFFM_MB_mod4 XD2_XDFFM_MB mod4 2.4201e-17
* device instance cc_XD2_XDFFM_MB_net1 r0 *1 0,0
Ccc_XD2_XDFFM_MB_net1 XD2_XDFFM_MB net1 1.21e-17
* device instance cc_XD2_XDFFM_MFB_XD2_XDFFM_S r0 *1 0,0
Ccc_XD2_XDFFM_MFB_XD2_XDFFM_S XD2_XDFFM_MFB XD2_XDFFM_S 1.8151e-17
* device instance cc_XD2_XDFFM_MFB_XD2_XDFFM_SB r0 *1 0,0
Ccc_XD2_XDFFM_MFB_XD2_XDFFM_SB XD2_XDFFM_MFB XD2_XDFFM_SB 1.8151e-17
* device instance cc_XD2_XDFFM_MFB_XD2_XDFFM_SFB r0 *1 0,0
Ccc_XD2_XDFFM_MFB_XD2_XDFFM_SFB XD2_XDFFM_MFB XD2_XDFFM_SFB 1.21e-17
* device instance cc_XD2_XDFFM_MFB_XD2_XDFFQ_CKBB r0 *1 0,0
Ccc_XD2_XDFFM_MFB_XD2_XDFFQ_CKBB XD2_XDFFM_MFB XD2_XDFFQ_CKBB 1.8151e-17
* device instance cc_XD2_XDFFM_MFB_XD2_XDFFQ_CLKB r0 *1 0,0
Ccc_XD2_XDFFM_MFB_XD2_XDFFQ_CLKB XD2_XDFFM_MFB XD2_XDFFQ_CLKB 2.4201e-17
* device instance cc_XD2_XDFFM_MFB_XD2_XDFFQ_M r0 *1 0,0
Ccc_XD2_XDFFM_MFB_XD2_XDFFQ_M XD2_XDFFM_MFB XD2_XDFFQ_M 2.4201e-17
* device instance cc_XD2_XDFFM_MFB_XD2_XDFFQ_MB r0 *1 0,0
Ccc_XD2_XDFFM_MFB_XD2_XDFFQ_MB XD2_XDFFM_MFB XD2_XDFFQ_MB 1.21e-17
* device instance cc_XD2_XDFFM_MFB_XD2_XDFFQ_MFB r0 *1 0,0
Ccc_XD2_XDFFM_MFB_XD2_XDFFQ_MFB XD2_XDFFM_MFB XD2_XDFFQ_MFB 1.21e-17
* device instance cc_XD2_XDFFM_MFB_XD2_XDFFQ_S r0 *1 0,0
Ccc_XD2_XDFFM_MFB_XD2_XDFFQ_S XD2_XDFFM_MFB XD2_XDFFQ_S 1.8151e-17
* device instance cc_XD2_XDFFM_MFB_XD2_XDFFQ_SB r0 *1 0,0
Ccc_XD2_XDFFM_MFB_XD2_XDFFQ_SB XD2_XDFFM_MFB XD2_XDFFQ_SB 1.8151e-17
* device instance cc_XD2_XDFFM_MFB_XD2_XDFFQ_SFB r0 *1 0,0
Ccc_XD2_XDFFM_MFB_XD2_XDFFQ_SFB XD2_XDFFM_MFB XD2_XDFFQ_SFB 1.21e-17
* device instance cc_XD2_XDFFM_MFB_XD2_XNOR_midp r0 *1 0,0
Ccc_XD2_XDFFM_MFB_XD2_XNOR_midp XD2_XDFFM_MFB XD2_XNOR_midp 1.21e-17
* device instance cc_XD2_XDFFM_MFB_XD2_dmodout r0 *1 0,0
Ccc_XD2_XDFFM_MFB_XD2_dmodout XD2_XDFFM_MFB XD2_dmodout 1.21e-17
* device instance cc_XD2_XDFFM_MFB_XD2_dq r0 *1 0,0
Ccc_XD2_XDFFM_MFB_XD2_dq XD2_XDFFM_MFB XD2_dq 1.21e-17
* device instance cc_XD2_XDFFM_MFB_XD2_nm r0 *1 0,0
Ccc_XD2_XDFFM_MFB_XD2_nm XD2_XDFFM_MFB XD2_nm 1.8151e-17
* device instance cc_XD2_XDFFM_MFB_XD2_nt r0 *1 0,0
Ccc_XD2_XDFFM_MFB_XD2_nt XD2_XDFFM_MFB XD2_nt 2.4201e-17
* device instance cc_XD2_XDFFM_MFB_XD2_t1 r0 *1 0,0
Ccc_XD2_XDFFM_MFB_XD2_t1 XD2_XDFFM_MFB XD2_t1 1.21e-17
* device instance cc_XD2_XDFFM_MFB_XD3_XDFFM_CKBB r0 *1 0,0
Ccc_XD2_XDFFM_MFB_XD3_XDFFM_CKBB XD2_XDFFM_MFB XD3_XDFFM_CKBB 1.8151e-17
* device instance cc_XD2_XDFFM_MFB_XD3_XDFFM_CLKB r0 *1 0,0
Ccc_XD2_XDFFM_MFB_XD3_XDFFM_CLKB XD2_XDFFM_MFB XD3_XDFFM_CLKB 2.4201e-17
* device instance cc_XD2_XDFFM_MFB_XD3_XDFFM_M r0 *1 0,0
Ccc_XD2_XDFFM_MFB_XD3_XDFFM_M XD2_XDFFM_MFB XD3_XDFFM_M 2.4201e-17
* device instance cc_XD2_XDFFM_MFB_XD3_XDFFM_MB r0 *1 0,0
Ccc_XD2_XDFFM_MFB_XD3_XDFFM_MB XD2_XDFFM_MFB XD3_XDFFM_MB 1.21e-17
* device instance cc_XD2_XDFFM_MFB_XD3_XDFFM_MFB r0 *1 0,0
Ccc_XD2_XDFFM_MFB_XD3_XDFFM_MFB XD2_XDFFM_MFB XD3_XDFFM_MFB 1.21e-17
* device instance cc_XD2_XDFFM_MFB_XD3_XDFFM_S r0 *1 0,0
Ccc_XD2_XDFFM_MFB_XD3_XDFFM_S XD2_XDFFM_MFB XD3_XDFFM_S 1.8151e-17
* device instance cc_XD2_XDFFM_MFB_XD3_XDFFM_SB r0 *1 0,0
Ccc_XD2_XDFFM_MFB_XD3_XDFFM_SB XD2_XDFFM_MFB XD3_XDFFM_SB 1.8151e-17
* device instance cc_XD2_XDFFM_MFB_XD3_XDFFM_SFB r0 *1 0,0
Ccc_XD2_XDFFM_MFB_XD3_XDFFM_SFB XD2_XDFFM_MFB XD3_XDFFM_SFB 1.21e-17
* device instance cc_XD2_XDFFM_MFB_XD3_XDFFQ_CKBB r0 *1 0,0
Ccc_XD2_XDFFM_MFB_XD3_XDFFQ_CKBB XD2_XDFFM_MFB XD3_XDFFQ_CKBB 1.8151e-17
* device instance cc_XD2_XDFFM_MFB_XD3_XDFFQ_CLKB r0 *1 0,0
Ccc_XD2_XDFFM_MFB_XD3_XDFFQ_CLKB XD2_XDFFM_MFB XD3_XDFFQ_CLKB 2.4201e-17
* device instance cc_XD2_XDFFM_MFB_XD3_XDFFQ_M r0 *1 0,0
Ccc_XD2_XDFFM_MFB_XD3_XDFFQ_M XD2_XDFFM_MFB XD3_XDFFQ_M 2.4201e-17
* device instance cc_XD2_XDFFM_MFB_XD3_XDFFQ_MB r0 *1 0,0
Ccc_XD2_XDFFM_MFB_XD3_XDFFQ_MB XD2_XDFFM_MFB XD3_XDFFQ_MB 1.21e-17
* device instance cc_XD2_XDFFM_MFB_XD3_XDFFQ_MFB r0 *1 0,0
Ccc_XD2_XDFFM_MFB_XD3_XDFFQ_MFB XD2_XDFFM_MFB XD3_XDFFQ_MFB 1.21e-17
* device instance cc_XD2_XDFFM_MFB_XD3_XDFFQ_S r0 *1 0,0
Ccc_XD2_XDFFM_MFB_XD3_XDFFQ_S XD2_XDFFM_MFB XD3_XDFFQ_S 1.8151e-17
* device instance cc_XD2_XDFFM_MFB_XD3_XDFFQ_SB r0 *1 0,0
Ccc_XD2_XDFFM_MFB_XD3_XDFFQ_SB XD2_XDFFM_MFB XD3_XDFFQ_SB 1.8151e-17
* device instance cc_XD2_XDFFM_MFB_XD3_XDFFQ_SFB r0 *1 0,0
Ccc_XD2_XDFFM_MFB_XD3_XDFFQ_SFB XD2_XDFFM_MFB XD3_XDFFQ_SFB 1.21e-17
* device instance cc_XD2_XDFFM_MFB_XD3_XN2_mid1 r0 *1 0,0
Ccc_XD2_XDFFM_MFB_XD3_XN2_mid1 XD2_XDFFM_MFB XD3_XN2_mid1 1.21e-17
* device instance cc_XD2_XDFFM_MFB_XD3_XN3_mid1 r0 *1 0,0
Ccc_XD2_XDFFM_MFB_XD3_XN3_mid1 XD2_XDFFM_MFB XD3_XN3_mid1 1.21e-17
* device instance cc_XD2_XDFFM_MFB_XD3_XN3_mid2 r0 *1 0,0
Ccc_XD2_XDFFM_MFB_XD3_XN3_mid2 XD2_XDFFM_MFB XD3_XN3_mid2 1.21e-17
* device instance cc_XD2_XDFFM_MFB_XD3_dmodout r0 *1 0,0
Ccc_XD2_XDFFM_MFB_XD3_dmodout XD2_XDFFM_MFB XD3_dmodout 1.21e-17
* device instance cc_XD2_XDFFM_MFB_XD3_dq r0 *1 0,0
Ccc_XD2_XDFFM_MFB_XD3_dq XD2_XDFFM_MFB XD3_dq 1.8151e-17
* device instance cc_XD2_XDFFM_MFB_XD3_nm r0 *1 0,0
Ccc_XD2_XDFFM_MFB_XD3_nm XD2_XDFFM_MFB XD3_nm 1.21e-17
* device instance cc_XD2_XDFFM_MFB_XD3_nt r0 *1 0,0
Ccc_XD2_XDFFM_MFB_XD3_nt XD2_XDFFM_MFB XD3_nt 1.21e-17
* device instance cc_XD2_XDFFM_MFB_XD3_t1 r0 *1 0,0
Ccc_XD2_XDFFM_MFB_XD3_t1 XD2_XDFFM_MFB XD3_t1 1.21e-17
* device instance cc_XD2_XDFFM_MFB_XD4_XDFFM_CKBB r0 *1 0,0
Ccc_XD2_XDFFM_MFB_XD4_XDFFM_CKBB XD2_XDFFM_MFB XD4_XDFFM_CKBB 1.8151e-17
* device instance cc_XD2_XDFFM_MFB_XD4_XDFFM_CLKB r0 *1 0,0
Ccc_XD2_XDFFM_MFB_XD4_XDFFM_CLKB XD2_XDFFM_MFB XD4_XDFFM_CLKB 2.4201e-17
* device instance cc_XD2_XDFFM_MFB_XD4_XDFFM_M r0 *1 0,0
Ccc_XD2_XDFFM_MFB_XD4_XDFFM_M XD2_XDFFM_MFB XD4_XDFFM_M 2.4201e-17
* device instance cc_XD2_XDFFM_MFB_XD4_XDFFM_MB r0 *1 0,0
Ccc_XD2_XDFFM_MFB_XD4_XDFFM_MB XD2_XDFFM_MFB XD4_XDFFM_MB 1.21e-17
* device instance cc_XD2_XDFFM_MFB_XD4_XDFFM_MFB r0 *1 0,0
Ccc_XD2_XDFFM_MFB_XD4_XDFFM_MFB XD2_XDFFM_MFB XD4_XDFFM_MFB 1.21e-17
* device instance cc_XD2_XDFFM_MFB_XD4_XDFFM_S r0 *1 0,0
Ccc_XD2_XDFFM_MFB_XD4_XDFFM_S XD2_XDFFM_MFB XD4_XDFFM_S 1.8151e-17
* device instance cc_XD2_XDFFM_MFB_XD4_XDFFM_SB r0 *1 0,0
Ccc_XD2_XDFFM_MFB_XD4_XDFFM_SB XD2_XDFFM_MFB XD4_XDFFM_SB 1.8151e-17
* device instance cc_XD2_XDFFM_MFB_XD4_XDFFM_SFB r0 *1 0,0
Ccc_XD2_XDFFM_MFB_XD4_XDFFM_SFB XD2_XDFFM_MFB XD4_XDFFM_SFB 1.21e-17
* device instance cc_XD2_XDFFM_MFB_XD4_XDFFQ_CKBB r0 *1 0,0
Ccc_XD2_XDFFM_MFB_XD4_XDFFQ_CKBB XD2_XDFFM_MFB XD4_XDFFQ_CKBB 1.8151e-17
* device instance cc_XD2_XDFFM_MFB_XD4_XDFFQ_CLKB r0 *1 0,0
Ccc_XD2_XDFFM_MFB_XD4_XDFFQ_CLKB XD2_XDFFM_MFB XD4_XDFFQ_CLKB 2.4201e-17
* device instance cc_XD2_XDFFM_MFB_XD4_XDFFQ_M r0 *1 0,0
Ccc_XD2_XDFFM_MFB_XD4_XDFFQ_M XD2_XDFFM_MFB XD4_XDFFQ_M 2.4201e-17
* device instance cc_XD2_XDFFM_MFB_XD4_XDFFQ_MB r0 *1 0,0
Ccc_XD2_XDFFM_MFB_XD4_XDFFQ_MB XD2_XDFFM_MFB XD4_XDFFQ_MB 1.21e-17
* device instance cc_XD2_XDFFM_MFB_XD4_XDFFQ_MFB r0 *1 0,0
Ccc_XD2_XDFFM_MFB_XD4_XDFFQ_MFB XD2_XDFFM_MFB XD4_XDFFQ_MFB 1.21e-17
* device instance cc_XD2_XDFFM_MFB_XD4_XDFFQ_S r0 *1 0,0
Ccc_XD2_XDFFM_MFB_XD4_XDFFQ_S XD2_XDFFM_MFB XD4_XDFFQ_S 1.8151e-17
* device instance cc_XD2_XDFFM_MFB_XD4_XDFFQ_SB r0 *1 0,0
Ccc_XD2_XDFFM_MFB_XD4_XDFFQ_SB XD2_XDFFM_MFB XD4_XDFFQ_SB 1.8151e-17
* device instance cc_XD2_XDFFM_MFB_XD4_XDFFQ_SFB r0 *1 0,0
Ccc_XD2_XDFFM_MFB_XD4_XDFFQ_SFB XD2_XDFFM_MFB XD4_XDFFQ_SFB 1.21e-17
* device instance cc_XD2_XDFFM_MFB_XD4_XN2_mid1 r0 *1 0,0
Ccc_XD2_XDFFM_MFB_XD4_XN2_mid1 XD2_XDFFM_MFB XD4_XN2_mid1 1.21e-17
* device instance cc_XD2_XDFFM_MFB_XD4_XN3_mid1 r0 *1 0,0
Ccc_XD2_XDFFM_MFB_XD4_XN3_mid1 XD2_XDFFM_MFB XD4_XN3_mid1 1.21e-17
* device instance cc_XD2_XDFFM_MFB_XD4_XN3_mid2 r0 *1 0,0
Ccc_XD2_XDFFM_MFB_XD4_XN3_mid2 XD2_XDFFM_MFB XD4_XN3_mid2 1.21e-17
* device instance cc_XD2_XDFFM_MFB_XD4_dmodout r0 *1 0,0
Ccc_XD2_XDFFM_MFB_XD4_dmodout XD2_XDFFM_MFB XD4_dmodout 1.21e-17
* device instance cc_XD2_XDFFM_MFB_XD4_dq r0 *1 0,0
Ccc_XD2_XDFFM_MFB_XD4_dq XD2_XDFFM_MFB XD4_dq 1.8151e-17
* device instance cc_XD2_XDFFM_MFB_XD4_nm r0 *1 0,0
Ccc_XD2_XDFFM_MFB_XD4_nm XD2_XDFFM_MFB XD4_nm 1.21e-17
* device instance cc_XD2_XDFFM_MFB_XD4_nt r0 *1 0,0
Ccc_XD2_XDFFM_MFB_XD4_nt XD2_XDFFM_MFB XD4_nt 1.21e-17
* device instance cc_XD2_XDFFM_MFB_XD4_t1 r0 *1 0,0
Ccc_XD2_XDFFM_MFB_XD4_t1 XD2_XDFFM_MFB XD4_t1 1.21e-17
* device instance cc_XD2_XDFFM_MFB_XD5_XDFFM_CKBB r0 *1 0,0
Ccc_XD2_XDFFM_MFB_XD5_XDFFM_CKBB XD2_XDFFM_MFB XD5_XDFFM_CKBB 1.8151e-17
* device instance cc_XD2_XDFFM_MFB_XD5_XDFFM_CLKB r0 *1 0,0
Ccc_XD2_XDFFM_MFB_XD5_XDFFM_CLKB XD2_XDFFM_MFB XD5_XDFFM_CLKB 2.4201e-17
* device instance cc_XD2_XDFFM_MFB_XD5_XDFFM_M r0 *1 0,0
Ccc_XD2_XDFFM_MFB_XD5_XDFFM_M XD2_XDFFM_MFB XD5_XDFFM_M 2.4201e-17
* device instance cc_XD2_XDFFM_MFB_XD5_XDFFM_MB r0 *1 0,0
Ccc_XD2_XDFFM_MFB_XD5_XDFFM_MB XD2_XDFFM_MFB XD5_XDFFM_MB 1.21e-17
* device instance cc_XD2_XDFFM_MFB_XD5_XDFFM_MFB r0 *1 0,0
Ccc_XD2_XDFFM_MFB_XD5_XDFFM_MFB XD2_XDFFM_MFB XD5_XDFFM_MFB 1.21e-17
* device instance cc_XD2_XDFFM_MFB_XD5_XDFFM_S r0 *1 0,0
Ccc_XD2_XDFFM_MFB_XD5_XDFFM_S XD2_XDFFM_MFB XD5_XDFFM_S 1.8151e-17
* device instance cc_XD2_XDFFM_MFB_XD5_XDFFM_SB r0 *1 0,0
Ccc_XD2_XDFFM_MFB_XD5_XDFFM_SB XD2_XDFFM_MFB XD5_XDFFM_SB 1.8151e-17
* device instance cc_XD2_XDFFM_MFB_XD5_XDFFM_SFB r0 *1 0,0
Ccc_XD2_XDFFM_MFB_XD5_XDFFM_SFB XD2_XDFFM_MFB XD5_XDFFM_SFB 1.21e-17
* device instance cc_XD2_XDFFM_MFB_XD5_XDFFQ_CKBB r0 *1 0,0
Ccc_XD2_XDFFM_MFB_XD5_XDFFQ_CKBB XD2_XDFFM_MFB XD5_XDFFQ_CKBB 1.8151e-17
* device instance cc_XD2_XDFFM_MFB_XD5_XDFFQ_CLKB r0 *1 0,0
Ccc_XD2_XDFFM_MFB_XD5_XDFFQ_CLKB XD2_XDFFM_MFB XD5_XDFFQ_CLKB 2.4201e-17
* device instance cc_XD2_XDFFM_MFB_XD5_XDFFQ_M r0 *1 0,0
Ccc_XD2_XDFFM_MFB_XD5_XDFFQ_M XD2_XDFFM_MFB XD5_XDFFQ_M 2.4201e-17
* device instance cc_XD2_XDFFM_MFB_XD5_XDFFQ_MB r0 *1 0,0
Ccc_XD2_XDFFM_MFB_XD5_XDFFQ_MB XD2_XDFFM_MFB XD5_XDFFQ_MB 1.21e-17
* device instance cc_XD2_XDFFM_MFB_XD5_XDFFQ_MFB r0 *1 0,0
Ccc_XD2_XDFFM_MFB_XD5_XDFFQ_MFB XD2_XDFFM_MFB XD5_XDFFQ_MFB 1.21e-17
* device instance cc_XD2_XDFFM_MFB_XD5_XDFFQ_S r0 *1 0,0
Ccc_XD2_XDFFM_MFB_XD5_XDFFQ_S XD2_XDFFM_MFB XD5_XDFFQ_S 1.8151e-17
* device instance cc_XD2_XDFFM_MFB_XD5_XDFFQ_SB r0 *1 0,0
Ccc_XD2_XDFFM_MFB_XD5_XDFFQ_SB XD2_XDFFM_MFB XD5_XDFFQ_SB 1.8151e-17
* device instance cc_XD2_XDFFM_MFB_XD5_XDFFQ_SFB r0 *1 0,0
Ccc_XD2_XDFFM_MFB_XD5_XDFFQ_SFB XD2_XDFFM_MFB XD5_XDFFQ_SFB 1.21e-17
* device instance cc_XD2_XDFFM_MFB_XD5_XN2_mid1 r0 *1 0,0
Ccc_XD2_XDFFM_MFB_XD5_XN2_mid1 XD2_XDFFM_MFB XD5_XN2_mid1 1.21e-17
* device instance cc_XD2_XDFFM_MFB_XD5_XN3_mid1 r0 *1 0,0
Ccc_XD2_XDFFM_MFB_XD5_XN3_mid1 XD2_XDFFM_MFB XD5_XN3_mid1 1.21e-17
* device instance cc_XD2_XDFFM_MFB_XD5_XN3_mid2 r0 *1 0,0
Ccc_XD2_XDFFM_MFB_XD5_XN3_mid2 XD2_XDFFM_MFB XD5_XN3_mid2 1.21e-17
* device instance cc_XD2_XDFFM_MFB_XD5_dmodout r0 *1 0,0
Ccc_XD2_XDFFM_MFB_XD5_dmodout XD2_XDFFM_MFB XD5_dmodout 1.21e-17
* device instance cc_XD2_XDFFM_MFB_XD5_dq r0 *1 0,0
Ccc_XD2_XDFFM_MFB_XD5_dq XD2_XDFFM_MFB XD5_dq 1.8151e-17
* device instance cc_XD2_XDFFM_MFB_XD5_nm r0 *1 0,0
Ccc_XD2_XDFFM_MFB_XD5_nm XD2_XDFFM_MFB XD5_nm 1.21e-17
* device instance cc_XD2_XDFFM_MFB_XD5_nt r0 *1 0,0
Ccc_XD2_XDFFM_MFB_XD5_nt XD2_XDFFM_MFB XD5_nt 1.21e-17
* device instance cc_XD2_XDFFM_MFB_XD5_t1 r0 *1 0,0
Ccc_XD2_XDFFM_MFB_XD5_t1 XD2_XDFFM_MFB XD5_t1 1.21e-17
* device instance cc_XD2_XDFFM_MFB_XFRT_CKBB r0 *1 0,0
Ccc_XD2_XDFFM_MFB_XFRT_CKBB XD2_XDFFM_MFB XFRT_CKBB 1.8151e-17
* device instance cc_XD2_XDFFM_MFB_XFRT_CLKB r0 *1 0,0
Ccc_XD2_XDFFM_MFB_XFRT_CLKB XD2_XDFFM_MFB XFRT_CLKB 2.4201e-17
* device instance cc_XD2_XDFFM_MFB_XFRT_M r0 *1 0,0
Ccc_XD2_XDFFM_MFB_XFRT_M XD2_XDFFM_MFB XFRT_M 2.4201e-17
* device instance cc_XD2_XDFFM_MFB_XFRT_MB r0 *1 0,0
Ccc_XD2_XDFFM_MFB_XFRT_MB XD2_XDFFM_MFB XFRT_MB 1.21e-17
* device instance cc_XD2_XDFFM_MFB_XFRT_MFB r0 *1 0,0
Ccc_XD2_XDFFM_MFB_XFRT_MFB XD2_XDFFM_MFB XFRT_MFB 1.21e-17
* device instance cc_XD2_XDFFM_MFB_XFRT_S r0 *1 0,0
Ccc_XD2_XDFFM_MFB_XFRT_S XD2_XDFFM_MFB XFRT_S 1.8151e-17
* device instance cc_XD2_XDFFM_MFB_XFRT_SB r0 *1 0,0
Ccc_XD2_XDFFM_MFB_XFRT_SB XD2_XDFFM_MFB XFRT_SB 1.8151e-17
* device instance cc_XD2_XDFFM_MFB_XFRT_SFB r0 *1 0,0
Ccc_XD2_XDFFM_MFB_XFRT_SFB XD2_XDFFM_MFB XFRT_SFB 1.21e-17
* device instance cc_XD2_XDFFM_MFB_ck1 r0 *1 0,0
Ccc_XD2_XDFFM_MFB_ck1 XD2_XDFFM_MFB ck1 3.0251e-17
* device instance cc_XD2_XDFFM_MFB_ck2 r0 *1 0,0
Ccc_XD2_XDFFM_MFB_ck2 XD2_XDFFM_MFB ck2 3.0251e-17
* device instance cc_XD2_XDFFM_MFB_ck3 r0 *1 0,0
Ccc_XD2_XDFFM_MFB_ck3 XD2_XDFFM_MFB ck3 3.0251e-17
* device instance cc_XD2_XDFFM_MFB_ck4 r0 *1 0,0
Ccc_XD2_XDFFM_MFB_ck4 XD2_XDFFM_MFB ck4 3.0251e-17
* device instance cc_XD2_XDFFM_MFB_ck5 r0 *1 0,0
Ccc_XD2_XDFFM_MFB_ck5 XD2_XDFFM_MFB ck5 3.0251e-17
* device instance cc_XD2_XDFFM_MFB_mod0 r0 *1 0,0
Ccc_XD2_XDFFM_MFB_mod0 XD2_XDFFM_MFB mod0 2.4201e-17
* device instance cc_XD2_XDFFM_MFB_mod1 r0 *1 0,0
Ccc_XD2_XDFFM_MFB_mod1 XD2_XDFFM_MFB mod1 2.4201e-17
* device instance cc_XD2_XDFFM_MFB_mod2 r0 *1 0,0
Ccc_XD2_XDFFM_MFB_mod2 XD2_XDFFM_MFB mod2 2.4201e-17
* device instance cc_XD2_XDFFM_MFB_mod3 r0 *1 0,0
Ccc_XD2_XDFFM_MFB_mod3 XD2_XDFFM_MFB mod3 2.4201e-17
* device instance cc_XD2_XDFFM_MFB_mod4 r0 *1 0,0
Ccc_XD2_XDFFM_MFB_mod4 XD2_XDFFM_MFB mod4 2.4201e-17
* device instance cc_XD2_XDFFM_MFB_net1 r0 *1 0,0
Ccc_XD2_XDFFM_MFB_net1 XD2_XDFFM_MFB net1 1.21e-17
* device instance cc_XD2_XDFFM_S_XD2_XDFFM_SB r0 *1 0,0
Ccc_XD2_XDFFM_S_XD2_XDFFM_SB XD2_XDFFM_S XD2_XDFFM_SB 3.0251e-17
* device instance cc_XD2_XDFFM_S_XD2_XDFFM_SFB r0 *1 0,0
Ccc_XD2_XDFFM_S_XD2_XDFFM_SFB XD2_XDFFM_S XD2_XDFFM_SFB 3.4688e-17
* device instance cc_XD2_XDFFM_S_XD2_XDFFQ_CKBB r0 *1 0,0
Ccc_XD2_XDFFM_S_XD2_XDFFQ_CKBB XD2_XDFFM_S XD2_XDFFQ_CKBB 1.8151e-17
* device instance cc_XD2_XDFFM_S_XD2_XDFFQ_CLKB r0 *1 0,0
Ccc_XD2_XDFFM_S_XD2_XDFFQ_CLKB XD2_XDFFM_S XD2_XDFFQ_CLKB 2.4201e-17
* device instance cc_XD2_XDFFM_S_XD2_XDFFQ_M r0 *1 0,0
Ccc_XD2_XDFFM_S_XD2_XDFFQ_M XD2_XDFFM_S XD2_XDFFQ_M 2.4201e-17
* device instance cc_XD2_XDFFM_S_XD2_XDFFQ_MB r0 *1 0,0
Ccc_XD2_XDFFM_S_XD2_XDFFQ_MB XD2_XDFFM_S XD2_XDFFQ_MB 1.21e-17
* device instance cc_XD2_XDFFM_S_XD2_XDFFQ_MFB r0 *1 0,0
Ccc_XD2_XDFFM_S_XD2_XDFFQ_MFB XD2_XDFFM_S XD2_XDFFQ_MFB 1.21e-17
* device instance cc_XD2_XDFFM_S_XD2_XDFFQ_S r0 *1 0,0
Ccc_XD2_XDFFM_S_XD2_XDFFQ_S XD2_XDFFM_S XD2_XDFFQ_S 1.8151e-17
* device instance cc_XD2_XDFFM_S_XD2_XDFFQ_SB r0 *1 0,0
Ccc_XD2_XDFFM_S_XD2_XDFFQ_SB XD2_XDFFM_S XD2_XDFFQ_SB 1.8151e-17
* device instance cc_XD2_XDFFM_S_XD2_XDFFQ_SFB r0 *1 0,0
Ccc_XD2_XDFFM_S_XD2_XDFFQ_SFB XD2_XDFFM_S XD2_XDFFQ_SFB 1.21e-17
* device instance cc_XD2_XDFFM_S_XD2_XNOR_midp r0 *1 0,0
Ccc_XD2_XDFFM_S_XD2_XNOR_midp XD2_XDFFM_S XD2_XNOR_midp 1.21e-17
* device instance cc_XD2_XDFFM_S_XD2_dmodout r0 *1 0,0
Ccc_XD2_XDFFM_S_XD2_dmodout XD2_XDFFM_S XD2_dmodout 1.21e-17
* device instance cc_XD2_XDFFM_S_XD2_dq r0 *1 0,0
Ccc_XD2_XDFFM_S_XD2_dq XD2_XDFFM_S XD2_dq 1.21e-17
* device instance cc_XD2_XDFFM_S_XD2_nm r0 *1 0,0
Ccc_XD2_XDFFM_S_XD2_nm XD2_XDFFM_S XD2_nm 1.8151e-17
* device instance cc_XD2_XDFFM_S_XD2_nt r0 *1 0,0
Ccc_XD2_XDFFM_S_XD2_nt XD2_XDFFM_S XD2_nt 2.4201e-17
* device instance cc_XD2_XDFFM_S_XD2_t1 r0 *1 0,0
Ccc_XD2_XDFFM_S_XD2_t1 XD2_XDFFM_S XD2_t1 1.21e-17
* device instance cc_XD2_XDFFM_S_XD3_XDFFM_CKBB r0 *1 0,0
Ccc_XD2_XDFFM_S_XD3_XDFFM_CKBB XD2_XDFFM_S XD3_XDFFM_CKBB 1.8151e-17
* device instance cc_XD2_XDFFM_S_XD3_XDFFM_CLKB r0 *1 0,0
Ccc_XD2_XDFFM_S_XD3_XDFFM_CLKB XD2_XDFFM_S XD3_XDFFM_CLKB 2.4201e-17
* device instance cc_XD2_XDFFM_S_XD3_XDFFM_M r0 *1 0,0
Ccc_XD2_XDFFM_S_XD3_XDFFM_M XD2_XDFFM_S XD3_XDFFM_M 2.4201e-17
* device instance cc_XD2_XDFFM_S_XD3_XDFFM_MB r0 *1 0,0
Ccc_XD2_XDFFM_S_XD3_XDFFM_MB XD2_XDFFM_S XD3_XDFFM_MB 1.21e-17
* device instance cc_XD2_XDFFM_S_XD3_XDFFM_MFB r0 *1 0,0
Ccc_XD2_XDFFM_S_XD3_XDFFM_MFB XD2_XDFFM_S XD3_XDFFM_MFB 1.21e-17
* device instance cc_XD2_XDFFM_S_XD3_XDFFM_S r0 *1 0,0
Ccc_XD2_XDFFM_S_XD3_XDFFM_S XD2_XDFFM_S XD3_XDFFM_S 1.8151e-17
* device instance cc_XD2_XDFFM_S_XD3_XDFFM_SB r0 *1 0,0
Ccc_XD2_XDFFM_S_XD3_XDFFM_SB XD2_XDFFM_S XD3_XDFFM_SB 1.8151e-17
* device instance cc_XD2_XDFFM_S_XD3_XDFFM_SFB r0 *1 0,0
Ccc_XD2_XDFFM_S_XD3_XDFFM_SFB XD2_XDFFM_S XD3_XDFFM_SFB 1.21e-17
* device instance cc_XD2_XDFFM_S_XD3_XDFFQ_CKBB r0 *1 0,0
Ccc_XD2_XDFFM_S_XD3_XDFFQ_CKBB XD2_XDFFM_S XD3_XDFFQ_CKBB 1.8151e-17
* device instance cc_XD2_XDFFM_S_XD3_XDFFQ_CLKB r0 *1 0,0
Ccc_XD2_XDFFM_S_XD3_XDFFQ_CLKB XD2_XDFFM_S XD3_XDFFQ_CLKB 2.4201e-17
* device instance cc_XD2_XDFFM_S_XD3_XDFFQ_M r0 *1 0,0
Ccc_XD2_XDFFM_S_XD3_XDFFQ_M XD2_XDFFM_S XD3_XDFFQ_M 2.4201e-17
* device instance cc_XD2_XDFFM_S_XD3_XDFFQ_MB r0 *1 0,0
Ccc_XD2_XDFFM_S_XD3_XDFFQ_MB XD2_XDFFM_S XD3_XDFFQ_MB 1.21e-17
* device instance cc_XD2_XDFFM_S_XD3_XDFFQ_MFB r0 *1 0,0
Ccc_XD2_XDFFM_S_XD3_XDFFQ_MFB XD2_XDFFM_S XD3_XDFFQ_MFB 1.21e-17
* device instance cc_XD2_XDFFM_S_XD3_XDFFQ_S r0 *1 0,0
Ccc_XD2_XDFFM_S_XD3_XDFFQ_S XD2_XDFFM_S XD3_XDFFQ_S 1.8151e-17
* device instance cc_XD2_XDFFM_S_XD3_XDFFQ_SB r0 *1 0,0
Ccc_XD2_XDFFM_S_XD3_XDFFQ_SB XD2_XDFFM_S XD3_XDFFQ_SB 1.8151e-17
* device instance cc_XD2_XDFFM_S_XD3_XDFFQ_SFB r0 *1 0,0
Ccc_XD2_XDFFM_S_XD3_XDFFQ_SFB XD2_XDFFM_S XD3_XDFFQ_SFB 1.21e-17
* device instance cc_XD2_XDFFM_S_XD3_XN2_mid1 r0 *1 0,0
Ccc_XD2_XDFFM_S_XD3_XN2_mid1 XD2_XDFFM_S XD3_XN2_mid1 1.21e-17
* device instance cc_XD2_XDFFM_S_XD3_XN3_mid1 r0 *1 0,0
Ccc_XD2_XDFFM_S_XD3_XN3_mid1 XD2_XDFFM_S XD3_XN3_mid1 1.21e-17
* device instance cc_XD2_XDFFM_S_XD3_XN3_mid2 r0 *1 0,0
Ccc_XD2_XDFFM_S_XD3_XN3_mid2 XD2_XDFFM_S XD3_XN3_mid2 1.21e-17
* device instance cc_XD2_XDFFM_S_XD3_dmodout r0 *1 0,0
Ccc_XD2_XDFFM_S_XD3_dmodout XD2_XDFFM_S XD3_dmodout 1.21e-17
* device instance cc_XD2_XDFFM_S_XD3_dq r0 *1 0,0
Ccc_XD2_XDFFM_S_XD3_dq XD2_XDFFM_S XD3_dq 1.8151e-17
* device instance cc_XD2_XDFFM_S_XD3_nm r0 *1 0,0
Ccc_XD2_XDFFM_S_XD3_nm XD2_XDFFM_S XD3_nm 1.21e-17
* device instance cc_XD2_XDFFM_S_XD3_nt r0 *1 0,0
Ccc_XD2_XDFFM_S_XD3_nt XD2_XDFFM_S XD3_nt 1.21e-17
* device instance cc_XD2_XDFFM_S_XD3_t1 r0 *1 0,0
Ccc_XD2_XDFFM_S_XD3_t1 XD2_XDFFM_S XD3_t1 1.21e-17
* device instance cc_XD2_XDFFM_S_XD4_XDFFM_CKBB r0 *1 0,0
Ccc_XD2_XDFFM_S_XD4_XDFFM_CKBB XD2_XDFFM_S XD4_XDFFM_CKBB 1.8151e-17
* device instance cc_XD2_XDFFM_S_XD4_XDFFM_CLKB r0 *1 0,0
Ccc_XD2_XDFFM_S_XD4_XDFFM_CLKB XD2_XDFFM_S XD4_XDFFM_CLKB 2.4201e-17
* device instance cc_XD2_XDFFM_S_XD4_XDFFM_M r0 *1 0,0
Ccc_XD2_XDFFM_S_XD4_XDFFM_M XD2_XDFFM_S XD4_XDFFM_M 2.4201e-17
* device instance cc_XD2_XDFFM_S_XD4_XDFFM_MB r0 *1 0,0
Ccc_XD2_XDFFM_S_XD4_XDFFM_MB XD2_XDFFM_S XD4_XDFFM_MB 1.21e-17
* device instance cc_XD2_XDFFM_S_XD4_XDFFM_MFB r0 *1 0,0
Ccc_XD2_XDFFM_S_XD4_XDFFM_MFB XD2_XDFFM_S XD4_XDFFM_MFB 1.21e-17
* device instance cc_XD2_XDFFM_S_XD4_XDFFM_S r0 *1 0,0
Ccc_XD2_XDFFM_S_XD4_XDFFM_S XD2_XDFFM_S XD4_XDFFM_S 1.8151e-17
* device instance cc_XD2_XDFFM_S_XD4_XDFFM_SB r0 *1 0,0
Ccc_XD2_XDFFM_S_XD4_XDFFM_SB XD2_XDFFM_S XD4_XDFFM_SB 1.8151e-17
* device instance cc_XD2_XDFFM_S_XD4_XDFFM_SFB r0 *1 0,0
Ccc_XD2_XDFFM_S_XD4_XDFFM_SFB XD2_XDFFM_S XD4_XDFFM_SFB 1.21e-17
* device instance cc_XD2_XDFFM_S_XD4_XDFFQ_CKBB r0 *1 0,0
Ccc_XD2_XDFFM_S_XD4_XDFFQ_CKBB XD2_XDFFM_S XD4_XDFFQ_CKBB 1.8151e-17
* device instance cc_XD2_XDFFM_S_XD4_XDFFQ_CLKB r0 *1 0,0
Ccc_XD2_XDFFM_S_XD4_XDFFQ_CLKB XD2_XDFFM_S XD4_XDFFQ_CLKB 2.4201e-17
* device instance cc_XD2_XDFFM_S_XD4_XDFFQ_M r0 *1 0,0
Ccc_XD2_XDFFM_S_XD4_XDFFQ_M XD2_XDFFM_S XD4_XDFFQ_M 2.4201e-17
* device instance cc_XD2_XDFFM_S_XD4_XDFFQ_MB r0 *1 0,0
Ccc_XD2_XDFFM_S_XD4_XDFFQ_MB XD2_XDFFM_S XD4_XDFFQ_MB 1.21e-17
* device instance cc_XD2_XDFFM_S_XD4_XDFFQ_MFB r0 *1 0,0
Ccc_XD2_XDFFM_S_XD4_XDFFQ_MFB XD2_XDFFM_S XD4_XDFFQ_MFB 1.21e-17
* device instance cc_XD2_XDFFM_S_XD4_XDFFQ_S r0 *1 0,0
Ccc_XD2_XDFFM_S_XD4_XDFFQ_S XD2_XDFFM_S XD4_XDFFQ_S 1.8151e-17
* device instance cc_XD2_XDFFM_S_XD4_XDFFQ_SB r0 *1 0,0
Ccc_XD2_XDFFM_S_XD4_XDFFQ_SB XD2_XDFFM_S XD4_XDFFQ_SB 1.8151e-17
* device instance cc_XD2_XDFFM_S_XD4_XDFFQ_SFB r0 *1 0,0
Ccc_XD2_XDFFM_S_XD4_XDFFQ_SFB XD2_XDFFM_S XD4_XDFFQ_SFB 1.21e-17
* device instance cc_XD2_XDFFM_S_XD4_XN2_mid1 r0 *1 0,0
Ccc_XD2_XDFFM_S_XD4_XN2_mid1 XD2_XDFFM_S XD4_XN2_mid1 1.21e-17
* device instance cc_XD2_XDFFM_S_XD4_XN3_mid1 r0 *1 0,0
Ccc_XD2_XDFFM_S_XD4_XN3_mid1 XD2_XDFFM_S XD4_XN3_mid1 1.21e-17
* device instance cc_XD2_XDFFM_S_XD4_XN3_mid2 r0 *1 0,0
Ccc_XD2_XDFFM_S_XD4_XN3_mid2 XD2_XDFFM_S XD4_XN3_mid2 1.21e-17
* device instance cc_XD2_XDFFM_S_XD4_dmodout r0 *1 0,0
Ccc_XD2_XDFFM_S_XD4_dmodout XD2_XDFFM_S XD4_dmodout 1.21e-17
* device instance cc_XD2_XDFFM_S_XD4_dq r0 *1 0,0
Ccc_XD2_XDFFM_S_XD4_dq XD2_XDFFM_S XD4_dq 1.8151e-17
* device instance cc_XD2_XDFFM_S_XD4_nm r0 *1 0,0
Ccc_XD2_XDFFM_S_XD4_nm XD2_XDFFM_S XD4_nm 1.21e-17
* device instance cc_XD2_XDFFM_S_XD4_nt r0 *1 0,0
Ccc_XD2_XDFFM_S_XD4_nt XD2_XDFFM_S XD4_nt 1.21e-17
* device instance cc_XD2_XDFFM_S_XD4_t1 r0 *1 0,0
Ccc_XD2_XDFFM_S_XD4_t1 XD2_XDFFM_S XD4_t1 1.21e-17
* device instance cc_XD2_XDFFM_S_XD5_XDFFM_CKBB r0 *1 0,0
Ccc_XD2_XDFFM_S_XD5_XDFFM_CKBB XD2_XDFFM_S XD5_XDFFM_CKBB 1.8151e-17
* device instance cc_XD2_XDFFM_S_XD5_XDFFM_CLKB r0 *1 0,0
Ccc_XD2_XDFFM_S_XD5_XDFFM_CLKB XD2_XDFFM_S XD5_XDFFM_CLKB 2.4201e-17
* device instance cc_XD2_XDFFM_S_XD5_XDFFM_M r0 *1 0,0
Ccc_XD2_XDFFM_S_XD5_XDFFM_M XD2_XDFFM_S XD5_XDFFM_M 2.4201e-17
* device instance cc_XD2_XDFFM_S_XD5_XDFFM_MB r0 *1 0,0
Ccc_XD2_XDFFM_S_XD5_XDFFM_MB XD2_XDFFM_S XD5_XDFFM_MB 1.21e-17
* device instance cc_XD2_XDFFM_S_XD5_XDFFM_MFB r0 *1 0,0
Ccc_XD2_XDFFM_S_XD5_XDFFM_MFB XD2_XDFFM_S XD5_XDFFM_MFB 1.21e-17
* device instance cc_XD2_XDFFM_S_XD5_XDFFM_S r0 *1 0,0
Ccc_XD2_XDFFM_S_XD5_XDFFM_S XD2_XDFFM_S XD5_XDFFM_S 1.8151e-17
* device instance cc_XD2_XDFFM_S_XD5_XDFFM_SB r0 *1 0,0
Ccc_XD2_XDFFM_S_XD5_XDFFM_SB XD2_XDFFM_S XD5_XDFFM_SB 1.8151e-17
* device instance cc_XD2_XDFFM_S_XD5_XDFFM_SFB r0 *1 0,0
Ccc_XD2_XDFFM_S_XD5_XDFFM_SFB XD2_XDFFM_S XD5_XDFFM_SFB 1.21e-17
* device instance cc_XD2_XDFFM_S_XD5_XDFFQ_CKBB r0 *1 0,0
Ccc_XD2_XDFFM_S_XD5_XDFFQ_CKBB XD2_XDFFM_S XD5_XDFFQ_CKBB 1.8151e-17
* device instance cc_XD2_XDFFM_S_XD5_XDFFQ_CLKB r0 *1 0,0
Ccc_XD2_XDFFM_S_XD5_XDFFQ_CLKB XD2_XDFFM_S XD5_XDFFQ_CLKB 2.4201e-17
* device instance cc_XD2_XDFFM_S_XD5_XDFFQ_M r0 *1 0,0
Ccc_XD2_XDFFM_S_XD5_XDFFQ_M XD2_XDFFM_S XD5_XDFFQ_M 2.4201e-17
* device instance cc_XD2_XDFFM_S_XD5_XDFFQ_MB r0 *1 0,0
Ccc_XD2_XDFFM_S_XD5_XDFFQ_MB XD2_XDFFM_S XD5_XDFFQ_MB 1.21e-17
* device instance cc_XD2_XDFFM_S_XD5_XDFFQ_MFB r0 *1 0,0
Ccc_XD2_XDFFM_S_XD5_XDFFQ_MFB XD2_XDFFM_S XD5_XDFFQ_MFB 1.21e-17
* device instance cc_XD2_XDFFM_S_XD5_XDFFQ_S r0 *1 0,0
Ccc_XD2_XDFFM_S_XD5_XDFFQ_S XD2_XDFFM_S XD5_XDFFQ_S 1.8151e-17
* device instance cc_XD2_XDFFM_S_XD5_XDFFQ_SB r0 *1 0,0
Ccc_XD2_XDFFM_S_XD5_XDFFQ_SB XD2_XDFFM_S XD5_XDFFQ_SB 1.8151e-17
* device instance cc_XD2_XDFFM_S_XD5_XDFFQ_SFB r0 *1 0,0
Ccc_XD2_XDFFM_S_XD5_XDFFQ_SFB XD2_XDFFM_S XD5_XDFFQ_SFB 1.21e-17
* device instance cc_XD2_XDFFM_S_XD5_XN2_mid1 r0 *1 0,0
Ccc_XD2_XDFFM_S_XD5_XN2_mid1 XD2_XDFFM_S XD5_XN2_mid1 1.21e-17
* device instance cc_XD2_XDFFM_S_XD5_XN3_mid1 r0 *1 0,0
Ccc_XD2_XDFFM_S_XD5_XN3_mid1 XD2_XDFFM_S XD5_XN3_mid1 1.21e-17
* device instance cc_XD2_XDFFM_S_XD5_XN3_mid2 r0 *1 0,0
Ccc_XD2_XDFFM_S_XD5_XN3_mid2 XD2_XDFFM_S XD5_XN3_mid2 1.21e-17
* device instance cc_XD2_XDFFM_S_XD5_dmodout r0 *1 0,0
Ccc_XD2_XDFFM_S_XD5_dmodout XD2_XDFFM_S XD5_dmodout 1.21e-17
* device instance cc_XD2_XDFFM_S_XD5_dq r0 *1 0,0
Ccc_XD2_XDFFM_S_XD5_dq XD2_XDFFM_S XD5_dq 1.8151e-17
* device instance cc_XD2_XDFFM_S_XD5_nm r0 *1 0,0
Ccc_XD2_XDFFM_S_XD5_nm XD2_XDFFM_S XD5_nm 1.21e-17
* device instance cc_XD2_XDFFM_S_XD5_nt r0 *1 0,0
Ccc_XD2_XDFFM_S_XD5_nt XD2_XDFFM_S XD5_nt 1.21e-17
* device instance cc_XD2_XDFFM_S_XD5_t1 r0 *1 0,0
Ccc_XD2_XDFFM_S_XD5_t1 XD2_XDFFM_S XD5_t1 1.21e-17
* device instance cc_XD2_XDFFM_S_XFRT_CKBB r0 *1 0,0
Ccc_XD2_XDFFM_S_XFRT_CKBB XD2_XDFFM_S XFRT_CKBB 1.8151e-17
* device instance cc_XD2_XDFFM_S_XFRT_CLKB r0 *1 0,0
Ccc_XD2_XDFFM_S_XFRT_CLKB XD2_XDFFM_S XFRT_CLKB 2.4201e-17
* device instance cc_XD2_XDFFM_S_XFRT_M r0 *1 0,0
Ccc_XD2_XDFFM_S_XFRT_M XD2_XDFFM_S XFRT_M 2.4201e-17
* device instance cc_XD2_XDFFM_S_XFRT_MB r0 *1 0,0
Ccc_XD2_XDFFM_S_XFRT_MB XD2_XDFFM_S XFRT_MB 1.21e-17
* device instance cc_XD2_XDFFM_S_XFRT_MFB r0 *1 0,0
Ccc_XD2_XDFFM_S_XFRT_MFB XD2_XDFFM_S XFRT_MFB 1.21e-17
* device instance cc_XD2_XDFFM_S_XFRT_S r0 *1 0,0
Ccc_XD2_XDFFM_S_XFRT_S XD2_XDFFM_S XFRT_S 1.8151e-17
* device instance cc_XD2_XDFFM_S_XFRT_SB r0 *1 0,0
Ccc_XD2_XDFFM_S_XFRT_SB XD2_XDFFM_S XFRT_SB 1.8151e-17
* device instance cc_XD2_XDFFM_S_XFRT_SFB r0 *1 0,0
Ccc_XD2_XDFFM_S_XFRT_SFB XD2_XDFFM_S XFRT_SFB 1.21e-17
* device instance cc_XD2_XDFFM_S_ck1 r0 *1 0,0
Ccc_XD2_XDFFM_S_ck1 XD2_XDFFM_S ck1 3.0251e-17
* device instance cc_XD2_XDFFM_S_ck2 r0 *1 0,0
Ccc_XD2_XDFFM_S_ck2 XD2_XDFFM_S ck2 3.0251e-17
* device instance cc_XD2_XDFFM_S_ck3 r0 *1 0,0
Ccc_XD2_XDFFM_S_ck3 XD2_XDFFM_S ck3 3.0251e-17
* device instance cc_XD2_XDFFM_S_ck4 r0 *1 0,0
Ccc_XD2_XDFFM_S_ck4 XD2_XDFFM_S ck4 3.0251e-17
* device instance cc_XD2_XDFFM_S_ck5 r0 *1 0,0
Ccc_XD2_XDFFM_S_ck5 XD2_XDFFM_S ck5 3.0251e-17
* device instance cc_XD2_XDFFM_S_mod0 r0 *1 0,0
Ccc_XD2_XDFFM_S_mod0 XD2_XDFFM_S mod0 2.4201e-17
* device instance cc_XD2_XDFFM_S_mod1 r0 *1 0,0
Ccc_XD2_XDFFM_S_mod1 XD2_XDFFM_S mod1 2.4201e-17
* device instance cc_XD2_XDFFM_S_mod2 r0 *1 0,0
Ccc_XD2_XDFFM_S_mod2 XD2_XDFFM_S mod2 2.4201e-17
* device instance cc_XD2_XDFFM_S_mod3 r0 *1 0,0
Ccc_XD2_XDFFM_S_mod3 XD2_XDFFM_S mod3 2.4201e-17
* device instance cc_XD2_XDFFM_S_mod4 r0 *1 0,0
Ccc_XD2_XDFFM_S_mod4 XD2_XDFFM_S mod4 2.4201e-17
* device instance cc_XD2_XDFFM_S_net1 r0 *1 0,0
Ccc_XD2_XDFFM_S_net1 XD2_XDFFM_S net1 1.21e-17
* device instance cc_XD2_XDFFM_SB_XD2_XDFFM_SFB r0 *1 0,0
Ccc_XD2_XDFFM_SB_XD2_XDFFM_SFB XD2_XDFFM_SB XD2_XDFFM_SFB 2.4201e-17
* device instance cc_XD2_XDFFM_SB_XD2_XDFFQ_CKBB r0 *1 0,0
Ccc_XD2_XDFFM_SB_XD2_XDFFQ_CKBB XD2_XDFFM_SB XD2_XDFFQ_CKBB 1.8151e-17
* device instance cc_XD2_XDFFM_SB_XD2_XDFFQ_CLKB r0 *1 0,0
Ccc_XD2_XDFFM_SB_XD2_XDFFQ_CLKB XD2_XDFFM_SB XD2_XDFFQ_CLKB 2.4201e-17
* device instance cc_XD2_XDFFM_SB_XD2_XDFFQ_M r0 *1 0,0
Ccc_XD2_XDFFM_SB_XD2_XDFFQ_M XD2_XDFFM_SB XD2_XDFFQ_M 2.4201e-17
* device instance cc_XD2_XDFFM_SB_XD2_XDFFQ_MB r0 *1 0,0
Ccc_XD2_XDFFM_SB_XD2_XDFFQ_MB XD2_XDFFM_SB XD2_XDFFQ_MB 1.21e-17
* device instance cc_XD2_XDFFM_SB_XD2_XDFFQ_MFB r0 *1 0,0
Ccc_XD2_XDFFM_SB_XD2_XDFFQ_MFB XD2_XDFFM_SB XD2_XDFFQ_MFB 1.21e-17
* device instance cc_XD2_XDFFM_SB_XD2_XDFFQ_S r0 *1 0,0
Ccc_XD2_XDFFM_SB_XD2_XDFFQ_S XD2_XDFFM_SB XD2_XDFFQ_S 1.8151e-17
* device instance cc_XD2_XDFFM_SB_XD2_XDFFQ_SB r0 *1 0,0
Ccc_XD2_XDFFM_SB_XD2_XDFFQ_SB XD2_XDFFM_SB XD2_XDFFQ_SB 1.8151e-17
* device instance cc_XD2_XDFFM_SB_XD2_XDFFQ_SFB r0 *1 0,0
Ccc_XD2_XDFFM_SB_XD2_XDFFQ_SFB XD2_XDFFM_SB XD2_XDFFQ_SFB 1.21e-17
* device instance cc_XD2_XDFFM_SB_XD2_XNOR_midp r0 *1 0,0
Ccc_XD2_XDFFM_SB_XD2_XNOR_midp XD2_XDFFM_SB XD2_XNOR_midp 1.21e-17
* device instance cc_XD2_XDFFM_SB_XD2_dmodout r0 *1 0,0
Ccc_XD2_XDFFM_SB_XD2_dmodout XD2_XDFFM_SB XD2_dmodout 1.21e-17
* device instance cc_XD2_XDFFM_SB_XD2_dq r0 *1 0,0
Ccc_XD2_XDFFM_SB_XD2_dq XD2_XDFFM_SB XD2_dq 1.21e-17
* device instance cc_XD2_XDFFM_SB_XD2_nm r0 *1 0,0
Ccc_XD2_XDFFM_SB_XD2_nm XD2_XDFFM_SB XD2_nm 1.8151e-17
* device instance cc_XD2_XDFFM_SB_XD2_nt r0 *1 0,0
Ccc_XD2_XDFFM_SB_XD2_nt XD2_XDFFM_SB XD2_nt 2.4201e-17
* device instance cc_XD2_XDFFM_SB_XD2_t1 r0 *1 0,0
Ccc_XD2_XDFFM_SB_XD2_t1 XD2_XDFFM_SB XD2_t1 1.21e-17
* device instance cc_XD2_XDFFM_SB_XD3_XDFFM_CKBB r0 *1 0,0
Ccc_XD2_XDFFM_SB_XD3_XDFFM_CKBB XD2_XDFFM_SB XD3_XDFFM_CKBB 1.8151e-17
* device instance cc_XD2_XDFFM_SB_XD3_XDFFM_CLKB r0 *1 0,0
Ccc_XD2_XDFFM_SB_XD3_XDFFM_CLKB XD2_XDFFM_SB XD3_XDFFM_CLKB 2.4201e-17
* device instance cc_XD2_XDFFM_SB_XD3_XDFFM_M r0 *1 0,0
Ccc_XD2_XDFFM_SB_XD3_XDFFM_M XD2_XDFFM_SB XD3_XDFFM_M 2.4201e-17
* device instance cc_XD2_XDFFM_SB_XD3_XDFFM_MB r0 *1 0,0
Ccc_XD2_XDFFM_SB_XD3_XDFFM_MB XD2_XDFFM_SB XD3_XDFFM_MB 1.21e-17
* device instance cc_XD2_XDFFM_SB_XD3_XDFFM_MFB r0 *1 0,0
Ccc_XD2_XDFFM_SB_XD3_XDFFM_MFB XD2_XDFFM_SB XD3_XDFFM_MFB 1.21e-17
* device instance cc_XD2_XDFFM_SB_XD3_XDFFM_S r0 *1 0,0
Ccc_XD2_XDFFM_SB_XD3_XDFFM_S XD2_XDFFM_SB XD3_XDFFM_S 1.8151e-17
* device instance cc_XD2_XDFFM_SB_XD3_XDFFM_SB r0 *1 0,0
Ccc_XD2_XDFFM_SB_XD3_XDFFM_SB XD2_XDFFM_SB XD3_XDFFM_SB 1.8151e-17
* device instance cc_XD2_XDFFM_SB_XD3_XDFFM_SFB r0 *1 0,0
Ccc_XD2_XDFFM_SB_XD3_XDFFM_SFB XD2_XDFFM_SB XD3_XDFFM_SFB 1.21e-17
* device instance cc_XD2_XDFFM_SB_XD3_XDFFQ_CKBB r0 *1 0,0
Ccc_XD2_XDFFM_SB_XD3_XDFFQ_CKBB XD2_XDFFM_SB XD3_XDFFQ_CKBB 1.8151e-17
* device instance cc_XD2_XDFFM_SB_XD3_XDFFQ_CLKB r0 *1 0,0
Ccc_XD2_XDFFM_SB_XD3_XDFFQ_CLKB XD2_XDFFM_SB XD3_XDFFQ_CLKB 2.4201e-17
* device instance cc_XD2_XDFFM_SB_XD3_XDFFQ_M r0 *1 0,0
Ccc_XD2_XDFFM_SB_XD3_XDFFQ_M XD2_XDFFM_SB XD3_XDFFQ_M 2.4201e-17
* device instance cc_XD2_XDFFM_SB_XD3_XDFFQ_MB r0 *1 0,0
Ccc_XD2_XDFFM_SB_XD3_XDFFQ_MB XD2_XDFFM_SB XD3_XDFFQ_MB 1.21e-17
* device instance cc_XD2_XDFFM_SB_XD3_XDFFQ_MFB r0 *1 0,0
Ccc_XD2_XDFFM_SB_XD3_XDFFQ_MFB XD2_XDFFM_SB XD3_XDFFQ_MFB 1.21e-17
* device instance cc_XD2_XDFFM_SB_XD3_XDFFQ_S r0 *1 0,0
Ccc_XD2_XDFFM_SB_XD3_XDFFQ_S XD2_XDFFM_SB XD3_XDFFQ_S 1.8151e-17
* device instance cc_XD2_XDFFM_SB_XD3_XDFFQ_SB r0 *1 0,0
Ccc_XD2_XDFFM_SB_XD3_XDFFQ_SB XD2_XDFFM_SB XD3_XDFFQ_SB 1.8151e-17
* device instance cc_XD2_XDFFM_SB_XD3_XDFFQ_SFB r0 *1 0,0
Ccc_XD2_XDFFM_SB_XD3_XDFFQ_SFB XD2_XDFFM_SB XD3_XDFFQ_SFB 1.21e-17
* device instance cc_XD2_XDFFM_SB_XD3_XN2_mid1 r0 *1 0,0
Ccc_XD2_XDFFM_SB_XD3_XN2_mid1 XD2_XDFFM_SB XD3_XN2_mid1 1.21e-17
* device instance cc_XD2_XDFFM_SB_XD3_XN3_mid1 r0 *1 0,0
Ccc_XD2_XDFFM_SB_XD3_XN3_mid1 XD2_XDFFM_SB XD3_XN3_mid1 1.21e-17
* device instance cc_XD2_XDFFM_SB_XD3_XN3_mid2 r0 *1 0,0
Ccc_XD2_XDFFM_SB_XD3_XN3_mid2 XD2_XDFFM_SB XD3_XN3_mid2 1.21e-17
* device instance cc_XD2_XDFFM_SB_XD3_dmodout r0 *1 0,0
Ccc_XD2_XDFFM_SB_XD3_dmodout XD2_XDFFM_SB XD3_dmodout 1.21e-17
* device instance cc_XD2_XDFFM_SB_XD3_dq r0 *1 0,0
Ccc_XD2_XDFFM_SB_XD3_dq XD2_XDFFM_SB XD3_dq 1.8151e-17
* device instance cc_XD2_XDFFM_SB_XD3_nm r0 *1 0,0
Ccc_XD2_XDFFM_SB_XD3_nm XD2_XDFFM_SB XD3_nm 1.21e-17
* device instance cc_XD2_XDFFM_SB_XD3_nt r0 *1 0,0
Ccc_XD2_XDFFM_SB_XD3_nt XD2_XDFFM_SB XD3_nt 1.21e-17
* device instance cc_XD2_XDFFM_SB_XD3_t1 r0 *1 0,0
Ccc_XD2_XDFFM_SB_XD3_t1 XD2_XDFFM_SB XD3_t1 1.21e-17
* device instance cc_XD2_XDFFM_SB_XD4_XDFFM_CKBB r0 *1 0,0
Ccc_XD2_XDFFM_SB_XD4_XDFFM_CKBB XD2_XDFFM_SB XD4_XDFFM_CKBB 1.8151e-17
* device instance cc_XD2_XDFFM_SB_XD4_XDFFM_CLKB r0 *1 0,0
Ccc_XD2_XDFFM_SB_XD4_XDFFM_CLKB XD2_XDFFM_SB XD4_XDFFM_CLKB 2.4201e-17
* device instance cc_XD2_XDFFM_SB_XD4_XDFFM_M r0 *1 0,0
Ccc_XD2_XDFFM_SB_XD4_XDFFM_M XD2_XDFFM_SB XD4_XDFFM_M 2.4201e-17
* device instance cc_XD2_XDFFM_SB_XD4_XDFFM_MB r0 *1 0,0
Ccc_XD2_XDFFM_SB_XD4_XDFFM_MB XD2_XDFFM_SB XD4_XDFFM_MB 1.21e-17
* device instance cc_XD2_XDFFM_SB_XD4_XDFFM_MFB r0 *1 0,0
Ccc_XD2_XDFFM_SB_XD4_XDFFM_MFB XD2_XDFFM_SB XD4_XDFFM_MFB 1.21e-17
* device instance cc_XD2_XDFFM_SB_XD4_XDFFM_S r0 *1 0,0
Ccc_XD2_XDFFM_SB_XD4_XDFFM_S XD2_XDFFM_SB XD4_XDFFM_S 1.8151e-17
* device instance cc_XD2_XDFFM_SB_XD4_XDFFM_SB r0 *1 0,0
Ccc_XD2_XDFFM_SB_XD4_XDFFM_SB XD2_XDFFM_SB XD4_XDFFM_SB 1.8151e-17
* device instance cc_XD2_XDFFM_SB_XD4_XDFFM_SFB r0 *1 0,0
Ccc_XD2_XDFFM_SB_XD4_XDFFM_SFB XD2_XDFFM_SB XD4_XDFFM_SFB 1.21e-17
* device instance cc_XD2_XDFFM_SB_XD4_XDFFQ_CKBB r0 *1 0,0
Ccc_XD2_XDFFM_SB_XD4_XDFFQ_CKBB XD2_XDFFM_SB XD4_XDFFQ_CKBB 1.8151e-17
* device instance cc_XD2_XDFFM_SB_XD4_XDFFQ_CLKB r0 *1 0,0
Ccc_XD2_XDFFM_SB_XD4_XDFFQ_CLKB XD2_XDFFM_SB XD4_XDFFQ_CLKB 2.4201e-17
* device instance cc_XD2_XDFFM_SB_XD4_XDFFQ_M r0 *1 0,0
Ccc_XD2_XDFFM_SB_XD4_XDFFQ_M XD2_XDFFM_SB XD4_XDFFQ_M 2.4201e-17
* device instance cc_XD2_XDFFM_SB_XD4_XDFFQ_MB r0 *1 0,0
Ccc_XD2_XDFFM_SB_XD4_XDFFQ_MB XD2_XDFFM_SB XD4_XDFFQ_MB 1.21e-17
* device instance cc_XD2_XDFFM_SB_XD4_XDFFQ_MFB r0 *1 0,0
Ccc_XD2_XDFFM_SB_XD4_XDFFQ_MFB XD2_XDFFM_SB XD4_XDFFQ_MFB 1.21e-17
* device instance cc_XD2_XDFFM_SB_XD4_XDFFQ_S r0 *1 0,0
Ccc_XD2_XDFFM_SB_XD4_XDFFQ_S XD2_XDFFM_SB XD4_XDFFQ_S 1.8151e-17
* device instance cc_XD2_XDFFM_SB_XD4_XDFFQ_SB r0 *1 0,0
Ccc_XD2_XDFFM_SB_XD4_XDFFQ_SB XD2_XDFFM_SB XD4_XDFFQ_SB 1.8151e-17
* device instance cc_XD2_XDFFM_SB_XD4_XDFFQ_SFB r0 *1 0,0
Ccc_XD2_XDFFM_SB_XD4_XDFFQ_SFB XD2_XDFFM_SB XD4_XDFFQ_SFB 1.21e-17
* device instance cc_XD2_XDFFM_SB_XD4_XN2_mid1 r0 *1 0,0
Ccc_XD2_XDFFM_SB_XD4_XN2_mid1 XD2_XDFFM_SB XD4_XN2_mid1 1.21e-17
* device instance cc_XD2_XDFFM_SB_XD4_XN3_mid1 r0 *1 0,0
Ccc_XD2_XDFFM_SB_XD4_XN3_mid1 XD2_XDFFM_SB XD4_XN3_mid1 1.21e-17
* device instance cc_XD2_XDFFM_SB_XD4_XN3_mid2 r0 *1 0,0
Ccc_XD2_XDFFM_SB_XD4_XN3_mid2 XD2_XDFFM_SB XD4_XN3_mid2 1.21e-17
* device instance cc_XD2_XDFFM_SB_XD4_dmodout r0 *1 0,0
Ccc_XD2_XDFFM_SB_XD4_dmodout XD2_XDFFM_SB XD4_dmodout 1.21e-17
* device instance cc_XD2_XDFFM_SB_XD4_dq r0 *1 0,0
Ccc_XD2_XDFFM_SB_XD4_dq XD2_XDFFM_SB XD4_dq 1.8151e-17
* device instance cc_XD2_XDFFM_SB_XD4_nm r0 *1 0,0
Ccc_XD2_XDFFM_SB_XD4_nm XD2_XDFFM_SB XD4_nm 1.21e-17
* device instance cc_XD2_XDFFM_SB_XD4_nt r0 *1 0,0
Ccc_XD2_XDFFM_SB_XD4_nt XD2_XDFFM_SB XD4_nt 1.21e-17
* device instance cc_XD2_XDFFM_SB_XD4_t1 r0 *1 0,0
Ccc_XD2_XDFFM_SB_XD4_t1 XD2_XDFFM_SB XD4_t1 1.21e-17
* device instance cc_XD2_XDFFM_SB_XD5_XDFFM_CKBB r0 *1 0,0
Ccc_XD2_XDFFM_SB_XD5_XDFFM_CKBB XD2_XDFFM_SB XD5_XDFFM_CKBB 1.8151e-17
* device instance cc_XD2_XDFFM_SB_XD5_XDFFM_CLKB r0 *1 0,0
Ccc_XD2_XDFFM_SB_XD5_XDFFM_CLKB XD2_XDFFM_SB XD5_XDFFM_CLKB 2.4201e-17
* device instance cc_XD2_XDFFM_SB_XD5_XDFFM_M r0 *1 0,0
Ccc_XD2_XDFFM_SB_XD5_XDFFM_M XD2_XDFFM_SB XD5_XDFFM_M 2.4201e-17
* device instance cc_XD2_XDFFM_SB_XD5_XDFFM_MB r0 *1 0,0
Ccc_XD2_XDFFM_SB_XD5_XDFFM_MB XD2_XDFFM_SB XD5_XDFFM_MB 1.21e-17
* device instance cc_XD2_XDFFM_SB_XD5_XDFFM_MFB r0 *1 0,0
Ccc_XD2_XDFFM_SB_XD5_XDFFM_MFB XD2_XDFFM_SB XD5_XDFFM_MFB 1.21e-17
* device instance cc_XD2_XDFFM_SB_XD5_XDFFM_S r0 *1 0,0
Ccc_XD2_XDFFM_SB_XD5_XDFFM_S XD2_XDFFM_SB XD5_XDFFM_S 1.8151e-17
* device instance cc_XD2_XDFFM_SB_XD5_XDFFM_SB r0 *1 0,0
Ccc_XD2_XDFFM_SB_XD5_XDFFM_SB XD2_XDFFM_SB XD5_XDFFM_SB 1.8151e-17
* device instance cc_XD2_XDFFM_SB_XD5_XDFFM_SFB r0 *1 0,0
Ccc_XD2_XDFFM_SB_XD5_XDFFM_SFB XD2_XDFFM_SB XD5_XDFFM_SFB 1.21e-17
* device instance cc_XD2_XDFFM_SB_XD5_XDFFQ_CKBB r0 *1 0,0
Ccc_XD2_XDFFM_SB_XD5_XDFFQ_CKBB XD2_XDFFM_SB XD5_XDFFQ_CKBB 1.8151e-17
* device instance cc_XD2_XDFFM_SB_XD5_XDFFQ_CLKB r0 *1 0,0
Ccc_XD2_XDFFM_SB_XD5_XDFFQ_CLKB XD2_XDFFM_SB XD5_XDFFQ_CLKB 2.4201e-17
* device instance cc_XD2_XDFFM_SB_XD5_XDFFQ_M r0 *1 0,0
Ccc_XD2_XDFFM_SB_XD5_XDFFQ_M XD2_XDFFM_SB XD5_XDFFQ_M 2.4201e-17
* device instance cc_XD2_XDFFM_SB_XD5_XDFFQ_MB r0 *1 0,0
Ccc_XD2_XDFFM_SB_XD5_XDFFQ_MB XD2_XDFFM_SB XD5_XDFFQ_MB 1.21e-17
* device instance cc_XD2_XDFFM_SB_XD5_XDFFQ_MFB r0 *1 0,0
Ccc_XD2_XDFFM_SB_XD5_XDFFQ_MFB XD2_XDFFM_SB XD5_XDFFQ_MFB 1.21e-17
* device instance cc_XD2_XDFFM_SB_XD5_XDFFQ_S r0 *1 0,0
Ccc_XD2_XDFFM_SB_XD5_XDFFQ_S XD2_XDFFM_SB XD5_XDFFQ_S 1.8151e-17
* device instance cc_XD2_XDFFM_SB_XD5_XDFFQ_SB r0 *1 0,0
Ccc_XD2_XDFFM_SB_XD5_XDFFQ_SB XD2_XDFFM_SB XD5_XDFFQ_SB 1.8151e-17
* device instance cc_XD2_XDFFM_SB_XD5_XDFFQ_SFB r0 *1 0,0
Ccc_XD2_XDFFM_SB_XD5_XDFFQ_SFB XD2_XDFFM_SB XD5_XDFFQ_SFB 1.21e-17
* device instance cc_XD2_XDFFM_SB_XD5_XN2_mid1 r0 *1 0,0
Ccc_XD2_XDFFM_SB_XD5_XN2_mid1 XD2_XDFFM_SB XD5_XN2_mid1 1.21e-17
* device instance cc_XD2_XDFFM_SB_XD5_XN3_mid1 r0 *1 0,0
Ccc_XD2_XDFFM_SB_XD5_XN3_mid1 XD2_XDFFM_SB XD5_XN3_mid1 1.21e-17
* device instance cc_XD2_XDFFM_SB_XD5_XN3_mid2 r0 *1 0,0
Ccc_XD2_XDFFM_SB_XD5_XN3_mid2 XD2_XDFFM_SB XD5_XN3_mid2 1.21e-17
* device instance cc_XD2_XDFFM_SB_XD5_dmodout r0 *1 0,0
Ccc_XD2_XDFFM_SB_XD5_dmodout XD2_XDFFM_SB XD5_dmodout 1.21e-17
* device instance cc_XD2_XDFFM_SB_XD5_dq r0 *1 0,0
Ccc_XD2_XDFFM_SB_XD5_dq XD2_XDFFM_SB XD5_dq 1.8151e-17
* device instance cc_XD2_XDFFM_SB_XD5_nm r0 *1 0,0
Ccc_XD2_XDFFM_SB_XD5_nm XD2_XDFFM_SB XD5_nm 1.21e-17
* device instance cc_XD2_XDFFM_SB_XD5_nt r0 *1 0,0
Ccc_XD2_XDFFM_SB_XD5_nt XD2_XDFFM_SB XD5_nt 1.21e-17
* device instance cc_XD2_XDFFM_SB_XD5_t1 r0 *1 0,0
Ccc_XD2_XDFFM_SB_XD5_t1 XD2_XDFFM_SB XD5_t1 1.21e-17
* device instance cc_XD2_XDFFM_SB_XFRT_CKBB r0 *1 0,0
Ccc_XD2_XDFFM_SB_XFRT_CKBB XD2_XDFFM_SB XFRT_CKBB 1.8151e-17
* device instance cc_XD2_XDFFM_SB_XFRT_CLKB r0 *1 0,0
Ccc_XD2_XDFFM_SB_XFRT_CLKB XD2_XDFFM_SB XFRT_CLKB 2.4201e-17
* device instance cc_XD2_XDFFM_SB_XFRT_M r0 *1 0,0
Ccc_XD2_XDFFM_SB_XFRT_M XD2_XDFFM_SB XFRT_M 2.4201e-17
* device instance cc_XD2_XDFFM_SB_XFRT_MB r0 *1 0,0
Ccc_XD2_XDFFM_SB_XFRT_MB XD2_XDFFM_SB XFRT_MB 1.21e-17
* device instance cc_XD2_XDFFM_SB_XFRT_MFB r0 *1 0,0
Ccc_XD2_XDFFM_SB_XFRT_MFB XD2_XDFFM_SB XFRT_MFB 1.21e-17
* device instance cc_XD2_XDFFM_SB_XFRT_S r0 *1 0,0
Ccc_XD2_XDFFM_SB_XFRT_S XD2_XDFFM_SB XFRT_S 1.8151e-17
* device instance cc_XD2_XDFFM_SB_XFRT_SB r0 *1 0,0
Ccc_XD2_XDFFM_SB_XFRT_SB XD2_XDFFM_SB XFRT_SB 1.8151e-17
* device instance cc_XD2_XDFFM_SB_XFRT_SFB r0 *1 0,0
Ccc_XD2_XDFFM_SB_XFRT_SFB XD2_XDFFM_SB XFRT_SFB 1.21e-17
* device instance cc_XD2_XDFFM_SB_ck1 r0 *1 0,0
Ccc_XD2_XDFFM_SB_ck1 XD2_XDFFM_SB ck1 3.0251e-17
* device instance cc_XD2_XDFFM_SB_ck2 r0 *1 0,0
Ccc_XD2_XDFFM_SB_ck2 XD2_XDFFM_SB ck2 3.0251e-17
* device instance cc_XD2_XDFFM_SB_ck3 r0 *1 0,0
Ccc_XD2_XDFFM_SB_ck3 XD2_XDFFM_SB ck3 3.0251e-17
* device instance cc_XD2_XDFFM_SB_ck4 r0 *1 0,0
Ccc_XD2_XDFFM_SB_ck4 XD2_XDFFM_SB ck4 3.0251e-17
* device instance cc_XD2_XDFFM_SB_ck5 r0 *1 0,0
Ccc_XD2_XDFFM_SB_ck5 XD2_XDFFM_SB ck5 3.0251e-17
* device instance cc_XD2_XDFFM_SB_mod0 r0 *1 0,0
Ccc_XD2_XDFFM_SB_mod0 XD2_XDFFM_SB mod0 2.4201e-17
* device instance cc_XD2_XDFFM_SB_mod1 r0 *1 0,0
Ccc_XD2_XDFFM_SB_mod1 XD2_XDFFM_SB mod1 2.4201e-17
* device instance cc_XD2_XDFFM_SB_mod2 r0 *1 0,0
Ccc_XD2_XDFFM_SB_mod2 XD2_XDFFM_SB mod2 2.4201e-17
* device instance cc_XD2_XDFFM_SB_mod3 r0 *1 0,0
Ccc_XD2_XDFFM_SB_mod3 XD2_XDFFM_SB mod3 2.4201e-17
* device instance cc_XD2_XDFFM_SB_mod4 r0 *1 0,0
Ccc_XD2_XDFFM_SB_mod4 XD2_XDFFM_SB mod4 2.4201e-17
* device instance cc_XD2_XDFFM_SB_net1 r0 *1 0,0
Ccc_XD2_XDFFM_SB_net1 XD2_XDFFM_SB net1 1.21e-17
* device instance cc_XD2_XDFFM_SFB_XD2_XDFFQ_CKBB r0 *1 0,0
Ccc_XD2_XDFFM_SFB_XD2_XDFFQ_CKBB XD2_XDFFM_SFB XD2_XDFFQ_CKBB 1.8151e-17
* device instance cc_XD2_XDFFM_SFB_XD2_XDFFQ_CLKB r0 *1 0,0
Ccc_XD2_XDFFM_SFB_XD2_XDFFQ_CLKB XD2_XDFFM_SFB XD2_XDFFQ_CLKB 2.4201e-17
* device instance cc_XD2_XDFFM_SFB_XD2_XDFFQ_M r0 *1 0,0
Ccc_XD2_XDFFM_SFB_XD2_XDFFQ_M XD2_XDFFM_SFB XD2_XDFFQ_M 2.4201e-17
* device instance cc_XD2_XDFFM_SFB_XD2_XDFFQ_MB r0 *1 0,0
Ccc_XD2_XDFFM_SFB_XD2_XDFFQ_MB XD2_XDFFM_SFB XD2_XDFFQ_MB 1.21e-17
* device instance cc_XD2_XDFFM_SFB_XD2_XDFFQ_MFB r0 *1 0,0
Ccc_XD2_XDFFM_SFB_XD2_XDFFQ_MFB XD2_XDFFM_SFB XD2_XDFFQ_MFB 1.21e-17
* device instance cc_XD2_XDFFM_SFB_XD2_XDFFQ_S r0 *1 0,0
Ccc_XD2_XDFFM_SFB_XD2_XDFFQ_S XD2_XDFFM_SFB XD2_XDFFQ_S 1.8151e-17
* device instance cc_XD2_XDFFM_SFB_XD2_XDFFQ_SB r0 *1 0,0
Ccc_XD2_XDFFM_SFB_XD2_XDFFQ_SB XD2_XDFFM_SFB XD2_XDFFQ_SB 1.8151e-17
* device instance cc_XD2_XDFFM_SFB_XD2_XDFFQ_SFB r0 *1 0,0
Ccc_XD2_XDFFM_SFB_XD2_XDFFQ_SFB XD2_XDFFM_SFB XD2_XDFFQ_SFB 1.21e-17
* device instance cc_XD2_XDFFM_SFB_XD2_XNOR_midp r0 *1 0,0
Ccc_XD2_XDFFM_SFB_XD2_XNOR_midp XD2_XDFFM_SFB XD2_XNOR_midp 1.21e-17
* device instance cc_XD2_XDFFM_SFB_XD2_dmodout r0 *1 0,0
Ccc_XD2_XDFFM_SFB_XD2_dmodout XD2_XDFFM_SFB XD2_dmodout 1.21e-17
* device instance cc_XD2_XDFFM_SFB_XD2_dq r0 *1 0,0
Ccc_XD2_XDFFM_SFB_XD2_dq XD2_XDFFM_SFB XD2_dq 1.21e-17
* device instance cc_XD2_XDFFM_SFB_XD2_nm r0 *1 0,0
Ccc_XD2_XDFFM_SFB_XD2_nm XD2_XDFFM_SFB XD2_nm 1.8151e-17
* device instance cc_XD2_XDFFM_SFB_XD2_nt r0 *1 0,0
Ccc_XD2_XDFFM_SFB_XD2_nt XD2_XDFFM_SFB XD2_nt 2.4201e-17
* device instance cc_XD2_XDFFM_SFB_XD2_t1 r0 *1 0,0
Ccc_XD2_XDFFM_SFB_XD2_t1 XD2_XDFFM_SFB XD2_t1 1.21e-17
* device instance cc_XD2_XDFFM_SFB_XD3_XDFFM_CKBB r0 *1 0,0
Ccc_XD2_XDFFM_SFB_XD3_XDFFM_CKBB XD2_XDFFM_SFB XD3_XDFFM_CKBB 1.8151e-17
* device instance cc_XD2_XDFFM_SFB_XD3_XDFFM_CLKB r0 *1 0,0
Ccc_XD2_XDFFM_SFB_XD3_XDFFM_CLKB XD2_XDFFM_SFB XD3_XDFFM_CLKB 2.4201e-17
* device instance cc_XD2_XDFFM_SFB_XD3_XDFFM_M r0 *1 0,0
Ccc_XD2_XDFFM_SFB_XD3_XDFFM_M XD2_XDFFM_SFB XD3_XDFFM_M 2.4201e-17
* device instance cc_XD2_XDFFM_SFB_XD3_XDFFM_MB r0 *1 0,0
Ccc_XD2_XDFFM_SFB_XD3_XDFFM_MB XD2_XDFFM_SFB XD3_XDFFM_MB 1.21e-17
* device instance cc_XD2_XDFFM_SFB_XD3_XDFFM_MFB r0 *1 0,0
Ccc_XD2_XDFFM_SFB_XD3_XDFFM_MFB XD2_XDFFM_SFB XD3_XDFFM_MFB 1.21e-17
* device instance cc_XD2_XDFFM_SFB_XD3_XDFFM_S r0 *1 0,0
Ccc_XD2_XDFFM_SFB_XD3_XDFFM_S XD2_XDFFM_SFB XD3_XDFFM_S 1.8151e-17
* device instance cc_XD2_XDFFM_SFB_XD3_XDFFM_SB r0 *1 0,0
Ccc_XD2_XDFFM_SFB_XD3_XDFFM_SB XD2_XDFFM_SFB XD3_XDFFM_SB 1.8151e-17
* device instance cc_XD2_XDFFM_SFB_XD3_XDFFM_SFB r0 *1 0,0
Ccc_XD2_XDFFM_SFB_XD3_XDFFM_SFB XD2_XDFFM_SFB XD3_XDFFM_SFB 1.21e-17
* device instance cc_XD2_XDFFM_SFB_XD3_XDFFQ_CKBB r0 *1 0,0
Ccc_XD2_XDFFM_SFB_XD3_XDFFQ_CKBB XD2_XDFFM_SFB XD3_XDFFQ_CKBB 1.8151e-17
* device instance cc_XD2_XDFFM_SFB_XD3_XDFFQ_CLKB r0 *1 0,0
Ccc_XD2_XDFFM_SFB_XD3_XDFFQ_CLKB XD2_XDFFM_SFB XD3_XDFFQ_CLKB 2.4201e-17
* device instance cc_XD2_XDFFM_SFB_XD3_XDFFQ_M r0 *1 0,0
Ccc_XD2_XDFFM_SFB_XD3_XDFFQ_M XD2_XDFFM_SFB XD3_XDFFQ_M 2.4201e-17
* device instance cc_XD2_XDFFM_SFB_XD3_XDFFQ_MB r0 *1 0,0
Ccc_XD2_XDFFM_SFB_XD3_XDFFQ_MB XD2_XDFFM_SFB XD3_XDFFQ_MB 1.21e-17
* device instance cc_XD2_XDFFM_SFB_XD3_XDFFQ_MFB r0 *1 0,0
Ccc_XD2_XDFFM_SFB_XD3_XDFFQ_MFB XD2_XDFFM_SFB XD3_XDFFQ_MFB 1.21e-17
* device instance cc_XD2_XDFFM_SFB_XD3_XDFFQ_S r0 *1 0,0
Ccc_XD2_XDFFM_SFB_XD3_XDFFQ_S XD2_XDFFM_SFB XD3_XDFFQ_S 1.8151e-17
* device instance cc_XD2_XDFFM_SFB_XD3_XDFFQ_SB r0 *1 0,0
Ccc_XD2_XDFFM_SFB_XD3_XDFFQ_SB XD2_XDFFM_SFB XD3_XDFFQ_SB 1.8151e-17
* device instance cc_XD2_XDFFM_SFB_XD3_XDFFQ_SFB r0 *1 0,0
Ccc_XD2_XDFFM_SFB_XD3_XDFFQ_SFB XD2_XDFFM_SFB XD3_XDFFQ_SFB 1.21e-17
* device instance cc_XD2_XDFFM_SFB_XD3_XN2_mid1 r0 *1 0,0
Ccc_XD2_XDFFM_SFB_XD3_XN2_mid1 XD2_XDFFM_SFB XD3_XN2_mid1 1.21e-17
* device instance cc_XD2_XDFFM_SFB_XD3_XN3_mid1 r0 *1 0,0
Ccc_XD2_XDFFM_SFB_XD3_XN3_mid1 XD2_XDFFM_SFB XD3_XN3_mid1 1.21e-17
* device instance cc_XD2_XDFFM_SFB_XD3_XN3_mid2 r0 *1 0,0
Ccc_XD2_XDFFM_SFB_XD3_XN3_mid2 XD2_XDFFM_SFB XD3_XN3_mid2 1.21e-17
* device instance cc_XD2_XDFFM_SFB_XD3_dmodout r0 *1 0,0
Ccc_XD2_XDFFM_SFB_XD3_dmodout XD2_XDFFM_SFB XD3_dmodout 1.21e-17
* device instance cc_XD2_XDFFM_SFB_XD3_dq r0 *1 0,0
Ccc_XD2_XDFFM_SFB_XD3_dq XD2_XDFFM_SFB XD3_dq 1.8151e-17
* device instance cc_XD2_XDFFM_SFB_XD3_nm r0 *1 0,0
Ccc_XD2_XDFFM_SFB_XD3_nm XD2_XDFFM_SFB XD3_nm 1.21e-17
* device instance cc_XD2_XDFFM_SFB_XD3_nt r0 *1 0,0
Ccc_XD2_XDFFM_SFB_XD3_nt XD2_XDFFM_SFB XD3_nt 1.21e-17
* device instance cc_XD2_XDFFM_SFB_XD3_t1 r0 *1 0,0
Ccc_XD2_XDFFM_SFB_XD3_t1 XD2_XDFFM_SFB XD3_t1 1.21e-17
* device instance cc_XD2_XDFFM_SFB_XD4_XDFFM_CKBB r0 *1 0,0
Ccc_XD2_XDFFM_SFB_XD4_XDFFM_CKBB XD2_XDFFM_SFB XD4_XDFFM_CKBB 1.8151e-17
* device instance cc_XD2_XDFFM_SFB_XD4_XDFFM_CLKB r0 *1 0,0
Ccc_XD2_XDFFM_SFB_XD4_XDFFM_CLKB XD2_XDFFM_SFB XD4_XDFFM_CLKB 2.4201e-17
* device instance cc_XD2_XDFFM_SFB_XD4_XDFFM_M r0 *1 0,0
Ccc_XD2_XDFFM_SFB_XD4_XDFFM_M XD2_XDFFM_SFB XD4_XDFFM_M 2.4201e-17
* device instance cc_XD2_XDFFM_SFB_XD4_XDFFM_MB r0 *1 0,0
Ccc_XD2_XDFFM_SFB_XD4_XDFFM_MB XD2_XDFFM_SFB XD4_XDFFM_MB 1.21e-17
* device instance cc_XD2_XDFFM_SFB_XD4_XDFFM_MFB r0 *1 0,0
Ccc_XD2_XDFFM_SFB_XD4_XDFFM_MFB XD2_XDFFM_SFB XD4_XDFFM_MFB 1.21e-17
* device instance cc_XD2_XDFFM_SFB_XD4_XDFFM_S r0 *1 0,0
Ccc_XD2_XDFFM_SFB_XD4_XDFFM_S XD2_XDFFM_SFB XD4_XDFFM_S 1.8151e-17
* device instance cc_XD2_XDFFM_SFB_XD4_XDFFM_SB r0 *1 0,0
Ccc_XD2_XDFFM_SFB_XD4_XDFFM_SB XD2_XDFFM_SFB XD4_XDFFM_SB 1.8151e-17
* device instance cc_XD2_XDFFM_SFB_XD4_XDFFM_SFB r0 *1 0,0
Ccc_XD2_XDFFM_SFB_XD4_XDFFM_SFB XD2_XDFFM_SFB XD4_XDFFM_SFB 1.21e-17
* device instance cc_XD2_XDFFM_SFB_XD4_XDFFQ_CKBB r0 *1 0,0
Ccc_XD2_XDFFM_SFB_XD4_XDFFQ_CKBB XD2_XDFFM_SFB XD4_XDFFQ_CKBB 1.8151e-17
* device instance cc_XD2_XDFFM_SFB_XD4_XDFFQ_CLKB r0 *1 0,0
Ccc_XD2_XDFFM_SFB_XD4_XDFFQ_CLKB XD2_XDFFM_SFB XD4_XDFFQ_CLKB 2.4201e-17
* device instance cc_XD2_XDFFM_SFB_XD4_XDFFQ_M r0 *1 0,0
Ccc_XD2_XDFFM_SFB_XD4_XDFFQ_M XD2_XDFFM_SFB XD4_XDFFQ_M 2.4201e-17
* device instance cc_XD2_XDFFM_SFB_XD4_XDFFQ_MB r0 *1 0,0
Ccc_XD2_XDFFM_SFB_XD4_XDFFQ_MB XD2_XDFFM_SFB XD4_XDFFQ_MB 1.21e-17
* device instance cc_XD2_XDFFM_SFB_XD4_XDFFQ_MFB r0 *1 0,0
Ccc_XD2_XDFFM_SFB_XD4_XDFFQ_MFB XD2_XDFFM_SFB XD4_XDFFQ_MFB 1.21e-17
* device instance cc_XD2_XDFFM_SFB_XD4_XDFFQ_S r0 *1 0,0
Ccc_XD2_XDFFM_SFB_XD4_XDFFQ_S XD2_XDFFM_SFB XD4_XDFFQ_S 1.8151e-17
* device instance cc_XD2_XDFFM_SFB_XD4_XDFFQ_SB r0 *1 0,0
Ccc_XD2_XDFFM_SFB_XD4_XDFFQ_SB XD2_XDFFM_SFB XD4_XDFFQ_SB 1.8151e-17
* device instance cc_XD2_XDFFM_SFB_XD4_XDFFQ_SFB r0 *1 0,0
Ccc_XD2_XDFFM_SFB_XD4_XDFFQ_SFB XD2_XDFFM_SFB XD4_XDFFQ_SFB 1.21e-17
* device instance cc_XD2_XDFFM_SFB_XD4_XN2_mid1 r0 *1 0,0
Ccc_XD2_XDFFM_SFB_XD4_XN2_mid1 XD2_XDFFM_SFB XD4_XN2_mid1 1.21e-17
* device instance cc_XD2_XDFFM_SFB_XD4_XN3_mid1 r0 *1 0,0
Ccc_XD2_XDFFM_SFB_XD4_XN3_mid1 XD2_XDFFM_SFB XD4_XN3_mid1 1.21e-17
* device instance cc_XD2_XDFFM_SFB_XD4_XN3_mid2 r0 *1 0,0
Ccc_XD2_XDFFM_SFB_XD4_XN3_mid2 XD2_XDFFM_SFB XD4_XN3_mid2 1.21e-17
* device instance cc_XD2_XDFFM_SFB_XD4_dmodout r0 *1 0,0
Ccc_XD2_XDFFM_SFB_XD4_dmodout XD2_XDFFM_SFB XD4_dmodout 1.21e-17
* device instance cc_XD2_XDFFM_SFB_XD4_dq r0 *1 0,0
Ccc_XD2_XDFFM_SFB_XD4_dq XD2_XDFFM_SFB XD4_dq 1.8151e-17
* device instance cc_XD2_XDFFM_SFB_XD4_nm r0 *1 0,0
Ccc_XD2_XDFFM_SFB_XD4_nm XD2_XDFFM_SFB XD4_nm 1.21e-17
* device instance cc_XD2_XDFFM_SFB_XD4_nt r0 *1 0,0
Ccc_XD2_XDFFM_SFB_XD4_nt XD2_XDFFM_SFB XD4_nt 1.21e-17
* device instance cc_XD2_XDFFM_SFB_XD4_t1 r0 *1 0,0
Ccc_XD2_XDFFM_SFB_XD4_t1 XD2_XDFFM_SFB XD4_t1 1.21e-17
* device instance cc_XD2_XDFFM_SFB_XD5_XDFFM_CKBB r0 *1 0,0
Ccc_XD2_XDFFM_SFB_XD5_XDFFM_CKBB XD2_XDFFM_SFB XD5_XDFFM_CKBB 1.8151e-17
* device instance cc_XD2_XDFFM_SFB_XD5_XDFFM_CLKB r0 *1 0,0
Ccc_XD2_XDFFM_SFB_XD5_XDFFM_CLKB XD2_XDFFM_SFB XD5_XDFFM_CLKB 2.4201e-17
* device instance cc_XD2_XDFFM_SFB_XD5_XDFFM_M r0 *1 0,0
Ccc_XD2_XDFFM_SFB_XD5_XDFFM_M XD2_XDFFM_SFB XD5_XDFFM_M 2.4201e-17
* device instance cc_XD2_XDFFM_SFB_XD5_XDFFM_MB r0 *1 0,0
Ccc_XD2_XDFFM_SFB_XD5_XDFFM_MB XD2_XDFFM_SFB XD5_XDFFM_MB 1.21e-17
* device instance cc_XD2_XDFFM_SFB_XD5_XDFFM_MFB r0 *1 0,0
Ccc_XD2_XDFFM_SFB_XD5_XDFFM_MFB XD2_XDFFM_SFB XD5_XDFFM_MFB 1.21e-17
* device instance cc_XD2_XDFFM_SFB_XD5_XDFFM_S r0 *1 0,0
Ccc_XD2_XDFFM_SFB_XD5_XDFFM_S XD2_XDFFM_SFB XD5_XDFFM_S 1.8151e-17
* device instance cc_XD2_XDFFM_SFB_XD5_XDFFM_SB r0 *1 0,0
Ccc_XD2_XDFFM_SFB_XD5_XDFFM_SB XD2_XDFFM_SFB XD5_XDFFM_SB 1.8151e-17
* device instance cc_XD2_XDFFM_SFB_XD5_XDFFM_SFB r0 *1 0,0
Ccc_XD2_XDFFM_SFB_XD5_XDFFM_SFB XD2_XDFFM_SFB XD5_XDFFM_SFB 1.21e-17
* device instance cc_XD2_XDFFM_SFB_XD5_XDFFQ_CKBB r0 *1 0,0
Ccc_XD2_XDFFM_SFB_XD5_XDFFQ_CKBB XD2_XDFFM_SFB XD5_XDFFQ_CKBB 1.8151e-17
* device instance cc_XD2_XDFFM_SFB_XD5_XDFFQ_CLKB r0 *1 0,0
Ccc_XD2_XDFFM_SFB_XD5_XDFFQ_CLKB XD2_XDFFM_SFB XD5_XDFFQ_CLKB 2.4201e-17
* device instance cc_XD2_XDFFM_SFB_XD5_XDFFQ_M r0 *1 0,0
Ccc_XD2_XDFFM_SFB_XD5_XDFFQ_M XD2_XDFFM_SFB XD5_XDFFQ_M 2.4201e-17
* device instance cc_XD2_XDFFM_SFB_XD5_XDFFQ_MB r0 *1 0,0
Ccc_XD2_XDFFM_SFB_XD5_XDFFQ_MB XD2_XDFFM_SFB XD5_XDFFQ_MB 1.21e-17
* device instance cc_XD2_XDFFM_SFB_XD5_XDFFQ_MFB r0 *1 0,0
Ccc_XD2_XDFFM_SFB_XD5_XDFFQ_MFB XD2_XDFFM_SFB XD5_XDFFQ_MFB 1.21e-17
* device instance cc_XD2_XDFFM_SFB_XD5_XDFFQ_S r0 *1 0,0
Ccc_XD2_XDFFM_SFB_XD5_XDFFQ_S XD2_XDFFM_SFB XD5_XDFFQ_S 1.8151e-17
* device instance cc_XD2_XDFFM_SFB_XD5_XDFFQ_SB r0 *1 0,0
Ccc_XD2_XDFFM_SFB_XD5_XDFFQ_SB XD2_XDFFM_SFB XD5_XDFFQ_SB 1.8151e-17
* device instance cc_XD2_XDFFM_SFB_XD5_XDFFQ_SFB r0 *1 0,0
Ccc_XD2_XDFFM_SFB_XD5_XDFFQ_SFB XD2_XDFFM_SFB XD5_XDFFQ_SFB 1.21e-17
* device instance cc_XD2_XDFFM_SFB_XD5_XN2_mid1 r0 *1 0,0
Ccc_XD2_XDFFM_SFB_XD5_XN2_mid1 XD2_XDFFM_SFB XD5_XN2_mid1 1.21e-17
* device instance cc_XD2_XDFFM_SFB_XD5_XN3_mid1 r0 *1 0,0
Ccc_XD2_XDFFM_SFB_XD5_XN3_mid1 XD2_XDFFM_SFB XD5_XN3_mid1 1.21e-17
* device instance cc_XD2_XDFFM_SFB_XD5_XN3_mid2 r0 *1 0,0
Ccc_XD2_XDFFM_SFB_XD5_XN3_mid2 XD2_XDFFM_SFB XD5_XN3_mid2 1.21e-17
* device instance cc_XD2_XDFFM_SFB_XD5_dmodout r0 *1 0,0
Ccc_XD2_XDFFM_SFB_XD5_dmodout XD2_XDFFM_SFB XD5_dmodout 1.21e-17
* device instance cc_XD2_XDFFM_SFB_XD5_dq r0 *1 0,0
Ccc_XD2_XDFFM_SFB_XD5_dq XD2_XDFFM_SFB XD5_dq 1.8151e-17
* device instance cc_XD2_XDFFM_SFB_XD5_nm r0 *1 0,0
Ccc_XD2_XDFFM_SFB_XD5_nm XD2_XDFFM_SFB XD5_nm 1.21e-17
* device instance cc_XD2_XDFFM_SFB_XD5_nt r0 *1 0,0
Ccc_XD2_XDFFM_SFB_XD5_nt XD2_XDFFM_SFB XD5_nt 1.21e-17
* device instance cc_XD2_XDFFM_SFB_XD5_t1 r0 *1 0,0
Ccc_XD2_XDFFM_SFB_XD5_t1 XD2_XDFFM_SFB XD5_t1 1.21e-17
* device instance cc_XD2_XDFFM_SFB_XFRT_CKBB r0 *1 0,0
Ccc_XD2_XDFFM_SFB_XFRT_CKBB XD2_XDFFM_SFB XFRT_CKBB 1.8151e-17
* device instance cc_XD2_XDFFM_SFB_XFRT_CLKB r0 *1 0,0
Ccc_XD2_XDFFM_SFB_XFRT_CLKB XD2_XDFFM_SFB XFRT_CLKB 2.4201e-17
* device instance cc_XD2_XDFFM_SFB_XFRT_M r0 *1 0,0
Ccc_XD2_XDFFM_SFB_XFRT_M XD2_XDFFM_SFB XFRT_M 2.4201e-17
* device instance cc_XD2_XDFFM_SFB_XFRT_MB r0 *1 0,0
Ccc_XD2_XDFFM_SFB_XFRT_MB XD2_XDFFM_SFB XFRT_MB 1.21e-17
* device instance cc_XD2_XDFFM_SFB_XFRT_MFB r0 *1 0,0
Ccc_XD2_XDFFM_SFB_XFRT_MFB XD2_XDFFM_SFB XFRT_MFB 1.21e-17
* device instance cc_XD2_XDFFM_SFB_XFRT_S r0 *1 0,0
Ccc_XD2_XDFFM_SFB_XFRT_S XD2_XDFFM_SFB XFRT_S 1.8151e-17
* device instance cc_XD2_XDFFM_SFB_XFRT_SB r0 *1 0,0
Ccc_XD2_XDFFM_SFB_XFRT_SB XD2_XDFFM_SFB XFRT_SB 1.8151e-17
* device instance cc_XD2_XDFFM_SFB_XFRT_SFB r0 *1 0,0
Ccc_XD2_XDFFM_SFB_XFRT_SFB XD2_XDFFM_SFB XFRT_SFB 1.21e-17
* device instance cc_XD2_XDFFM_SFB_ck1 r0 *1 0,0
Ccc_XD2_XDFFM_SFB_ck1 XD2_XDFFM_SFB ck1 3.0251e-17
* device instance cc_XD2_XDFFM_SFB_ck2 r0 *1 0,0
Ccc_XD2_XDFFM_SFB_ck2 XD2_XDFFM_SFB ck2 3.0251e-17
* device instance cc_XD2_XDFFM_SFB_ck3 r0 *1 0,0
Ccc_XD2_XDFFM_SFB_ck3 XD2_XDFFM_SFB ck3 3.0251e-17
* device instance cc_XD2_XDFFM_SFB_ck4 r0 *1 0,0
Ccc_XD2_XDFFM_SFB_ck4 XD2_XDFFM_SFB ck4 3.0251e-17
* device instance cc_XD2_XDFFM_SFB_ck5 r0 *1 0,0
Ccc_XD2_XDFFM_SFB_ck5 XD2_XDFFM_SFB ck5 3.0251e-17
* device instance cc_XD2_XDFFM_SFB_mod0 r0 *1 0,0
Ccc_XD2_XDFFM_SFB_mod0 XD2_XDFFM_SFB mod0 2.4201e-17
* device instance cc_XD2_XDFFM_SFB_mod1 r0 *1 0,0
Ccc_XD2_XDFFM_SFB_mod1 XD2_XDFFM_SFB mod1 2.4201e-17
* device instance cc_XD2_XDFFM_SFB_mod2 r0 *1 0,0
Ccc_XD2_XDFFM_SFB_mod2 XD2_XDFFM_SFB mod2 2.4201e-17
* device instance cc_XD2_XDFFM_SFB_mod3 r0 *1 0,0
Ccc_XD2_XDFFM_SFB_mod3 XD2_XDFFM_SFB mod3 2.4201e-17
* device instance cc_XD2_XDFFM_SFB_mod4 r0 *1 0,0
Ccc_XD2_XDFFM_SFB_mod4 XD2_XDFFM_SFB mod4 2.4201e-17
* device instance cc_XD2_XDFFM_SFB_net1 r0 *1 0,0
Ccc_XD2_XDFFM_SFB_net1 XD2_XDFFM_SFB net1 1.21e-17
* device instance cc_XD2_XDFFQ_CKBB_XD2_XDFFQ_CLKB r0 *1 0,0
Ccc_XD2_XDFFQ_CKBB_XD2_XDFFQ_CLKB XD2_XDFFQ_CKBB XD2_XDFFQ_CLKB 3.6302e-17
* device instance cc_XD2_XDFFQ_CKBB_XD2_XDFFQ_M r0 *1 0,0
Ccc_XD2_XDFFQ_CKBB_XD2_XDFFQ_M XD2_XDFFQ_CKBB XD2_XDFFQ_M 4.8402e-17
* device instance cc_XD2_XDFFQ_CKBB_XD2_XDFFQ_MB r0 *1 0,0
Ccc_XD2_XDFFQ_CKBB_XD2_XDFFQ_MB XD2_XDFFQ_CKBB XD2_XDFFQ_MB 2.4201e-17
* device instance cc_XD2_XDFFQ_CKBB_XD2_XDFFQ_MFB r0 *1 0,0
Ccc_XD2_XDFFQ_CKBB_XD2_XDFFQ_MFB XD2_XDFFQ_CKBB XD2_XDFFQ_MFB 2.4201e-17
* device instance cc_XD2_XDFFQ_CKBB_XD2_XDFFQ_S r0 *1 0,0
Ccc_XD2_XDFFQ_CKBB_XD2_XDFFQ_S XD2_XDFFQ_CKBB XD2_XDFFQ_S 3.0251e-17
* device instance cc_XD2_XDFFQ_CKBB_XD2_XDFFQ_SB r0 *1 0,0
Ccc_XD2_XDFFQ_CKBB_XD2_XDFFQ_SB XD2_XDFFQ_CKBB XD2_XDFFQ_SB 3.0251e-17
* device instance cc_XD2_XDFFQ_CKBB_XD2_XDFFQ_SFB r0 *1 0,0
Ccc_XD2_XDFFQ_CKBB_XD2_XDFFQ_SFB XD2_XDFFQ_CKBB XD2_XDFFQ_SFB 1.8151e-17
* device instance cc_XD2_XDFFQ_CKBB_XD2_XN2_mid1 r0 *1 0,0
Ccc_XD2_XDFFQ_CKBB_XD2_XN2_mid1 XD2_XDFFQ_CKBB XD2_XN2_mid1 1.21e-17
* device instance cc_XD2_XDFFQ_CKBB_XD2_XNOR_midp r0 *1 0,0
Ccc_XD2_XDFFQ_CKBB_XD2_XNOR_midp XD2_XDFFQ_CKBB XD2_XNOR_midp 1.21e-17
* device instance cc_XD2_XDFFQ_CKBB_XD2_dmodout r0 *1 0,0
Ccc_XD2_XDFFQ_CKBB_XD2_dmodout XD2_XDFFQ_CKBB XD2_dmodout 1.21e-17
* device instance cc_XD2_XDFFQ_CKBB_XD2_dq r0 *1 0,0
Ccc_XD2_XDFFQ_CKBB_XD2_dq XD2_XDFFQ_CKBB XD2_dq 1.8151e-17
* device instance cc_XD2_XDFFQ_CKBB_XD2_nm r0 *1 0,0
Ccc_XD2_XDFFQ_CKBB_XD2_nm XD2_XDFFQ_CKBB XD2_nm 1.21e-17
* device instance cc_XD2_XDFFQ_CKBB_XD2_nt r0 *1 0,0
Ccc_XD2_XDFFQ_CKBB_XD2_nt XD2_XDFFQ_CKBB XD2_nt 2.4201e-17
* device instance cc_XD2_XDFFQ_CKBB_XD2_t1 r0 *1 0,0
Ccc_XD2_XDFFQ_CKBB_XD2_t1 XD2_XDFFQ_CKBB XD2_t1 1.21e-17
* device instance cc_XD2_XDFFQ_CKBB_XD3_XDFFM_CKBB r0 *1 0,0
Ccc_XD2_XDFFQ_CKBB_XD3_XDFFM_CKBB XD2_XDFFQ_CKBB XD3_XDFFM_CKBB 1.8151e-17
* device instance cc_XD2_XDFFQ_CKBB_XD3_XDFFM_CLKB r0 *1 0,0
Ccc_XD2_XDFFQ_CKBB_XD3_XDFFM_CLKB XD2_XDFFQ_CKBB XD3_XDFFM_CLKB 2.4201e-17
* device instance cc_XD2_XDFFQ_CKBB_XD3_XDFFM_M r0 *1 0,0
Ccc_XD2_XDFFQ_CKBB_XD3_XDFFM_M XD2_XDFFQ_CKBB XD3_XDFFM_M 2.4201e-17
* device instance cc_XD2_XDFFQ_CKBB_XD3_XDFFM_MB r0 *1 0,0
Ccc_XD2_XDFFQ_CKBB_XD3_XDFFM_MB XD2_XDFFQ_CKBB XD3_XDFFM_MB 1.21e-17
* device instance cc_XD2_XDFFQ_CKBB_XD3_XDFFM_MFB r0 *1 0,0
Ccc_XD2_XDFFQ_CKBB_XD3_XDFFM_MFB XD2_XDFFQ_CKBB XD3_XDFFM_MFB 1.21e-17
* device instance cc_XD2_XDFFQ_CKBB_XD3_XDFFM_S r0 *1 0,0
Ccc_XD2_XDFFQ_CKBB_XD3_XDFFM_S XD2_XDFFQ_CKBB XD3_XDFFM_S 1.8151e-17
* device instance cc_XD2_XDFFQ_CKBB_XD3_XDFFM_SB r0 *1 0,0
Ccc_XD2_XDFFQ_CKBB_XD3_XDFFM_SB XD2_XDFFQ_CKBB XD3_XDFFM_SB 1.8151e-17
* device instance cc_XD2_XDFFQ_CKBB_XD3_XDFFM_SFB r0 *1 0,0
Ccc_XD2_XDFFQ_CKBB_XD3_XDFFM_SFB XD2_XDFFQ_CKBB XD3_XDFFM_SFB 1.21e-17
* device instance cc_XD2_XDFFQ_CKBB_XD3_XDFFQ_CKBB r0 *1 0,0
Ccc_XD2_XDFFQ_CKBB_XD3_XDFFQ_CKBB XD2_XDFFQ_CKBB XD3_XDFFQ_CKBB 1.8151e-17
* device instance cc_XD2_XDFFQ_CKBB_XD3_XDFFQ_CLKB r0 *1 0,0
Ccc_XD2_XDFFQ_CKBB_XD3_XDFFQ_CLKB XD2_XDFFQ_CKBB XD3_XDFFQ_CLKB 2.4201e-17
* device instance cc_XD2_XDFFQ_CKBB_XD3_XDFFQ_M r0 *1 0,0
Ccc_XD2_XDFFQ_CKBB_XD3_XDFFQ_M XD2_XDFFQ_CKBB XD3_XDFFQ_M 2.4201e-17
* device instance cc_XD2_XDFFQ_CKBB_XD3_XDFFQ_MB r0 *1 0,0
Ccc_XD2_XDFFQ_CKBB_XD3_XDFFQ_MB XD2_XDFFQ_CKBB XD3_XDFFQ_MB 1.21e-17
* device instance cc_XD2_XDFFQ_CKBB_XD3_XDFFQ_MFB r0 *1 0,0
Ccc_XD2_XDFFQ_CKBB_XD3_XDFFQ_MFB XD2_XDFFQ_CKBB XD3_XDFFQ_MFB 1.21e-17
* device instance cc_XD2_XDFFQ_CKBB_XD3_XDFFQ_S r0 *1 0,0
Ccc_XD2_XDFFQ_CKBB_XD3_XDFFQ_S XD2_XDFFQ_CKBB XD3_XDFFQ_S 1.8151e-17
* device instance cc_XD2_XDFFQ_CKBB_XD3_XDFFQ_SB r0 *1 0,0
Ccc_XD2_XDFFQ_CKBB_XD3_XDFFQ_SB XD2_XDFFQ_CKBB XD3_XDFFQ_SB 1.8151e-17
* device instance cc_XD2_XDFFQ_CKBB_XD3_XDFFQ_SFB r0 *1 0,0
Ccc_XD2_XDFFQ_CKBB_XD3_XDFFQ_SFB XD2_XDFFQ_CKBB XD3_XDFFQ_SFB 1.21e-17
* device instance cc_XD2_XDFFQ_CKBB_XD3_XN2_mid1 r0 *1 0,0
Ccc_XD2_XDFFQ_CKBB_XD3_XN2_mid1 XD2_XDFFQ_CKBB XD3_XN2_mid1 1.21e-17
* device instance cc_XD2_XDFFQ_CKBB_XD3_XN3_mid1 r0 *1 0,0
Ccc_XD2_XDFFQ_CKBB_XD3_XN3_mid1 XD2_XDFFQ_CKBB XD3_XN3_mid1 1.21e-17
* device instance cc_XD2_XDFFQ_CKBB_XD3_XN3_mid2 r0 *1 0,0
Ccc_XD2_XDFFQ_CKBB_XD3_XN3_mid2 XD2_XDFFQ_CKBB XD3_XN3_mid2 1.21e-17
* device instance cc_XD2_XDFFQ_CKBB_XD3_dmodout r0 *1 0,0
Ccc_XD2_XDFFQ_CKBB_XD3_dmodout XD2_XDFFQ_CKBB XD3_dmodout 1.21e-17
* device instance cc_XD2_XDFFQ_CKBB_XD3_dq r0 *1 0,0
Ccc_XD2_XDFFQ_CKBB_XD3_dq XD2_XDFFQ_CKBB XD3_dq 1.8151e-17
* device instance cc_XD2_XDFFQ_CKBB_XD3_nm r0 *1 0,0
Ccc_XD2_XDFFQ_CKBB_XD3_nm XD2_XDFFQ_CKBB XD3_nm 1.21e-17
* device instance cc_XD2_XDFFQ_CKBB_XD3_nt r0 *1 0,0
Ccc_XD2_XDFFQ_CKBB_XD3_nt XD2_XDFFQ_CKBB XD3_nt 1.21e-17
* device instance cc_XD2_XDFFQ_CKBB_XD3_t1 r0 *1 0,0
Ccc_XD2_XDFFQ_CKBB_XD3_t1 XD2_XDFFQ_CKBB XD3_t1 1.21e-17
* device instance cc_XD2_XDFFQ_CKBB_XD4_XDFFM_CKBB r0 *1 0,0
Ccc_XD2_XDFFQ_CKBB_XD4_XDFFM_CKBB XD2_XDFFQ_CKBB XD4_XDFFM_CKBB 1.8151e-17
* device instance cc_XD2_XDFFQ_CKBB_XD4_XDFFM_CLKB r0 *1 0,0
Ccc_XD2_XDFFQ_CKBB_XD4_XDFFM_CLKB XD2_XDFFQ_CKBB XD4_XDFFM_CLKB 2.4201e-17
* device instance cc_XD2_XDFFQ_CKBB_XD4_XDFFM_M r0 *1 0,0
Ccc_XD2_XDFFQ_CKBB_XD4_XDFFM_M XD2_XDFFQ_CKBB XD4_XDFFM_M 2.4201e-17
* device instance cc_XD2_XDFFQ_CKBB_XD4_XDFFM_MB r0 *1 0,0
Ccc_XD2_XDFFQ_CKBB_XD4_XDFFM_MB XD2_XDFFQ_CKBB XD4_XDFFM_MB 1.21e-17
* device instance cc_XD2_XDFFQ_CKBB_XD4_XDFFM_MFB r0 *1 0,0
Ccc_XD2_XDFFQ_CKBB_XD4_XDFFM_MFB XD2_XDFFQ_CKBB XD4_XDFFM_MFB 1.21e-17
* device instance cc_XD2_XDFFQ_CKBB_XD4_XDFFM_S r0 *1 0,0
Ccc_XD2_XDFFQ_CKBB_XD4_XDFFM_S XD2_XDFFQ_CKBB XD4_XDFFM_S 1.8151e-17
* device instance cc_XD2_XDFFQ_CKBB_XD4_XDFFM_SB r0 *1 0,0
Ccc_XD2_XDFFQ_CKBB_XD4_XDFFM_SB XD2_XDFFQ_CKBB XD4_XDFFM_SB 1.8151e-17
* device instance cc_XD2_XDFFQ_CKBB_XD4_XDFFM_SFB r0 *1 0,0
Ccc_XD2_XDFFQ_CKBB_XD4_XDFFM_SFB XD2_XDFFQ_CKBB XD4_XDFFM_SFB 1.21e-17
* device instance cc_XD2_XDFFQ_CKBB_XD4_XDFFQ_CKBB r0 *1 0,0
Ccc_XD2_XDFFQ_CKBB_XD4_XDFFQ_CKBB XD2_XDFFQ_CKBB XD4_XDFFQ_CKBB 1.8151e-17
* device instance cc_XD2_XDFFQ_CKBB_XD4_XDFFQ_CLKB r0 *1 0,0
Ccc_XD2_XDFFQ_CKBB_XD4_XDFFQ_CLKB XD2_XDFFQ_CKBB XD4_XDFFQ_CLKB 2.4201e-17
* device instance cc_XD2_XDFFQ_CKBB_XD4_XDFFQ_M r0 *1 0,0
Ccc_XD2_XDFFQ_CKBB_XD4_XDFFQ_M XD2_XDFFQ_CKBB XD4_XDFFQ_M 2.4201e-17
* device instance cc_XD2_XDFFQ_CKBB_XD4_XDFFQ_MB r0 *1 0,0
Ccc_XD2_XDFFQ_CKBB_XD4_XDFFQ_MB XD2_XDFFQ_CKBB XD4_XDFFQ_MB 1.21e-17
* device instance cc_XD2_XDFFQ_CKBB_XD4_XDFFQ_MFB r0 *1 0,0
Ccc_XD2_XDFFQ_CKBB_XD4_XDFFQ_MFB XD2_XDFFQ_CKBB XD4_XDFFQ_MFB 1.21e-17
* device instance cc_XD2_XDFFQ_CKBB_XD4_XDFFQ_S r0 *1 0,0
Ccc_XD2_XDFFQ_CKBB_XD4_XDFFQ_S XD2_XDFFQ_CKBB XD4_XDFFQ_S 1.8151e-17
* device instance cc_XD2_XDFFQ_CKBB_XD4_XDFFQ_SB r0 *1 0,0
Ccc_XD2_XDFFQ_CKBB_XD4_XDFFQ_SB XD2_XDFFQ_CKBB XD4_XDFFQ_SB 1.8151e-17
* device instance cc_XD2_XDFFQ_CKBB_XD4_XDFFQ_SFB r0 *1 0,0
Ccc_XD2_XDFFQ_CKBB_XD4_XDFFQ_SFB XD2_XDFFQ_CKBB XD4_XDFFQ_SFB 1.21e-17
* device instance cc_XD2_XDFFQ_CKBB_XD4_XN2_mid1 r0 *1 0,0
Ccc_XD2_XDFFQ_CKBB_XD4_XN2_mid1 XD2_XDFFQ_CKBB XD4_XN2_mid1 1.21e-17
* device instance cc_XD2_XDFFQ_CKBB_XD4_XN3_mid1 r0 *1 0,0
Ccc_XD2_XDFFQ_CKBB_XD4_XN3_mid1 XD2_XDFFQ_CKBB XD4_XN3_mid1 1.21e-17
* device instance cc_XD2_XDFFQ_CKBB_XD4_XN3_mid2 r0 *1 0,0
Ccc_XD2_XDFFQ_CKBB_XD4_XN3_mid2 XD2_XDFFQ_CKBB XD4_XN3_mid2 1.21e-17
* device instance cc_XD2_XDFFQ_CKBB_XD4_dmodout r0 *1 0,0
Ccc_XD2_XDFFQ_CKBB_XD4_dmodout XD2_XDFFQ_CKBB XD4_dmodout 1.21e-17
* device instance cc_XD2_XDFFQ_CKBB_XD4_dq r0 *1 0,0
Ccc_XD2_XDFFQ_CKBB_XD4_dq XD2_XDFFQ_CKBB XD4_dq 1.8151e-17
* device instance cc_XD2_XDFFQ_CKBB_XD4_nm r0 *1 0,0
Ccc_XD2_XDFFQ_CKBB_XD4_nm XD2_XDFFQ_CKBB XD4_nm 1.21e-17
* device instance cc_XD2_XDFFQ_CKBB_XD4_nt r0 *1 0,0
Ccc_XD2_XDFFQ_CKBB_XD4_nt XD2_XDFFQ_CKBB XD4_nt 1.21e-17
* device instance cc_XD2_XDFFQ_CKBB_XD4_t1 r0 *1 0,0
Ccc_XD2_XDFFQ_CKBB_XD4_t1 XD2_XDFFQ_CKBB XD4_t1 1.21e-17
* device instance cc_XD2_XDFFQ_CKBB_XD5_XDFFM_CKBB r0 *1 0,0
Ccc_XD2_XDFFQ_CKBB_XD5_XDFFM_CKBB XD2_XDFFQ_CKBB XD5_XDFFM_CKBB 1.8151e-17
* device instance cc_XD2_XDFFQ_CKBB_XD5_XDFFM_CLKB r0 *1 0,0
Ccc_XD2_XDFFQ_CKBB_XD5_XDFFM_CLKB XD2_XDFFQ_CKBB XD5_XDFFM_CLKB 2.4201e-17
* device instance cc_XD2_XDFFQ_CKBB_XD5_XDFFM_M r0 *1 0,0
Ccc_XD2_XDFFQ_CKBB_XD5_XDFFM_M XD2_XDFFQ_CKBB XD5_XDFFM_M 2.4201e-17
* device instance cc_XD2_XDFFQ_CKBB_XD5_XDFFM_MB r0 *1 0,0
Ccc_XD2_XDFFQ_CKBB_XD5_XDFFM_MB XD2_XDFFQ_CKBB XD5_XDFFM_MB 1.21e-17
* device instance cc_XD2_XDFFQ_CKBB_XD5_XDFFM_MFB r0 *1 0,0
Ccc_XD2_XDFFQ_CKBB_XD5_XDFFM_MFB XD2_XDFFQ_CKBB XD5_XDFFM_MFB 1.21e-17
* device instance cc_XD2_XDFFQ_CKBB_XD5_XDFFM_S r0 *1 0,0
Ccc_XD2_XDFFQ_CKBB_XD5_XDFFM_S XD2_XDFFQ_CKBB XD5_XDFFM_S 1.8151e-17
* device instance cc_XD2_XDFFQ_CKBB_XD5_XDFFM_SB r0 *1 0,0
Ccc_XD2_XDFFQ_CKBB_XD5_XDFFM_SB XD2_XDFFQ_CKBB XD5_XDFFM_SB 1.8151e-17
* device instance cc_XD2_XDFFQ_CKBB_XD5_XDFFM_SFB r0 *1 0,0
Ccc_XD2_XDFFQ_CKBB_XD5_XDFFM_SFB XD2_XDFFQ_CKBB XD5_XDFFM_SFB 1.21e-17
* device instance cc_XD2_XDFFQ_CKBB_XD5_XDFFQ_CKBB r0 *1 0,0
Ccc_XD2_XDFFQ_CKBB_XD5_XDFFQ_CKBB XD2_XDFFQ_CKBB XD5_XDFFQ_CKBB 1.8151e-17
* device instance cc_XD2_XDFFQ_CKBB_XD5_XDFFQ_CLKB r0 *1 0,0
Ccc_XD2_XDFFQ_CKBB_XD5_XDFFQ_CLKB XD2_XDFFQ_CKBB XD5_XDFFQ_CLKB 2.4201e-17
* device instance cc_XD2_XDFFQ_CKBB_XD5_XDFFQ_M r0 *1 0,0
Ccc_XD2_XDFFQ_CKBB_XD5_XDFFQ_M XD2_XDFFQ_CKBB XD5_XDFFQ_M 2.4201e-17
* device instance cc_XD2_XDFFQ_CKBB_XD5_XDFFQ_MB r0 *1 0,0
Ccc_XD2_XDFFQ_CKBB_XD5_XDFFQ_MB XD2_XDFFQ_CKBB XD5_XDFFQ_MB 1.21e-17
* device instance cc_XD2_XDFFQ_CKBB_XD5_XDFFQ_MFB r0 *1 0,0
Ccc_XD2_XDFFQ_CKBB_XD5_XDFFQ_MFB XD2_XDFFQ_CKBB XD5_XDFFQ_MFB 1.21e-17
* device instance cc_XD2_XDFFQ_CKBB_XD5_XDFFQ_S r0 *1 0,0
Ccc_XD2_XDFFQ_CKBB_XD5_XDFFQ_S XD2_XDFFQ_CKBB XD5_XDFFQ_S 1.8151e-17
* device instance cc_XD2_XDFFQ_CKBB_XD5_XDFFQ_SB r0 *1 0,0
Ccc_XD2_XDFFQ_CKBB_XD5_XDFFQ_SB XD2_XDFFQ_CKBB XD5_XDFFQ_SB 1.8151e-17
* device instance cc_XD2_XDFFQ_CKBB_XD5_XDFFQ_SFB r0 *1 0,0
Ccc_XD2_XDFFQ_CKBB_XD5_XDFFQ_SFB XD2_XDFFQ_CKBB XD5_XDFFQ_SFB 1.21e-17
* device instance cc_XD2_XDFFQ_CKBB_XD5_XN2_mid1 r0 *1 0,0
Ccc_XD2_XDFFQ_CKBB_XD5_XN2_mid1 XD2_XDFFQ_CKBB XD5_XN2_mid1 1.21e-17
* device instance cc_XD2_XDFFQ_CKBB_XD5_XN3_mid1 r0 *1 0,0
Ccc_XD2_XDFFQ_CKBB_XD5_XN3_mid1 XD2_XDFFQ_CKBB XD5_XN3_mid1 1.21e-17
* device instance cc_XD2_XDFFQ_CKBB_XD5_XN3_mid2 r0 *1 0,0
Ccc_XD2_XDFFQ_CKBB_XD5_XN3_mid2 XD2_XDFFQ_CKBB XD5_XN3_mid2 1.21e-17
* device instance cc_XD2_XDFFQ_CKBB_XD5_dmodout r0 *1 0,0
Ccc_XD2_XDFFQ_CKBB_XD5_dmodout XD2_XDFFQ_CKBB XD5_dmodout 1.21e-17
* device instance cc_XD2_XDFFQ_CKBB_XD5_dq r0 *1 0,0
Ccc_XD2_XDFFQ_CKBB_XD5_dq XD2_XDFFQ_CKBB XD5_dq 1.8151e-17
* device instance cc_XD2_XDFFQ_CKBB_XD5_nm r0 *1 0,0
Ccc_XD2_XDFFQ_CKBB_XD5_nm XD2_XDFFQ_CKBB XD5_nm 1.21e-17
* device instance cc_XD2_XDFFQ_CKBB_XD5_nt r0 *1 0,0
Ccc_XD2_XDFFQ_CKBB_XD5_nt XD2_XDFFQ_CKBB XD5_nt 1.21e-17
* device instance cc_XD2_XDFFQ_CKBB_XD5_t1 r0 *1 0,0
Ccc_XD2_XDFFQ_CKBB_XD5_t1 XD2_XDFFQ_CKBB XD5_t1 1.21e-17
* device instance cc_XD2_XDFFQ_CKBB_XFRT_CKBB r0 *1 0,0
Ccc_XD2_XDFFQ_CKBB_XFRT_CKBB XD2_XDFFQ_CKBB XFRT_CKBB 1.8151e-17
* device instance cc_XD2_XDFFQ_CKBB_XFRT_CLKB r0 *1 0,0
Ccc_XD2_XDFFQ_CKBB_XFRT_CLKB XD2_XDFFQ_CKBB XFRT_CLKB 2.4201e-17
* device instance cc_XD2_XDFFQ_CKBB_XFRT_M r0 *1 0,0
Ccc_XD2_XDFFQ_CKBB_XFRT_M XD2_XDFFQ_CKBB XFRT_M 2.4201e-17
* device instance cc_XD2_XDFFQ_CKBB_XFRT_MB r0 *1 0,0
Ccc_XD2_XDFFQ_CKBB_XFRT_MB XD2_XDFFQ_CKBB XFRT_MB 1.21e-17
* device instance cc_XD2_XDFFQ_CKBB_XFRT_MFB r0 *1 0,0
Ccc_XD2_XDFFQ_CKBB_XFRT_MFB XD2_XDFFQ_CKBB XFRT_MFB 1.21e-17
* device instance cc_XD2_XDFFQ_CKBB_XFRT_S r0 *1 0,0
Ccc_XD2_XDFFQ_CKBB_XFRT_S XD2_XDFFQ_CKBB XFRT_S 1.8151e-17
* device instance cc_XD2_XDFFQ_CKBB_XFRT_SB r0 *1 0,0
Ccc_XD2_XDFFQ_CKBB_XFRT_SB XD2_XDFFQ_CKBB XFRT_SB 1.8151e-17
* device instance cc_XD2_XDFFQ_CKBB_XFRT_SFB r0 *1 0,0
Ccc_XD2_XDFFQ_CKBB_XFRT_SFB XD2_XDFFQ_CKBB XFRT_SFB 1.21e-17
* device instance cc_XD2_XDFFQ_CKBB_ck1 r0 *1 0,0
Ccc_XD2_XDFFQ_CKBB_ck1 XD2_XDFFQ_CKBB ck1 3.0251e-17
* device instance cc_XD2_XDFFQ_CKBB_ck2 r0 *1 0,0
Ccc_XD2_XDFFQ_CKBB_ck2 XD2_XDFFQ_CKBB ck2 3.0251e-17
* device instance cc_XD2_XDFFQ_CKBB_ck3 r0 *1 0,0
Ccc_XD2_XDFFQ_CKBB_ck3 XD2_XDFFQ_CKBB ck3 3.0251e-17
* device instance cc_XD2_XDFFQ_CKBB_ck4 r0 *1 0,0
Ccc_XD2_XDFFQ_CKBB_ck4 XD2_XDFFQ_CKBB ck4 3.0251e-17
* device instance cc_XD2_XDFFQ_CKBB_ck5 r0 *1 0,0
Ccc_XD2_XDFFQ_CKBB_ck5 XD2_XDFFQ_CKBB ck5 3.0251e-17
* device instance cc_XD2_XDFFQ_CKBB_mod0 r0 *1 0,0
Ccc_XD2_XDFFQ_CKBB_mod0 XD2_XDFFQ_CKBB mod0 2.4201e-17
* device instance cc_XD2_XDFFQ_CKBB_mod1 r0 *1 0,0
Ccc_XD2_XDFFQ_CKBB_mod1 XD2_XDFFQ_CKBB mod1 2.4201e-17
* device instance cc_XD2_XDFFQ_CKBB_mod2 r0 *1 0,0
Ccc_XD2_XDFFQ_CKBB_mod2 XD2_XDFFQ_CKBB mod2 2.4201e-17
* device instance cc_XD2_XDFFQ_CKBB_mod3 r0 *1 0,0
Ccc_XD2_XDFFQ_CKBB_mod3 XD2_XDFFQ_CKBB mod3 2.4201e-17
* device instance cc_XD2_XDFFQ_CKBB_mod4 r0 *1 0,0
Ccc_XD2_XDFFQ_CKBB_mod4 XD2_XDFFQ_CKBB mod4 2.4201e-17
* device instance cc_XD2_XDFFQ_CKBB_net1 r0 *1 0,0
Ccc_XD2_XDFFQ_CKBB_net1 XD2_XDFFQ_CKBB net1 1.21e-17
* device instance cc_XD2_XDFFQ_CLKB_XD2_XDFFQ_M r0 *1 0,0
Ccc_XD2_XDFFQ_CLKB_XD2_XDFFQ_M XD2_XDFFQ_CLKB XD2_XDFFQ_M 4.2352e-17
* device instance cc_XD2_XDFFQ_CLKB_XD2_XDFFQ_MB r0 *1 0,0
Ccc_XD2_XDFFQ_CLKB_XD2_XDFFQ_MB XD2_XDFFQ_CLKB XD2_XDFFQ_MB 2.4201e-17
* device instance cc_XD2_XDFFQ_CLKB_XD2_XDFFQ_MFB r0 *1 0,0
Ccc_XD2_XDFFQ_CLKB_XD2_XDFFQ_MFB XD2_XDFFQ_CLKB XD2_XDFFQ_MFB 2.4201e-17
* device instance cc_XD2_XDFFQ_CLKB_XD2_XDFFQ_S r0 *1 0,0
Ccc_XD2_XDFFQ_CLKB_XD2_XDFFQ_S XD2_XDFFQ_CLKB XD2_XDFFQ_S 1.8151e-17
* device instance cc_XD2_XDFFQ_CLKB_XD2_XDFFQ_SB r0 *1 0,0
Ccc_XD2_XDFFQ_CLKB_XD2_XDFFQ_SB XD2_XDFFQ_CLKB XD2_XDFFQ_SB 1.8151e-17
* device instance cc_XD2_XDFFQ_CLKB_XD2_XDFFQ_SFB r0 *1 0,0
Ccc_XD2_XDFFQ_CLKB_XD2_XDFFQ_SFB XD2_XDFFQ_CLKB XD2_XDFFQ_SFB 1.21e-17
* device instance cc_XD2_XDFFQ_CLKB_XD2_XN2_mid1 r0 *1 0,0
Ccc_XD2_XDFFQ_CLKB_XD2_XN2_mid1 XD2_XDFFQ_CLKB XD2_XN2_mid1 1.21e-17
* device instance cc_XD2_XDFFQ_CLKB_XD2_XNOR_midp r0 *1 0,0
Ccc_XD2_XDFFQ_CLKB_XD2_XNOR_midp XD2_XDFFQ_CLKB XD2_XNOR_midp 1.21e-17
* device instance cc_XD2_XDFFQ_CLKB_XD2_dmodout r0 *1 0,0
Ccc_XD2_XDFFQ_CLKB_XD2_dmodout XD2_XDFFQ_CLKB XD2_dmodout 1.21e-17
* device instance cc_XD2_XDFFQ_CLKB_XD2_dq r0 *1 0,0
Ccc_XD2_XDFFQ_CLKB_XD2_dq XD2_XDFFQ_CLKB XD2_dq 1.8151e-17
* device instance cc_XD2_XDFFQ_CLKB_XD2_nm r0 *1 0,0
Ccc_XD2_XDFFQ_CLKB_XD2_nm XD2_XDFFQ_CLKB XD2_nm 1.21e-17
* device instance cc_XD2_XDFFQ_CLKB_XD2_nt r0 *1 0,0
Ccc_XD2_XDFFQ_CLKB_XD2_nt XD2_XDFFQ_CLKB XD2_nt 2.4201e-17
* device instance cc_XD2_XDFFQ_CLKB_XD2_t1 r0 *1 0,0
Ccc_XD2_XDFFQ_CLKB_XD2_t1 XD2_XDFFQ_CLKB XD2_t1 1.21e-17
* device instance cc_XD2_XDFFQ_CLKB_XD3_XDFFM_CKBB r0 *1 0,0
Ccc_XD2_XDFFQ_CLKB_XD3_XDFFM_CKBB XD2_XDFFQ_CLKB XD3_XDFFM_CKBB 1.8151e-17
* device instance cc_XD2_XDFFQ_CLKB_XD3_XDFFM_CLKB r0 *1 0,0
Ccc_XD2_XDFFQ_CLKB_XD3_XDFFM_CLKB XD2_XDFFQ_CLKB XD3_XDFFM_CLKB 2.4201e-17
* device instance cc_XD2_XDFFQ_CLKB_XD3_XDFFM_M r0 *1 0,0
Ccc_XD2_XDFFQ_CLKB_XD3_XDFFM_M XD2_XDFFQ_CLKB XD3_XDFFM_M 2.4201e-17
* device instance cc_XD2_XDFFQ_CLKB_XD3_XDFFM_MB r0 *1 0,0
Ccc_XD2_XDFFQ_CLKB_XD3_XDFFM_MB XD2_XDFFQ_CLKB XD3_XDFFM_MB 1.21e-17
* device instance cc_XD2_XDFFQ_CLKB_XD3_XDFFM_MFB r0 *1 0,0
Ccc_XD2_XDFFQ_CLKB_XD3_XDFFM_MFB XD2_XDFFQ_CLKB XD3_XDFFM_MFB 1.21e-17
* device instance cc_XD2_XDFFQ_CLKB_XD3_XDFFM_S r0 *1 0,0
Ccc_XD2_XDFFQ_CLKB_XD3_XDFFM_S XD2_XDFFQ_CLKB XD3_XDFFM_S 1.8151e-17
* device instance cc_XD2_XDFFQ_CLKB_XD3_XDFFM_SB r0 *1 0,0
Ccc_XD2_XDFFQ_CLKB_XD3_XDFFM_SB XD2_XDFFQ_CLKB XD3_XDFFM_SB 1.8151e-17
* device instance cc_XD2_XDFFQ_CLKB_XD3_XDFFM_SFB r0 *1 0,0
Ccc_XD2_XDFFQ_CLKB_XD3_XDFFM_SFB XD2_XDFFQ_CLKB XD3_XDFFM_SFB 1.21e-17
* device instance cc_XD2_XDFFQ_CLKB_XD3_XDFFQ_CKBB r0 *1 0,0
Ccc_XD2_XDFFQ_CLKB_XD3_XDFFQ_CKBB XD2_XDFFQ_CLKB XD3_XDFFQ_CKBB 1.8151e-17
* device instance cc_XD2_XDFFQ_CLKB_XD3_XDFFQ_CLKB r0 *1 0,0
Ccc_XD2_XDFFQ_CLKB_XD3_XDFFQ_CLKB XD2_XDFFQ_CLKB XD3_XDFFQ_CLKB 2.4201e-17
* device instance cc_XD2_XDFFQ_CLKB_XD3_XDFFQ_M r0 *1 0,0
Ccc_XD2_XDFFQ_CLKB_XD3_XDFFQ_M XD2_XDFFQ_CLKB XD3_XDFFQ_M 2.4201e-17
* device instance cc_XD2_XDFFQ_CLKB_XD3_XDFFQ_MB r0 *1 0,0
Ccc_XD2_XDFFQ_CLKB_XD3_XDFFQ_MB XD2_XDFFQ_CLKB XD3_XDFFQ_MB 1.21e-17
* device instance cc_XD2_XDFFQ_CLKB_XD3_XDFFQ_MFB r0 *1 0,0
Ccc_XD2_XDFFQ_CLKB_XD3_XDFFQ_MFB XD2_XDFFQ_CLKB XD3_XDFFQ_MFB 1.21e-17
* device instance cc_XD2_XDFFQ_CLKB_XD3_XDFFQ_S r0 *1 0,0
Ccc_XD2_XDFFQ_CLKB_XD3_XDFFQ_S XD2_XDFFQ_CLKB XD3_XDFFQ_S 1.8151e-17
* device instance cc_XD2_XDFFQ_CLKB_XD3_XDFFQ_SB r0 *1 0,0
Ccc_XD2_XDFFQ_CLKB_XD3_XDFFQ_SB XD2_XDFFQ_CLKB XD3_XDFFQ_SB 1.8151e-17
* device instance cc_XD2_XDFFQ_CLKB_XD3_XDFFQ_SFB r0 *1 0,0
Ccc_XD2_XDFFQ_CLKB_XD3_XDFFQ_SFB XD2_XDFFQ_CLKB XD3_XDFFQ_SFB 1.21e-17
* device instance cc_XD2_XDFFQ_CLKB_XD3_XN2_mid1 r0 *1 0,0
Ccc_XD2_XDFFQ_CLKB_XD3_XN2_mid1 XD2_XDFFQ_CLKB XD3_XN2_mid1 1.21e-17
* device instance cc_XD2_XDFFQ_CLKB_XD3_XN3_mid1 r0 *1 0,0
Ccc_XD2_XDFFQ_CLKB_XD3_XN3_mid1 XD2_XDFFQ_CLKB XD3_XN3_mid1 1.21e-17
* device instance cc_XD2_XDFFQ_CLKB_XD3_XN3_mid2 r0 *1 0,0
Ccc_XD2_XDFFQ_CLKB_XD3_XN3_mid2 XD2_XDFFQ_CLKB XD3_XN3_mid2 1.21e-17
* device instance cc_XD2_XDFFQ_CLKB_XD3_dmodout r0 *1 0,0
Ccc_XD2_XDFFQ_CLKB_XD3_dmodout XD2_XDFFQ_CLKB XD3_dmodout 1.21e-17
* device instance cc_XD2_XDFFQ_CLKB_XD3_dq r0 *1 0,0
Ccc_XD2_XDFFQ_CLKB_XD3_dq XD2_XDFFQ_CLKB XD3_dq 1.8151e-17
* device instance cc_XD2_XDFFQ_CLKB_XD3_nm r0 *1 0,0
Ccc_XD2_XDFFQ_CLKB_XD3_nm XD2_XDFFQ_CLKB XD3_nm 1.21e-17
* device instance cc_XD2_XDFFQ_CLKB_XD3_nt r0 *1 0,0
Ccc_XD2_XDFFQ_CLKB_XD3_nt XD2_XDFFQ_CLKB XD3_nt 1.21e-17
* device instance cc_XD2_XDFFQ_CLKB_XD3_t1 r0 *1 0,0
Ccc_XD2_XDFFQ_CLKB_XD3_t1 XD2_XDFFQ_CLKB XD3_t1 1.21e-17
* device instance cc_XD2_XDFFQ_CLKB_XD4_XDFFM_CKBB r0 *1 0,0
Ccc_XD2_XDFFQ_CLKB_XD4_XDFFM_CKBB XD2_XDFFQ_CLKB XD4_XDFFM_CKBB 1.8151e-17
* device instance cc_XD2_XDFFQ_CLKB_XD4_XDFFM_CLKB r0 *1 0,0
Ccc_XD2_XDFFQ_CLKB_XD4_XDFFM_CLKB XD2_XDFFQ_CLKB XD4_XDFFM_CLKB 2.4201e-17
* device instance cc_XD2_XDFFQ_CLKB_XD4_XDFFM_M r0 *1 0,0
Ccc_XD2_XDFFQ_CLKB_XD4_XDFFM_M XD2_XDFFQ_CLKB XD4_XDFFM_M 2.4201e-17
* device instance cc_XD2_XDFFQ_CLKB_XD4_XDFFM_MB r0 *1 0,0
Ccc_XD2_XDFFQ_CLKB_XD4_XDFFM_MB XD2_XDFFQ_CLKB XD4_XDFFM_MB 1.21e-17
* device instance cc_XD2_XDFFQ_CLKB_XD4_XDFFM_MFB r0 *1 0,0
Ccc_XD2_XDFFQ_CLKB_XD4_XDFFM_MFB XD2_XDFFQ_CLKB XD4_XDFFM_MFB 1.21e-17
* device instance cc_XD2_XDFFQ_CLKB_XD4_XDFFM_S r0 *1 0,0
Ccc_XD2_XDFFQ_CLKB_XD4_XDFFM_S XD2_XDFFQ_CLKB XD4_XDFFM_S 1.8151e-17
* device instance cc_XD2_XDFFQ_CLKB_XD4_XDFFM_SB r0 *1 0,0
Ccc_XD2_XDFFQ_CLKB_XD4_XDFFM_SB XD2_XDFFQ_CLKB XD4_XDFFM_SB 1.8151e-17
* device instance cc_XD2_XDFFQ_CLKB_XD4_XDFFM_SFB r0 *1 0,0
Ccc_XD2_XDFFQ_CLKB_XD4_XDFFM_SFB XD2_XDFFQ_CLKB XD4_XDFFM_SFB 1.21e-17
* device instance cc_XD2_XDFFQ_CLKB_XD4_XDFFQ_CKBB r0 *1 0,0
Ccc_XD2_XDFFQ_CLKB_XD4_XDFFQ_CKBB XD2_XDFFQ_CLKB XD4_XDFFQ_CKBB 1.8151e-17
* device instance cc_XD2_XDFFQ_CLKB_XD4_XDFFQ_CLKB r0 *1 0,0
Ccc_XD2_XDFFQ_CLKB_XD4_XDFFQ_CLKB XD2_XDFFQ_CLKB XD4_XDFFQ_CLKB 2.4201e-17
* device instance cc_XD2_XDFFQ_CLKB_XD4_XDFFQ_M r0 *1 0,0
Ccc_XD2_XDFFQ_CLKB_XD4_XDFFQ_M XD2_XDFFQ_CLKB XD4_XDFFQ_M 2.4201e-17
* device instance cc_XD2_XDFFQ_CLKB_XD4_XDFFQ_MB r0 *1 0,0
Ccc_XD2_XDFFQ_CLKB_XD4_XDFFQ_MB XD2_XDFFQ_CLKB XD4_XDFFQ_MB 1.21e-17
* device instance cc_XD2_XDFFQ_CLKB_XD4_XDFFQ_MFB r0 *1 0,0
Ccc_XD2_XDFFQ_CLKB_XD4_XDFFQ_MFB XD2_XDFFQ_CLKB XD4_XDFFQ_MFB 1.21e-17
* device instance cc_XD2_XDFFQ_CLKB_XD4_XDFFQ_S r0 *1 0,0
Ccc_XD2_XDFFQ_CLKB_XD4_XDFFQ_S XD2_XDFFQ_CLKB XD4_XDFFQ_S 1.8151e-17
* device instance cc_XD2_XDFFQ_CLKB_XD4_XDFFQ_SB r0 *1 0,0
Ccc_XD2_XDFFQ_CLKB_XD4_XDFFQ_SB XD2_XDFFQ_CLKB XD4_XDFFQ_SB 1.8151e-17
* device instance cc_XD2_XDFFQ_CLKB_XD4_XDFFQ_SFB r0 *1 0,0
Ccc_XD2_XDFFQ_CLKB_XD4_XDFFQ_SFB XD2_XDFFQ_CLKB XD4_XDFFQ_SFB 1.21e-17
* device instance cc_XD2_XDFFQ_CLKB_XD4_XN2_mid1 r0 *1 0,0
Ccc_XD2_XDFFQ_CLKB_XD4_XN2_mid1 XD2_XDFFQ_CLKB XD4_XN2_mid1 1.21e-17
* device instance cc_XD2_XDFFQ_CLKB_XD4_XN3_mid1 r0 *1 0,0
Ccc_XD2_XDFFQ_CLKB_XD4_XN3_mid1 XD2_XDFFQ_CLKB XD4_XN3_mid1 1.21e-17
* device instance cc_XD2_XDFFQ_CLKB_XD4_XN3_mid2 r0 *1 0,0
Ccc_XD2_XDFFQ_CLKB_XD4_XN3_mid2 XD2_XDFFQ_CLKB XD4_XN3_mid2 1.21e-17
* device instance cc_XD2_XDFFQ_CLKB_XD4_dmodout r0 *1 0,0
Ccc_XD2_XDFFQ_CLKB_XD4_dmodout XD2_XDFFQ_CLKB XD4_dmodout 1.21e-17
* device instance cc_XD2_XDFFQ_CLKB_XD4_dq r0 *1 0,0
Ccc_XD2_XDFFQ_CLKB_XD4_dq XD2_XDFFQ_CLKB XD4_dq 1.8151e-17
* device instance cc_XD2_XDFFQ_CLKB_XD4_nm r0 *1 0,0
Ccc_XD2_XDFFQ_CLKB_XD4_nm XD2_XDFFQ_CLKB XD4_nm 1.21e-17
* device instance cc_XD2_XDFFQ_CLKB_XD4_nt r0 *1 0,0
Ccc_XD2_XDFFQ_CLKB_XD4_nt XD2_XDFFQ_CLKB XD4_nt 1.21e-17
* device instance cc_XD2_XDFFQ_CLKB_XD4_t1 r0 *1 0,0
Ccc_XD2_XDFFQ_CLKB_XD4_t1 XD2_XDFFQ_CLKB XD4_t1 1.21e-17
* device instance cc_XD2_XDFFQ_CLKB_XD5_XDFFM_CKBB r0 *1 0,0
Ccc_XD2_XDFFQ_CLKB_XD5_XDFFM_CKBB XD2_XDFFQ_CLKB XD5_XDFFM_CKBB 1.8151e-17
* device instance cc_XD2_XDFFQ_CLKB_XD5_XDFFM_CLKB r0 *1 0,0
Ccc_XD2_XDFFQ_CLKB_XD5_XDFFM_CLKB XD2_XDFFQ_CLKB XD5_XDFFM_CLKB 2.4201e-17
* device instance cc_XD2_XDFFQ_CLKB_XD5_XDFFM_M r0 *1 0,0
Ccc_XD2_XDFFQ_CLKB_XD5_XDFFM_M XD2_XDFFQ_CLKB XD5_XDFFM_M 2.4201e-17
* device instance cc_XD2_XDFFQ_CLKB_XD5_XDFFM_MB r0 *1 0,0
Ccc_XD2_XDFFQ_CLKB_XD5_XDFFM_MB XD2_XDFFQ_CLKB XD5_XDFFM_MB 1.21e-17
* device instance cc_XD2_XDFFQ_CLKB_XD5_XDFFM_MFB r0 *1 0,0
Ccc_XD2_XDFFQ_CLKB_XD5_XDFFM_MFB XD2_XDFFQ_CLKB XD5_XDFFM_MFB 1.21e-17
* device instance cc_XD2_XDFFQ_CLKB_XD5_XDFFM_S r0 *1 0,0
Ccc_XD2_XDFFQ_CLKB_XD5_XDFFM_S XD2_XDFFQ_CLKB XD5_XDFFM_S 1.8151e-17
* device instance cc_XD2_XDFFQ_CLKB_XD5_XDFFM_SB r0 *1 0,0
Ccc_XD2_XDFFQ_CLKB_XD5_XDFFM_SB XD2_XDFFQ_CLKB XD5_XDFFM_SB 1.8151e-17
* device instance cc_XD2_XDFFQ_CLKB_XD5_XDFFM_SFB r0 *1 0,0
Ccc_XD2_XDFFQ_CLKB_XD5_XDFFM_SFB XD2_XDFFQ_CLKB XD5_XDFFM_SFB 1.21e-17
* device instance cc_XD2_XDFFQ_CLKB_XD5_XDFFQ_CKBB r0 *1 0,0
Ccc_XD2_XDFFQ_CLKB_XD5_XDFFQ_CKBB XD2_XDFFQ_CLKB XD5_XDFFQ_CKBB 1.8151e-17
* device instance cc_XD2_XDFFQ_CLKB_XD5_XDFFQ_CLKB r0 *1 0,0
Ccc_XD2_XDFFQ_CLKB_XD5_XDFFQ_CLKB XD2_XDFFQ_CLKB XD5_XDFFQ_CLKB 2.4201e-17
* device instance cc_XD2_XDFFQ_CLKB_XD5_XDFFQ_M r0 *1 0,0
Ccc_XD2_XDFFQ_CLKB_XD5_XDFFQ_M XD2_XDFFQ_CLKB XD5_XDFFQ_M 2.4201e-17
* device instance cc_XD2_XDFFQ_CLKB_XD5_XDFFQ_MB r0 *1 0,0
Ccc_XD2_XDFFQ_CLKB_XD5_XDFFQ_MB XD2_XDFFQ_CLKB XD5_XDFFQ_MB 1.21e-17
* device instance cc_XD2_XDFFQ_CLKB_XD5_XDFFQ_MFB r0 *1 0,0
Ccc_XD2_XDFFQ_CLKB_XD5_XDFFQ_MFB XD2_XDFFQ_CLKB XD5_XDFFQ_MFB 1.21e-17
* device instance cc_XD2_XDFFQ_CLKB_XD5_XDFFQ_S r0 *1 0,0
Ccc_XD2_XDFFQ_CLKB_XD5_XDFFQ_S XD2_XDFFQ_CLKB XD5_XDFFQ_S 1.8151e-17
* device instance cc_XD2_XDFFQ_CLKB_XD5_XDFFQ_SB r0 *1 0,0
Ccc_XD2_XDFFQ_CLKB_XD5_XDFFQ_SB XD2_XDFFQ_CLKB XD5_XDFFQ_SB 1.8151e-17
* device instance cc_XD2_XDFFQ_CLKB_XD5_XDFFQ_SFB r0 *1 0,0
Ccc_XD2_XDFFQ_CLKB_XD5_XDFFQ_SFB XD2_XDFFQ_CLKB XD5_XDFFQ_SFB 1.21e-17
* device instance cc_XD2_XDFFQ_CLKB_XD5_XN2_mid1 r0 *1 0,0
Ccc_XD2_XDFFQ_CLKB_XD5_XN2_mid1 XD2_XDFFQ_CLKB XD5_XN2_mid1 1.21e-17
* device instance cc_XD2_XDFFQ_CLKB_XD5_XN3_mid1 r0 *1 0,0
Ccc_XD2_XDFFQ_CLKB_XD5_XN3_mid1 XD2_XDFFQ_CLKB XD5_XN3_mid1 1.21e-17
* device instance cc_XD2_XDFFQ_CLKB_XD5_XN3_mid2 r0 *1 0,0
Ccc_XD2_XDFFQ_CLKB_XD5_XN3_mid2 XD2_XDFFQ_CLKB XD5_XN3_mid2 1.21e-17
* device instance cc_XD2_XDFFQ_CLKB_XD5_dmodout r0 *1 0,0
Ccc_XD2_XDFFQ_CLKB_XD5_dmodout XD2_XDFFQ_CLKB XD5_dmodout 1.21e-17
* device instance cc_XD2_XDFFQ_CLKB_XD5_dq r0 *1 0,0
Ccc_XD2_XDFFQ_CLKB_XD5_dq XD2_XDFFQ_CLKB XD5_dq 1.8151e-17
* device instance cc_XD2_XDFFQ_CLKB_XD5_nm r0 *1 0,0
Ccc_XD2_XDFFQ_CLKB_XD5_nm XD2_XDFFQ_CLKB XD5_nm 1.21e-17
* device instance cc_XD2_XDFFQ_CLKB_XD5_nt r0 *1 0,0
Ccc_XD2_XDFFQ_CLKB_XD5_nt XD2_XDFFQ_CLKB XD5_nt 1.21e-17
* device instance cc_XD2_XDFFQ_CLKB_XD5_t1 r0 *1 0,0
Ccc_XD2_XDFFQ_CLKB_XD5_t1 XD2_XDFFQ_CLKB XD5_t1 1.21e-17
* device instance cc_XD2_XDFFQ_CLKB_XFRT_CKBB r0 *1 0,0
Ccc_XD2_XDFFQ_CLKB_XFRT_CKBB XD2_XDFFQ_CLKB XFRT_CKBB 1.8151e-17
* device instance cc_XD2_XDFFQ_CLKB_XFRT_CLKB r0 *1 0,0
Ccc_XD2_XDFFQ_CLKB_XFRT_CLKB XD2_XDFFQ_CLKB XFRT_CLKB 2.4201e-17
* device instance cc_XD2_XDFFQ_CLKB_XFRT_M r0 *1 0,0
Ccc_XD2_XDFFQ_CLKB_XFRT_M XD2_XDFFQ_CLKB XFRT_M 2.4201e-17
* device instance cc_XD2_XDFFQ_CLKB_XFRT_MB r0 *1 0,0
Ccc_XD2_XDFFQ_CLKB_XFRT_MB XD2_XDFFQ_CLKB XFRT_MB 1.21e-17
* device instance cc_XD2_XDFFQ_CLKB_XFRT_MFB r0 *1 0,0
Ccc_XD2_XDFFQ_CLKB_XFRT_MFB XD2_XDFFQ_CLKB XFRT_MFB 1.21e-17
* device instance cc_XD2_XDFFQ_CLKB_XFRT_S r0 *1 0,0
Ccc_XD2_XDFFQ_CLKB_XFRT_S XD2_XDFFQ_CLKB XFRT_S 1.8151e-17
* device instance cc_XD2_XDFFQ_CLKB_XFRT_SB r0 *1 0,0
Ccc_XD2_XDFFQ_CLKB_XFRT_SB XD2_XDFFQ_CLKB XFRT_SB 1.8151e-17
* device instance cc_XD2_XDFFQ_CLKB_XFRT_SFB r0 *1 0,0
Ccc_XD2_XDFFQ_CLKB_XFRT_SFB XD2_XDFFQ_CLKB XFRT_SFB 1.21e-17
* device instance cc_XD2_XDFFQ_CLKB_ck1 r0 *1 0,0
Ccc_XD2_XDFFQ_CLKB_ck1 XD2_XDFFQ_CLKB ck1 3.0251e-17
* device instance cc_XD2_XDFFQ_CLKB_ck2 r0 *1 0,0
Ccc_XD2_XDFFQ_CLKB_ck2 XD2_XDFFQ_CLKB ck2 3.0251e-17
* device instance cc_XD2_XDFFQ_CLKB_ck3 r0 *1 0,0
Ccc_XD2_XDFFQ_CLKB_ck3 XD2_XDFFQ_CLKB ck3 3.0251e-17
* device instance cc_XD2_XDFFQ_CLKB_ck4 r0 *1 0,0
Ccc_XD2_XDFFQ_CLKB_ck4 XD2_XDFFQ_CLKB ck4 3.0251e-17
* device instance cc_XD2_XDFFQ_CLKB_ck5 r0 *1 0,0
Ccc_XD2_XDFFQ_CLKB_ck5 XD2_XDFFQ_CLKB ck5 3.0251e-17
* device instance cc_XD2_XDFFQ_CLKB_mod0 r0 *1 0,0
Ccc_XD2_XDFFQ_CLKB_mod0 XD2_XDFFQ_CLKB mod0 2.4201e-17
* device instance cc_XD2_XDFFQ_CLKB_mod1 r0 *1 0,0
Ccc_XD2_XDFFQ_CLKB_mod1 XD2_XDFFQ_CLKB mod1 2.4201e-17
* device instance cc_XD2_XDFFQ_CLKB_mod2 r0 *1 0,0
Ccc_XD2_XDFFQ_CLKB_mod2 XD2_XDFFQ_CLKB mod2 2.4201e-17
* device instance cc_XD2_XDFFQ_CLKB_mod3 r0 *1 0,0
Ccc_XD2_XDFFQ_CLKB_mod3 XD2_XDFFQ_CLKB mod3 2.4201e-17
* device instance cc_XD2_XDFFQ_CLKB_mod4 r0 *1 0,0
Ccc_XD2_XDFFQ_CLKB_mod4 XD2_XDFFQ_CLKB mod4 2.4201e-17
* device instance cc_XD2_XDFFQ_CLKB_net1 r0 *1 0,0
Ccc_XD2_XDFFQ_CLKB_net1 XD2_XDFFQ_CLKB net1 1.21e-17
* device instance cc_XD2_XDFFQ_M_XD2_XDFFQ_MB r0 *1 0,0
Ccc_XD2_XDFFQ_M_XD2_XDFFQ_MB XD2_XDFFQ_M XD2_XDFFQ_MB 2.4201e-17
* device instance cc_XD2_XDFFQ_M_XD2_XDFFQ_MFB r0 *1 0,0
Ccc_XD2_XDFFQ_M_XD2_XDFFQ_MFB XD2_XDFFQ_M XD2_XDFFQ_MFB 3.4688e-17
* device instance cc_XD2_XDFFQ_M_XD2_XDFFQ_S r0 *1 0,0
Ccc_XD2_XDFFQ_M_XD2_XDFFQ_S XD2_XDFFQ_M XD2_XDFFQ_S 2.8638e-17
* device instance cc_XD2_XDFFQ_M_XD2_XDFFQ_SB r0 *1 0,0
Ccc_XD2_XDFFQ_M_XD2_XDFFQ_SB XD2_XDFFQ_M XD2_XDFFQ_SB 1.8151e-17
* device instance cc_XD2_XDFFQ_M_XD2_XDFFQ_SFB r0 *1 0,0
Ccc_XD2_XDFFQ_M_XD2_XDFFQ_SFB XD2_XDFFQ_M XD2_XDFFQ_SFB 1.21e-17
* device instance cc_XD2_XDFFQ_M_XD2_XN2_mid1 r0 *1 0,0
Ccc_XD2_XDFFQ_M_XD2_XN2_mid1 XD2_XDFFQ_M XD2_XN2_mid1 1.21e-17
* device instance cc_XD2_XDFFQ_M_XD2_XNOR_midp r0 *1 0,0
Ccc_XD2_XDFFQ_M_XD2_XNOR_midp XD2_XDFFQ_M XD2_XNOR_midp 1.21e-17
* device instance cc_XD2_XDFFQ_M_XD2_dmodout r0 *1 0,0
Ccc_XD2_XDFFQ_M_XD2_dmodout XD2_XDFFQ_M XD2_dmodout 1.21e-17
* device instance cc_XD2_XDFFQ_M_XD2_dq r0 *1 0,0
Ccc_XD2_XDFFQ_M_XD2_dq XD2_XDFFQ_M XD2_dq 2.8638e-17
* device instance cc_XD2_XDFFQ_M_XD2_nm r0 *1 0,0
Ccc_XD2_XDFFQ_M_XD2_nm XD2_XDFFQ_M XD2_nm 1.21e-17
* device instance cc_XD2_XDFFQ_M_XD2_nt r0 *1 0,0
Ccc_XD2_XDFFQ_M_XD2_nt XD2_XDFFQ_M XD2_nt 2.4201e-17
* device instance cc_XD2_XDFFQ_M_XD2_t1 r0 *1 0,0
Ccc_XD2_XDFFQ_M_XD2_t1 XD2_XDFFQ_M XD2_t1 1.21e-17
* device instance cc_XD2_XDFFQ_M_XD3_XDFFM_CKBB r0 *1 0,0
Ccc_XD2_XDFFQ_M_XD3_XDFFM_CKBB XD2_XDFFQ_M XD3_XDFFM_CKBB 1.8151e-17
* device instance cc_XD2_XDFFQ_M_XD3_XDFFM_CLKB r0 *1 0,0
Ccc_XD2_XDFFQ_M_XD3_XDFFM_CLKB XD2_XDFFQ_M XD3_XDFFM_CLKB 2.4201e-17
* device instance cc_XD2_XDFFQ_M_XD3_XDFFM_M r0 *1 0,0
Ccc_XD2_XDFFQ_M_XD3_XDFFM_M XD2_XDFFQ_M XD3_XDFFM_M 2.4201e-17
* device instance cc_XD2_XDFFQ_M_XD3_XDFFM_MB r0 *1 0,0
Ccc_XD2_XDFFQ_M_XD3_XDFFM_MB XD2_XDFFQ_M XD3_XDFFM_MB 1.21e-17
* device instance cc_XD2_XDFFQ_M_XD3_XDFFM_MFB r0 *1 0,0
Ccc_XD2_XDFFQ_M_XD3_XDFFM_MFB XD2_XDFFQ_M XD3_XDFFM_MFB 1.21e-17
* device instance cc_XD2_XDFFQ_M_XD3_XDFFM_S r0 *1 0,0
Ccc_XD2_XDFFQ_M_XD3_XDFFM_S XD2_XDFFQ_M XD3_XDFFM_S 1.8151e-17
* device instance cc_XD2_XDFFQ_M_XD3_XDFFM_SB r0 *1 0,0
Ccc_XD2_XDFFQ_M_XD3_XDFFM_SB XD2_XDFFQ_M XD3_XDFFM_SB 1.8151e-17
* device instance cc_XD2_XDFFQ_M_XD3_XDFFM_SFB r0 *1 0,0
Ccc_XD2_XDFFQ_M_XD3_XDFFM_SFB XD2_XDFFQ_M XD3_XDFFM_SFB 1.21e-17
* device instance cc_XD2_XDFFQ_M_XD3_XDFFQ_CKBB r0 *1 0,0
Ccc_XD2_XDFFQ_M_XD3_XDFFQ_CKBB XD2_XDFFQ_M XD3_XDFFQ_CKBB 1.8151e-17
* device instance cc_XD2_XDFFQ_M_XD3_XDFFQ_CLKB r0 *1 0,0
Ccc_XD2_XDFFQ_M_XD3_XDFFQ_CLKB XD2_XDFFQ_M XD3_XDFFQ_CLKB 2.4201e-17
* device instance cc_XD2_XDFFQ_M_XD3_XDFFQ_M r0 *1 0,0
Ccc_XD2_XDFFQ_M_XD3_XDFFQ_M XD2_XDFFQ_M XD3_XDFFQ_M 2.4201e-17
* device instance cc_XD2_XDFFQ_M_XD3_XDFFQ_MB r0 *1 0,0
Ccc_XD2_XDFFQ_M_XD3_XDFFQ_MB XD2_XDFFQ_M XD3_XDFFQ_MB 1.21e-17
* device instance cc_XD2_XDFFQ_M_XD3_XDFFQ_MFB r0 *1 0,0
Ccc_XD2_XDFFQ_M_XD3_XDFFQ_MFB XD2_XDFFQ_M XD3_XDFFQ_MFB 1.21e-17
* device instance cc_XD2_XDFFQ_M_XD3_XDFFQ_S r0 *1 0,0
Ccc_XD2_XDFFQ_M_XD3_XDFFQ_S XD2_XDFFQ_M XD3_XDFFQ_S 1.8151e-17
* device instance cc_XD2_XDFFQ_M_XD3_XDFFQ_SB r0 *1 0,0
Ccc_XD2_XDFFQ_M_XD3_XDFFQ_SB XD2_XDFFQ_M XD3_XDFFQ_SB 1.8151e-17
* device instance cc_XD2_XDFFQ_M_XD3_XDFFQ_SFB r0 *1 0,0
Ccc_XD2_XDFFQ_M_XD3_XDFFQ_SFB XD2_XDFFQ_M XD3_XDFFQ_SFB 1.21e-17
* device instance cc_XD2_XDFFQ_M_XD3_XN2_mid1 r0 *1 0,0
Ccc_XD2_XDFFQ_M_XD3_XN2_mid1 XD2_XDFFQ_M XD3_XN2_mid1 1.21e-17
* device instance cc_XD2_XDFFQ_M_XD3_XN3_mid1 r0 *1 0,0
Ccc_XD2_XDFFQ_M_XD3_XN3_mid1 XD2_XDFFQ_M XD3_XN3_mid1 1.21e-17
* device instance cc_XD2_XDFFQ_M_XD3_XN3_mid2 r0 *1 0,0
Ccc_XD2_XDFFQ_M_XD3_XN3_mid2 XD2_XDFFQ_M XD3_XN3_mid2 1.21e-17
* device instance cc_XD2_XDFFQ_M_XD3_dmodout r0 *1 0,0
Ccc_XD2_XDFFQ_M_XD3_dmodout XD2_XDFFQ_M XD3_dmodout 1.21e-17
* device instance cc_XD2_XDFFQ_M_XD3_dq r0 *1 0,0
Ccc_XD2_XDFFQ_M_XD3_dq XD2_XDFFQ_M XD3_dq 1.8151e-17
* device instance cc_XD2_XDFFQ_M_XD3_nm r0 *1 0,0
Ccc_XD2_XDFFQ_M_XD3_nm XD2_XDFFQ_M XD3_nm 1.21e-17
* device instance cc_XD2_XDFFQ_M_XD3_nt r0 *1 0,0
Ccc_XD2_XDFFQ_M_XD3_nt XD2_XDFFQ_M XD3_nt 1.21e-17
* device instance cc_XD2_XDFFQ_M_XD3_t1 r0 *1 0,0
Ccc_XD2_XDFFQ_M_XD3_t1 XD2_XDFFQ_M XD3_t1 1.21e-17
* device instance cc_XD2_XDFFQ_M_XD4_XDFFM_CKBB r0 *1 0,0
Ccc_XD2_XDFFQ_M_XD4_XDFFM_CKBB XD2_XDFFQ_M XD4_XDFFM_CKBB 1.8151e-17
* device instance cc_XD2_XDFFQ_M_XD4_XDFFM_CLKB r0 *1 0,0
Ccc_XD2_XDFFQ_M_XD4_XDFFM_CLKB XD2_XDFFQ_M XD4_XDFFM_CLKB 2.4201e-17
* device instance cc_XD2_XDFFQ_M_XD4_XDFFM_M r0 *1 0,0
Ccc_XD2_XDFFQ_M_XD4_XDFFM_M XD2_XDFFQ_M XD4_XDFFM_M 2.4201e-17
* device instance cc_XD2_XDFFQ_M_XD4_XDFFM_MB r0 *1 0,0
Ccc_XD2_XDFFQ_M_XD4_XDFFM_MB XD2_XDFFQ_M XD4_XDFFM_MB 1.21e-17
* device instance cc_XD2_XDFFQ_M_XD4_XDFFM_MFB r0 *1 0,0
Ccc_XD2_XDFFQ_M_XD4_XDFFM_MFB XD2_XDFFQ_M XD4_XDFFM_MFB 1.21e-17
* device instance cc_XD2_XDFFQ_M_XD4_XDFFM_S r0 *1 0,0
Ccc_XD2_XDFFQ_M_XD4_XDFFM_S XD2_XDFFQ_M XD4_XDFFM_S 1.8151e-17
* device instance cc_XD2_XDFFQ_M_XD4_XDFFM_SB r0 *1 0,0
Ccc_XD2_XDFFQ_M_XD4_XDFFM_SB XD2_XDFFQ_M XD4_XDFFM_SB 1.8151e-17
* device instance cc_XD2_XDFFQ_M_XD4_XDFFM_SFB r0 *1 0,0
Ccc_XD2_XDFFQ_M_XD4_XDFFM_SFB XD2_XDFFQ_M XD4_XDFFM_SFB 1.21e-17
* device instance cc_XD2_XDFFQ_M_XD4_XDFFQ_CKBB r0 *1 0,0
Ccc_XD2_XDFFQ_M_XD4_XDFFQ_CKBB XD2_XDFFQ_M XD4_XDFFQ_CKBB 1.8151e-17
* device instance cc_XD2_XDFFQ_M_XD4_XDFFQ_CLKB r0 *1 0,0
Ccc_XD2_XDFFQ_M_XD4_XDFFQ_CLKB XD2_XDFFQ_M XD4_XDFFQ_CLKB 2.4201e-17
* device instance cc_XD2_XDFFQ_M_XD4_XDFFQ_M r0 *1 0,0
Ccc_XD2_XDFFQ_M_XD4_XDFFQ_M XD2_XDFFQ_M XD4_XDFFQ_M 2.4201e-17
* device instance cc_XD2_XDFFQ_M_XD4_XDFFQ_MB r0 *1 0,0
Ccc_XD2_XDFFQ_M_XD4_XDFFQ_MB XD2_XDFFQ_M XD4_XDFFQ_MB 1.21e-17
* device instance cc_XD2_XDFFQ_M_XD4_XDFFQ_MFB r0 *1 0,0
Ccc_XD2_XDFFQ_M_XD4_XDFFQ_MFB XD2_XDFFQ_M XD4_XDFFQ_MFB 1.21e-17
* device instance cc_XD2_XDFFQ_M_XD4_XDFFQ_S r0 *1 0,0
Ccc_XD2_XDFFQ_M_XD4_XDFFQ_S XD2_XDFFQ_M XD4_XDFFQ_S 1.8151e-17
* device instance cc_XD2_XDFFQ_M_XD4_XDFFQ_SB r0 *1 0,0
Ccc_XD2_XDFFQ_M_XD4_XDFFQ_SB XD2_XDFFQ_M XD4_XDFFQ_SB 1.8151e-17
* device instance cc_XD2_XDFFQ_M_XD4_XDFFQ_SFB r0 *1 0,0
Ccc_XD2_XDFFQ_M_XD4_XDFFQ_SFB XD2_XDFFQ_M XD4_XDFFQ_SFB 1.21e-17
* device instance cc_XD2_XDFFQ_M_XD4_XN2_mid1 r0 *1 0,0
Ccc_XD2_XDFFQ_M_XD4_XN2_mid1 XD2_XDFFQ_M XD4_XN2_mid1 1.21e-17
* device instance cc_XD2_XDFFQ_M_XD4_XN3_mid1 r0 *1 0,0
Ccc_XD2_XDFFQ_M_XD4_XN3_mid1 XD2_XDFFQ_M XD4_XN3_mid1 1.21e-17
* device instance cc_XD2_XDFFQ_M_XD4_XN3_mid2 r0 *1 0,0
Ccc_XD2_XDFFQ_M_XD4_XN3_mid2 XD2_XDFFQ_M XD4_XN3_mid2 1.21e-17
* device instance cc_XD2_XDFFQ_M_XD4_dmodout r0 *1 0,0
Ccc_XD2_XDFFQ_M_XD4_dmodout XD2_XDFFQ_M XD4_dmodout 1.21e-17
* device instance cc_XD2_XDFFQ_M_XD4_dq r0 *1 0,0
Ccc_XD2_XDFFQ_M_XD4_dq XD2_XDFFQ_M XD4_dq 1.8151e-17
* device instance cc_XD2_XDFFQ_M_XD4_nm r0 *1 0,0
Ccc_XD2_XDFFQ_M_XD4_nm XD2_XDFFQ_M XD4_nm 1.21e-17
* device instance cc_XD2_XDFFQ_M_XD4_nt r0 *1 0,0
Ccc_XD2_XDFFQ_M_XD4_nt XD2_XDFFQ_M XD4_nt 1.21e-17
* device instance cc_XD2_XDFFQ_M_XD4_t1 r0 *1 0,0
Ccc_XD2_XDFFQ_M_XD4_t1 XD2_XDFFQ_M XD4_t1 1.21e-17
* device instance cc_XD2_XDFFQ_M_XD5_XDFFM_CKBB r0 *1 0,0
Ccc_XD2_XDFFQ_M_XD5_XDFFM_CKBB XD2_XDFFQ_M XD5_XDFFM_CKBB 1.8151e-17
* device instance cc_XD2_XDFFQ_M_XD5_XDFFM_CLKB r0 *1 0,0
Ccc_XD2_XDFFQ_M_XD5_XDFFM_CLKB XD2_XDFFQ_M XD5_XDFFM_CLKB 2.4201e-17
* device instance cc_XD2_XDFFQ_M_XD5_XDFFM_M r0 *1 0,0
Ccc_XD2_XDFFQ_M_XD5_XDFFM_M XD2_XDFFQ_M XD5_XDFFM_M 2.4201e-17
* device instance cc_XD2_XDFFQ_M_XD5_XDFFM_MB r0 *1 0,0
Ccc_XD2_XDFFQ_M_XD5_XDFFM_MB XD2_XDFFQ_M XD5_XDFFM_MB 1.21e-17
* device instance cc_XD2_XDFFQ_M_XD5_XDFFM_MFB r0 *1 0,0
Ccc_XD2_XDFFQ_M_XD5_XDFFM_MFB XD2_XDFFQ_M XD5_XDFFM_MFB 1.21e-17
* device instance cc_XD2_XDFFQ_M_XD5_XDFFM_S r0 *1 0,0
Ccc_XD2_XDFFQ_M_XD5_XDFFM_S XD2_XDFFQ_M XD5_XDFFM_S 1.8151e-17
* device instance cc_XD2_XDFFQ_M_XD5_XDFFM_SB r0 *1 0,0
Ccc_XD2_XDFFQ_M_XD5_XDFFM_SB XD2_XDFFQ_M XD5_XDFFM_SB 1.8151e-17
* device instance cc_XD2_XDFFQ_M_XD5_XDFFM_SFB r0 *1 0,0
Ccc_XD2_XDFFQ_M_XD5_XDFFM_SFB XD2_XDFFQ_M XD5_XDFFM_SFB 1.21e-17
* device instance cc_XD2_XDFFQ_M_XD5_XDFFQ_CKBB r0 *1 0,0
Ccc_XD2_XDFFQ_M_XD5_XDFFQ_CKBB XD2_XDFFQ_M XD5_XDFFQ_CKBB 1.8151e-17
* device instance cc_XD2_XDFFQ_M_XD5_XDFFQ_CLKB r0 *1 0,0
Ccc_XD2_XDFFQ_M_XD5_XDFFQ_CLKB XD2_XDFFQ_M XD5_XDFFQ_CLKB 2.4201e-17
* device instance cc_XD2_XDFFQ_M_XD5_XDFFQ_M r0 *1 0,0
Ccc_XD2_XDFFQ_M_XD5_XDFFQ_M XD2_XDFFQ_M XD5_XDFFQ_M 2.4201e-17
* device instance cc_XD2_XDFFQ_M_XD5_XDFFQ_MB r0 *1 0,0
Ccc_XD2_XDFFQ_M_XD5_XDFFQ_MB XD2_XDFFQ_M XD5_XDFFQ_MB 1.21e-17
* device instance cc_XD2_XDFFQ_M_XD5_XDFFQ_MFB r0 *1 0,0
Ccc_XD2_XDFFQ_M_XD5_XDFFQ_MFB XD2_XDFFQ_M XD5_XDFFQ_MFB 1.21e-17
* device instance cc_XD2_XDFFQ_M_XD5_XDFFQ_S r0 *1 0,0
Ccc_XD2_XDFFQ_M_XD5_XDFFQ_S XD2_XDFFQ_M XD5_XDFFQ_S 1.8151e-17
* device instance cc_XD2_XDFFQ_M_XD5_XDFFQ_SB r0 *1 0,0
Ccc_XD2_XDFFQ_M_XD5_XDFFQ_SB XD2_XDFFQ_M XD5_XDFFQ_SB 1.8151e-17
* device instance cc_XD2_XDFFQ_M_XD5_XDFFQ_SFB r0 *1 0,0
Ccc_XD2_XDFFQ_M_XD5_XDFFQ_SFB XD2_XDFFQ_M XD5_XDFFQ_SFB 1.21e-17
* device instance cc_XD2_XDFFQ_M_XD5_XN2_mid1 r0 *1 0,0
Ccc_XD2_XDFFQ_M_XD5_XN2_mid1 XD2_XDFFQ_M XD5_XN2_mid1 1.21e-17
* device instance cc_XD2_XDFFQ_M_XD5_XN3_mid1 r0 *1 0,0
Ccc_XD2_XDFFQ_M_XD5_XN3_mid1 XD2_XDFFQ_M XD5_XN3_mid1 1.21e-17
* device instance cc_XD2_XDFFQ_M_XD5_XN3_mid2 r0 *1 0,0
Ccc_XD2_XDFFQ_M_XD5_XN3_mid2 XD2_XDFFQ_M XD5_XN3_mid2 1.21e-17
* device instance cc_XD2_XDFFQ_M_XD5_dmodout r0 *1 0,0
Ccc_XD2_XDFFQ_M_XD5_dmodout XD2_XDFFQ_M XD5_dmodout 1.21e-17
* device instance cc_XD2_XDFFQ_M_XD5_dq r0 *1 0,0
Ccc_XD2_XDFFQ_M_XD5_dq XD2_XDFFQ_M XD5_dq 1.8151e-17
* device instance cc_XD2_XDFFQ_M_XD5_nm r0 *1 0,0
Ccc_XD2_XDFFQ_M_XD5_nm XD2_XDFFQ_M XD5_nm 1.21e-17
* device instance cc_XD2_XDFFQ_M_XD5_nt r0 *1 0,0
Ccc_XD2_XDFFQ_M_XD5_nt XD2_XDFFQ_M XD5_nt 1.21e-17
* device instance cc_XD2_XDFFQ_M_XD5_t1 r0 *1 0,0
Ccc_XD2_XDFFQ_M_XD5_t1 XD2_XDFFQ_M XD5_t1 1.21e-17
* device instance cc_XD2_XDFFQ_M_XFRT_CKBB r0 *1 0,0
Ccc_XD2_XDFFQ_M_XFRT_CKBB XD2_XDFFQ_M XFRT_CKBB 1.8151e-17
* device instance cc_XD2_XDFFQ_M_XFRT_CLKB r0 *1 0,0
Ccc_XD2_XDFFQ_M_XFRT_CLKB XD2_XDFFQ_M XFRT_CLKB 2.4201e-17
* device instance cc_XD2_XDFFQ_M_XFRT_M r0 *1 0,0
Ccc_XD2_XDFFQ_M_XFRT_M XD2_XDFFQ_M XFRT_M 2.4201e-17
* device instance cc_XD2_XDFFQ_M_XFRT_MB r0 *1 0,0
Ccc_XD2_XDFFQ_M_XFRT_MB XD2_XDFFQ_M XFRT_MB 1.21e-17
* device instance cc_XD2_XDFFQ_M_XFRT_MFB r0 *1 0,0
Ccc_XD2_XDFFQ_M_XFRT_MFB XD2_XDFFQ_M XFRT_MFB 1.21e-17
* device instance cc_XD2_XDFFQ_M_XFRT_S r0 *1 0,0
Ccc_XD2_XDFFQ_M_XFRT_S XD2_XDFFQ_M XFRT_S 1.8151e-17
* device instance cc_XD2_XDFFQ_M_XFRT_SB r0 *1 0,0
Ccc_XD2_XDFFQ_M_XFRT_SB XD2_XDFFQ_M XFRT_SB 1.8151e-17
* device instance cc_XD2_XDFFQ_M_XFRT_SFB r0 *1 0,0
Ccc_XD2_XDFFQ_M_XFRT_SFB XD2_XDFFQ_M XFRT_SFB 1.21e-17
* device instance cc_XD2_XDFFQ_M_ck1 r0 *1 0,0
Ccc_XD2_XDFFQ_M_ck1 XD2_XDFFQ_M ck1 3.0251e-17
* device instance cc_XD2_XDFFQ_M_ck2 r0 *1 0,0
Ccc_XD2_XDFFQ_M_ck2 XD2_XDFFQ_M ck2 3.0251e-17
* device instance cc_XD2_XDFFQ_M_ck3 r0 *1 0,0
Ccc_XD2_XDFFQ_M_ck3 XD2_XDFFQ_M ck3 3.0251e-17
* device instance cc_XD2_XDFFQ_M_ck4 r0 *1 0,0
Ccc_XD2_XDFFQ_M_ck4 XD2_XDFFQ_M ck4 3.0251e-17
* device instance cc_XD2_XDFFQ_M_ck5 r0 *1 0,0
Ccc_XD2_XDFFQ_M_ck5 XD2_XDFFQ_M ck5 3.0251e-17
* device instance cc_XD2_XDFFQ_M_mod0 r0 *1 0,0
Ccc_XD2_XDFFQ_M_mod0 XD2_XDFFQ_M mod0 2.4201e-17
* device instance cc_XD2_XDFFQ_M_mod1 r0 *1 0,0
Ccc_XD2_XDFFQ_M_mod1 XD2_XDFFQ_M mod1 2.4201e-17
* device instance cc_XD2_XDFFQ_M_mod2 r0 *1 0,0
Ccc_XD2_XDFFQ_M_mod2 XD2_XDFFQ_M mod2 2.4201e-17
* device instance cc_XD2_XDFFQ_M_mod3 r0 *1 0,0
Ccc_XD2_XDFFQ_M_mod3 XD2_XDFFQ_M mod3 2.4201e-17
* device instance cc_XD2_XDFFQ_M_mod4 r0 *1 0,0
Ccc_XD2_XDFFQ_M_mod4 XD2_XDFFQ_M mod4 2.4201e-17
* device instance cc_XD2_XDFFQ_M_net1 r0 *1 0,0
Ccc_XD2_XDFFQ_M_net1 XD2_XDFFQ_M net1 1.21e-17
* device instance cc_XD2_XDFFQ_MB_XD2_XDFFQ_MFB r0 *1 0,0
Ccc_XD2_XDFFQ_MB_XD2_XDFFQ_MFB XD2_XDFFQ_MB XD2_XDFFQ_MFB 1.21e-17
* device instance cc_XD2_XDFFQ_MB_XD2_XDFFQ_S r0 *1 0,0
Ccc_XD2_XDFFQ_MB_XD2_XDFFQ_S XD2_XDFFQ_MB XD2_XDFFQ_S 1.8151e-17
* device instance cc_XD2_XDFFQ_MB_XD2_XDFFQ_SB r0 *1 0,0
Ccc_XD2_XDFFQ_MB_XD2_XDFFQ_SB XD2_XDFFQ_MB XD2_XDFFQ_SB 1.8151e-17
* device instance cc_XD2_XDFFQ_MB_XD2_XDFFQ_SFB r0 *1 0,0
Ccc_XD2_XDFFQ_MB_XD2_XDFFQ_SFB XD2_XDFFQ_MB XD2_XDFFQ_SFB 1.21e-17
* device instance cc_XD2_XDFFQ_MB_XD2_XN2_mid1 r0 *1 0,0
Ccc_XD2_XDFFQ_MB_XD2_XN2_mid1 XD2_XDFFQ_MB XD2_XN2_mid1 1.21e-17
* device instance cc_XD2_XDFFQ_MB_XD2_XNOR_midp r0 *1 0,0
Ccc_XD2_XDFFQ_MB_XD2_XNOR_midp XD2_XDFFQ_MB XD2_XNOR_midp 1.21e-17
* device instance cc_XD2_XDFFQ_MB_XD2_dmodout r0 *1 0,0
Ccc_XD2_XDFFQ_MB_XD2_dmodout XD2_XDFFQ_MB XD2_dmodout 1.21e-17
* device instance cc_XD2_XDFFQ_MB_XD2_dq r0 *1 0,0
Ccc_XD2_XDFFQ_MB_XD2_dq XD2_XDFFQ_MB XD2_dq 1.21e-17
* device instance cc_XD2_XDFFQ_MB_XD2_nm r0 *1 0,0
Ccc_XD2_XDFFQ_MB_XD2_nm XD2_XDFFQ_MB XD2_nm 1.21e-17
* device instance cc_XD2_XDFFQ_MB_XD2_nt r0 *1 0,0
Ccc_XD2_XDFFQ_MB_XD2_nt XD2_XDFFQ_MB XD2_nt 2.4201e-17
* device instance cc_XD2_XDFFQ_MB_XD2_t1 r0 *1 0,0
Ccc_XD2_XDFFQ_MB_XD2_t1 XD2_XDFFQ_MB XD2_t1 1.21e-17
* device instance cc_XD2_XDFFQ_MB_XD3_XDFFM_CKBB r0 *1 0,0
Ccc_XD2_XDFFQ_MB_XD3_XDFFM_CKBB XD2_XDFFQ_MB XD3_XDFFM_CKBB 1.8151e-17
* device instance cc_XD2_XDFFQ_MB_XD3_XDFFM_CLKB r0 *1 0,0
Ccc_XD2_XDFFQ_MB_XD3_XDFFM_CLKB XD2_XDFFQ_MB XD3_XDFFM_CLKB 2.4201e-17
* device instance cc_XD2_XDFFQ_MB_XD3_XDFFM_M r0 *1 0,0
Ccc_XD2_XDFFQ_MB_XD3_XDFFM_M XD2_XDFFQ_MB XD3_XDFFM_M 2.4201e-17
* device instance cc_XD2_XDFFQ_MB_XD3_XDFFM_MB r0 *1 0,0
Ccc_XD2_XDFFQ_MB_XD3_XDFFM_MB XD2_XDFFQ_MB XD3_XDFFM_MB 1.21e-17
* device instance cc_XD2_XDFFQ_MB_XD3_XDFFM_MFB r0 *1 0,0
Ccc_XD2_XDFFQ_MB_XD3_XDFFM_MFB XD2_XDFFQ_MB XD3_XDFFM_MFB 1.21e-17
* device instance cc_XD2_XDFFQ_MB_XD3_XDFFM_S r0 *1 0,0
Ccc_XD2_XDFFQ_MB_XD3_XDFFM_S XD2_XDFFQ_MB XD3_XDFFM_S 1.8151e-17
* device instance cc_XD2_XDFFQ_MB_XD3_XDFFM_SB r0 *1 0,0
Ccc_XD2_XDFFQ_MB_XD3_XDFFM_SB XD2_XDFFQ_MB XD3_XDFFM_SB 1.8151e-17
* device instance cc_XD2_XDFFQ_MB_XD3_XDFFM_SFB r0 *1 0,0
Ccc_XD2_XDFFQ_MB_XD3_XDFFM_SFB XD2_XDFFQ_MB XD3_XDFFM_SFB 1.21e-17
* device instance cc_XD2_XDFFQ_MB_XD3_XDFFQ_CKBB r0 *1 0,0
Ccc_XD2_XDFFQ_MB_XD3_XDFFQ_CKBB XD2_XDFFQ_MB XD3_XDFFQ_CKBB 1.8151e-17
* device instance cc_XD2_XDFFQ_MB_XD3_XDFFQ_CLKB r0 *1 0,0
Ccc_XD2_XDFFQ_MB_XD3_XDFFQ_CLKB XD2_XDFFQ_MB XD3_XDFFQ_CLKB 2.4201e-17
* device instance cc_XD2_XDFFQ_MB_XD3_XDFFQ_M r0 *1 0,0
Ccc_XD2_XDFFQ_MB_XD3_XDFFQ_M XD2_XDFFQ_MB XD3_XDFFQ_M 2.4201e-17
* device instance cc_XD2_XDFFQ_MB_XD3_XDFFQ_MB r0 *1 0,0
Ccc_XD2_XDFFQ_MB_XD3_XDFFQ_MB XD2_XDFFQ_MB XD3_XDFFQ_MB 1.21e-17
* device instance cc_XD2_XDFFQ_MB_XD3_XDFFQ_MFB r0 *1 0,0
Ccc_XD2_XDFFQ_MB_XD3_XDFFQ_MFB XD2_XDFFQ_MB XD3_XDFFQ_MFB 1.21e-17
* device instance cc_XD2_XDFFQ_MB_XD3_XDFFQ_S r0 *1 0,0
Ccc_XD2_XDFFQ_MB_XD3_XDFFQ_S XD2_XDFFQ_MB XD3_XDFFQ_S 1.8151e-17
* device instance cc_XD2_XDFFQ_MB_XD3_XDFFQ_SB r0 *1 0,0
Ccc_XD2_XDFFQ_MB_XD3_XDFFQ_SB XD2_XDFFQ_MB XD3_XDFFQ_SB 1.8151e-17
* device instance cc_XD2_XDFFQ_MB_XD3_XDFFQ_SFB r0 *1 0,0
Ccc_XD2_XDFFQ_MB_XD3_XDFFQ_SFB XD2_XDFFQ_MB XD3_XDFFQ_SFB 1.21e-17
* device instance cc_XD2_XDFFQ_MB_XD3_XN2_mid1 r0 *1 0,0
Ccc_XD2_XDFFQ_MB_XD3_XN2_mid1 XD2_XDFFQ_MB XD3_XN2_mid1 1.21e-17
* device instance cc_XD2_XDFFQ_MB_XD3_XN3_mid1 r0 *1 0,0
Ccc_XD2_XDFFQ_MB_XD3_XN3_mid1 XD2_XDFFQ_MB XD3_XN3_mid1 1.21e-17
* device instance cc_XD2_XDFFQ_MB_XD3_XN3_mid2 r0 *1 0,0
Ccc_XD2_XDFFQ_MB_XD3_XN3_mid2 XD2_XDFFQ_MB XD3_XN3_mid2 1.21e-17
* device instance cc_XD2_XDFFQ_MB_XD3_dmodout r0 *1 0,0
Ccc_XD2_XDFFQ_MB_XD3_dmodout XD2_XDFFQ_MB XD3_dmodout 1.21e-17
* device instance cc_XD2_XDFFQ_MB_XD3_dq r0 *1 0,0
Ccc_XD2_XDFFQ_MB_XD3_dq XD2_XDFFQ_MB XD3_dq 1.8151e-17
* device instance cc_XD2_XDFFQ_MB_XD3_nm r0 *1 0,0
Ccc_XD2_XDFFQ_MB_XD3_nm XD2_XDFFQ_MB XD3_nm 1.21e-17
* device instance cc_XD2_XDFFQ_MB_XD3_nt r0 *1 0,0
Ccc_XD2_XDFFQ_MB_XD3_nt XD2_XDFFQ_MB XD3_nt 1.21e-17
* device instance cc_XD2_XDFFQ_MB_XD3_t1 r0 *1 0,0
Ccc_XD2_XDFFQ_MB_XD3_t1 XD2_XDFFQ_MB XD3_t1 1.21e-17
* device instance cc_XD2_XDFFQ_MB_XD4_XDFFM_CKBB r0 *1 0,0
Ccc_XD2_XDFFQ_MB_XD4_XDFFM_CKBB XD2_XDFFQ_MB XD4_XDFFM_CKBB 1.8151e-17
* device instance cc_XD2_XDFFQ_MB_XD4_XDFFM_CLKB r0 *1 0,0
Ccc_XD2_XDFFQ_MB_XD4_XDFFM_CLKB XD2_XDFFQ_MB XD4_XDFFM_CLKB 2.4201e-17
* device instance cc_XD2_XDFFQ_MB_XD4_XDFFM_M r0 *1 0,0
Ccc_XD2_XDFFQ_MB_XD4_XDFFM_M XD2_XDFFQ_MB XD4_XDFFM_M 2.4201e-17
* device instance cc_XD2_XDFFQ_MB_XD4_XDFFM_MB r0 *1 0,0
Ccc_XD2_XDFFQ_MB_XD4_XDFFM_MB XD2_XDFFQ_MB XD4_XDFFM_MB 1.21e-17
* device instance cc_XD2_XDFFQ_MB_XD4_XDFFM_MFB r0 *1 0,0
Ccc_XD2_XDFFQ_MB_XD4_XDFFM_MFB XD2_XDFFQ_MB XD4_XDFFM_MFB 1.21e-17
* device instance cc_XD2_XDFFQ_MB_XD4_XDFFM_S r0 *1 0,0
Ccc_XD2_XDFFQ_MB_XD4_XDFFM_S XD2_XDFFQ_MB XD4_XDFFM_S 1.8151e-17
* device instance cc_XD2_XDFFQ_MB_XD4_XDFFM_SB r0 *1 0,0
Ccc_XD2_XDFFQ_MB_XD4_XDFFM_SB XD2_XDFFQ_MB XD4_XDFFM_SB 1.8151e-17
* device instance cc_XD2_XDFFQ_MB_XD4_XDFFM_SFB r0 *1 0,0
Ccc_XD2_XDFFQ_MB_XD4_XDFFM_SFB XD2_XDFFQ_MB XD4_XDFFM_SFB 1.21e-17
* device instance cc_XD2_XDFFQ_MB_XD4_XDFFQ_CKBB r0 *1 0,0
Ccc_XD2_XDFFQ_MB_XD4_XDFFQ_CKBB XD2_XDFFQ_MB XD4_XDFFQ_CKBB 1.8151e-17
* device instance cc_XD2_XDFFQ_MB_XD4_XDFFQ_CLKB r0 *1 0,0
Ccc_XD2_XDFFQ_MB_XD4_XDFFQ_CLKB XD2_XDFFQ_MB XD4_XDFFQ_CLKB 2.4201e-17
* device instance cc_XD2_XDFFQ_MB_XD4_XDFFQ_M r0 *1 0,0
Ccc_XD2_XDFFQ_MB_XD4_XDFFQ_M XD2_XDFFQ_MB XD4_XDFFQ_M 2.4201e-17
* device instance cc_XD2_XDFFQ_MB_XD4_XDFFQ_MB r0 *1 0,0
Ccc_XD2_XDFFQ_MB_XD4_XDFFQ_MB XD2_XDFFQ_MB XD4_XDFFQ_MB 1.21e-17
* device instance cc_XD2_XDFFQ_MB_XD4_XDFFQ_MFB r0 *1 0,0
Ccc_XD2_XDFFQ_MB_XD4_XDFFQ_MFB XD2_XDFFQ_MB XD4_XDFFQ_MFB 1.21e-17
* device instance cc_XD2_XDFFQ_MB_XD4_XDFFQ_S r0 *1 0,0
Ccc_XD2_XDFFQ_MB_XD4_XDFFQ_S XD2_XDFFQ_MB XD4_XDFFQ_S 1.8151e-17
* device instance cc_XD2_XDFFQ_MB_XD4_XDFFQ_SB r0 *1 0,0
Ccc_XD2_XDFFQ_MB_XD4_XDFFQ_SB XD2_XDFFQ_MB XD4_XDFFQ_SB 1.8151e-17
* device instance cc_XD2_XDFFQ_MB_XD4_XDFFQ_SFB r0 *1 0,0
Ccc_XD2_XDFFQ_MB_XD4_XDFFQ_SFB XD2_XDFFQ_MB XD4_XDFFQ_SFB 1.21e-17
* device instance cc_XD2_XDFFQ_MB_XD4_XN2_mid1 r0 *1 0,0
Ccc_XD2_XDFFQ_MB_XD4_XN2_mid1 XD2_XDFFQ_MB XD4_XN2_mid1 1.21e-17
* device instance cc_XD2_XDFFQ_MB_XD4_XN3_mid1 r0 *1 0,0
Ccc_XD2_XDFFQ_MB_XD4_XN3_mid1 XD2_XDFFQ_MB XD4_XN3_mid1 1.21e-17
* device instance cc_XD2_XDFFQ_MB_XD4_XN3_mid2 r0 *1 0,0
Ccc_XD2_XDFFQ_MB_XD4_XN3_mid2 XD2_XDFFQ_MB XD4_XN3_mid2 1.21e-17
* device instance cc_XD2_XDFFQ_MB_XD4_dmodout r0 *1 0,0
Ccc_XD2_XDFFQ_MB_XD4_dmodout XD2_XDFFQ_MB XD4_dmodout 1.21e-17
* device instance cc_XD2_XDFFQ_MB_XD4_dq r0 *1 0,0
Ccc_XD2_XDFFQ_MB_XD4_dq XD2_XDFFQ_MB XD4_dq 1.8151e-17
* device instance cc_XD2_XDFFQ_MB_XD4_nm r0 *1 0,0
Ccc_XD2_XDFFQ_MB_XD4_nm XD2_XDFFQ_MB XD4_nm 1.21e-17
* device instance cc_XD2_XDFFQ_MB_XD4_nt r0 *1 0,0
Ccc_XD2_XDFFQ_MB_XD4_nt XD2_XDFFQ_MB XD4_nt 1.21e-17
* device instance cc_XD2_XDFFQ_MB_XD4_t1 r0 *1 0,0
Ccc_XD2_XDFFQ_MB_XD4_t1 XD2_XDFFQ_MB XD4_t1 1.21e-17
* device instance cc_XD2_XDFFQ_MB_XD5_XDFFM_CKBB r0 *1 0,0
Ccc_XD2_XDFFQ_MB_XD5_XDFFM_CKBB XD2_XDFFQ_MB XD5_XDFFM_CKBB 1.8151e-17
* device instance cc_XD2_XDFFQ_MB_XD5_XDFFM_CLKB r0 *1 0,0
Ccc_XD2_XDFFQ_MB_XD5_XDFFM_CLKB XD2_XDFFQ_MB XD5_XDFFM_CLKB 2.4201e-17
* device instance cc_XD2_XDFFQ_MB_XD5_XDFFM_M r0 *1 0,0
Ccc_XD2_XDFFQ_MB_XD5_XDFFM_M XD2_XDFFQ_MB XD5_XDFFM_M 2.4201e-17
* device instance cc_XD2_XDFFQ_MB_XD5_XDFFM_MB r0 *1 0,0
Ccc_XD2_XDFFQ_MB_XD5_XDFFM_MB XD2_XDFFQ_MB XD5_XDFFM_MB 1.21e-17
* device instance cc_XD2_XDFFQ_MB_XD5_XDFFM_MFB r0 *1 0,0
Ccc_XD2_XDFFQ_MB_XD5_XDFFM_MFB XD2_XDFFQ_MB XD5_XDFFM_MFB 1.21e-17
* device instance cc_XD2_XDFFQ_MB_XD5_XDFFM_S r0 *1 0,0
Ccc_XD2_XDFFQ_MB_XD5_XDFFM_S XD2_XDFFQ_MB XD5_XDFFM_S 1.8151e-17
* device instance cc_XD2_XDFFQ_MB_XD5_XDFFM_SB r0 *1 0,0
Ccc_XD2_XDFFQ_MB_XD5_XDFFM_SB XD2_XDFFQ_MB XD5_XDFFM_SB 1.8151e-17
* device instance cc_XD2_XDFFQ_MB_XD5_XDFFM_SFB r0 *1 0,0
Ccc_XD2_XDFFQ_MB_XD5_XDFFM_SFB XD2_XDFFQ_MB XD5_XDFFM_SFB 1.21e-17
* device instance cc_XD2_XDFFQ_MB_XD5_XDFFQ_CKBB r0 *1 0,0
Ccc_XD2_XDFFQ_MB_XD5_XDFFQ_CKBB XD2_XDFFQ_MB XD5_XDFFQ_CKBB 1.8151e-17
* device instance cc_XD2_XDFFQ_MB_XD5_XDFFQ_CLKB r0 *1 0,0
Ccc_XD2_XDFFQ_MB_XD5_XDFFQ_CLKB XD2_XDFFQ_MB XD5_XDFFQ_CLKB 2.4201e-17
* device instance cc_XD2_XDFFQ_MB_XD5_XDFFQ_M r0 *1 0,0
Ccc_XD2_XDFFQ_MB_XD5_XDFFQ_M XD2_XDFFQ_MB XD5_XDFFQ_M 2.4201e-17
* device instance cc_XD2_XDFFQ_MB_XD5_XDFFQ_MB r0 *1 0,0
Ccc_XD2_XDFFQ_MB_XD5_XDFFQ_MB XD2_XDFFQ_MB XD5_XDFFQ_MB 1.21e-17
* device instance cc_XD2_XDFFQ_MB_XD5_XDFFQ_MFB r0 *1 0,0
Ccc_XD2_XDFFQ_MB_XD5_XDFFQ_MFB XD2_XDFFQ_MB XD5_XDFFQ_MFB 1.21e-17
* device instance cc_XD2_XDFFQ_MB_XD5_XDFFQ_S r0 *1 0,0
Ccc_XD2_XDFFQ_MB_XD5_XDFFQ_S XD2_XDFFQ_MB XD5_XDFFQ_S 1.8151e-17
* device instance cc_XD2_XDFFQ_MB_XD5_XDFFQ_SB r0 *1 0,0
Ccc_XD2_XDFFQ_MB_XD5_XDFFQ_SB XD2_XDFFQ_MB XD5_XDFFQ_SB 1.8151e-17
* device instance cc_XD2_XDFFQ_MB_XD5_XDFFQ_SFB r0 *1 0,0
Ccc_XD2_XDFFQ_MB_XD5_XDFFQ_SFB XD2_XDFFQ_MB XD5_XDFFQ_SFB 1.21e-17
* device instance cc_XD2_XDFFQ_MB_XD5_XN2_mid1 r0 *1 0,0
Ccc_XD2_XDFFQ_MB_XD5_XN2_mid1 XD2_XDFFQ_MB XD5_XN2_mid1 1.21e-17
* device instance cc_XD2_XDFFQ_MB_XD5_XN3_mid1 r0 *1 0,0
Ccc_XD2_XDFFQ_MB_XD5_XN3_mid1 XD2_XDFFQ_MB XD5_XN3_mid1 1.21e-17
* device instance cc_XD2_XDFFQ_MB_XD5_XN3_mid2 r0 *1 0,0
Ccc_XD2_XDFFQ_MB_XD5_XN3_mid2 XD2_XDFFQ_MB XD5_XN3_mid2 1.21e-17
* device instance cc_XD2_XDFFQ_MB_XD5_dmodout r0 *1 0,0
Ccc_XD2_XDFFQ_MB_XD5_dmodout XD2_XDFFQ_MB XD5_dmodout 1.21e-17
* device instance cc_XD2_XDFFQ_MB_XD5_dq r0 *1 0,0
Ccc_XD2_XDFFQ_MB_XD5_dq XD2_XDFFQ_MB XD5_dq 1.8151e-17
* device instance cc_XD2_XDFFQ_MB_XD5_nm r0 *1 0,0
Ccc_XD2_XDFFQ_MB_XD5_nm XD2_XDFFQ_MB XD5_nm 1.21e-17
* device instance cc_XD2_XDFFQ_MB_XD5_nt r0 *1 0,0
Ccc_XD2_XDFFQ_MB_XD5_nt XD2_XDFFQ_MB XD5_nt 1.21e-17
* device instance cc_XD2_XDFFQ_MB_XD5_t1 r0 *1 0,0
Ccc_XD2_XDFFQ_MB_XD5_t1 XD2_XDFFQ_MB XD5_t1 1.21e-17
* device instance cc_XD2_XDFFQ_MB_XFRT_CKBB r0 *1 0,0
Ccc_XD2_XDFFQ_MB_XFRT_CKBB XD2_XDFFQ_MB XFRT_CKBB 1.8151e-17
* device instance cc_XD2_XDFFQ_MB_XFRT_CLKB r0 *1 0,0
Ccc_XD2_XDFFQ_MB_XFRT_CLKB XD2_XDFFQ_MB XFRT_CLKB 2.4201e-17
* device instance cc_XD2_XDFFQ_MB_XFRT_M r0 *1 0,0
Ccc_XD2_XDFFQ_MB_XFRT_M XD2_XDFFQ_MB XFRT_M 2.4201e-17
* device instance cc_XD2_XDFFQ_MB_XFRT_MB r0 *1 0,0
Ccc_XD2_XDFFQ_MB_XFRT_MB XD2_XDFFQ_MB XFRT_MB 1.21e-17
* device instance cc_XD2_XDFFQ_MB_XFRT_MFB r0 *1 0,0
Ccc_XD2_XDFFQ_MB_XFRT_MFB XD2_XDFFQ_MB XFRT_MFB 1.21e-17
* device instance cc_XD2_XDFFQ_MB_XFRT_S r0 *1 0,0
Ccc_XD2_XDFFQ_MB_XFRT_S XD2_XDFFQ_MB XFRT_S 1.8151e-17
* device instance cc_XD2_XDFFQ_MB_XFRT_SB r0 *1 0,0
Ccc_XD2_XDFFQ_MB_XFRT_SB XD2_XDFFQ_MB XFRT_SB 1.8151e-17
* device instance cc_XD2_XDFFQ_MB_XFRT_SFB r0 *1 0,0
Ccc_XD2_XDFFQ_MB_XFRT_SFB XD2_XDFFQ_MB XFRT_SFB 1.21e-17
* device instance cc_XD2_XDFFQ_MB_ck1 r0 *1 0,0
Ccc_XD2_XDFFQ_MB_ck1 XD2_XDFFQ_MB ck1 3.0251e-17
* device instance cc_XD2_XDFFQ_MB_ck2 r0 *1 0,0
Ccc_XD2_XDFFQ_MB_ck2 XD2_XDFFQ_MB ck2 3.0251e-17
* device instance cc_XD2_XDFFQ_MB_ck3 r0 *1 0,0
Ccc_XD2_XDFFQ_MB_ck3 XD2_XDFFQ_MB ck3 3.0251e-17
* device instance cc_XD2_XDFFQ_MB_ck4 r0 *1 0,0
Ccc_XD2_XDFFQ_MB_ck4 XD2_XDFFQ_MB ck4 3.0251e-17
* device instance cc_XD2_XDFFQ_MB_ck5 r0 *1 0,0
Ccc_XD2_XDFFQ_MB_ck5 XD2_XDFFQ_MB ck5 3.0251e-17
* device instance cc_XD2_XDFFQ_MB_mod0 r0 *1 0,0
Ccc_XD2_XDFFQ_MB_mod0 XD2_XDFFQ_MB mod0 2.4201e-17
* device instance cc_XD2_XDFFQ_MB_mod1 r0 *1 0,0
Ccc_XD2_XDFFQ_MB_mod1 XD2_XDFFQ_MB mod1 2.4201e-17
* device instance cc_XD2_XDFFQ_MB_mod2 r0 *1 0,0
Ccc_XD2_XDFFQ_MB_mod2 XD2_XDFFQ_MB mod2 2.4201e-17
* device instance cc_XD2_XDFFQ_MB_mod3 r0 *1 0,0
Ccc_XD2_XDFFQ_MB_mod3 XD2_XDFFQ_MB mod3 2.4201e-17
* device instance cc_XD2_XDFFQ_MB_mod4 r0 *1 0,0
Ccc_XD2_XDFFQ_MB_mod4 XD2_XDFFQ_MB mod4 2.4201e-17
* device instance cc_XD2_XDFFQ_MB_net1 r0 *1 0,0
Ccc_XD2_XDFFQ_MB_net1 XD2_XDFFQ_MB net1 1.21e-17
* device instance cc_XD2_XDFFQ_MFB_XD2_XDFFQ_S r0 *1 0,0
Ccc_XD2_XDFFQ_MFB_XD2_XDFFQ_S XD2_XDFFQ_MFB XD2_XDFFQ_S 1.8151e-17
* device instance cc_XD2_XDFFQ_MFB_XD2_XDFFQ_SB r0 *1 0,0
Ccc_XD2_XDFFQ_MFB_XD2_XDFFQ_SB XD2_XDFFQ_MFB XD2_XDFFQ_SB 1.8151e-17
* device instance cc_XD2_XDFFQ_MFB_XD2_XDFFQ_SFB r0 *1 0,0
Ccc_XD2_XDFFQ_MFB_XD2_XDFFQ_SFB XD2_XDFFQ_MFB XD2_XDFFQ_SFB 1.21e-17
* device instance cc_XD2_XDFFQ_MFB_XD2_XN2_mid1 r0 *1 0,0
Ccc_XD2_XDFFQ_MFB_XD2_XN2_mid1 XD2_XDFFQ_MFB XD2_XN2_mid1 1.21e-17
* device instance cc_XD2_XDFFQ_MFB_XD2_XNOR_midp r0 *1 0,0
Ccc_XD2_XDFFQ_MFB_XD2_XNOR_midp XD2_XDFFQ_MFB XD2_XNOR_midp 1.21e-17
* device instance cc_XD2_XDFFQ_MFB_XD2_dmodout r0 *1 0,0
Ccc_XD2_XDFFQ_MFB_XD2_dmodout XD2_XDFFQ_MFB XD2_dmodout 1.21e-17
* device instance cc_XD2_XDFFQ_MFB_XD2_dq r0 *1 0,0
Ccc_XD2_XDFFQ_MFB_XD2_dq XD2_XDFFQ_MFB XD2_dq 1.21e-17
* device instance cc_XD2_XDFFQ_MFB_XD2_nm r0 *1 0,0
Ccc_XD2_XDFFQ_MFB_XD2_nm XD2_XDFFQ_MFB XD2_nm 1.21e-17
* device instance cc_XD2_XDFFQ_MFB_XD2_nt r0 *1 0,0
Ccc_XD2_XDFFQ_MFB_XD2_nt XD2_XDFFQ_MFB XD2_nt 2.4201e-17
* device instance cc_XD2_XDFFQ_MFB_XD2_t1 r0 *1 0,0
Ccc_XD2_XDFFQ_MFB_XD2_t1 XD2_XDFFQ_MFB XD2_t1 1.21e-17
* device instance cc_XD2_XDFFQ_MFB_XD3_XDFFM_CKBB r0 *1 0,0
Ccc_XD2_XDFFQ_MFB_XD3_XDFFM_CKBB XD2_XDFFQ_MFB XD3_XDFFM_CKBB 1.8151e-17
* device instance cc_XD2_XDFFQ_MFB_XD3_XDFFM_CLKB r0 *1 0,0
Ccc_XD2_XDFFQ_MFB_XD3_XDFFM_CLKB XD2_XDFFQ_MFB XD3_XDFFM_CLKB 2.4201e-17
* device instance cc_XD2_XDFFQ_MFB_XD3_XDFFM_M r0 *1 0,0
Ccc_XD2_XDFFQ_MFB_XD3_XDFFM_M XD2_XDFFQ_MFB XD3_XDFFM_M 2.4201e-17
* device instance cc_XD2_XDFFQ_MFB_XD3_XDFFM_MB r0 *1 0,0
Ccc_XD2_XDFFQ_MFB_XD3_XDFFM_MB XD2_XDFFQ_MFB XD3_XDFFM_MB 1.21e-17
* device instance cc_XD2_XDFFQ_MFB_XD3_XDFFM_MFB r0 *1 0,0
Ccc_XD2_XDFFQ_MFB_XD3_XDFFM_MFB XD2_XDFFQ_MFB XD3_XDFFM_MFB 1.21e-17
* device instance cc_XD2_XDFFQ_MFB_XD3_XDFFM_S r0 *1 0,0
Ccc_XD2_XDFFQ_MFB_XD3_XDFFM_S XD2_XDFFQ_MFB XD3_XDFFM_S 1.8151e-17
* device instance cc_XD2_XDFFQ_MFB_XD3_XDFFM_SB r0 *1 0,0
Ccc_XD2_XDFFQ_MFB_XD3_XDFFM_SB XD2_XDFFQ_MFB XD3_XDFFM_SB 1.8151e-17
* device instance cc_XD2_XDFFQ_MFB_XD3_XDFFM_SFB r0 *1 0,0
Ccc_XD2_XDFFQ_MFB_XD3_XDFFM_SFB XD2_XDFFQ_MFB XD3_XDFFM_SFB 1.21e-17
* device instance cc_XD2_XDFFQ_MFB_XD3_XDFFQ_CKBB r0 *1 0,0
Ccc_XD2_XDFFQ_MFB_XD3_XDFFQ_CKBB XD2_XDFFQ_MFB XD3_XDFFQ_CKBB 1.8151e-17
* device instance cc_XD2_XDFFQ_MFB_XD3_XDFFQ_CLKB r0 *1 0,0
Ccc_XD2_XDFFQ_MFB_XD3_XDFFQ_CLKB XD2_XDFFQ_MFB XD3_XDFFQ_CLKB 2.4201e-17
* device instance cc_XD2_XDFFQ_MFB_XD3_XDFFQ_M r0 *1 0,0
Ccc_XD2_XDFFQ_MFB_XD3_XDFFQ_M XD2_XDFFQ_MFB XD3_XDFFQ_M 2.4201e-17
* device instance cc_XD2_XDFFQ_MFB_XD3_XDFFQ_MB r0 *1 0,0
Ccc_XD2_XDFFQ_MFB_XD3_XDFFQ_MB XD2_XDFFQ_MFB XD3_XDFFQ_MB 1.21e-17
* device instance cc_XD2_XDFFQ_MFB_XD3_XDFFQ_MFB r0 *1 0,0
Ccc_XD2_XDFFQ_MFB_XD3_XDFFQ_MFB XD2_XDFFQ_MFB XD3_XDFFQ_MFB 1.21e-17
* device instance cc_XD2_XDFFQ_MFB_XD3_XDFFQ_S r0 *1 0,0
Ccc_XD2_XDFFQ_MFB_XD3_XDFFQ_S XD2_XDFFQ_MFB XD3_XDFFQ_S 1.8151e-17
* device instance cc_XD2_XDFFQ_MFB_XD3_XDFFQ_SB r0 *1 0,0
Ccc_XD2_XDFFQ_MFB_XD3_XDFFQ_SB XD2_XDFFQ_MFB XD3_XDFFQ_SB 1.8151e-17
* device instance cc_XD2_XDFFQ_MFB_XD3_XDFFQ_SFB r0 *1 0,0
Ccc_XD2_XDFFQ_MFB_XD3_XDFFQ_SFB XD2_XDFFQ_MFB XD3_XDFFQ_SFB 1.21e-17
* device instance cc_XD2_XDFFQ_MFB_XD3_XN2_mid1 r0 *1 0,0
Ccc_XD2_XDFFQ_MFB_XD3_XN2_mid1 XD2_XDFFQ_MFB XD3_XN2_mid1 1.21e-17
* device instance cc_XD2_XDFFQ_MFB_XD3_XN3_mid1 r0 *1 0,0
Ccc_XD2_XDFFQ_MFB_XD3_XN3_mid1 XD2_XDFFQ_MFB XD3_XN3_mid1 1.21e-17
* device instance cc_XD2_XDFFQ_MFB_XD3_XN3_mid2 r0 *1 0,0
Ccc_XD2_XDFFQ_MFB_XD3_XN3_mid2 XD2_XDFFQ_MFB XD3_XN3_mid2 1.21e-17
* device instance cc_XD2_XDFFQ_MFB_XD3_dmodout r0 *1 0,0
Ccc_XD2_XDFFQ_MFB_XD3_dmodout XD2_XDFFQ_MFB XD3_dmodout 1.21e-17
* device instance cc_XD2_XDFFQ_MFB_XD3_dq r0 *1 0,0
Ccc_XD2_XDFFQ_MFB_XD3_dq XD2_XDFFQ_MFB XD3_dq 1.8151e-17
* device instance cc_XD2_XDFFQ_MFB_XD3_nm r0 *1 0,0
Ccc_XD2_XDFFQ_MFB_XD3_nm XD2_XDFFQ_MFB XD3_nm 1.21e-17
* device instance cc_XD2_XDFFQ_MFB_XD3_nt r0 *1 0,0
Ccc_XD2_XDFFQ_MFB_XD3_nt XD2_XDFFQ_MFB XD3_nt 1.21e-17
* device instance cc_XD2_XDFFQ_MFB_XD3_t1 r0 *1 0,0
Ccc_XD2_XDFFQ_MFB_XD3_t1 XD2_XDFFQ_MFB XD3_t1 1.21e-17
* device instance cc_XD2_XDFFQ_MFB_XD4_XDFFM_CKBB r0 *1 0,0
Ccc_XD2_XDFFQ_MFB_XD4_XDFFM_CKBB XD2_XDFFQ_MFB XD4_XDFFM_CKBB 1.8151e-17
* device instance cc_XD2_XDFFQ_MFB_XD4_XDFFM_CLKB r0 *1 0,0
Ccc_XD2_XDFFQ_MFB_XD4_XDFFM_CLKB XD2_XDFFQ_MFB XD4_XDFFM_CLKB 2.4201e-17
* device instance cc_XD2_XDFFQ_MFB_XD4_XDFFM_M r0 *1 0,0
Ccc_XD2_XDFFQ_MFB_XD4_XDFFM_M XD2_XDFFQ_MFB XD4_XDFFM_M 2.4201e-17
* device instance cc_XD2_XDFFQ_MFB_XD4_XDFFM_MB r0 *1 0,0
Ccc_XD2_XDFFQ_MFB_XD4_XDFFM_MB XD2_XDFFQ_MFB XD4_XDFFM_MB 1.21e-17
* device instance cc_XD2_XDFFQ_MFB_XD4_XDFFM_MFB r0 *1 0,0
Ccc_XD2_XDFFQ_MFB_XD4_XDFFM_MFB XD2_XDFFQ_MFB XD4_XDFFM_MFB 1.21e-17
* device instance cc_XD2_XDFFQ_MFB_XD4_XDFFM_S r0 *1 0,0
Ccc_XD2_XDFFQ_MFB_XD4_XDFFM_S XD2_XDFFQ_MFB XD4_XDFFM_S 1.8151e-17
* device instance cc_XD2_XDFFQ_MFB_XD4_XDFFM_SB r0 *1 0,0
Ccc_XD2_XDFFQ_MFB_XD4_XDFFM_SB XD2_XDFFQ_MFB XD4_XDFFM_SB 1.8151e-17
* device instance cc_XD2_XDFFQ_MFB_XD4_XDFFM_SFB r0 *1 0,0
Ccc_XD2_XDFFQ_MFB_XD4_XDFFM_SFB XD2_XDFFQ_MFB XD4_XDFFM_SFB 1.21e-17
* device instance cc_XD2_XDFFQ_MFB_XD4_XDFFQ_CKBB r0 *1 0,0
Ccc_XD2_XDFFQ_MFB_XD4_XDFFQ_CKBB XD2_XDFFQ_MFB XD4_XDFFQ_CKBB 1.8151e-17
* device instance cc_XD2_XDFFQ_MFB_XD4_XDFFQ_CLKB r0 *1 0,0
Ccc_XD2_XDFFQ_MFB_XD4_XDFFQ_CLKB XD2_XDFFQ_MFB XD4_XDFFQ_CLKB 2.4201e-17
* device instance cc_XD2_XDFFQ_MFB_XD4_XDFFQ_M r0 *1 0,0
Ccc_XD2_XDFFQ_MFB_XD4_XDFFQ_M XD2_XDFFQ_MFB XD4_XDFFQ_M 2.4201e-17
* device instance cc_XD2_XDFFQ_MFB_XD4_XDFFQ_MB r0 *1 0,0
Ccc_XD2_XDFFQ_MFB_XD4_XDFFQ_MB XD2_XDFFQ_MFB XD4_XDFFQ_MB 1.21e-17
* device instance cc_XD2_XDFFQ_MFB_XD4_XDFFQ_MFB r0 *1 0,0
Ccc_XD2_XDFFQ_MFB_XD4_XDFFQ_MFB XD2_XDFFQ_MFB XD4_XDFFQ_MFB 1.21e-17
* device instance cc_XD2_XDFFQ_MFB_XD4_XDFFQ_S r0 *1 0,0
Ccc_XD2_XDFFQ_MFB_XD4_XDFFQ_S XD2_XDFFQ_MFB XD4_XDFFQ_S 1.8151e-17
* device instance cc_XD2_XDFFQ_MFB_XD4_XDFFQ_SB r0 *1 0,0
Ccc_XD2_XDFFQ_MFB_XD4_XDFFQ_SB XD2_XDFFQ_MFB XD4_XDFFQ_SB 1.8151e-17
* device instance cc_XD2_XDFFQ_MFB_XD4_XDFFQ_SFB r0 *1 0,0
Ccc_XD2_XDFFQ_MFB_XD4_XDFFQ_SFB XD2_XDFFQ_MFB XD4_XDFFQ_SFB 1.21e-17
* device instance cc_XD2_XDFFQ_MFB_XD4_XN2_mid1 r0 *1 0,0
Ccc_XD2_XDFFQ_MFB_XD4_XN2_mid1 XD2_XDFFQ_MFB XD4_XN2_mid1 1.21e-17
* device instance cc_XD2_XDFFQ_MFB_XD4_XN3_mid1 r0 *1 0,0
Ccc_XD2_XDFFQ_MFB_XD4_XN3_mid1 XD2_XDFFQ_MFB XD4_XN3_mid1 1.21e-17
* device instance cc_XD2_XDFFQ_MFB_XD4_XN3_mid2 r0 *1 0,0
Ccc_XD2_XDFFQ_MFB_XD4_XN3_mid2 XD2_XDFFQ_MFB XD4_XN3_mid2 1.21e-17
* device instance cc_XD2_XDFFQ_MFB_XD4_dmodout r0 *1 0,0
Ccc_XD2_XDFFQ_MFB_XD4_dmodout XD2_XDFFQ_MFB XD4_dmodout 1.21e-17
* device instance cc_XD2_XDFFQ_MFB_XD4_dq r0 *1 0,0
Ccc_XD2_XDFFQ_MFB_XD4_dq XD2_XDFFQ_MFB XD4_dq 1.8151e-17
* device instance cc_XD2_XDFFQ_MFB_XD4_nm r0 *1 0,0
Ccc_XD2_XDFFQ_MFB_XD4_nm XD2_XDFFQ_MFB XD4_nm 1.21e-17
* device instance cc_XD2_XDFFQ_MFB_XD4_nt r0 *1 0,0
Ccc_XD2_XDFFQ_MFB_XD4_nt XD2_XDFFQ_MFB XD4_nt 1.21e-17
* device instance cc_XD2_XDFFQ_MFB_XD4_t1 r0 *1 0,0
Ccc_XD2_XDFFQ_MFB_XD4_t1 XD2_XDFFQ_MFB XD4_t1 1.21e-17
* device instance cc_XD2_XDFFQ_MFB_XD5_XDFFM_CKBB r0 *1 0,0
Ccc_XD2_XDFFQ_MFB_XD5_XDFFM_CKBB XD2_XDFFQ_MFB XD5_XDFFM_CKBB 1.8151e-17
* device instance cc_XD2_XDFFQ_MFB_XD5_XDFFM_CLKB r0 *1 0,0
Ccc_XD2_XDFFQ_MFB_XD5_XDFFM_CLKB XD2_XDFFQ_MFB XD5_XDFFM_CLKB 2.4201e-17
* device instance cc_XD2_XDFFQ_MFB_XD5_XDFFM_M r0 *1 0,0
Ccc_XD2_XDFFQ_MFB_XD5_XDFFM_M XD2_XDFFQ_MFB XD5_XDFFM_M 2.4201e-17
* device instance cc_XD2_XDFFQ_MFB_XD5_XDFFM_MB r0 *1 0,0
Ccc_XD2_XDFFQ_MFB_XD5_XDFFM_MB XD2_XDFFQ_MFB XD5_XDFFM_MB 1.21e-17
* device instance cc_XD2_XDFFQ_MFB_XD5_XDFFM_MFB r0 *1 0,0
Ccc_XD2_XDFFQ_MFB_XD5_XDFFM_MFB XD2_XDFFQ_MFB XD5_XDFFM_MFB 1.21e-17
* device instance cc_XD2_XDFFQ_MFB_XD5_XDFFM_S r0 *1 0,0
Ccc_XD2_XDFFQ_MFB_XD5_XDFFM_S XD2_XDFFQ_MFB XD5_XDFFM_S 1.8151e-17
* device instance cc_XD2_XDFFQ_MFB_XD5_XDFFM_SB r0 *1 0,0
Ccc_XD2_XDFFQ_MFB_XD5_XDFFM_SB XD2_XDFFQ_MFB XD5_XDFFM_SB 1.8151e-17
* device instance cc_XD2_XDFFQ_MFB_XD5_XDFFM_SFB r0 *1 0,0
Ccc_XD2_XDFFQ_MFB_XD5_XDFFM_SFB XD2_XDFFQ_MFB XD5_XDFFM_SFB 1.21e-17
* device instance cc_XD2_XDFFQ_MFB_XD5_XDFFQ_CKBB r0 *1 0,0
Ccc_XD2_XDFFQ_MFB_XD5_XDFFQ_CKBB XD2_XDFFQ_MFB XD5_XDFFQ_CKBB 1.8151e-17
* device instance cc_XD2_XDFFQ_MFB_XD5_XDFFQ_CLKB r0 *1 0,0
Ccc_XD2_XDFFQ_MFB_XD5_XDFFQ_CLKB XD2_XDFFQ_MFB XD5_XDFFQ_CLKB 2.4201e-17
* device instance cc_XD2_XDFFQ_MFB_XD5_XDFFQ_M r0 *1 0,0
Ccc_XD2_XDFFQ_MFB_XD5_XDFFQ_M XD2_XDFFQ_MFB XD5_XDFFQ_M 2.4201e-17
* device instance cc_XD2_XDFFQ_MFB_XD5_XDFFQ_MB r0 *1 0,0
Ccc_XD2_XDFFQ_MFB_XD5_XDFFQ_MB XD2_XDFFQ_MFB XD5_XDFFQ_MB 1.21e-17
* device instance cc_XD2_XDFFQ_MFB_XD5_XDFFQ_MFB r0 *1 0,0
Ccc_XD2_XDFFQ_MFB_XD5_XDFFQ_MFB XD2_XDFFQ_MFB XD5_XDFFQ_MFB 1.21e-17
* device instance cc_XD2_XDFFQ_MFB_XD5_XDFFQ_S r0 *1 0,0
Ccc_XD2_XDFFQ_MFB_XD5_XDFFQ_S XD2_XDFFQ_MFB XD5_XDFFQ_S 1.8151e-17
* device instance cc_XD2_XDFFQ_MFB_XD5_XDFFQ_SB r0 *1 0,0
Ccc_XD2_XDFFQ_MFB_XD5_XDFFQ_SB XD2_XDFFQ_MFB XD5_XDFFQ_SB 1.8151e-17
* device instance cc_XD2_XDFFQ_MFB_XD5_XDFFQ_SFB r0 *1 0,0
Ccc_XD2_XDFFQ_MFB_XD5_XDFFQ_SFB XD2_XDFFQ_MFB XD5_XDFFQ_SFB 1.21e-17
* device instance cc_XD2_XDFFQ_MFB_XD5_XN2_mid1 r0 *1 0,0
Ccc_XD2_XDFFQ_MFB_XD5_XN2_mid1 XD2_XDFFQ_MFB XD5_XN2_mid1 1.21e-17
* device instance cc_XD2_XDFFQ_MFB_XD5_XN3_mid1 r0 *1 0,0
Ccc_XD2_XDFFQ_MFB_XD5_XN3_mid1 XD2_XDFFQ_MFB XD5_XN3_mid1 1.21e-17
* device instance cc_XD2_XDFFQ_MFB_XD5_XN3_mid2 r0 *1 0,0
Ccc_XD2_XDFFQ_MFB_XD5_XN3_mid2 XD2_XDFFQ_MFB XD5_XN3_mid2 1.21e-17
* device instance cc_XD2_XDFFQ_MFB_XD5_dmodout r0 *1 0,0
Ccc_XD2_XDFFQ_MFB_XD5_dmodout XD2_XDFFQ_MFB XD5_dmodout 1.21e-17
* device instance cc_XD2_XDFFQ_MFB_XD5_dq r0 *1 0,0
Ccc_XD2_XDFFQ_MFB_XD5_dq XD2_XDFFQ_MFB XD5_dq 1.8151e-17
* device instance cc_XD2_XDFFQ_MFB_XD5_nm r0 *1 0,0
Ccc_XD2_XDFFQ_MFB_XD5_nm XD2_XDFFQ_MFB XD5_nm 1.21e-17
* device instance cc_XD2_XDFFQ_MFB_XD5_nt r0 *1 0,0
Ccc_XD2_XDFFQ_MFB_XD5_nt XD2_XDFFQ_MFB XD5_nt 1.21e-17
* device instance cc_XD2_XDFFQ_MFB_XD5_t1 r0 *1 0,0
Ccc_XD2_XDFFQ_MFB_XD5_t1 XD2_XDFFQ_MFB XD5_t1 1.21e-17
* device instance cc_XD2_XDFFQ_MFB_XFRT_CKBB r0 *1 0,0
Ccc_XD2_XDFFQ_MFB_XFRT_CKBB XD2_XDFFQ_MFB XFRT_CKBB 1.8151e-17
* device instance cc_XD2_XDFFQ_MFB_XFRT_CLKB r0 *1 0,0
Ccc_XD2_XDFFQ_MFB_XFRT_CLKB XD2_XDFFQ_MFB XFRT_CLKB 2.4201e-17
* device instance cc_XD2_XDFFQ_MFB_XFRT_M r0 *1 0,0
Ccc_XD2_XDFFQ_MFB_XFRT_M XD2_XDFFQ_MFB XFRT_M 2.4201e-17
* device instance cc_XD2_XDFFQ_MFB_XFRT_MB r0 *1 0,0
Ccc_XD2_XDFFQ_MFB_XFRT_MB XD2_XDFFQ_MFB XFRT_MB 1.21e-17
* device instance cc_XD2_XDFFQ_MFB_XFRT_MFB r0 *1 0,0
Ccc_XD2_XDFFQ_MFB_XFRT_MFB XD2_XDFFQ_MFB XFRT_MFB 1.21e-17
* device instance cc_XD2_XDFFQ_MFB_XFRT_S r0 *1 0,0
Ccc_XD2_XDFFQ_MFB_XFRT_S XD2_XDFFQ_MFB XFRT_S 1.8151e-17
* device instance cc_XD2_XDFFQ_MFB_XFRT_SB r0 *1 0,0
Ccc_XD2_XDFFQ_MFB_XFRT_SB XD2_XDFFQ_MFB XFRT_SB 1.8151e-17
* device instance cc_XD2_XDFFQ_MFB_XFRT_SFB r0 *1 0,0
Ccc_XD2_XDFFQ_MFB_XFRT_SFB XD2_XDFFQ_MFB XFRT_SFB 1.21e-17
* device instance cc_XD2_XDFFQ_MFB_ck1 r0 *1 0,0
Ccc_XD2_XDFFQ_MFB_ck1 XD2_XDFFQ_MFB ck1 3.0251e-17
* device instance cc_XD2_XDFFQ_MFB_ck2 r0 *1 0,0
Ccc_XD2_XDFFQ_MFB_ck2 XD2_XDFFQ_MFB ck2 3.0251e-17
* device instance cc_XD2_XDFFQ_MFB_ck3 r0 *1 0,0
Ccc_XD2_XDFFQ_MFB_ck3 XD2_XDFFQ_MFB ck3 3.0251e-17
* device instance cc_XD2_XDFFQ_MFB_ck4 r0 *1 0,0
Ccc_XD2_XDFFQ_MFB_ck4 XD2_XDFFQ_MFB ck4 3.0251e-17
* device instance cc_XD2_XDFFQ_MFB_ck5 r0 *1 0,0
Ccc_XD2_XDFFQ_MFB_ck5 XD2_XDFFQ_MFB ck5 3.0251e-17
* device instance cc_XD2_XDFFQ_MFB_mod0 r0 *1 0,0
Ccc_XD2_XDFFQ_MFB_mod0 XD2_XDFFQ_MFB mod0 2.4201e-17
* device instance cc_XD2_XDFFQ_MFB_mod1 r0 *1 0,0
Ccc_XD2_XDFFQ_MFB_mod1 XD2_XDFFQ_MFB mod1 2.4201e-17
* device instance cc_XD2_XDFFQ_MFB_mod2 r0 *1 0,0
Ccc_XD2_XDFFQ_MFB_mod2 XD2_XDFFQ_MFB mod2 2.4201e-17
* device instance cc_XD2_XDFFQ_MFB_mod3 r0 *1 0,0
Ccc_XD2_XDFFQ_MFB_mod3 XD2_XDFFQ_MFB mod3 2.4201e-17
* device instance cc_XD2_XDFFQ_MFB_mod4 r0 *1 0,0
Ccc_XD2_XDFFQ_MFB_mod4 XD2_XDFFQ_MFB mod4 2.4201e-17
* device instance cc_XD2_XDFFQ_MFB_net1 r0 *1 0,0
Ccc_XD2_XDFFQ_MFB_net1 XD2_XDFFQ_MFB net1 1.21e-17
* device instance cc_XD2_XDFFQ_S_XD2_XDFFQ_SB r0 *1 0,0
Ccc_XD2_XDFFQ_S_XD2_XDFFQ_SB XD2_XDFFQ_S XD2_XDFFQ_SB 3.0251e-17
* device instance cc_XD2_XDFFQ_S_XD2_XDFFQ_SFB r0 *1 0,0
Ccc_XD2_XDFFQ_S_XD2_XDFFQ_SFB XD2_XDFFQ_S XD2_XDFFQ_SFB 3.4688e-17
* device instance cc_XD2_XDFFQ_S_XD2_XN2_mid1 r0 *1 0,0
Ccc_XD2_XDFFQ_S_XD2_XN2_mid1 XD2_XDFFQ_S XD2_XN2_mid1 1.21e-17
* device instance cc_XD2_XDFFQ_S_XD2_XNOR_midp r0 *1 0,0
Ccc_XD2_XDFFQ_S_XD2_XNOR_midp XD2_XDFFQ_S XD2_XNOR_midp 1.21e-17
* device instance cc_XD2_XDFFQ_S_XD2_dmodout r0 *1 0,0
Ccc_XD2_XDFFQ_S_XD2_dmodout XD2_XDFFQ_S XD2_dmodout 1.21e-17
* device instance cc_XD2_XDFFQ_S_XD2_dq r0 *1 0,0
Ccc_XD2_XDFFQ_S_XD2_dq XD2_XDFFQ_S XD2_dq 1.21e-17
* device instance cc_XD2_XDFFQ_S_XD2_nm r0 *1 0,0
Ccc_XD2_XDFFQ_S_XD2_nm XD2_XDFFQ_S XD2_nm 1.21e-17
* device instance cc_XD2_XDFFQ_S_XD2_nt r0 *1 0,0
Ccc_XD2_XDFFQ_S_XD2_nt XD2_XDFFQ_S XD2_nt 2.4201e-17
* device instance cc_XD2_XDFFQ_S_XD2_t1 r0 *1 0,0
Ccc_XD2_XDFFQ_S_XD2_t1 XD2_XDFFQ_S XD2_t1 1.21e-17
* device instance cc_XD2_XDFFQ_S_XD3_XDFFM_CKBB r0 *1 0,0
Ccc_XD2_XDFFQ_S_XD3_XDFFM_CKBB XD2_XDFFQ_S XD3_XDFFM_CKBB 1.8151e-17
* device instance cc_XD2_XDFFQ_S_XD3_XDFFM_CLKB r0 *1 0,0
Ccc_XD2_XDFFQ_S_XD3_XDFFM_CLKB XD2_XDFFQ_S XD3_XDFFM_CLKB 2.4201e-17
* device instance cc_XD2_XDFFQ_S_XD3_XDFFM_M r0 *1 0,0
Ccc_XD2_XDFFQ_S_XD3_XDFFM_M XD2_XDFFQ_S XD3_XDFFM_M 2.4201e-17
* device instance cc_XD2_XDFFQ_S_XD3_XDFFM_MB r0 *1 0,0
Ccc_XD2_XDFFQ_S_XD3_XDFFM_MB XD2_XDFFQ_S XD3_XDFFM_MB 1.21e-17
* device instance cc_XD2_XDFFQ_S_XD3_XDFFM_MFB r0 *1 0,0
Ccc_XD2_XDFFQ_S_XD3_XDFFM_MFB XD2_XDFFQ_S XD3_XDFFM_MFB 1.21e-17
* device instance cc_XD2_XDFFQ_S_XD3_XDFFM_S r0 *1 0,0
Ccc_XD2_XDFFQ_S_XD3_XDFFM_S XD2_XDFFQ_S XD3_XDFFM_S 1.8151e-17
* device instance cc_XD2_XDFFQ_S_XD3_XDFFM_SB r0 *1 0,0
Ccc_XD2_XDFFQ_S_XD3_XDFFM_SB XD2_XDFFQ_S XD3_XDFFM_SB 1.8151e-17
* device instance cc_XD2_XDFFQ_S_XD3_XDFFM_SFB r0 *1 0,0
Ccc_XD2_XDFFQ_S_XD3_XDFFM_SFB XD2_XDFFQ_S XD3_XDFFM_SFB 1.21e-17
* device instance cc_XD2_XDFFQ_S_XD3_XDFFQ_CKBB r0 *1 0,0
Ccc_XD2_XDFFQ_S_XD3_XDFFQ_CKBB XD2_XDFFQ_S XD3_XDFFQ_CKBB 1.8151e-17
* device instance cc_XD2_XDFFQ_S_XD3_XDFFQ_CLKB r0 *1 0,0
Ccc_XD2_XDFFQ_S_XD3_XDFFQ_CLKB XD2_XDFFQ_S XD3_XDFFQ_CLKB 2.4201e-17
* device instance cc_XD2_XDFFQ_S_XD3_XDFFQ_M r0 *1 0,0
Ccc_XD2_XDFFQ_S_XD3_XDFFQ_M XD2_XDFFQ_S XD3_XDFFQ_M 2.4201e-17
* device instance cc_XD2_XDFFQ_S_XD3_XDFFQ_MB r0 *1 0,0
Ccc_XD2_XDFFQ_S_XD3_XDFFQ_MB XD2_XDFFQ_S XD3_XDFFQ_MB 1.21e-17
* device instance cc_XD2_XDFFQ_S_XD3_XDFFQ_MFB r0 *1 0,0
Ccc_XD2_XDFFQ_S_XD3_XDFFQ_MFB XD2_XDFFQ_S XD3_XDFFQ_MFB 1.21e-17
* device instance cc_XD2_XDFFQ_S_XD3_XDFFQ_S r0 *1 0,0
Ccc_XD2_XDFFQ_S_XD3_XDFFQ_S XD2_XDFFQ_S XD3_XDFFQ_S 1.8151e-17
* device instance cc_XD2_XDFFQ_S_XD3_XDFFQ_SB r0 *1 0,0
Ccc_XD2_XDFFQ_S_XD3_XDFFQ_SB XD2_XDFFQ_S XD3_XDFFQ_SB 1.8151e-17
* device instance cc_XD2_XDFFQ_S_XD3_XDFFQ_SFB r0 *1 0,0
Ccc_XD2_XDFFQ_S_XD3_XDFFQ_SFB XD2_XDFFQ_S XD3_XDFFQ_SFB 1.21e-17
* device instance cc_XD2_XDFFQ_S_XD3_XN2_mid1 r0 *1 0,0
Ccc_XD2_XDFFQ_S_XD3_XN2_mid1 XD2_XDFFQ_S XD3_XN2_mid1 1.21e-17
* device instance cc_XD2_XDFFQ_S_XD3_XN3_mid1 r0 *1 0,0
Ccc_XD2_XDFFQ_S_XD3_XN3_mid1 XD2_XDFFQ_S XD3_XN3_mid1 1.21e-17
* device instance cc_XD2_XDFFQ_S_XD3_XN3_mid2 r0 *1 0,0
Ccc_XD2_XDFFQ_S_XD3_XN3_mid2 XD2_XDFFQ_S XD3_XN3_mid2 1.21e-17
* device instance cc_XD2_XDFFQ_S_XD3_dmodout r0 *1 0,0
Ccc_XD2_XDFFQ_S_XD3_dmodout XD2_XDFFQ_S XD3_dmodout 1.21e-17
* device instance cc_XD2_XDFFQ_S_XD3_dq r0 *1 0,0
Ccc_XD2_XDFFQ_S_XD3_dq XD2_XDFFQ_S XD3_dq 1.8151e-17
* device instance cc_XD2_XDFFQ_S_XD3_nm r0 *1 0,0
Ccc_XD2_XDFFQ_S_XD3_nm XD2_XDFFQ_S XD3_nm 1.21e-17
* device instance cc_XD2_XDFFQ_S_XD3_nt r0 *1 0,0
Ccc_XD2_XDFFQ_S_XD3_nt XD2_XDFFQ_S XD3_nt 1.21e-17
* device instance cc_XD2_XDFFQ_S_XD3_t1 r0 *1 0,0
Ccc_XD2_XDFFQ_S_XD3_t1 XD2_XDFFQ_S XD3_t1 1.21e-17
* device instance cc_XD2_XDFFQ_S_XD4_XDFFM_CKBB r0 *1 0,0
Ccc_XD2_XDFFQ_S_XD4_XDFFM_CKBB XD2_XDFFQ_S XD4_XDFFM_CKBB 1.8151e-17
* device instance cc_XD2_XDFFQ_S_XD4_XDFFM_CLKB r0 *1 0,0
Ccc_XD2_XDFFQ_S_XD4_XDFFM_CLKB XD2_XDFFQ_S XD4_XDFFM_CLKB 2.4201e-17
* device instance cc_XD2_XDFFQ_S_XD4_XDFFM_M r0 *1 0,0
Ccc_XD2_XDFFQ_S_XD4_XDFFM_M XD2_XDFFQ_S XD4_XDFFM_M 2.4201e-17
* device instance cc_XD2_XDFFQ_S_XD4_XDFFM_MB r0 *1 0,0
Ccc_XD2_XDFFQ_S_XD4_XDFFM_MB XD2_XDFFQ_S XD4_XDFFM_MB 1.21e-17
* device instance cc_XD2_XDFFQ_S_XD4_XDFFM_MFB r0 *1 0,0
Ccc_XD2_XDFFQ_S_XD4_XDFFM_MFB XD2_XDFFQ_S XD4_XDFFM_MFB 1.21e-17
* device instance cc_XD2_XDFFQ_S_XD4_XDFFM_S r0 *1 0,0
Ccc_XD2_XDFFQ_S_XD4_XDFFM_S XD2_XDFFQ_S XD4_XDFFM_S 1.8151e-17
* device instance cc_XD2_XDFFQ_S_XD4_XDFFM_SB r0 *1 0,0
Ccc_XD2_XDFFQ_S_XD4_XDFFM_SB XD2_XDFFQ_S XD4_XDFFM_SB 1.8151e-17
* device instance cc_XD2_XDFFQ_S_XD4_XDFFM_SFB r0 *1 0,0
Ccc_XD2_XDFFQ_S_XD4_XDFFM_SFB XD2_XDFFQ_S XD4_XDFFM_SFB 1.21e-17
* device instance cc_XD2_XDFFQ_S_XD4_XDFFQ_CKBB r0 *1 0,0
Ccc_XD2_XDFFQ_S_XD4_XDFFQ_CKBB XD2_XDFFQ_S XD4_XDFFQ_CKBB 1.8151e-17
* device instance cc_XD2_XDFFQ_S_XD4_XDFFQ_CLKB r0 *1 0,0
Ccc_XD2_XDFFQ_S_XD4_XDFFQ_CLKB XD2_XDFFQ_S XD4_XDFFQ_CLKB 2.4201e-17
* device instance cc_XD2_XDFFQ_S_XD4_XDFFQ_M r0 *1 0,0
Ccc_XD2_XDFFQ_S_XD4_XDFFQ_M XD2_XDFFQ_S XD4_XDFFQ_M 2.4201e-17
* device instance cc_XD2_XDFFQ_S_XD4_XDFFQ_MB r0 *1 0,0
Ccc_XD2_XDFFQ_S_XD4_XDFFQ_MB XD2_XDFFQ_S XD4_XDFFQ_MB 1.21e-17
* device instance cc_XD2_XDFFQ_S_XD4_XDFFQ_MFB r0 *1 0,0
Ccc_XD2_XDFFQ_S_XD4_XDFFQ_MFB XD2_XDFFQ_S XD4_XDFFQ_MFB 1.21e-17
* device instance cc_XD2_XDFFQ_S_XD4_XDFFQ_S r0 *1 0,0
Ccc_XD2_XDFFQ_S_XD4_XDFFQ_S XD2_XDFFQ_S XD4_XDFFQ_S 1.8151e-17
* device instance cc_XD2_XDFFQ_S_XD4_XDFFQ_SB r0 *1 0,0
Ccc_XD2_XDFFQ_S_XD4_XDFFQ_SB XD2_XDFFQ_S XD4_XDFFQ_SB 1.8151e-17
* device instance cc_XD2_XDFFQ_S_XD4_XDFFQ_SFB r0 *1 0,0
Ccc_XD2_XDFFQ_S_XD4_XDFFQ_SFB XD2_XDFFQ_S XD4_XDFFQ_SFB 1.21e-17
* device instance cc_XD2_XDFFQ_S_XD4_XN2_mid1 r0 *1 0,0
Ccc_XD2_XDFFQ_S_XD4_XN2_mid1 XD2_XDFFQ_S XD4_XN2_mid1 1.21e-17
* device instance cc_XD2_XDFFQ_S_XD4_XN3_mid1 r0 *1 0,0
Ccc_XD2_XDFFQ_S_XD4_XN3_mid1 XD2_XDFFQ_S XD4_XN3_mid1 1.21e-17
* device instance cc_XD2_XDFFQ_S_XD4_XN3_mid2 r0 *1 0,0
Ccc_XD2_XDFFQ_S_XD4_XN3_mid2 XD2_XDFFQ_S XD4_XN3_mid2 1.21e-17
* device instance cc_XD2_XDFFQ_S_XD4_dmodout r0 *1 0,0
Ccc_XD2_XDFFQ_S_XD4_dmodout XD2_XDFFQ_S XD4_dmodout 1.21e-17
* device instance cc_XD2_XDFFQ_S_XD4_dq r0 *1 0,0
Ccc_XD2_XDFFQ_S_XD4_dq XD2_XDFFQ_S XD4_dq 1.8151e-17
* device instance cc_XD2_XDFFQ_S_XD4_nm r0 *1 0,0
Ccc_XD2_XDFFQ_S_XD4_nm XD2_XDFFQ_S XD4_nm 1.21e-17
* device instance cc_XD2_XDFFQ_S_XD4_nt r0 *1 0,0
Ccc_XD2_XDFFQ_S_XD4_nt XD2_XDFFQ_S XD4_nt 1.21e-17
* device instance cc_XD2_XDFFQ_S_XD4_t1 r0 *1 0,0
Ccc_XD2_XDFFQ_S_XD4_t1 XD2_XDFFQ_S XD4_t1 1.21e-17
* device instance cc_XD2_XDFFQ_S_XD5_XDFFM_CKBB r0 *1 0,0
Ccc_XD2_XDFFQ_S_XD5_XDFFM_CKBB XD2_XDFFQ_S XD5_XDFFM_CKBB 1.8151e-17
* device instance cc_XD2_XDFFQ_S_XD5_XDFFM_CLKB r0 *1 0,0
Ccc_XD2_XDFFQ_S_XD5_XDFFM_CLKB XD2_XDFFQ_S XD5_XDFFM_CLKB 2.4201e-17
* device instance cc_XD2_XDFFQ_S_XD5_XDFFM_M r0 *1 0,0
Ccc_XD2_XDFFQ_S_XD5_XDFFM_M XD2_XDFFQ_S XD5_XDFFM_M 2.4201e-17
* device instance cc_XD2_XDFFQ_S_XD5_XDFFM_MB r0 *1 0,0
Ccc_XD2_XDFFQ_S_XD5_XDFFM_MB XD2_XDFFQ_S XD5_XDFFM_MB 1.21e-17
* device instance cc_XD2_XDFFQ_S_XD5_XDFFM_MFB r0 *1 0,0
Ccc_XD2_XDFFQ_S_XD5_XDFFM_MFB XD2_XDFFQ_S XD5_XDFFM_MFB 1.21e-17
* device instance cc_XD2_XDFFQ_S_XD5_XDFFM_S r0 *1 0,0
Ccc_XD2_XDFFQ_S_XD5_XDFFM_S XD2_XDFFQ_S XD5_XDFFM_S 1.8151e-17
* device instance cc_XD2_XDFFQ_S_XD5_XDFFM_SB r0 *1 0,0
Ccc_XD2_XDFFQ_S_XD5_XDFFM_SB XD2_XDFFQ_S XD5_XDFFM_SB 1.8151e-17
* device instance cc_XD2_XDFFQ_S_XD5_XDFFM_SFB r0 *1 0,0
Ccc_XD2_XDFFQ_S_XD5_XDFFM_SFB XD2_XDFFQ_S XD5_XDFFM_SFB 1.21e-17
* device instance cc_XD2_XDFFQ_S_XD5_XDFFQ_CKBB r0 *1 0,0
Ccc_XD2_XDFFQ_S_XD5_XDFFQ_CKBB XD2_XDFFQ_S XD5_XDFFQ_CKBB 1.8151e-17
* device instance cc_XD2_XDFFQ_S_XD5_XDFFQ_CLKB r0 *1 0,0
Ccc_XD2_XDFFQ_S_XD5_XDFFQ_CLKB XD2_XDFFQ_S XD5_XDFFQ_CLKB 2.4201e-17
* device instance cc_XD2_XDFFQ_S_XD5_XDFFQ_M r0 *1 0,0
Ccc_XD2_XDFFQ_S_XD5_XDFFQ_M XD2_XDFFQ_S XD5_XDFFQ_M 2.4201e-17
* device instance cc_XD2_XDFFQ_S_XD5_XDFFQ_MB r0 *1 0,0
Ccc_XD2_XDFFQ_S_XD5_XDFFQ_MB XD2_XDFFQ_S XD5_XDFFQ_MB 1.21e-17
* device instance cc_XD2_XDFFQ_S_XD5_XDFFQ_MFB r0 *1 0,0
Ccc_XD2_XDFFQ_S_XD5_XDFFQ_MFB XD2_XDFFQ_S XD5_XDFFQ_MFB 1.21e-17
* device instance cc_XD2_XDFFQ_S_XD5_XDFFQ_S r0 *1 0,0
Ccc_XD2_XDFFQ_S_XD5_XDFFQ_S XD2_XDFFQ_S XD5_XDFFQ_S 1.8151e-17
* device instance cc_XD2_XDFFQ_S_XD5_XDFFQ_SB r0 *1 0,0
Ccc_XD2_XDFFQ_S_XD5_XDFFQ_SB XD2_XDFFQ_S XD5_XDFFQ_SB 1.8151e-17
* device instance cc_XD2_XDFFQ_S_XD5_XDFFQ_SFB r0 *1 0,0
Ccc_XD2_XDFFQ_S_XD5_XDFFQ_SFB XD2_XDFFQ_S XD5_XDFFQ_SFB 1.21e-17
* device instance cc_XD2_XDFFQ_S_XD5_XN2_mid1 r0 *1 0,0
Ccc_XD2_XDFFQ_S_XD5_XN2_mid1 XD2_XDFFQ_S XD5_XN2_mid1 1.21e-17
* device instance cc_XD2_XDFFQ_S_XD5_XN3_mid1 r0 *1 0,0
Ccc_XD2_XDFFQ_S_XD5_XN3_mid1 XD2_XDFFQ_S XD5_XN3_mid1 1.21e-17
* device instance cc_XD2_XDFFQ_S_XD5_XN3_mid2 r0 *1 0,0
Ccc_XD2_XDFFQ_S_XD5_XN3_mid2 XD2_XDFFQ_S XD5_XN3_mid2 1.21e-17
* device instance cc_XD2_XDFFQ_S_XD5_dmodout r0 *1 0,0
Ccc_XD2_XDFFQ_S_XD5_dmodout XD2_XDFFQ_S XD5_dmodout 1.21e-17
* device instance cc_XD2_XDFFQ_S_XD5_dq r0 *1 0,0
Ccc_XD2_XDFFQ_S_XD5_dq XD2_XDFFQ_S XD5_dq 1.8151e-17
* device instance cc_XD2_XDFFQ_S_XD5_nm r0 *1 0,0
Ccc_XD2_XDFFQ_S_XD5_nm XD2_XDFFQ_S XD5_nm 1.21e-17
* device instance cc_XD2_XDFFQ_S_XD5_nt r0 *1 0,0
Ccc_XD2_XDFFQ_S_XD5_nt XD2_XDFFQ_S XD5_nt 1.21e-17
* device instance cc_XD2_XDFFQ_S_XD5_t1 r0 *1 0,0
Ccc_XD2_XDFFQ_S_XD5_t1 XD2_XDFFQ_S XD5_t1 1.21e-17
* device instance cc_XD2_XDFFQ_S_XFRT_CKBB r0 *1 0,0
Ccc_XD2_XDFFQ_S_XFRT_CKBB XD2_XDFFQ_S XFRT_CKBB 1.8151e-17
* device instance cc_XD2_XDFFQ_S_XFRT_CLKB r0 *1 0,0
Ccc_XD2_XDFFQ_S_XFRT_CLKB XD2_XDFFQ_S XFRT_CLKB 2.4201e-17
* device instance cc_XD2_XDFFQ_S_XFRT_M r0 *1 0,0
Ccc_XD2_XDFFQ_S_XFRT_M XD2_XDFFQ_S XFRT_M 2.4201e-17
* device instance cc_XD2_XDFFQ_S_XFRT_MB r0 *1 0,0
Ccc_XD2_XDFFQ_S_XFRT_MB XD2_XDFFQ_S XFRT_MB 1.21e-17
* device instance cc_XD2_XDFFQ_S_XFRT_MFB r0 *1 0,0
Ccc_XD2_XDFFQ_S_XFRT_MFB XD2_XDFFQ_S XFRT_MFB 1.21e-17
* device instance cc_XD2_XDFFQ_S_XFRT_S r0 *1 0,0
Ccc_XD2_XDFFQ_S_XFRT_S XD2_XDFFQ_S XFRT_S 1.8151e-17
* device instance cc_XD2_XDFFQ_S_XFRT_SB r0 *1 0,0
Ccc_XD2_XDFFQ_S_XFRT_SB XD2_XDFFQ_S XFRT_SB 1.8151e-17
* device instance cc_XD2_XDFFQ_S_XFRT_SFB r0 *1 0,0
Ccc_XD2_XDFFQ_S_XFRT_SFB XD2_XDFFQ_S XFRT_SFB 1.21e-17
* device instance cc_XD2_XDFFQ_S_ck1 r0 *1 0,0
Ccc_XD2_XDFFQ_S_ck1 XD2_XDFFQ_S ck1 3.0251e-17
* device instance cc_XD2_XDFFQ_S_ck2 r0 *1 0,0
Ccc_XD2_XDFFQ_S_ck2 XD2_XDFFQ_S ck2 3.0251e-17
* device instance cc_XD2_XDFFQ_S_ck3 r0 *1 0,0
Ccc_XD2_XDFFQ_S_ck3 XD2_XDFFQ_S ck3 3.0251e-17
* device instance cc_XD2_XDFFQ_S_ck4 r0 *1 0,0
Ccc_XD2_XDFFQ_S_ck4 XD2_XDFFQ_S ck4 3.0251e-17
* device instance cc_XD2_XDFFQ_S_ck5 r0 *1 0,0
Ccc_XD2_XDFFQ_S_ck5 XD2_XDFFQ_S ck5 3.0251e-17
* device instance cc_XD2_XDFFQ_S_mod0 r0 *1 0,0
Ccc_XD2_XDFFQ_S_mod0 XD2_XDFFQ_S mod0 2.4201e-17
* device instance cc_XD2_XDFFQ_S_mod1 r0 *1 0,0
Ccc_XD2_XDFFQ_S_mod1 XD2_XDFFQ_S mod1 2.4201e-17
* device instance cc_XD2_XDFFQ_S_mod2 r0 *1 0,0
Ccc_XD2_XDFFQ_S_mod2 XD2_XDFFQ_S mod2 2.4201e-17
* device instance cc_XD2_XDFFQ_S_mod3 r0 *1 0,0
Ccc_XD2_XDFFQ_S_mod3 XD2_XDFFQ_S mod3 2.4201e-17
* device instance cc_XD2_XDFFQ_S_mod4 r0 *1 0,0
Ccc_XD2_XDFFQ_S_mod4 XD2_XDFFQ_S mod4 2.4201e-17
* device instance cc_XD2_XDFFQ_S_net1 r0 *1 0,0
Ccc_XD2_XDFFQ_S_net1 XD2_XDFFQ_S net1 1.21e-17
* device instance cc_XD2_XDFFQ_SB_XD2_XDFFQ_SFB r0 *1 0,0
Ccc_XD2_XDFFQ_SB_XD2_XDFFQ_SFB XD2_XDFFQ_SB XD2_XDFFQ_SFB 2.4201e-17
* device instance cc_XD2_XDFFQ_SB_XD2_XN2_mid1 r0 *1 0,0
Ccc_XD2_XDFFQ_SB_XD2_XN2_mid1 XD2_XDFFQ_SB XD2_XN2_mid1 1.21e-17
* device instance cc_XD2_XDFFQ_SB_XD2_XNOR_midp r0 *1 0,0
Ccc_XD2_XDFFQ_SB_XD2_XNOR_midp XD2_XDFFQ_SB XD2_XNOR_midp 1.21e-17
* device instance cc_XD2_XDFFQ_SB_XD2_dmodout r0 *1 0,0
Ccc_XD2_XDFFQ_SB_XD2_dmodout XD2_XDFFQ_SB XD2_dmodout 1.21e-17
* device instance cc_XD2_XDFFQ_SB_XD2_dq r0 *1 0,0
Ccc_XD2_XDFFQ_SB_XD2_dq XD2_XDFFQ_SB XD2_dq 1.21e-17
* device instance cc_XD2_XDFFQ_SB_XD2_nm r0 *1 0,0
Ccc_XD2_XDFFQ_SB_XD2_nm XD2_XDFFQ_SB XD2_nm 1.21e-17
* device instance cc_XD2_XDFFQ_SB_XD2_nt r0 *1 0,0
Ccc_XD2_XDFFQ_SB_XD2_nt XD2_XDFFQ_SB XD2_nt 2.4201e-17
* device instance cc_XD2_XDFFQ_SB_XD2_t1 r0 *1 0,0
Ccc_XD2_XDFFQ_SB_XD2_t1 XD2_XDFFQ_SB XD2_t1 1.21e-17
* device instance cc_XD2_XDFFQ_SB_XD3_XDFFM_CKBB r0 *1 0,0
Ccc_XD2_XDFFQ_SB_XD3_XDFFM_CKBB XD2_XDFFQ_SB XD3_XDFFM_CKBB 1.8151e-17
* device instance cc_XD2_XDFFQ_SB_XD3_XDFFM_CLKB r0 *1 0,0
Ccc_XD2_XDFFQ_SB_XD3_XDFFM_CLKB XD2_XDFFQ_SB XD3_XDFFM_CLKB 2.4201e-17
* device instance cc_XD2_XDFFQ_SB_XD3_XDFFM_M r0 *1 0,0
Ccc_XD2_XDFFQ_SB_XD3_XDFFM_M XD2_XDFFQ_SB XD3_XDFFM_M 2.4201e-17
* device instance cc_XD2_XDFFQ_SB_XD3_XDFFM_MB r0 *1 0,0
Ccc_XD2_XDFFQ_SB_XD3_XDFFM_MB XD2_XDFFQ_SB XD3_XDFFM_MB 1.21e-17
* device instance cc_XD2_XDFFQ_SB_XD3_XDFFM_MFB r0 *1 0,0
Ccc_XD2_XDFFQ_SB_XD3_XDFFM_MFB XD2_XDFFQ_SB XD3_XDFFM_MFB 1.21e-17
* device instance cc_XD2_XDFFQ_SB_XD3_XDFFM_S r0 *1 0,0
Ccc_XD2_XDFFQ_SB_XD3_XDFFM_S XD2_XDFFQ_SB XD3_XDFFM_S 1.8151e-17
* device instance cc_XD2_XDFFQ_SB_XD3_XDFFM_SB r0 *1 0,0
Ccc_XD2_XDFFQ_SB_XD3_XDFFM_SB XD2_XDFFQ_SB XD3_XDFFM_SB 1.8151e-17
* device instance cc_XD2_XDFFQ_SB_XD3_XDFFM_SFB r0 *1 0,0
Ccc_XD2_XDFFQ_SB_XD3_XDFFM_SFB XD2_XDFFQ_SB XD3_XDFFM_SFB 1.21e-17
* device instance cc_XD2_XDFFQ_SB_XD3_XDFFQ_CKBB r0 *1 0,0
Ccc_XD2_XDFFQ_SB_XD3_XDFFQ_CKBB XD2_XDFFQ_SB XD3_XDFFQ_CKBB 1.8151e-17
* device instance cc_XD2_XDFFQ_SB_XD3_XDFFQ_CLKB r0 *1 0,0
Ccc_XD2_XDFFQ_SB_XD3_XDFFQ_CLKB XD2_XDFFQ_SB XD3_XDFFQ_CLKB 2.4201e-17
* device instance cc_XD2_XDFFQ_SB_XD3_XDFFQ_M r0 *1 0,0
Ccc_XD2_XDFFQ_SB_XD3_XDFFQ_M XD2_XDFFQ_SB XD3_XDFFQ_M 2.4201e-17
* device instance cc_XD2_XDFFQ_SB_XD3_XDFFQ_MB r0 *1 0,0
Ccc_XD2_XDFFQ_SB_XD3_XDFFQ_MB XD2_XDFFQ_SB XD3_XDFFQ_MB 1.21e-17
* device instance cc_XD2_XDFFQ_SB_XD3_XDFFQ_MFB r0 *1 0,0
Ccc_XD2_XDFFQ_SB_XD3_XDFFQ_MFB XD2_XDFFQ_SB XD3_XDFFQ_MFB 1.21e-17
* device instance cc_XD2_XDFFQ_SB_XD3_XDFFQ_S r0 *1 0,0
Ccc_XD2_XDFFQ_SB_XD3_XDFFQ_S XD2_XDFFQ_SB XD3_XDFFQ_S 1.8151e-17
* device instance cc_XD2_XDFFQ_SB_XD3_XDFFQ_SB r0 *1 0,0
Ccc_XD2_XDFFQ_SB_XD3_XDFFQ_SB XD2_XDFFQ_SB XD3_XDFFQ_SB 1.8151e-17
* device instance cc_XD2_XDFFQ_SB_XD3_XDFFQ_SFB r0 *1 0,0
Ccc_XD2_XDFFQ_SB_XD3_XDFFQ_SFB XD2_XDFFQ_SB XD3_XDFFQ_SFB 1.21e-17
* device instance cc_XD2_XDFFQ_SB_XD3_XN2_mid1 r0 *1 0,0
Ccc_XD2_XDFFQ_SB_XD3_XN2_mid1 XD2_XDFFQ_SB XD3_XN2_mid1 1.21e-17
* device instance cc_XD2_XDFFQ_SB_XD3_XN3_mid1 r0 *1 0,0
Ccc_XD2_XDFFQ_SB_XD3_XN3_mid1 XD2_XDFFQ_SB XD3_XN3_mid1 1.21e-17
* device instance cc_XD2_XDFFQ_SB_XD3_XN3_mid2 r0 *1 0,0
Ccc_XD2_XDFFQ_SB_XD3_XN3_mid2 XD2_XDFFQ_SB XD3_XN3_mid2 1.21e-17
* device instance cc_XD2_XDFFQ_SB_XD3_dmodout r0 *1 0,0
Ccc_XD2_XDFFQ_SB_XD3_dmodout XD2_XDFFQ_SB XD3_dmodout 1.21e-17
* device instance cc_XD2_XDFFQ_SB_XD3_dq r0 *1 0,0
Ccc_XD2_XDFFQ_SB_XD3_dq XD2_XDFFQ_SB XD3_dq 1.8151e-17
* device instance cc_XD2_XDFFQ_SB_XD3_nm r0 *1 0,0
Ccc_XD2_XDFFQ_SB_XD3_nm XD2_XDFFQ_SB XD3_nm 1.21e-17
* device instance cc_XD2_XDFFQ_SB_XD3_nt r0 *1 0,0
Ccc_XD2_XDFFQ_SB_XD3_nt XD2_XDFFQ_SB XD3_nt 1.21e-17
* device instance cc_XD2_XDFFQ_SB_XD3_t1 r0 *1 0,0
Ccc_XD2_XDFFQ_SB_XD3_t1 XD2_XDFFQ_SB XD3_t1 1.21e-17
* device instance cc_XD2_XDFFQ_SB_XD4_XDFFM_CKBB r0 *1 0,0
Ccc_XD2_XDFFQ_SB_XD4_XDFFM_CKBB XD2_XDFFQ_SB XD4_XDFFM_CKBB 1.8151e-17
* device instance cc_XD2_XDFFQ_SB_XD4_XDFFM_CLKB r0 *1 0,0
Ccc_XD2_XDFFQ_SB_XD4_XDFFM_CLKB XD2_XDFFQ_SB XD4_XDFFM_CLKB 2.4201e-17
* device instance cc_XD2_XDFFQ_SB_XD4_XDFFM_M r0 *1 0,0
Ccc_XD2_XDFFQ_SB_XD4_XDFFM_M XD2_XDFFQ_SB XD4_XDFFM_M 2.4201e-17
* device instance cc_XD2_XDFFQ_SB_XD4_XDFFM_MB r0 *1 0,0
Ccc_XD2_XDFFQ_SB_XD4_XDFFM_MB XD2_XDFFQ_SB XD4_XDFFM_MB 1.21e-17
* device instance cc_XD2_XDFFQ_SB_XD4_XDFFM_MFB r0 *1 0,0
Ccc_XD2_XDFFQ_SB_XD4_XDFFM_MFB XD2_XDFFQ_SB XD4_XDFFM_MFB 1.21e-17
* device instance cc_XD2_XDFFQ_SB_XD4_XDFFM_S r0 *1 0,0
Ccc_XD2_XDFFQ_SB_XD4_XDFFM_S XD2_XDFFQ_SB XD4_XDFFM_S 1.8151e-17
* device instance cc_XD2_XDFFQ_SB_XD4_XDFFM_SB r0 *1 0,0
Ccc_XD2_XDFFQ_SB_XD4_XDFFM_SB XD2_XDFFQ_SB XD4_XDFFM_SB 1.8151e-17
* device instance cc_XD2_XDFFQ_SB_XD4_XDFFM_SFB r0 *1 0,0
Ccc_XD2_XDFFQ_SB_XD4_XDFFM_SFB XD2_XDFFQ_SB XD4_XDFFM_SFB 1.21e-17
* device instance cc_XD2_XDFFQ_SB_XD4_XDFFQ_CKBB r0 *1 0,0
Ccc_XD2_XDFFQ_SB_XD4_XDFFQ_CKBB XD2_XDFFQ_SB XD4_XDFFQ_CKBB 1.8151e-17
* device instance cc_XD2_XDFFQ_SB_XD4_XDFFQ_CLKB r0 *1 0,0
Ccc_XD2_XDFFQ_SB_XD4_XDFFQ_CLKB XD2_XDFFQ_SB XD4_XDFFQ_CLKB 2.4201e-17
* device instance cc_XD2_XDFFQ_SB_XD4_XDFFQ_M r0 *1 0,0
Ccc_XD2_XDFFQ_SB_XD4_XDFFQ_M XD2_XDFFQ_SB XD4_XDFFQ_M 2.4201e-17
* device instance cc_XD2_XDFFQ_SB_XD4_XDFFQ_MB r0 *1 0,0
Ccc_XD2_XDFFQ_SB_XD4_XDFFQ_MB XD2_XDFFQ_SB XD4_XDFFQ_MB 1.21e-17
* device instance cc_XD2_XDFFQ_SB_XD4_XDFFQ_MFB r0 *1 0,0
Ccc_XD2_XDFFQ_SB_XD4_XDFFQ_MFB XD2_XDFFQ_SB XD4_XDFFQ_MFB 1.21e-17
* device instance cc_XD2_XDFFQ_SB_XD4_XDFFQ_S r0 *1 0,0
Ccc_XD2_XDFFQ_SB_XD4_XDFFQ_S XD2_XDFFQ_SB XD4_XDFFQ_S 1.8151e-17
* device instance cc_XD2_XDFFQ_SB_XD4_XDFFQ_SB r0 *1 0,0
Ccc_XD2_XDFFQ_SB_XD4_XDFFQ_SB XD2_XDFFQ_SB XD4_XDFFQ_SB 1.8151e-17
* device instance cc_XD2_XDFFQ_SB_XD4_XDFFQ_SFB r0 *1 0,0
Ccc_XD2_XDFFQ_SB_XD4_XDFFQ_SFB XD2_XDFFQ_SB XD4_XDFFQ_SFB 1.21e-17
* device instance cc_XD2_XDFFQ_SB_XD4_XN2_mid1 r0 *1 0,0
Ccc_XD2_XDFFQ_SB_XD4_XN2_mid1 XD2_XDFFQ_SB XD4_XN2_mid1 1.21e-17
* device instance cc_XD2_XDFFQ_SB_XD4_XN3_mid1 r0 *1 0,0
Ccc_XD2_XDFFQ_SB_XD4_XN3_mid1 XD2_XDFFQ_SB XD4_XN3_mid1 1.21e-17
* device instance cc_XD2_XDFFQ_SB_XD4_XN3_mid2 r0 *1 0,0
Ccc_XD2_XDFFQ_SB_XD4_XN3_mid2 XD2_XDFFQ_SB XD4_XN3_mid2 1.21e-17
* device instance cc_XD2_XDFFQ_SB_XD4_dmodout r0 *1 0,0
Ccc_XD2_XDFFQ_SB_XD4_dmodout XD2_XDFFQ_SB XD4_dmodout 1.21e-17
* device instance cc_XD2_XDFFQ_SB_XD4_dq r0 *1 0,0
Ccc_XD2_XDFFQ_SB_XD4_dq XD2_XDFFQ_SB XD4_dq 1.8151e-17
* device instance cc_XD2_XDFFQ_SB_XD4_nm r0 *1 0,0
Ccc_XD2_XDFFQ_SB_XD4_nm XD2_XDFFQ_SB XD4_nm 1.21e-17
* device instance cc_XD2_XDFFQ_SB_XD4_nt r0 *1 0,0
Ccc_XD2_XDFFQ_SB_XD4_nt XD2_XDFFQ_SB XD4_nt 1.21e-17
* device instance cc_XD2_XDFFQ_SB_XD4_t1 r0 *1 0,0
Ccc_XD2_XDFFQ_SB_XD4_t1 XD2_XDFFQ_SB XD4_t1 1.21e-17
* device instance cc_XD2_XDFFQ_SB_XD5_XDFFM_CKBB r0 *1 0,0
Ccc_XD2_XDFFQ_SB_XD5_XDFFM_CKBB XD2_XDFFQ_SB XD5_XDFFM_CKBB 1.8151e-17
* device instance cc_XD2_XDFFQ_SB_XD5_XDFFM_CLKB r0 *1 0,0
Ccc_XD2_XDFFQ_SB_XD5_XDFFM_CLKB XD2_XDFFQ_SB XD5_XDFFM_CLKB 2.4201e-17
* device instance cc_XD2_XDFFQ_SB_XD5_XDFFM_M r0 *1 0,0
Ccc_XD2_XDFFQ_SB_XD5_XDFFM_M XD2_XDFFQ_SB XD5_XDFFM_M 2.4201e-17
* device instance cc_XD2_XDFFQ_SB_XD5_XDFFM_MB r0 *1 0,0
Ccc_XD2_XDFFQ_SB_XD5_XDFFM_MB XD2_XDFFQ_SB XD5_XDFFM_MB 1.21e-17
* device instance cc_XD2_XDFFQ_SB_XD5_XDFFM_MFB r0 *1 0,0
Ccc_XD2_XDFFQ_SB_XD5_XDFFM_MFB XD2_XDFFQ_SB XD5_XDFFM_MFB 1.21e-17
* device instance cc_XD2_XDFFQ_SB_XD5_XDFFM_S r0 *1 0,0
Ccc_XD2_XDFFQ_SB_XD5_XDFFM_S XD2_XDFFQ_SB XD5_XDFFM_S 1.8151e-17
* device instance cc_XD2_XDFFQ_SB_XD5_XDFFM_SB r0 *1 0,0
Ccc_XD2_XDFFQ_SB_XD5_XDFFM_SB XD2_XDFFQ_SB XD5_XDFFM_SB 1.8151e-17
* device instance cc_XD2_XDFFQ_SB_XD5_XDFFM_SFB r0 *1 0,0
Ccc_XD2_XDFFQ_SB_XD5_XDFFM_SFB XD2_XDFFQ_SB XD5_XDFFM_SFB 1.21e-17
* device instance cc_XD2_XDFFQ_SB_XD5_XDFFQ_CKBB r0 *1 0,0
Ccc_XD2_XDFFQ_SB_XD5_XDFFQ_CKBB XD2_XDFFQ_SB XD5_XDFFQ_CKBB 1.8151e-17
* device instance cc_XD2_XDFFQ_SB_XD5_XDFFQ_CLKB r0 *1 0,0
Ccc_XD2_XDFFQ_SB_XD5_XDFFQ_CLKB XD2_XDFFQ_SB XD5_XDFFQ_CLKB 2.4201e-17
* device instance cc_XD2_XDFFQ_SB_XD5_XDFFQ_M r0 *1 0,0
Ccc_XD2_XDFFQ_SB_XD5_XDFFQ_M XD2_XDFFQ_SB XD5_XDFFQ_M 2.4201e-17
* device instance cc_XD2_XDFFQ_SB_XD5_XDFFQ_MB r0 *1 0,0
Ccc_XD2_XDFFQ_SB_XD5_XDFFQ_MB XD2_XDFFQ_SB XD5_XDFFQ_MB 1.21e-17
* device instance cc_XD2_XDFFQ_SB_XD5_XDFFQ_MFB r0 *1 0,0
Ccc_XD2_XDFFQ_SB_XD5_XDFFQ_MFB XD2_XDFFQ_SB XD5_XDFFQ_MFB 1.21e-17
* device instance cc_XD2_XDFFQ_SB_XD5_XDFFQ_S r0 *1 0,0
Ccc_XD2_XDFFQ_SB_XD5_XDFFQ_S XD2_XDFFQ_SB XD5_XDFFQ_S 1.8151e-17
* device instance cc_XD2_XDFFQ_SB_XD5_XDFFQ_SB r0 *1 0,0
Ccc_XD2_XDFFQ_SB_XD5_XDFFQ_SB XD2_XDFFQ_SB XD5_XDFFQ_SB 1.8151e-17
* device instance cc_XD2_XDFFQ_SB_XD5_XDFFQ_SFB r0 *1 0,0
Ccc_XD2_XDFFQ_SB_XD5_XDFFQ_SFB XD2_XDFFQ_SB XD5_XDFFQ_SFB 1.21e-17
* device instance cc_XD2_XDFFQ_SB_XD5_XN2_mid1 r0 *1 0,0
Ccc_XD2_XDFFQ_SB_XD5_XN2_mid1 XD2_XDFFQ_SB XD5_XN2_mid1 1.21e-17
* device instance cc_XD2_XDFFQ_SB_XD5_XN3_mid1 r0 *1 0,0
Ccc_XD2_XDFFQ_SB_XD5_XN3_mid1 XD2_XDFFQ_SB XD5_XN3_mid1 1.21e-17
* device instance cc_XD2_XDFFQ_SB_XD5_XN3_mid2 r0 *1 0,0
Ccc_XD2_XDFFQ_SB_XD5_XN3_mid2 XD2_XDFFQ_SB XD5_XN3_mid2 1.21e-17
* device instance cc_XD2_XDFFQ_SB_XD5_dmodout r0 *1 0,0
Ccc_XD2_XDFFQ_SB_XD5_dmodout XD2_XDFFQ_SB XD5_dmodout 1.21e-17
* device instance cc_XD2_XDFFQ_SB_XD5_dq r0 *1 0,0
Ccc_XD2_XDFFQ_SB_XD5_dq XD2_XDFFQ_SB XD5_dq 1.8151e-17
* device instance cc_XD2_XDFFQ_SB_XD5_nm r0 *1 0,0
Ccc_XD2_XDFFQ_SB_XD5_nm XD2_XDFFQ_SB XD5_nm 1.21e-17
* device instance cc_XD2_XDFFQ_SB_XD5_nt r0 *1 0,0
Ccc_XD2_XDFFQ_SB_XD5_nt XD2_XDFFQ_SB XD5_nt 1.21e-17
* device instance cc_XD2_XDFFQ_SB_XD5_t1 r0 *1 0,0
Ccc_XD2_XDFFQ_SB_XD5_t1 XD2_XDFFQ_SB XD5_t1 1.21e-17
* device instance cc_XD2_XDFFQ_SB_XFRT_CKBB r0 *1 0,0
Ccc_XD2_XDFFQ_SB_XFRT_CKBB XD2_XDFFQ_SB XFRT_CKBB 1.8151e-17
* device instance cc_XD2_XDFFQ_SB_XFRT_CLKB r0 *1 0,0
Ccc_XD2_XDFFQ_SB_XFRT_CLKB XD2_XDFFQ_SB XFRT_CLKB 2.4201e-17
* device instance cc_XD2_XDFFQ_SB_XFRT_M r0 *1 0,0
Ccc_XD2_XDFFQ_SB_XFRT_M XD2_XDFFQ_SB XFRT_M 2.4201e-17
* device instance cc_XD2_XDFFQ_SB_XFRT_MB r0 *1 0,0
Ccc_XD2_XDFFQ_SB_XFRT_MB XD2_XDFFQ_SB XFRT_MB 1.21e-17
* device instance cc_XD2_XDFFQ_SB_XFRT_MFB r0 *1 0,0
Ccc_XD2_XDFFQ_SB_XFRT_MFB XD2_XDFFQ_SB XFRT_MFB 1.21e-17
* device instance cc_XD2_XDFFQ_SB_XFRT_S r0 *1 0,0
Ccc_XD2_XDFFQ_SB_XFRT_S XD2_XDFFQ_SB XFRT_S 1.8151e-17
* device instance cc_XD2_XDFFQ_SB_XFRT_SB r0 *1 0,0
Ccc_XD2_XDFFQ_SB_XFRT_SB XD2_XDFFQ_SB XFRT_SB 1.8151e-17
* device instance cc_XD2_XDFFQ_SB_XFRT_SFB r0 *1 0,0
Ccc_XD2_XDFFQ_SB_XFRT_SFB XD2_XDFFQ_SB XFRT_SFB 1.21e-17
* device instance cc_XD2_XDFFQ_SB_ck1 r0 *1 0,0
Ccc_XD2_XDFFQ_SB_ck1 XD2_XDFFQ_SB ck1 3.0251e-17
* device instance cc_XD2_XDFFQ_SB_ck2 r0 *1 0,0
Ccc_XD2_XDFFQ_SB_ck2 XD2_XDFFQ_SB ck2 3.0251e-17
* device instance cc_XD2_XDFFQ_SB_ck3 r0 *1 0,0
Ccc_XD2_XDFFQ_SB_ck3 XD2_XDFFQ_SB ck3 3.0251e-17
* device instance cc_XD2_XDFFQ_SB_ck4 r0 *1 0,0
Ccc_XD2_XDFFQ_SB_ck4 XD2_XDFFQ_SB ck4 3.0251e-17
* device instance cc_XD2_XDFFQ_SB_ck5 r0 *1 0,0
Ccc_XD2_XDFFQ_SB_ck5 XD2_XDFFQ_SB ck5 3.0251e-17
* device instance cc_XD2_XDFFQ_SB_mod0 r0 *1 0,0
Ccc_XD2_XDFFQ_SB_mod0 XD2_XDFFQ_SB mod0 2.4201e-17
* device instance cc_XD2_XDFFQ_SB_mod1 r0 *1 0,0
Ccc_XD2_XDFFQ_SB_mod1 XD2_XDFFQ_SB mod1 2.4201e-17
* device instance cc_XD2_XDFFQ_SB_mod2 r0 *1 0,0
Ccc_XD2_XDFFQ_SB_mod2 XD2_XDFFQ_SB mod2 2.4201e-17
* device instance cc_XD2_XDFFQ_SB_mod3 r0 *1 0,0
Ccc_XD2_XDFFQ_SB_mod3 XD2_XDFFQ_SB mod3 2.4201e-17
* device instance cc_XD2_XDFFQ_SB_mod4 r0 *1 0,0
Ccc_XD2_XDFFQ_SB_mod4 XD2_XDFFQ_SB mod4 2.4201e-17
* device instance cc_XD2_XDFFQ_SB_net1 r0 *1 0,0
Ccc_XD2_XDFFQ_SB_net1 XD2_XDFFQ_SB net1 1.21e-17
* device instance cc_XD2_XDFFQ_SFB_XD2_XN2_mid1 r0 *1 0,0
Ccc_XD2_XDFFQ_SFB_XD2_XN2_mid1 XD2_XDFFQ_SFB XD2_XN2_mid1 1.21e-17
* device instance cc_XD2_XDFFQ_SFB_XD2_XNOR_midp r0 *1 0,0
Ccc_XD2_XDFFQ_SFB_XD2_XNOR_midp XD2_XDFFQ_SFB XD2_XNOR_midp 1.21e-17
* device instance cc_XD2_XDFFQ_SFB_XD2_dmodout r0 *1 0,0
Ccc_XD2_XDFFQ_SFB_XD2_dmodout XD2_XDFFQ_SFB XD2_dmodout 1.21e-17
* device instance cc_XD2_XDFFQ_SFB_XD2_dq r0 *1 0,0
Ccc_XD2_XDFFQ_SFB_XD2_dq XD2_XDFFQ_SFB XD2_dq 1.21e-17
* device instance cc_XD2_XDFFQ_SFB_XD2_nm r0 *1 0,0
Ccc_XD2_XDFFQ_SFB_XD2_nm XD2_XDFFQ_SFB XD2_nm 1.21e-17
* device instance cc_XD2_XDFFQ_SFB_XD2_nt r0 *1 0,0
Ccc_XD2_XDFFQ_SFB_XD2_nt XD2_XDFFQ_SFB XD2_nt 2.4201e-17
* device instance cc_XD2_XDFFQ_SFB_XD2_t1 r0 *1 0,0
Ccc_XD2_XDFFQ_SFB_XD2_t1 XD2_XDFFQ_SFB XD2_t1 1.21e-17
* device instance cc_XD2_XDFFQ_SFB_XD3_XDFFM_CKBB r0 *1 0,0
Ccc_XD2_XDFFQ_SFB_XD3_XDFFM_CKBB XD2_XDFFQ_SFB XD3_XDFFM_CKBB 1.8151e-17
* device instance cc_XD2_XDFFQ_SFB_XD3_XDFFM_CLKB r0 *1 0,0
Ccc_XD2_XDFFQ_SFB_XD3_XDFFM_CLKB XD2_XDFFQ_SFB XD3_XDFFM_CLKB 2.4201e-17
* device instance cc_XD2_XDFFQ_SFB_XD3_XDFFM_M r0 *1 0,0
Ccc_XD2_XDFFQ_SFB_XD3_XDFFM_M XD2_XDFFQ_SFB XD3_XDFFM_M 2.4201e-17
* device instance cc_XD2_XDFFQ_SFB_XD3_XDFFM_MB r0 *1 0,0
Ccc_XD2_XDFFQ_SFB_XD3_XDFFM_MB XD2_XDFFQ_SFB XD3_XDFFM_MB 1.21e-17
* device instance cc_XD2_XDFFQ_SFB_XD3_XDFFM_MFB r0 *1 0,0
Ccc_XD2_XDFFQ_SFB_XD3_XDFFM_MFB XD2_XDFFQ_SFB XD3_XDFFM_MFB 1.21e-17
* device instance cc_XD2_XDFFQ_SFB_XD3_XDFFM_S r0 *1 0,0
Ccc_XD2_XDFFQ_SFB_XD3_XDFFM_S XD2_XDFFQ_SFB XD3_XDFFM_S 1.8151e-17
* device instance cc_XD2_XDFFQ_SFB_XD3_XDFFM_SB r0 *1 0,0
Ccc_XD2_XDFFQ_SFB_XD3_XDFFM_SB XD2_XDFFQ_SFB XD3_XDFFM_SB 1.8151e-17
* device instance cc_XD2_XDFFQ_SFB_XD3_XDFFM_SFB r0 *1 0,0
Ccc_XD2_XDFFQ_SFB_XD3_XDFFM_SFB XD2_XDFFQ_SFB XD3_XDFFM_SFB 1.21e-17
* device instance cc_XD2_XDFFQ_SFB_XD3_XDFFQ_CKBB r0 *1 0,0
Ccc_XD2_XDFFQ_SFB_XD3_XDFFQ_CKBB XD2_XDFFQ_SFB XD3_XDFFQ_CKBB 1.8151e-17
* device instance cc_XD2_XDFFQ_SFB_XD3_XDFFQ_CLKB r0 *1 0,0
Ccc_XD2_XDFFQ_SFB_XD3_XDFFQ_CLKB XD2_XDFFQ_SFB XD3_XDFFQ_CLKB 2.4201e-17
* device instance cc_XD2_XDFFQ_SFB_XD3_XDFFQ_M r0 *1 0,0
Ccc_XD2_XDFFQ_SFB_XD3_XDFFQ_M XD2_XDFFQ_SFB XD3_XDFFQ_M 2.4201e-17
* device instance cc_XD2_XDFFQ_SFB_XD3_XDFFQ_MB r0 *1 0,0
Ccc_XD2_XDFFQ_SFB_XD3_XDFFQ_MB XD2_XDFFQ_SFB XD3_XDFFQ_MB 1.21e-17
* device instance cc_XD2_XDFFQ_SFB_XD3_XDFFQ_MFB r0 *1 0,0
Ccc_XD2_XDFFQ_SFB_XD3_XDFFQ_MFB XD2_XDFFQ_SFB XD3_XDFFQ_MFB 1.21e-17
* device instance cc_XD2_XDFFQ_SFB_XD3_XDFFQ_S r0 *1 0,0
Ccc_XD2_XDFFQ_SFB_XD3_XDFFQ_S XD2_XDFFQ_SFB XD3_XDFFQ_S 1.8151e-17
* device instance cc_XD2_XDFFQ_SFB_XD3_XDFFQ_SB r0 *1 0,0
Ccc_XD2_XDFFQ_SFB_XD3_XDFFQ_SB XD2_XDFFQ_SFB XD3_XDFFQ_SB 1.8151e-17
* device instance cc_XD2_XDFFQ_SFB_XD3_XDFFQ_SFB r0 *1 0,0
Ccc_XD2_XDFFQ_SFB_XD3_XDFFQ_SFB XD2_XDFFQ_SFB XD3_XDFFQ_SFB 1.21e-17
* device instance cc_XD2_XDFFQ_SFB_XD3_XN2_mid1 r0 *1 0,0
Ccc_XD2_XDFFQ_SFB_XD3_XN2_mid1 XD2_XDFFQ_SFB XD3_XN2_mid1 1.21e-17
* device instance cc_XD2_XDFFQ_SFB_XD3_XN3_mid1 r0 *1 0,0
Ccc_XD2_XDFFQ_SFB_XD3_XN3_mid1 XD2_XDFFQ_SFB XD3_XN3_mid1 1.21e-17
* device instance cc_XD2_XDFFQ_SFB_XD3_XN3_mid2 r0 *1 0,0
Ccc_XD2_XDFFQ_SFB_XD3_XN3_mid2 XD2_XDFFQ_SFB XD3_XN3_mid2 1.21e-17
* device instance cc_XD2_XDFFQ_SFB_XD3_dmodout r0 *1 0,0
Ccc_XD2_XDFFQ_SFB_XD3_dmodout XD2_XDFFQ_SFB XD3_dmodout 1.21e-17
* device instance cc_XD2_XDFFQ_SFB_XD3_dq r0 *1 0,0
Ccc_XD2_XDFFQ_SFB_XD3_dq XD2_XDFFQ_SFB XD3_dq 1.8151e-17
* device instance cc_XD2_XDFFQ_SFB_XD3_nm r0 *1 0,0
Ccc_XD2_XDFFQ_SFB_XD3_nm XD2_XDFFQ_SFB XD3_nm 1.21e-17
* device instance cc_XD2_XDFFQ_SFB_XD3_nt r0 *1 0,0
Ccc_XD2_XDFFQ_SFB_XD3_nt XD2_XDFFQ_SFB XD3_nt 1.21e-17
* device instance cc_XD2_XDFFQ_SFB_XD3_t1 r0 *1 0,0
Ccc_XD2_XDFFQ_SFB_XD3_t1 XD2_XDFFQ_SFB XD3_t1 1.21e-17
* device instance cc_XD2_XDFFQ_SFB_XD4_XDFFM_CKBB r0 *1 0,0
Ccc_XD2_XDFFQ_SFB_XD4_XDFFM_CKBB XD2_XDFFQ_SFB XD4_XDFFM_CKBB 1.8151e-17
* device instance cc_XD2_XDFFQ_SFB_XD4_XDFFM_CLKB r0 *1 0,0
Ccc_XD2_XDFFQ_SFB_XD4_XDFFM_CLKB XD2_XDFFQ_SFB XD4_XDFFM_CLKB 2.4201e-17
* device instance cc_XD2_XDFFQ_SFB_XD4_XDFFM_M r0 *1 0,0
Ccc_XD2_XDFFQ_SFB_XD4_XDFFM_M XD2_XDFFQ_SFB XD4_XDFFM_M 2.4201e-17
* device instance cc_XD2_XDFFQ_SFB_XD4_XDFFM_MB r0 *1 0,0
Ccc_XD2_XDFFQ_SFB_XD4_XDFFM_MB XD2_XDFFQ_SFB XD4_XDFFM_MB 1.21e-17
* device instance cc_XD2_XDFFQ_SFB_XD4_XDFFM_MFB r0 *1 0,0
Ccc_XD2_XDFFQ_SFB_XD4_XDFFM_MFB XD2_XDFFQ_SFB XD4_XDFFM_MFB 1.21e-17
* device instance cc_XD2_XDFFQ_SFB_XD4_XDFFM_S r0 *1 0,0
Ccc_XD2_XDFFQ_SFB_XD4_XDFFM_S XD2_XDFFQ_SFB XD4_XDFFM_S 1.8151e-17
* device instance cc_XD2_XDFFQ_SFB_XD4_XDFFM_SB r0 *1 0,0
Ccc_XD2_XDFFQ_SFB_XD4_XDFFM_SB XD2_XDFFQ_SFB XD4_XDFFM_SB 1.8151e-17
* device instance cc_XD2_XDFFQ_SFB_XD4_XDFFM_SFB r0 *1 0,0
Ccc_XD2_XDFFQ_SFB_XD4_XDFFM_SFB XD2_XDFFQ_SFB XD4_XDFFM_SFB 1.21e-17
* device instance cc_XD2_XDFFQ_SFB_XD4_XDFFQ_CKBB r0 *1 0,0
Ccc_XD2_XDFFQ_SFB_XD4_XDFFQ_CKBB XD2_XDFFQ_SFB XD4_XDFFQ_CKBB 1.8151e-17
* device instance cc_XD2_XDFFQ_SFB_XD4_XDFFQ_CLKB r0 *1 0,0
Ccc_XD2_XDFFQ_SFB_XD4_XDFFQ_CLKB XD2_XDFFQ_SFB XD4_XDFFQ_CLKB 2.4201e-17
* device instance cc_XD2_XDFFQ_SFB_XD4_XDFFQ_M r0 *1 0,0
Ccc_XD2_XDFFQ_SFB_XD4_XDFFQ_M XD2_XDFFQ_SFB XD4_XDFFQ_M 2.4201e-17
* device instance cc_XD2_XDFFQ_SFB_XD4_XDFFQ_MB r0 *1 0,0
Ccc_XD2_XDFFQ_SFB_XD4_XDFFQ_MB XD2_XDFFQ_SFB XD4_XDFFQ_MB 1.21e-17
* device instance cc_XD2_XDFFQ_SFB_XD4_XDFFQ_MFB r0 *1 0,0
Ccc_XD2_XDFFQ_SFB_XD4_XDFFQ_MFB XD2_XDFFQ_SFB XD4_XDFFQ_MFB 1.21e-17
* device instance cc_XD2_XDFFQ_SFB_XD4_XDFFQ_S r0 *1 0,0
Ccc_XD2_XDFFQ_SFB_XD4_XDFFQ_S XD2_XDFFQ_SFB XD4_XDFFQ_S 1.8151e-17
* device instance cc_XD2_XDFFQ_SFB_XD4_XDFFQ_SB r0 *1 0,0
Ccc_XD2_XDFFQ_SFB_XD4_XDFFQ_SB XD2_XDFFQ_SFB XD4_XDFFQ_SB 1.8151e-17
* device instance cc_XD2_XDFFQ_SFB_XD4_XDFFQ_SFB r0 *1 0,0
Ccc_XD2_XDFFQ_SFB_XD4_XDFFQ_SFB XD2_XDFFQ_SFB XD4_XDFFQ_SFB 1.21e-17
* device instance cc_XD2_XDFFQ_SFB_XD4_XN2_mid1 r0 *1 0,0
Ccc_XD2_XDFFQ_SFB_XD4_XN2_mid1 XD2_XDFFQ_SFB XD4_XN2_mid1 1.21e-17
* device instance cc_XD2_XDFFQ_SFB_XD4_XN3_mid1 r0 *1 0,0
Ccc_XD2_XDFFQ_SFB_XD4_XN3_mid1 XD2_XDFFQ_SFB XD4_XN3_mid1 1.21e-17
* device instance cc_XD2_XDFFQ_SFB_XD4_XN3_mid2 r0 *1 0,0
Ccc_XD2_XDFFQ_SFB_XD4_XN3_mid2 XD2_XDFFQ_SFB XD4_XN3_mid2 1.21e-17
* device instance cc_XD2_XDFFQ_SFB_XD4_dmodout r0 *1 0,0
Ccc_XD2_XDFFQ_SFB_XD4_dmodout XD2_XDFFQ_SFB XD4_dmodout 1.21e-17
* device instance cc_XD2_XDFFQ_SFB_XD4_dq r0 *1 0,0
Ccc_XD2_XDFFQ_SFB_XD4_dq XD2_XDFFQ_SFB XD4_dq 1.8151e-17
* device instance cc_XD2_XDFFQ_SFB_XD4_nm r0 *1 0,0
Ccc_XD2_XDFFQ_SFB_XD4_nm XD2_XDFFQ_SFB XD4_nm 1.21e-17
* device instance cc_XD2_XDFFQ_SFB_XD4_nt r0 *1 0,0
Ccc_XD2_XDFFQ_SFB_XD4_nt XD2_XDFFQ_SFB XD4_nt 1.21e-17
* device instance cc_XD2_XDFFQ_SFB_XD4_t1 r0 *1 0,0
Ccc_XD2_XDFFQ_SFB_XD4_t1 XD2_XDFFQ_SFB XD4_t1 1.21e-17
* device instance cc_XD2_XDFFQ_SFB_XD5_XDFFM_CKBB r0 *1 0,0
Ccc_XD2_XDFFQ_SFB_XD5_XDFFM_CKBB XD2_XDFFQ_SFB XD5_XDFFM_CKBB 1.8151e-17
* device instance cc_XD2_XDFFQ_SFB_XD5_XDFFM_CLKB r0 *1 0,0
Ccc_XD2_XDFFQ_SFB_XD5_XDFFM_CLKB XD2_XDFFQ_SFB XD5_XDFFM_CLKB 2.4201e-17
* device instance cc_XD2_XDFFQ_SFB_XD5_XDFFM_M r0 *1 0,0
Ccc_XD2_XDFFQ_SFB_XD5_XDFFM_M XD2_XDFFQ_SFB XD5_XDFFM_M 2.4201e-17
* device instance cc_XD2_XDFFQ_SFB_XD5_XDFFM_MB r0 *1 0,0
Ccc_XD2_XDFFQ_SFB_XD5_XDFFM_MB XD2_XDFFQ_SFB XD5_XDFFM_MB 1.21e-17
* device instance cc_XD2_XDFFQ_SFB_XD5_XDFFM_MFB r0 *1 0,0
Ccc_XD2_XDFFQ_SFB_XD5_XDFFM_MFB XD2_XDFFQ_SFB XD5_XDFFM_MFB 1.21e-17
* device instance cc_XD2_XDFFQ_SFB_XD5_XDFFM_S r0 *1 0,0
Ccc_XD2_XDFFQ_SFB_XD5_XDFFM_S XD2_XDFFQ_SFB XD5_XDFFM_S 1.8151e-17
* device instance cc_XD2_XDFFQ_SFB_XD5_XDFFM_SB r0 *1 0,0
Ccc_XD2_XDFFQ_SFB_XD5_XDFFM_SB XD2_XDFFQ_SFB XD5_XDFFM_SB 1.8151e-17
* device instance cc_XD2_XDFFQ_SFB_XD5_XDFFM_SFB r0 *1 0,0
Ccc_XD2_XDFFQ_SFB_XD5_XDFFM_SFB XD2_XDFFQ_SFB XD5_XDFFM_SFB 1.21e-17
* device instance cc_XD2_XDFFQ_SFB_XD5_XDFFQ_CKBB r0 *1 0,0
Ccc_XD2_XDFFQ_SFB_XD5_XDFFQ_CKBB XD2_XDFFQ_SFB XD5_XDFFQ_CKBB 1.8151e-17
* device instance cc_XD2_XDFFQ_SFB_XD5_XDFFQ_CLKB r0 *1 0,0
Ccc_XD2_XDFFQ_SFB_XD5_XDFFQ_CLKB XD2_XDFFQ_SFB XD5_XDFFQ_CLKB 2.4201e-17
* device instance cc_XD2_XDFFQ_SFB_XD5_XDFFQ_M r0 *1 0,0
Ccc_XD2_XDFFQ_SFB_XD5_XDFFQ_M XD2_XDFFQ_SFB XD5_XDFFQ_M 2.4201e-17
* device instance cc_XD2_XDFFQ_SFB_XD5_XDFFQ_MB r0 *1 0,0
Ccc_XD2_XDFFQ_SFB_XD5_XDFFQ_MB XD2_XDFFQ_SFB XD5_XDFFQ_MB 1.21e-17
* device instance cc_XD2_XDFFQ_SFB_XD5_XDFFQ_MFB r0 *1 0,0
Ccc_XD2_XDFFQ_SFB_XD5_XDFFQ_MFB XD2_XDFFQ_SFB XD5_XDFFQ_MFB 1.21e-17
* device instance cc_XD2_XDFFQ_SFB_XD5_XDFFQ_S r0 *1 0,0
Ccc_XD2_XDFFQ_SFB_XD5_XDFFQ_S XD2_XDFFQ_SFB XD5_XDFFQ_S 1.8151e-17
* device instance cc_XD2_XDFFQ_SFB_XD5_XDFFQ_SB r0 *1 0,0
Ccc_XD2_XDFFQ_SFB_XD5_XDFFQ_SB XD2_XDFFQ_SFB XD5_XDFFQ_SB 1.8151e-17
* device instance cc_XD2_XDFFQ_SFB_XD5_XDFFQ_SFB r0 *1 0,0
Ccc_XD2_XDFFQ_SFB_XD5_XDFFQ_SFB XD2_XDFFQ_SFB XD5_XDFFQ_SFB 1.21e-17
* device instance cc_XD2_XDFFQ_SFB_XD5_XN2_mid1 r0 *1 0,0
Ccc_XD2_XDFFQ_SFB_XD5_XN2_mid1 XD2_XDFFQ_SFB XD5_XN2_mid1 1.21e-17
* device instance cc_XD2_XDFFQ_SFB_XD5_XN3_mid1 r0 *1 0,0
Ccc_XD2_XDFFQ_SFB_XD5_XN3_mid1 XD2_XDFFQ_SFB XD5_XN3_mid1 1.21e-17
* device instance cc_XD2_XDFFQ_SFB_XD5_XN3_mid2 r0 *1 0,0
Ccc_XD2_XDFFQ_SFB_XD5_XN3_mid2 XD2_XDFFQ_SFB XD5_XN3_mid2 1.21e-17
* device instance cc_XD2_XDFFQ_SFB_XD5_dmodout r0 *1 0,0
Ccc_XD2_XDFFQ_SFB_XD5_dmodout XD2_XDFFQ_SFB XD5_dmodout 1.21e-17
* device instance cc_XD2_XDFFQ_SFB_XD5_dq r0 *1 0,0
Ccc_XD2_XDFFQ_SFB_XD5_dq XD2_XDFFQ_SFB XD5_dq 1.8151e-17
* device instance cc_XD2_XDFFQ_SFB_XD5_nm r0 *1 0,0
Ccc_XD2_XDFFQ_SFB_XD5_nm XD2_XDFFQ_SFB XD5_nm 1.21e-17
* device instance cc_XD2_XDFFQ_SFB_XD5_nt r0 *1 0,0
Ccc_XD2_XDFFQ_SFB_XD5_nt XD2_XDFFQ_SFB XD5_nt 1.21e-17
* device instance cc_XD2_XDFFQ_SFB_XD5_t1 r0 *1 0,0
Ccc_XD2_XDFFQ_SFB_XD5_t1 XD2_XDFFQ_SFB XD5_t1 1.21e-17
* device instance cc_XD2_XDFFQ_SFB_XFRT_CKBB r0 *1 0,0
Ccc_XD2_XDFFQ_SFB_XFRT_CKBB XD2_XDFFQ_SFB XFRT_CKBB 1.8151e-17
* device instance cc_XD2_XDFFQ_SFB_XFRT_CLKB r0 *1 0,0
Ccc_XD2_XDFFQ_SFB_XFRT_CLKB XD2_XDFFQ_SFB XFRT_CLKB 2.4201e-17
* device instance cc_XD2_XDFFQ_SFB_XFRT_M r0 *1 0,0
Ccc_XD2_XDFFQ_SFB_XFRT_M XD2_XDFFQ_SFB XFRT_M 2.4201e-17
* device instance cc_XD2_XDFFQ_SFB_XFRT_MB r0 *1 0,0
Ccc_XD2_XDFFQ_SFB_XFRT_MB XD2_XDFFQ_SFB XFRT_MB 1.21e-17
* device instance cc_XD2_XDFFQ_SFB_XFRT_MFB r0 *1 0,0
Ccc_XD2_XDFFQ_SFB_XFRT_MFB XD2_XDFFQ_SFB XFRT_MFB 1.21e-17
* device instance cc_XD2_XDFFQ_SFB_XFRT_S r0 *1 0,0
Ccc_XD2_XDFFQ_SFB_XFRT_S XD2_XDFFQ_SFB XFRT_S 1.8151e-17
* device instance cc_XD2_XDFFQ_SFB_XFRT_SB r0 *1 0,0
Ccc_XD2_XDFFQ_SFB_XFRT_SB XD2_XDFFQ_SFB XFRT_SB 1.8151e-17
* device instance cc_XD2_XDFFQ_SFB_XFRT_SFB r0 *1 0,0
Ccc_XD2_XDFFQ_SFB_XFRT_SFB XD2_XDFFQ_SFB XFRT_SFB 1.21e-17
* device instance cc_XD2_XDFFQ_SFB_ck1 r0 *1 0,0
Ccc_XD2_XDFFQ_SFB_ck1 XD2_XDFFQ_SFB ck1 3.0251e-17
* device instance cc_XD2_XDFFQ_SFB_ck2 r0 *1 0,0
Ccc_XD2_XDFFQ_SFB_ck2 XD2_XDFFQ_SFB ck2 3.0251e-17
* device instance cc_XD2_XDFFQ_SFB_ck3 r0 *1 0,0
Ccc_XD2_XDFFQ_SFB_ck3 XD2_XDFFQ_SFB ck3 3.0251e-17
* device instance cc_XD2_XDFFQ_SFB_ck4 r0 *1 0,0
Ccc_XD2_XDFFQ_SFB_ck4 XD2_XDFFQ_SFB ck4 3.0251e-17
* device instance cc_XD2_XDFFQ_SFB_ck5 r0 *1 0,0
Ccc_XD2_XDFFQ_SFB_ck5 XD2_XDFFQ_SFB ck5 3.0251e-17
* device instance cc_XD2_XDFFQ_SFB_mod0 r0 *1 0,0
Ccc_XD2_XDFFQ_SFB_mod0 XD2_XDFFQ_SFB mod0 2.4201e-17
* device instance cc_XD2_XDFFQ_SFB_mod1 r0 *1 0,0
Ccc_XD2_XDFFQ_SFB_mod1 XD2_XDFFQ_SFB mod1 2.4201e-17
* device instance cc_XD2_XDFFQ_SFB_mod2 r0 *1 0,0
Ccc_XD2_XDFFQ_SFB_mod2 XD2_XDFFQ_SFB mod2 2.4201e-17
* device instance cc_XD2_XDFFQ_SFB_mod3 r0 *1 0,0
Ccc_XD2_XDFFQ_SFB_mod3 XD2_XDFFQ_SFB mod3 2.4201e-17
* device instance cc_XD2_XDFFQ_SFB_mod4 r0 *1 0,0
Ccc_XD2_XDFFQ_SFB_mod4 XD2_XDFFQ_SFB mod4 2.4201e-17
* device instance cc_XD2_XDFFQ_SFB_net1 r0 *1 0,0
Ccc_XD2_XDFFQ_SFB_net1 XD2_XDFFQ_SFB net1 1.21e-17
* device instance cc_XD2_XN2_mid1_XD2_nm r0 *1 0,0
Ccc_XD2_XN2_mid1_XD2_nm XD2_XN2_mid1 XD2_nm 1.1294e-17
* device instance cc_XD2_XN2_mid1_ck3 r0 *1 0,0
Ccc_XD2_XN2_mid1_ck3 XD2_XN2_mid1 ck3 6.05e-18
* device instance cc_XD2_XN3_mid1_XD2_XN3_mid2 r0 *1 0,0
Ccc_XD2_XN3_mid1_XD2_XN3_mid2 XD2_XN3_mid1 XD2_XN3_mid2 1.1294e-17
* device instance cc_XD2_XN3_mid1_XD2_nt r0 *1 0,0
Ccc_XD2_XN3_mid1_XD2_nt XD2_XN3_mid1 XD2_nt 1.1294e-17
* device instance cc_XD2_XN3_mid2_mod1 r0 *1 0,0
Ccc_XD2_XN3_mid2_mod1 XD2_XN3_mid2 mod1 6.05e-18
* device instance cc_XD2_XNOR_midp_XD2_dq r0 *1 0,0
Ccc_XD2_XNOR_midp_XD2_dq XD2_XNOR_midp XD2_dq 5.244e-18
* device instance cc_XD2_XNOR_midp_XD2_t1 r0 *1 0,0
Ccc_XD2_XNOR_midp_XD2_t1 XD2_XNOR_midp XD2_t1 6.05e-18
* device instance cc_XD2_dmodout_XD2_dq r0 *1 0,0
Ccc_XD2_dmodout_XD2_dq XD2_dmodout XD2_dq 1.21e-17
* device instance cc_XD2_dmodout_XD2_nm r0 *1 0,0
Ccc_XD2_dmodout_XD2_nm XD2_dmodout XD2_nm 1.8151e-17
* device instance cc_XD2_dmodout_XD2_nt r0 *1 0,0
Ccc_XD2_dmodout_XD2_nt XD2_dmodout XD2_nt 2.4201e-17
* device instance cc_XD2_dmodout_XD2_t1 r0 *1 0,0
Ccc_XD2_dmodout_XD2_t1 XD2_dmodout XD2_t1 1.21e-17
* device instance cc_XD2_dmodout_XD3_XDFFM_CKBB r0 *1 0,0
Ccc_XD2_dmodout_XD3_XDFFM_CKBB XD2_dmodout XD3_XDFFM_CKBB 1.8151e-17
* device instance cc_XD2_dmodout_XD3_XDFFM_CLKB r0 *1 0,0
Ccc_XD2_dmodout_XD3_XDFFM_CLKB XD2_dmodout XD3_XDFFM_CLKB 2.4201e-17
* device instance cc_XD2_dmodout_XD3_XDFFM_M r0 *1 0,0
Ccc_XD2_dmodout_XD3_XDFFM_M XD2_dmodout XD3_XDFFM_M 2.4201e-17
* device instance cc_XD2_dmodout_XD3_XDFFM_MB r0 *1 0,0
Ccc_XD2_dmodout_XD3_XDFFM_MB XD2_dmodout XD3_XDFFM_MB 1.21e-17
* device instance cc_XD2_dmodout_XD3_XDFFM_MFB r0 *1 0,0
Ccc_XD2_dmodout_XD3_XDFFM_MFB XD2_dmodout XD3_XDFFM_MFB 1.21e-17
* device instance cc_XD2_dmodout_XD3_XDFFM_S r0 *1 0,0
Ccc_XD2_dmodout_XD3_XDFFM_S XD2_dmodout XD3_XDFFM_S 1.8151e-17
* device instance cc_XD2_dmodout_XD3_XDFFM_SB r0 *1 0,0
Ccc_XD2_dmodout_XD3_XDFFM_SB XD2_dmodout XD3_XDFFM_SB 1.8151e-17
* device instance cc_XD2_dmodout_XD3_XDFFM_SFB r0 *1 0,0
Ccc_XD2_dmodout_XD3_XDFFM_SFB XD2_dmodout XD3_XDFFM_SFB 1.21e-17
* device instance cc_XD2_dmodout_XD3_XDFFQ_CKBB r0 *1 0,0
Ccc_XD2_dmodout_XD3_XDFFQ_CKBB XD2_dmodout XD3_XDFFQ_CKBB 1.8151e-17
* device instance cc_XD2_dmodout_XD3_XDFFQ_CLKB r0 *1 0,0
Ccc_XD2_dmodout_XD3_XDFFQ_CLKB XD2_dmodout XD3_XDFFQ_CLKB 2.4201e-17
* device instance cc_XD2_dmodout_XD3_XDFFQ_M r0 *1 0,0
Ccc_XD2_dmodout_XD3_XDFFQ_M XD2_dmodout XD3_XDFFQ_M 2.4201e-17
* device instance cc_XD2_dmodout_XD3_XDFFQ_MB r0 *1 0,0
Ccc_XD2_dmodout_XD3_XDFFQ_MB XD2_dmodout XD3_XDFFQ_MB 1.21e-17
* device instance cc_XD2_dmodout_XD3_XDFFQ_MFB r0 *1 0,0
Ccc_XD2_dmodout_XD3_XDFFQ_MFB XD2_dmodout XD3_XDFFQ_MFB 1.21e-17
* device instance cc_XD2_dmodout_XD3_XDFFQ_S r0 *1 0,0
Ccc_XD2_dmodout_XD3_XDFFQ_S XD2_dmodout XD3_XDFFQ_S 1.8151e-17
* device instance cc_XD2_dmodout_XD3_XDFFQ_SB r0 *1 0,0
Ccc_XD2_dmodout_XD3_XDFFQ_SB XD2_dmodout XD3_XDFFQ_SB 1.8151e-17
* device instance cc_XD2_dmodout_XD3_XDFFQ_SFB r0 *1 0,0
Ccc_XD2_dmodout_XD3_XDFFQ_SFB XD2_dmodout XD3_XDFFQ_SFB 1.21e-17
* device instance cc_XD2_dmodout_XD3_XN2_mid1 r0 *1 0,0
Ccc_XD2_dmodout_XD3_XN2_mid1 XD2_dmodout XD3_XN2_mid1 1.21e-17
* device instance cc_XD2_dmodout_XD3_XN3_mid1 r0 *1 0,0
Ccc_XD2_dmodout_XD3_XN3_mid1 XD2_dmodout XD3_XN3_mid1 1.21e-17
* device instance cc_XD2_dmodout_XD3_XN3_mid2 r0 *1 0,0
Ccc_XD2_dmodout_XD3_XN3_mid2 XD2_dmodout XD3_XN3_mid2 1.21e-17
* device instance cc_XD2_dmodout_XD3_dmodout r0 *1 0,0
Ccc_XD2_dmodout_XD3_dmodout XD2_dmodout XD3_dmodout 1.21e-17
* device instance cc_XD2_dmodout_XD3_dq r0 *1 0,0
Ccc_XD2_dmodout_XD3_dq XD2_dmodout XD3_dq 1.8151e-17
* device instance cc_XD2_dmodout_XD3_nm r0 *1 0,0
Ccc_XD2_dmodout_XD3_nm XD2_dmodout XD3_nm 1.21e-17
* device instance cc_XD2_dmodout_XD3_nt r0 *1 0,0
Ccc_XD2_dmodout_XD3_nt XD2_dmodout XD3_nt 1.21e-17
* device instance cc_XD2_dmodout_XD3_t1 r0 *1 0,0
Ccc_XD2_dmodout_XD3_t1 XD2_dmodout XD3_t1 1.21e-17
* device instance cc_XD2_dmodout_XD4_XDFFM_CKBB r0 *1 0,0
Ccc_XD2_dmodout_XD4_XDFFM_CKBB XD2_dmodout XD4_XDFFM_CKBB 1.8151e-17
* device instance cc_XD2_dmodout_XD4_XDFFM_CLKB r0 *1 0,0
Ccc_XD2_dmodout_XD4_XDFFM_CLKB XD2_dmodout XD4_XDFFM_CLKB 2.4201e-17
* device instance cc_XD2_dmodout_XD4_XDFFM_M r0 *1 0,0
Ccc_XD2_dmodout_XD4_XDFFM_M XD2_dmodout XD4_XDFFM_M 2.4201e-17
* device instance cc_XD2_dmodout_XD4_XDFFM_MB r0 *1 0,0
Ccc_XD2_dmodout_XD4_XDFFM_MB XD2_dmodout XD4_XDFFM_MB 1.21e-17
* device instance cc_XD2_dmodout_XD4_XDFFM_MFB r0 *1 0,0
Ccc_XD2_dmodout_XD4_XDFFM_MFB XD2_dmodout XD4_XDFFM_MFB 1.21e-17
* device instance cc_XD2_dmodout_XD4_XDFFM_S r0 *1 0,0
Ccc_XD2_dmodout_XD4_XDFFM_S XD2_dmodout XD4_XDFFM_S 1.8151e-17
* device instance cc_XD2_dmodout_XD4_XDFFM_SB r0 *1 0,0
Ccc_XD2_dmodout_XD4_XDFFM_SB XD2_dmodout XD4_XDFFM_SB 1.8151e-17
* device instance cc_XD2_dmodout_XD4_XDFFM_SFB r0 *1 0,0
Ccc_XD2_dmodout_XD4_XDFFM_SFB XD2_dmodout XD4_XDFFM_SFB 1.21e-17
* device instance cc_XD2_dmodout_XD4_XDFFQ_CKBB r0 *1 0,0
Ccc_XD2_dmodout_XD4_XDFFQ_CKBB XD2_dmodout XD4_XDFFQ_CKBB 1.8151e-17
* device instance cc_XD2_dmodout_XD4_XDFFQ_CLKB r0 *1 0,0
Ccc_XD2_dmodout_XD4_XDFFQ_CLKB XD2_dmodout XD4_XDFFQ_CLKB 2.4201e-17
* device instance cc_XD2_dmodout_XD4_XDFFQ_M r0 *1 0,0
Ccc_XD2_dmodout_XD4_XDFFQ_M XD2_dmodout XD4_XDFFQ_M 2.4201e-17
* device instance cc_XD2_dmodout_XD4_XDFFQ_MB r0 *1 0,0
Ccc_XD2_dmodout_XD4_XDFFQ_MB XD2_dmodout XD4_XDFFQ_MB 1.21e-17
* device instance cc_XD2_dmodout_XD4_XDFFQ_MFB r0 *1 0,0
Ccc_XD2_dmodout_XD4_XDFFQ_MFB XD2_dmodout XD4_XDFFQ_MFB 1.21e-17
* device instance cc_XD2_dmodout_XD4_XDFFQ_S r0 *1 0,0
Ccc_XD2_dmodout_XD4_XDFFQ_S XD2_dmodout XD4_XDFFQ_S 1.8151e-17
* device instance cc_XD2_dmodout_XD4_XDFFQ_SB r0 *1 0,0
Ccc_XD2_dmodout_XD4_XDFFQ_SB XD2_dmodout XD4_XDFFQ_SB 1.8151e-17
* device instance cc_XD2_dmodout_XD4_XDFFQ_SFB r0 *1 0,0
Ccc_XD2_dmodout_XD4_XDFFQ_SFB XD2_dmodout XD4_XDFFQ_SFB 1.21e-17
* device instance cc_XD2_dmodout_XD4_XN2_mid1 r0 *1 0,0
Ccc_XD2_dmodout_XD4_XN2_mid1 XD2_dmodout XD4_XN2_mid1 1.21e-17
* device instance cc_XD2_dmodout_XD4_XN3_mid1 r0 *1 0,0
Ccc_XD2_dmodout_XD4_XN3_mid1 XD2_dmodout XD4_XN3_mid1 1.21e-17
* device instance cc_XD2_dmodout_XD4_XN3_mid2 r0 *1 0,0
Ccc_XD2_dmodout_XD4_XN3_mid2 XD2_dmodout XD4_XN3_mid2 1.21e-17
* device instance cc_XD2_dmodout_XD4_dmodout r0 *1 0,0
Ccc_XD2_dmodout_XD4_dmodout XD2_dmodout XD4_dmodout 1.21e-17
* device instance cc_XD2_dmodout_XD4_dq r0 *1 0,0
Ccc_XD2_dmodout_XD4_dq XD2_dmodout XD4_dq 1.8151e-17
* device instance cc_XD2_dmodout_XD4_nm r0 *1 0,0
Ccc_XD2_dmodout_XD4_nm XD2_dmodout XD4_nm 1.21e-17
* device instance cc_XD2_dmodout_XD4_nt r0 *1 0,0
Ccc_XD2_dmodout_XD4_nt XD2_dmodout XD4_nt 1.21e-17
* device instance cc_XD2_dmodout_XD4_t1 r0 *1 0,0
Ccc_XD2_dmodout_XD4_t1 XD2_dmodout XD4_t1 1.21e-17
* device instance cc_XD2_dmodout_XD5_XDFFM_CKBB r0 *1 0,0
Ccc_XD2_dmodout_XD5_XDFFM_CKBB XD2_dmodout XD5_XDFFM_CKBB 1.8151e-17
* device instance cc_XD2_dmodout_XD5_XDFFM_CLKB r0 *1 0,0
Ccc_XD2_dmodout_XD5_XDFFM_CLKB XD2_dmodout XD5_XDFFM_CLKB 2.4201e-17
* device instance cc_XD2_dmodout_XD5_XDFFM_M r0 *1 0,0
Ccc_XD2_dmodout_XD5_XDFFM_M XD2_dmodout XD5_XDFFM_M 2.4201e-17
* device instance cc_XD2_dmodout_XD5_XDFFM_MB r0 *1 0,0
Ccc_XD2_dmodout_XD5_XDFFM_MB XD2_dmodout XD5_XDFFM_MB 1.21e-17
* device instance cc_XD2_dmodout_XD5_XDFFM_MFB r0 *1 0,0
Ccc_XD2_dmodout_XD5_XDFFM_MFB XD2_dmodout XD5_XDFFM_MFB 1.21e-17
* device instance cc_XD2_dmodout_XD5_XDFFM_S r0 *1 0,0
Ccc_XD2_dmodout_XD5_XDFFM_S XD2_dmodout XD5_XDFFM_S 1.8151e-17
* device instance cc_XD2_dmodout_XD5_XDFFM_SB r0 *1 0,0
Ccc_XD2_dmodout_XD5_XDFFM_SB XD2_dmodout XD5_XDFFM_SB 1.8151e-17
* device instance cc_XD2_dmodout_XD5_XDFFM_SFB r0 *1 0,0
Ccc_XD2_dmodout_XD5_XDFFM_SFB XD2_dmodout XD5_XDFFM_SFB 1.21e-17
* device instance cc_XD2_dmodout_XD5_XDFFQ_CKBB r0 *1 0,0
Ccc_XD2_dmodout_XD5_XDFFQ_CKBB XD2_dmodout XD5_XDFFQ_CKBB 1.8151e-17
* device instance cc_XD2_dmodout_XD5_XDFFQ_CLKB r0 *1 0,0
Ccc_XD2_dmodout_XD5_XDFFQ_CLKB XD2_dmodout XD5_XDFFQ_CLKB 2.4201e-17
* device instance cc_XD2_dmodout_XD5_XDFFQ_M r0 *1 0,0
Ccc_XD2_dmodout_XD5_XDFFQ_M XD2_dmodout XD5_XDFFQ_M 2.4201e-17
* device instance cc_XD2_dmodout_XD5_XDFFQ_MB r0 *1 0,0
Ccc_XD2_dmodout_XD5_XDFFQ_MB XD2_dmodout XD5_XDFFQ_MB 1.21e-17
* device instance cc_XD2_dmodout_XD5_XDFFQ_MFB r0 *1 0,0
Ccc_XD2_dmodout_XD5_XDFFQ_MFB XD2_dmodout XD5_XDFFQ_MFB 1.21e-17
* device instance cc_XD2_dmodout_XD5_XDFFQ_S r0 *1 0,0
Ccc_XD2_dmodout_XD5_XDFFQ_S XD2_dmodout XD5_XDFFQ_S 1.8151e-17
* device instance cc_XD2_dmodout_XD5_XDFFQ_SB r0 *1 0,0
Ccc_XD2_dmodout_XD5_XDFFQ_SB XD2_dmodout XD5_XDFFQ_SB 1.8151e-17
* device instance cc_XD2_dmodout_XD5_XDFFQ_SFB r0 *1 0,0
Ccc_XD2_dmodout_XD5_XDFFQ_SFB XD2_dmodout XD5_XDFFQ_SFB 1.21e-17
* device instance cc_XD2_dmodout_XD5_XN2_mid1 r0 *1 0,0
Ccc_XD2_dmodout_XD5_XN2_mid1 XD2_dmodout XD5_XN2_mid1 1.21e-17
* device instance cc_XD2_dmodout_XD5_XN3_mid1 r0 *1 0,0
Ccc_XD2_dmodout_XD5_XN3_mid1 XD2_dmodout XD5_XN3_mid1 1.21e-17
* device instance cc_XD2_dmodout_XD5_XN3_mid2 r0 *1 0,0
Ccc_XD2_dmodout_XD5_XN3_mid2 XD2_dmodout XD5_XN3_mid2 1.21e-17
* device instance cc_XD2_dmodout_XD5_dmodout r0 *1 0,0
Ccc_XD2_dmodout_XD5_dmodout XD2_dmodout XD5_dmodout 1.21e-17
* device instance cc_XD2_dmodout_XD5_dq r0 *1 0,0
Ccc_XD2_dmodout_XD5_dq XD2_dmodout XD5_dq 1.8151e-17
* device instance cc_XD2_dmodout_XD5_nm r0 *1 0,0
Ccc_XD2_dmodout_XD5_nm XD2_dmodout XD5_nm 1.21e-17
* device instance cc_XD2_dmodout_XD5_nt r0 *1 0,0
Ccc_XD2_dmodout_XD5_nt XD2_dmodout XD5_nt 1.21e-17
* device instance cc_XD2_dmodout_XD5_t1 r0 *1 0,0
Ccc_XD2_dmodout_XD5_t1 XD2_dmodout XD5_t1 1.21e-17
* device instance cc_XD2_dmodout_XFRT_CKBB r0 *1 0,0
Ccc_XD2_dmodout_XFRT_CKBB XD2_dmodout XFRT_CKBB 1.8151e-17
* device instance cc_XD2_dmodout_XFRT_CLKB r0 *1 0,0
Ccc_XD2_dmodout_XFRT_CLKB XD2_dmodout XFRT_CLKB 2.4201e-17
* device instance cc_XD2_dmodout_XFRT_M r0 *1 0,0
Ccc_XD2_dmodout_XFRT_M XD2_dmodout XFRT_M 2.4201e-17
* device instance cc_XD2_dmodout_XFRT_MB r0 *1 0,0
Ccc_XD2_dmodout_XFRT_MB XD2_dmodout XFRT_MB 1.21e-17
* device instance cc_XD2_dmodout_XFRT_MFB r0 *1 0,0
Ccc_XD2_dmodout_XFRT_MFB XD2_dmodout XFRT_MFB 1.21e-17
* device instance cc_XD2_dmodout_XFRT_S r0 *1 0,0
Ccc_XD2_dmodout_XFRT_S XD2_dmodout XFRT_S 1.8151e-17
* device instance cc_XD2_dmodout_XFRT_SB r0 *1 0,0
Ccc_XD2_dmodout_XFRT_SB XD2_dmodout XFRT_SB 1.8151e-17
* device instance cc_XD2_dmodout_XFRT_SFB r0 *1 0,0
Ccc_XD2_dmodout_XFRT_SFB XD2_dmodout XFRT_SFB 1.21e-17
* device instance cc_XD2_dmodout_ck1 r0 *1 0,0
Ccc_XD2_dmodout_ck1 XD2_dmodout ck1 3.0251e-17
* device instance cc_XD2_dmodout_ck2 r0 *1 0,0
Ccc_XD2_dmodout_ck2 XD2_dmodout ck2 3.6302e-17
* device instance cc_XD2_dmodout_ck3 r0 *1 0,0
Ccc_XD2_dmodout_ck3 XD2_dmodout ck3 3.0251e-17
* device instance cc_XD2_dmodout_ck4 r0 *1 0,0
Ccc_XD2_dmodout_ck4 XD2_dmodout ck4 3.0251e-17
* device instance cc_XD2_dmodout_ck5 r0 *1 0,0
Ccc_XD2_dmodout_ck5 XD2_dmodout ck5 3.0251e-17
* device instance cc_XD2_dmodout_mod0 r0 *1 0,0
Ccc_XD2_dmodout_mod0 XD2_dmodout mod0 2.4201e-17
* device instance cc_XD2_dmodout_mod1 r0 *1 0,0
Ccc_XD2_dmodout_mod1 XD2_dmodout mod1 2.4201e-17
* device instance cc_XD2_dmodout_mod2 r0 *1 0,0
Ccc_XD2_dmodout_mod2 XD2_dmodout mod2 2.4201e-17
* device instance cc_XD2_dmodout_mod3 r0 *1 0,0
Ccc_XD2_dmodout_mod3 XD2_dmodout mod3 2.4201e-17
* device instance cc_XD2_dmodout_mod4 r0 *1 0,0
Ccc_XD2_dmodout_mod4 XD2_dmodout mod4 2.4201e-17
* device instance cc_XD2_dmodout_net1 r0 *1 0,0
Ccc_XD2_dmodout_net1 XD2_dmodout net1 1.21e-17
* device instance cc_XD2_dq_XD2_nm r0 *1 0,0
Ccc_XD2_dq_XD2_nm XD2_dq XD2_nm 1.21e-17
* device instance cc_XD2_dq_XD2_nt r0 *1 0,0
Ccc_XD2_dq_XD2_nt XD2_dq XD2_nt 2.4201e-17
* device instance cc_XD2_dq_XD2_t1 r0 *1 0,0
Ccc_XD2_dq_XD2_t1 XD2_dq XD2_t1 1.8151e-17
* device instance cc_XD2_dq_XD3_XDFFM_CKBB r0 *1 0,0
Ccc_XD2_dq_XD3_XDFFM_CKBB XD2_dq XD3_XDFFM_CKBB 1.8151e-17
* device instance cc_XD2_dq_XD3_XDFFM_CLKB r0 *1 0,0
Ccc_XD2_dq_XD3_XDFFM_CLKB XD2_dq XD3_XDFFM_CLKB 2.4201e-17
* device instance cc_XD2_dq_XD3_XDFFM_M r0 *1 0,0
Ccc_XD2_dq_XD3_XDFFM_M XD2_dq XD3_XDFFM_M 2.4201e-17
* device instance cc_XD2_dq_XD3_XDFFM_MB r0 *1 0,0
Ccc_XD2_dq_XD3_XDFFM_MB XD2_dq XD3_XDFFM_MB 1.21e-17
* device instance cc_XD2_dq_XD3_XDFFM_MFB r0 *1 0,0
Ccc_XD2_dq_XD3_XDFFM_MFB XD2_dq XD3_XDFFM_MFB 1.21e-17
* device instance cc_XD2_dq_XD3_XDFFM_S r0 *1 0,0
Ccc_XD2_dq_XD3_XDFFM_S XD2_dq XD3_XDFFM_S 1.8151e-17
* device instance cc_XD2_dq_XD3_XDFFM_SB r0 *1 0,0
Ccc_XD2_dq_XD3_XDFFM_SB XD2_dq XD3_XDFFM_SB 1.8151e-17
* device instance cc_XD2_dq_XD3_XDFFM_SFB r0 *1 0,0
Ccc_XD2_dq_XD3_XDFFM_SFB XD2_dq XD3_XDFFM_SFB 1.21e-17
* device instance cc_XD2_dq_XD3_XDFFQ_CKBB r0 *1 0,0
Ccc_XD2_dq_XD3_XDFFQ_CKBB XD2_dq XD3_XDFFQ_CKBB 1.8151e-17
* device instance cc_XD2_dq_XD3_XDFFQ_CLKB r0 *1 0,0
Ccc_XD2_dq_XD3_XDFFQ_CLKB XD2_dq XD3_XDFFQ_CLKB 2.4201e-17
* device instance cc_XD2_dq_XD3_XDFFQ_M r0 *1 0,0
Ccc_XD2_dq_XD3_XDFFQ_M XD2_dq XD3_XDFFQ_M 2.4201e-17
* device instance cc_XD2_dq_XD3_XDFFQ_MB r0 *1 0,0
Ccc_XD2_dq_XD3_XDFFQ_MB XD2_dq XD3_XDFFQ_MB 1.21e-17
* device instance cc_XD2_dq_XD3_XDFFQ_MFB r0 *1 0,0
Ccc_XD2_dq_XD3_XDFFQ_MFB XD2_dq XD3_XDFFQ_MFB 1.21e-17
* device instance cc_XD2_dq_XD3_XDFFQ_S r0 *1 0,0
Ccc_XD2_dq_XD3_XDFFQ_S XD2_dq XD3_XDFFQ_S 1.8151e-17
* device instance cc_XD2_dq_XD3_XDFFQ_SB r0 *1 0,0
Ccc_XD2_dq_XD3_XDFFQ_SB XD2_dq XD3_XDFFQ_SB 1.8151e-17
* device instance cc_XD2_dq_XD3_XDFFQ_SFB r0 *1 0,0
Ccc_XD2_dq_XD3_XDFFQ_SFB XD2_dq XD3_XDFFQ_SFB 1.21e-17
* device instance cc_XD2_dq_XD3_XN2_mid1 r0 *1 0,0
Ccc_XD2_dq_XD3_XN2_mid1 XD2_dq XD3_XN2_mid1 1.21e-17
* device instance cc_XD2_dq_XD3_XN3_mid1 r0 *1 0,0
Ccc_XD2_dq_XD3_XN3_mid1 XD2_dq XD3_XN3_mid1 1.21e-17
* device instance cc_XD2_dq_XD3_XN3_mid2 r0 *1 0,0
Ccc_XD2_dq_XD3_XN3_mid2 XD2_dq XD3_XN3_mid2 1.21e-17
* device instance cc_XD2_dq_XD3_dmodout r0 *1 0,0
Ccc_XD2_dq_XD3_dmodout XD2_dq XD3_dmodout 1.21e-17
* device instance cc_XD2_dq_XD3_dq r0 *1 0,0
Ccc_XD2_dq_XD3_dq XD2_dq XD3_dq 1.8151e-17
* device instance cc_XD2_dq_XD3_nm r0 *1 0,0
Ccc_XD2_dq_XD3_nm XD2_dq XD3_nm 1.21e-17
* device instance cc_XD2_dq_XD3_nt r0 *1 0,0
Ccc_XD2_dq_XD3_nt XD2_dq XD3_nt 1.21e-17
* device instance cc_XD2_dq_XD3_t1 r0 *1 0,0
Ccc_XD2_dq_XD3_t1 XD2_dq XD3_t1 1.21e-17
* device instance cc_XD2_dq_XD4_XDFFM_CKBB r0 *1 0,0
Ccc_XD2_dq_XD4_XDFFM_CKBB XD2_dq XD4_XDFFM_CKBB 1.8151e-17
* device instance cc_XD2_dq_XD4_XDFFM_CLKB r0 *1 0,0
Ccc_XD2_dq_XD4_XDFFM_CLKB XD2_dq XD4_XDFFM_CLKB 2.4201e-17
* device instance cc_XD2_dq_XD4_XDFFM_M r0 *1 0,0
Ccc_XD2_dq_XD4_XDFFM_M XD2_dq XD4_XDFFM_M 2.4201e-17
* device instance cc_XD2_dq_XD4_XDFFM_MB r0 *1 0,0
Ccc_XD2_dq_XD4_XDFFM_MB XD2_dq XD4_XDFFM_MB 1.21e-17
* device instance cc_XD2_dq_XD4_XDFFM_MFB r0 *1 0,0
Ccc_XD2_dq_XD4_XDFFM_MFB XD2_dq XD4_XDFFM_MFB 1.21e-17
* device instance cc_XD2_dq_XD4_XDFFM_S r0 *1 0,0
Ccc_XD2_dq_XD4_XDFFM_S XD2_dq XD4_XDFFM_S 1.8151e-17
* device instance cc_XD2_dq_XD4_XDFFM_SB r0 *1 0,0
Ccc_XD2_dq_XD4_XDFFM_SB XD2_dq XD4_XDFFM_SB 1.8151e-17
* device instance cc_XD2_dq_XD4_XDFFM_SFB r0 *1 0,0
Ccc_XD2_dq_XD4_XDFFM_SFB XD2_dq XD4_XDFFM_SFB 1.21e-17
* device instance cc_XD2_dq_XD4_XDFFQ_CKBB r0 *1 0,0
Ccc_XD2_dq_XD4_XDFFQ_CKBB XD2_dq XD4_XDFFQ_CKBB 1.8151e-17
* device instance cc_XD2_dq_XD4_XDFFQ_CLKB r0 *1 0,0
Ccc_XD2_dq_XD4_XDFFQ_CLKB XD2_dq XD4_XDFFQ_CLKB 2.4201e-17
* device instance cc_XD2_dq_XD4_XDFFQ_M r0 *1 0,0
Ccc_XD2_dq_XD4_XDFFQ_M XD2_dq XD4_XDFFQ_M 2.4201e-17
* device instance cc_XD2_dq_XD4_XDFFQ_MB r0 *1 0,0
Ccc_XD2_dq_XD4_XDFFQ_MB XD2_dq XD4_XDFFQ_MB 1.21e-17
* device instance cc_XD2_dq_XD4_XDFFQ_MFB r0 *1 0,0
Ccc_XD2_dq_XD4_XDFFQ_MFB XD2_dq XD4_XDFFQ_MFB 1.21e-17
* device instance cc_XD2_dq_XD4_XDFFQ_S r0 *1 0,0
Ccc_XD2_dq_XD4_XDFFQ_S XD2_dq XD4_XDFFQ_S 1.8151e-17
* device instance cc_XD2_dq_XD4_XDFFQ_SB r0 *1 0,0
Ccc_XD2_dq_XD4_XDFFQ_SB XD2_dq XD4_XDFFQ_SB 1.8151e-17
* device instance cc_XD2_dq_XD4_XDFFQ_SFB r0 *1 0,0
Ccc_XD2_dq_XD4_XDFFQ_SFB XD2_dq XD4_XDFFQ_SFB 1.21e-17
* device instance cc_XD2_dq_XD4_XN2_mid1 r0 *1 0,0
Ccc_XD2_dq_XD4_XN2_mid1 XD2_dq XD4_XN2_mid1 1.21e-17
* device instance cc_XD2_dq_XD4_XN3_mid1 r0 *1 0,0
Ccc_XD2_dq_XD4_XN3_mid1 XD2_dq XD4_XN3_mid1 1.21e-17
* device instance cc_XD2_dq_XD4_XN3_mid2 r0 *1 0,0
Ccc_XD2_dq_XD4_XN3_mid2 XD2_dq XD4_XN3_mid2 1.21e-17
* device instance cc_XD2_dq_XD4_dmodout r0 *1 0,0
Ccc_XD2_dq_XD4_dmodout XD2_dq XD4_dmodout 1.21e-17
* device instance cc_XD2_dq_XD4_dq r0 *1 0,0
Ccc_XD2_dq_XD4_dq XD2_dq XD4_dq 1.8151e-17
* device instance cc_XD2_dq_XD4_nm r0 *1 0,0
Ccc_XD2_dq_XD4_nm XD2_dq XD4_nm 1.21e-17
* device instance cc_XD2_dq_XD4_nt r0 *1 0,0
Ccc_XD2_dq_XD4_nt XD2_dq XD4_nt 1.21e-17
* device instance cc_XD2_dq_XD4_t1 r0 *1 0,0
Ccc_XD2_dq_XD4_t1 XD2_dq XD4_t1 1.21e-17
* device instance cc_XD2_dq_XD5_XDFFM_CKBB r0 *1 0,0
Ccc_XD2_dq_XD5_XDFFM_CKBB XD2_dq XD5_XDFFM_CKBB 1.8151e-17
* device instance cc_XD2_dq_XD5_XDFFM_CLKB r0 *1 0,0
Ccc_XD2_dq_XD5_XDFFM_CLKB XD2_dq XD5_XDFFM_CLKB 2.4201e-17
* device instance cc_XD2_dq_XD5_XDFFM_M r0 *1 0,0
Ccc_XD2_dq_XD5_XDFFM_M XD2_dq XD5_XDFFM_M 2.4201e-17
* device instance cc_XD2_dq_XD5_XDFFM_MB r0 *1 0,0
Ccc_XD2_dq_XD5_XDFFM_MB XD2_dq XD5_XDFFM_MB 1.21e-17
* device instance cc_XD2_dq_XD5_XDFFM_MFB r0 *1 0,0
Ccc_XD2_dq_XD5_XDFFM_MFB XD2_dq XD5_XDFFM_MFB 1.21e-17
* device instance cc_XD2_dq_XD5_XDFFM_S r0 *1 0,0
Ccc_XD2_dq_XD5_XDFFM_S XD2_dq XD5_XDFFM_S 1.8151e-17
* device instance cc_XD2_dq_XD5_XDFFM_SB r0 *1 0,0
Ccc_XD2_dq_XD5_XDFFM_SB XD2_dq XD5_XDFFM_SB 1.8151e-17
* device instance cc_XD2_dq_XD5_XDFFM_SFB r0 *1 0,0
Ccc_XD2_dq_XD5_XDFFM_SFB XD2_dq XD5_XDFFM_SFB 1.21e-17
* device instance cc_XD2_dq_XD5_XDFFQ_CKBB r0 *1 0,0
Ccc_XD2_dq_XD5_XDFFQ_CKBB XD2_dq XD5_XDFFQ_CKBB 1.8151e-17
* device instance cc_XD2_dq_XD5_XDFFQ_CLKB r0 *1 0,0
Ccc_XD2_dq_XD5_XDFFQ_CLKB XD2_dq XD5_XDFFQ_CLKB 2.4201e-17
* device instance cc_XD2_dq_XD5_XDFFQ_M r0 *1 0,0
Ccc_XD2_dq_XD5_XDFFQ_M XD2_dq XD5_XDFFQ_M 2.4201e-17
* device instance cc_XD2_dq_XD5_XDFFQ_MB r0 *1 0,0
Ccc_XD2_dq_XD5_XDFFQ_MB XD2_dq XD5_XDFFQ_MB 1.21e-17
* device instance cc_XD2_dq_XD5_XDFFQ_MFB r0 *1 0,0
Ccc_XD2_dq_XD5_XDFFQ_MFB XD2_dq XD5_XDFFQ_MFB 1.21e-17
* device instance cc_XD2_dq_XD5_XDFFQ_S r0 *1 0,0
Ccc_XD2_dq_XD5_XDFFQ_S XD2_dq XD5_XDFFQ_S 1.8151e-17
* device instance cc_XD2_dq_XD5_XDFFQ_SB r0 *1 0,0
Ccc_XD2_dq_XD5_XDFFQ_SB XD2_dq XD5_XDFFQ_SB 1.8151e-17
* device instance cc_XD2_dq_XD5_XDFFQ_SFB r0 *1 0,0
Ccc_XD2_dq_XD5_XDFFQ_SFB XD2_dq XD5_XDFFQ_SFB 1.21e-17
* device instance cc_XD2_dq_XD5_XN2_mid1 r0 *1 0,0
Ccc_XD2_dq_XD5_XN2_mid1 XD2_dq XD5_XN2_mid1 1.21e-17
* device instance cc_XD2_dq_XD5_XN3_mid1 r0 *1 0,0
Ccc_XD2_dq_XD5_XN3_mid1 XD2_dq XD5_XN3_mid1 1.21e-17
* device instance cc_XD2_dq_XD5_XN3_mid2 r0 *1 0,0
Ccc_XD2_dq_XD5_XN3_mid2 XD2_dq XD5_XN3_mid2 1.21e-17
* device instance cc_XD2_dq_XD5_dmodout r0 *1 0,0
Ccc_XD2_dq_XD5_dmodout XD2_dq XD5_dmodout 1.21e-17
* device instance cc_XD2_dq_XD5_dq r0 *1 0,0
Ccc_XD2_dq_XD5_dq XD2_dq XD5_dq 1.8151e-17
* device instance cc_XD2_dq_XD5_nm r0 *1 0,0
Ccc_XD2_dq_XD5_nm XD2_dq XD5_nm 1.21e-17
* device instance cc_XD2_dq_XD5_nt r0 *1 0,0
Ccc_XD2_dq_XD5_nt XD2_dq XD5_nt 1.21e-17
* device instance cc_XD2_dq_XD5_t1 r0 *1 0,0
Ccc_XD2_dq_XD5_t1 XD2_dq XD5_t1 1.21e-17
* device instance cc_XD2_dq_XFRT_CKBB r0 *1 0,0
Ccc_XD2_dq_XFRT_CKBB XD2_dq XFRT_CKBB 1.8151e-17
* device instance cc_XD2_dq_XFRT_CLKB r0 *1 0,0
Ccc_XD2_dq_XFRT_CLKB XD2_dq XFRT_CLKB 2.4201e-17
* device instance cc_XD2_dq_XFRT_M r0 *1 0,0
Ccc_XD2_dq_XFRT_M XD2_dq XFRT_M 2.4201e-17
* device instance cc_XD2_dq_XFRT_MB r0 *1 0,0
Ccc_XD2_dq_XFRT_MB XD2_dq XFRT_MB 1.21e-17
* device instance cc_XD2_dq_XFRT_MFB r0 *1 0,0
Ccc_XD2_dq_XFRT_MFB XD2_dq XFRT_MFB 1.21e-17
* device instance cc_XD2_dq_XFRT_S r0 *1 0,0
Ccc_XD2_dq_XFRT_S XD2_dq XFRT_S 1.8151e-17
* device instance cc_XD2_dq_XFRT_SB r0 *1 0,0
Ccc_XD2_dq_XFRT_SB XD2_dq XFRT_SB 1.8151e-17
* device instance cc_XD2_dq_XFRT_SFB r0 *1 0,0
Ccc_XD2_dq_XFRT_SFB XD2_dq XFRT_SFB 1.21e-17
* device instance cc_XD2_dq_ck1 r0 *1 0,0
Ccc_XD2_dq_ck1 XD2_dq ck1 3.0251e-17
* device instance cc_XD2_dq_ck2 r0 *1 0,0
Ccc_XD2_dq_ck2 XD2_dq ck2 3.6302e-17
* device instance cc_XD2_dq_ck3 r0 *1 0,0
Ccc_XD2_dq_ck3 XD2_dq ck3 3.0251e-17
* device instance cc_XD2_dq_ck4 r0 *1 0,0
Ccc_XD2_dq_ck4 XD2_dq ck4 3.0251e-17
* device instance cc_XD2_dq_ck5 r0 *1 0,0
Ccc_XD2_dq_ck5 XD2_dq ck5 3.0251e-17
* device instance cc_XD2_dq_mod0 r0 *1 0,0
Ccc_XD2_dq_mod0 XD2_dq mod0 2.4201e-17
* device instance cc_XD2_dq_mod1 r0 *1 0,0
Ccc_XD2_dq_mod1 XD2_dq mod1 2.4201e-17
* device instance cc_XD2_dq_mod2 r0 *1 0,0
Ccc_XD2_dq_mod2 XD2_dq mod2 2.4201e-17
* device instance cc_XD2_dq_mod3 r0 *1 0,0
Ccc_XD2_dq_mod3 XD2_dq mod3 2.4201e-17
* device instance cc_XD2_dq_mod4 r0 *1 0,0
Ccc_XD2_dq_mod4 XD2_dq mod4 2.4201e-17
* device instance cc_XD2_dq_net1 r0 *1 0,0
Ccc_XD2_dq_net1 XD2_dq net1 1.21e-17
* device instance cc_XD2_nm_XD2_nt r0 *1 0,0
Ccc_XD2_nm_XD2_nt XD2_nm XD2_nt 2.4201e-17
* device instance cc_XD2_nm_XD2_t1 r0 *1 0,0
Ccc_XD2_nm_XD2_t1 XD2_nm XD2_t1 1.21e-17
* device instance cc_XD2_nm_XD3_XDFFM_CKBB r0 *1 0,0
Ccc_XD2_nm_XD3_XDFFM_CKBB XD2_nm XD3_XDFFM_CKBB 1.8151e-17
* device instance cc_XD2_nm_XD3_XDFFM_CLKB r0 *1 0,0
Ccc_XD2_nm_XD3_XDFFM_CLKB XD2_nm XD3_XDFFM_CLKB 2.4201e-17
* device instance cc_XD2_nm_XD3_XDFFM_M r0 *1 0,0
Ccc_XD2_nm_XD3_XDFFM_M XD2_nm XD3_XDFFM_M 2.4201e-17
* device instance cc_XD2_nm_XD3_XDFFM_MB r0 *1 0,0
Ccc_XD2_nm_XD3_XDFFM_MB XD2_nm XD3_XDFFM_MB 1.21e-17
* device instance cc_XD2_nm_XD3_XDFFM_MFB r0 *1 0,0
Ccc_XD2_nm_XD3_XDFFM_MFB XD2_nm XD3_XDFFM_MFB 1.21e-17
* device instance cc_XD2_nm_XD3_XDFFM_S r0 *1 0,0
Ccc_XD2_nm_XD3_XDFFM_S XD2_nm XD3_XDFFM_S 1.8151e-17
* device instance cc_XD2_nm_XD3_XDFFM_SB r0 *1 0,0
Ccc_XD2_nm_XD3_XDFFM_SB XD2_nm XD3_XDFFM_SB 1.8151e-17
* device instance cc_XD2_nm_XD3_XDFFM_SFB r0 *1 0,0
Ccc_XD2_nm_XD3_XDFFM_SFB XD2_nm XD3_XDFFM_SFB 1.21e-17
* device instance cc_XD2_nm_XD3_XDFFQ_CKBB r0 *1 0,0
Ccc_XD2_nm_XD3_XDFFQ_CKBB XD2_nm XD3_XDFFQ_CKBB 1.8151e-17
* device instance cc_XD2_nm_XD3_XDFFQ_CLKB r0 *1 0,0
Ccc_XD2_nm_XD3_XDFFQ_CLKB XD2_nm XD3_XDFFQ_CLKB 2.4201e-17
* device instance cc_XD2_nm_XD3_XDFFQ_M r0 *1 0,0
Ccc_XD2_nm_XD3_XDFFQ_M XD2_nm XD3_XDFFQ_M 2.4201e-17
* device instance cc_XD2_nm_XD3_XDFFQ_MB r0 *1 0,0
Ccc_XD2_nm_XD3_XDFFQ_MB XD2_nm XD3_XDFFQ_MB 1.21e-17
* device instance cc_XD2_nm_XD3_XDFFQ_MFB r0 *1 0,0
Ccc_XD2_nm_XD3_XDFFQ_MFB XD2_nm XD3_XDFFQ_MFB 1.21e-17
* device instance cc_XD2_nm_XD3_XDFFQ_S r0 *1 0,0
Ccc_XD2_nm_XD3_XDFFQ_S XD2_nm XD3_XDFFQ_S 1.8151e-17
* device instance cc_XD2_nm_XD3_XDFFQ_SB r0 *1 0,0
Ccc_XD2_nm_XD3_XDFFQ_SB XD2_nm XD3_XDFFQ_SB 1.8151e-17
* device instance cc_XD2_nm_XD3_XDFFQ_SFB r0 *1 0,0
Ccc_XD2_nm_XD3_XDFFQ_SFB XD2_nm XD3_XDFFQ_SFB 1.21e-17
* device instance cc_XD2_nm_XD3_XN2_mid1 r0 *1 0,0
Ccc_XD2_nm_XD3_XN2_mid1 XD2_nm XD3_XN2_mid1 1.21e-17
* device instance cc_XD2_nm_XD3_XN3_mid1 r0 *1 0,0
Ccc_XD2_nm_XD3_XN3_mid1 XD2_nm XD3_XN3_mid1 1.21e-17
* device instance cc_XD2_nm_XD3_XN3_mid2 r0 *1 0,0
Ccc_XD2_nm_XD3_XN3_mid2 XD2_nm XD3_XN3_mid2 1.21e-17
* device instance cc_XD2_nm_XD3_dmodout r0 *1 0,0
Ccc_XD2_nm_XD3_dmodout XD2_nm XD3_dmodout 1.21e-17
* device instance cc_XD2_nm_XD3_dq r0 *1 0,0
Ccc_XD2_nm_XD3_dq XD2_nm XD3_dq 1.8151e-17
* device instance cc_XD2_nm_XD3_nm r0 *1 0,0
Ccc_XD2_nm_XD3_nm XD2_nm XD3_nm 1.21e-17
* device instance cc_XD2_nm_XD3_nt r0 *1 0,0
Ccc_XD2_nm_XD3_nt XD2_nm XD3_nt 1.21e-17
* device instance cc_XD2_nm_XD3_t1 r0 *1 0,0
Ccc_XD2_nm_XD3_t1 XD2_nm XD3_t1 1.21e-17
* device instance cc_XD2_nm_XD4_XDFFM_CKBB r0 *1 0,0
Ccc_XD2_nm_XD4_XDFFM_CKBB XD2_nm XD4_XDFFM_CKBB 1.8151e-17
* device instance cc_XD2_nm_XD4_XDFFM_CLKB r0 *1 0,0
Ccc_XD2_nm_XD4_XDFFM_CLKB XD2_nm XD4_XDFFM_CLKB 2.4201e-17
* device instance cc_XD2_nm_XD4_XDFFM_M r0 *1 0,0
Ccc_XD2_nm_XD4_XDFFM_M XD2_nm XD4_XDFFM_M 2.4201e-17
* device instance cc_XD2_nm_XD4_XDFFM_MB r0 *1 0,0
Ccc_XD2_nm_XD4_XDFFM_MB XD2_nm XD4_XDFFM_MB 1.21e-17
* device instance cc_XD2_nm_XD4_XDFFM_MFB r0 *1 0,0
Ccc_XD2_nm_XD4_XDFFM_MFB XD2_nm XD4_XDFFM_MFB 1.21e-17
* device instance cc_XD2_nm_XD4_XDFFM_S r0 *1 0,0
Ccc_XD2_nm_XD4_XDFFM_S XD2_nm XD4_XDFFM_S 1.8151e-17
* device instance cc_XD2_nm_XD4_XDFFM_SB r0 *1 0,0
Ccc_XD2_nm_XD4_XDFFM_SB XD2_nm XD4_XDFFM_SB 1.8151e-17
* device instance cc_XD2_nm_XD4_XDFFM_SFB r0 *1 0,0
Ccc_XD2_nm_XD4_XDFFM_SFB XD2_nm XD4_XDFFM_SFB 1.21e-17
* device instance cc_XD2_nm_XD4_XDFFQ_CKBB r0 *1 0,0
Ccc_XD2_nm_XD4_XDFFQ_CKBB XD2_nm XD4_XDFFQ_CKBB 1.8151e-17
* device instance cc_XD2_nm_XD4_XDFFQ_CLKB r0 *1 0,0
Ccc_XD2_nm_XD4_XDFFQ_CLKB XD2_nm XD4_XDFFQ_CLKB 2.4201e-17
* device instance cc_XD2_nm_XD4_XDFFQ_M r0 *1 0,0
Ccc_XD2_nm_XD4_XDFFQ_M XD2_nm XD4_XDFFQ_M 2.4201e-17
* device instance cc_XD2_nm_XD4_XDFFQ_MB r0 *1 0,0
Ccc_XD2_nm_XD4_XDFFQ_MB XD2_nm XD4_XDFFQ_MB 1.21e-17
* device instance cc_XD2_nm_XD4_XDFFQ_MFB r0 *1 0,0
Ccc_XD2_nm_XD4_XDFFQ_MFB XD2_nm XD4_XDFFQ_MFB 1.21e-17
* device instance cc_XD2_nm_XD4_XDFFQ_S r0 *1 0,0
Ccc_XD2_nm_XD4_XDFFQ_S XD2_nm XD4_XDFFQ_S 1.8151e-17
* device instance cc_XD2_nm_XD4_XDFFQ_SB r0 *1 0,0
Ccc_XD2_nm_XD4_XDFFQ_SB XD2_nm XD4_XDFFQ_SB 1.8151e-17
* device instance cc_XD2_nm_XD4_XDFFQ_SFB r0 *1 0,0
Ccc_XD2_nm_XD4_XDFFQ_SFB XD2_nm XD4_XDFFQ_SFB 1.21e-17
* device instance cc_XD2_nm_XD4_XN2_mid1 r0 *1 0,0
Ccc_XD2_nm_XD4_XN2_mid1 XD2_nm XD4_XN2_mid1 1.21e-17
* device instance cc_XD2_nm_XD4_XN3_mid1 r0 *1 0,0
Ccc_XD2_nm_XD4_XN3_mid1 XD2_nm XD4_XN3_mid1 1.21e-17
* device instance cc_XD2_nm_XD4_XN3_mid2 r0 *1 0,0
Ccc_XD2_nm_XD4_XN3_mid2 XD2_nm XD4_XN3_mid2 1.21e-17
* device instance cc_XD2_nm_XD4_dmodout r0 *1 0,0
Ccc_XD2_nm_XD4_dmodout XD2_nm XD4_dmodout 1.21e-17
* device instance cc_XD2_nm_XD4_dq r0 *1 0,0
Ccc_XD2_nm_XD4_dq XD2_nm XD4_dq 1.8151e-17
* device instance cc_XD2_nm_XD4_nm r0 *1 0,0
Ccc_XD2_nm_XD4_nm XD2_nm XD4_nm 1.21e-17
* device instance cc_XD2_nm_XD4_nt r0 *1 0,0
Ccc_XD2_nm_XD4_nt XD2_nm XD4_nt 1.21e-17
* device instance cc_XD2_nm_XD4_t1 r0 *1 0,0
Ccc_XD2_nm_XD4_t1 XD2_nm XD4_t1 1.21e-17
* device instance cc_XD2_nm_XD5_XDFFM_CKBB r0 *1 0,0
Ccc_XD2_nm_XD5_XDFFM_CKBB XD2_nm XD5_XDFFM_CKBB 1.8151e-17
* device instance cc_XD2_nm_XD5_XDFFM_CLKB r0 *1 0,0
Ccc_XD2_nm_XD5_XDFFM_CLKB XD2_nm XD5_XDFFM_CLKB 2.4201e-17
* device instance cc_XD2_nm_XD5_XDFFM_M r0 *1 0,0
Ccc_XD2_nm_XD5_XDFFM_M XD2_nm XD5_XDFFM_M 2.4201e-17
* device instance cc_XD2_nm_XD5_XDFFM_MB r0 *1 0,0
Ccc_XD2_nm_XD5_XDFFM_MB XD2_nm XD5_XDFFM_MB 1.21e-17
* device instance cc_XD2_nm_XD5_XDFFM_MFB r0 *1 0,0
Ccc_XD2_nm_XD5_XDFFM_MFB XD2_nm XD5_XDFFM_MFB 1.21e-17
* device instance cc_XD2_nm_XD5_XDFFM_S r0 *1 0,0
Ccc_XD2_nm_XD5_XDFFM_S XD2_nm XD5_XDFFM_S 1.8151e-17
* device instance cc_XD2_nm_XD5_XDFFM_SB r0 *1 0,0
Ccc_XD2_nm_XD5_XDFFM_SB XD2_nm XD5_XDFFM_SB 1.8151e-17
* device instance cc_XD2_nm_XD5_XDFFM_SFB r0 *1 0,0
Ccc_XD2_nm_XD5_XDFFM_SFB XD2_nm XD5_XDFFM_SFB 1.21e-17
* device instance cc_XD2_nm_XD5_XDFFQ_CKBB r0 *1 0,0
Ccc_XD2_nm_XD5_XDFFQ_CKBB XD2_nm XD5_XDFFQ_CKBB 1.8151e-17
* device instance cc_XD2_nm_XD5_XDFFQ_CLKB r0 *1 0,0
Ccc_XD2_nm_XD5_XDFFQ_CLKB XD2_nm XD5_XDFFQ_CLKB 2.4201e-17
* device instance cc_XD2_nm_XD5_XDFFQ_M r0 *1 0,0
Ccc_XD2_nm_XD5_XDFFQ_M XD2_nm XD5_XDFFQ_M 2.4201e-17
* device instance cc_XD2_nm_XD5_XDFFQ_MB r0 *1 0,0
Ccc_XD2_nm_XD5_XDFFQ_MB XD2_nm XD5_XDFFQ_MB 1.21e-17
* device instance cc_XD2_nm_XD5_XDFFQ_MFB r0 *1 0,0
Ccc_XD2_nm_XD5_XDFFQ_MFB XD2_nm XD5_XDFFQ_MFB 1.21e-17
* device instance cc_XD2_nm_XD5_XDFFQ_S r0 *1 0,0
Ccc_XD2_nm_XD5_XDFFQ_S XD2_nm XD5_XDFFQ_S 1.8151e-17
* device instance cc_XD2_nm_XD5_XDFFQ_SB r0 *1 0,0
Ccc_XD2_nm_XD5_XDFFQ_SB XD2_nm XD5_XDFFQ_SB 1.8151e-17
* device instance cc_XD2_nm_XD5_XDFFQ_SFB r0 *1 0,0
Ccc_XD2_nm_XD5_XDFFQ_SFB XD2_nm XD5_XDFFQ_SFB 1.21e-17
* device instance cc_XD2_nm_XD5_XN2_mid1 r0 *1 0,0
Ccc_XD2_nm_XD5_XN2_mid1 XD2_nm XD5_XN2_mid1 1.21e-17
* device instance cc_XD2_nm_XD5_XN3_mid1 r0 *1 0,0
Ccc_XD2_nm_XD5_XN3_mid1 XD2_nm XD5_XN3_mid1 1.21e-17
* device instance cc_XD2_nm_XD5_XN3_mid2 r0 *1 0,0
Ccc_XD2_nm_XD5_XN3_mid2 XD2_nm XD5_XN3_mid2 1.21e-17
* device instance cc_XD2_nm_XD5_dmodout r0 *1 0,0
Ccc_XD2_nm_XD5_dmodout XD2_nm XD5_dmodout 1.21e-17
* device instance cc_XD2_nm_XD5_dq r0 *1 0,0
Ccc_XD2_nm_XD5_dq XD2_nm XD5_dq 1.8151e-17
* device instance cc_XD2_nm_XD5_nm r0 *1 0,0
Ccc_XD2_nm_XD5_nm XD2_nm XD5_nm 1.21e-17
* device instance cc_XD2_nm_XD5_nt r0 *1 0,0
Ccc_XD2_nm_XD5_nt XD2_nm XD5_nt 1.21e-17
* device instance cc_XD2_nm_XD5_t1 r0 *1 0,0
Ccc_XD2_nm_XD5_t1 XD2_nm XD5_t1 1.21e-17
* device instance cc_XD2_nm_XFRT_CKBB r0 *1 0,0
Ccc_XD2_nm_XFRT_CKBB XD2_nm XFRT_CKBB 1.8151e-17
* device instance cc_XD2_nm_XFRT_CLKB r0 *1 0,0
Ccc_XD2_nm_XFRT_CLKB XD2_nm XFRT_CLKB 2.4201e-17
* device instance cc_XD2_nm_XFRT_M r0 *1 0,0
Ccc_XD2_nm_XFRT_M XD2_nm XFRT_M 2.4201e-17
* device instance cc_XD2_nm_XFRT_MB r0 *1 0,0
Ccc_XD2_nm_XFRT_MB XD2_nm XFRT_MB 1.21e-17
* device instance cc_XD2_nm_XFRT_MFB r0 *1 0,0
Ccc_XD2_nm_XFRT_MFB XD2_nm XFRT_MFB 1.21e-17
* device instance cc_XD2_nm_XFRT_S r0 *1 0,0
Ccc_XD2_nm_XFRT_S XD2_nm XFRT_S 1.8151e-17
* device instance cc_XD2_nm_XFRT_SB r0 *1 0,0
Ccc_XD2_nm_XFRT_SB XD2_nm XFRT_SB 1.8151e-17
* device instance cc_XD2_nm_XFRT_SFB r0 *1 0,0
Ccc_XD2_nm_XFRT_SFB XD2_nm XFRT_SFB 1.21e-17
* device instance cc_XD2_nm_ck1 r0 *1 0,0
Ccc_XD2_nm_ck1 XD2_nm ck1 3.0251e-17
* device instance cc_XD2_nm_ck2 r0 *1 0,0
Ccc_XD2_nm_ck2 XD2_nm ck2 3.0251e-17
* device instance cc_XD2_nm_ck3 r0 *1 0,0
Ccc_XD2_nm_ck3 XD2_nm ck3 3.6302e-17
* device instance cc_XD2_nm_ck4 r0 *1 0,0
Ccc_XD2_nm_ck4 XD2_nm ck4 3.0251e-17
* device instance cc_XD2_nm_ck5 r0 *1 0,0
Ccc_XD2_nm_ck5 XD2_nm ck5 3.0251e-17
* device instance cc_XD2_nm_mod0 r0 *1 0,0
Ccc_XD2_nm_mod0 XD2_nm mod0 2.4201e-17
* device instance cc_XD2_nm_mod1 r0 *1 0,0
Ccc_XD2_nm_mod1 XD2_nm mod1 2.4201e-17
* device instance cc_XD2_nm_mod2 r0 *1 0,0
Ccc_XD2_nm_mod2 XD2_nm mod2 2.4201e-17
* device instance cc_XD2_nm_mod3 r0 *1 0,0
Ccc_XD2_nm_mod3 XD2_nm mod3 2.4201e-17
* device instance cc_XD2_nm_mod4 r0 *1 0,0
Ccc_XD2_nm_mod4 XD2_nm mod4 2.4201e-17
* device instance cc_XD2_nm_net1 r0 *1 0,0
Ccc_XD2_nm_net1 XD2_nm net1 1.21e-17
* device instance cc_XD2_nt_XD2_t1 r0 *1 0,0
Ccc_XD2_nt_XD2_t1 XD2_nt XD2_t1 1.21e-17
* device instance cc_XD2_nt_XD3_XDFFM_CKBB r0 *1 0,0
Ccc_XD2_nt_XD3_XDFFM_CKBB XD2_nt XD3_XDFFM_CKBB 1.8151e-17
* device instance cc_XD2_nt_XD3_XDFFM_CLKB r0 *1 0,0
Ccc_XD2_nt_XD3_XDFFM_CLKB XD2_nt XD3_XDFFM_CLKB 2.4201e-17
* device instance cc_XD2_nt_XD3_XDFFM_M r0 *1 0,0
Ccc_XD2_nt_XD3_XDFFM_M XD2_nt XD3_XDFFM_M 2.4201e-17
* device instance cc_XD2_nt_XD3_XDFFM_MB r0 *1 0,0
Ccc_XD2_nt_XD3_XDFFM_MB XD2_nt XD3_XDFFM_MB 1.21e-17
* device instance cc_XD2_nt_XD3_XDFFM_MFB r0 *1 0,0
Ccc_XD2_nt_XD3_XDFFM_MFB XD2_nt XD3_XDFFM_MFB 1.21e-17
* device instance cc_XD2_nt_XD3_XDFFM_S r0 *1 0,0
Ccc_XD2_nt_XD3_XDFFM_S XD2_nt XD3_XDFFM_S 1.8151e-17
* device instance cc_XD2_nt_XD3_XDFFM_SB r0 *1 0,0
Ccc_XD2_nt_XD3_XDFFM_SB XD2_nt XD3_XDFFM_SB 1.8151e-17
* device instance cc_XD2_nt_XD3_XDFFM_SFB r0 *1 0,0
Ccc_XD2_nt_XD3_XDFFM_SFB XD2_nt XD3_XDFFM_SFB 1.21e-17
* device instance cc_XD2_nt_XD3_XDFFQ_CKBB r0 *1 0,0
Ccc_XD2_nt_XD3_XDFFQ_CKBB XD2_nt XD3_XDFFQ_CKBB 1.8151e-17
* device instance cc_XD2_nt_XD3_XDFFQ_CLKB r0 *1 0,0
Ccc_XD2_nt_XD3_XDFFQ_CLKB XD2_nt XD3_XDFFQ_CLKB 2.4201e-17
* device instance cc_XD2_nt_XD3_XDFFQ_M r0 *1 0,0
Ccc_XD2_nt_XD3_XDFFQ_M XD2_nt XD3_XDFFQ_M 2.4201e-17
* device instance cc_XD2_nt_XD3_XDFFQ_MB r0 *1 0,0
Ccc_XD2_nt_XD3_XDFFQ_MB XD2_nt XD3_XDFFQ_MB 1.21e-17
* device instance cc_XD2_nt_XD3_XDFFQ_MFB r0 *1 0,0
Ccc_XD2_nt_XD3_XDFFQ_MFB XD2_nt XD3_XDFFQ_MFB 1.21e-17
* device instance cc_XD2_nt_XD3_XDFFQ_S r0 *1 0,0
Ccc_XD2_nt_XD3_XDFFQ_S XD2_nt XD3_XDFFQ_S 1.8151e-17
* device instance cc_XD2_nt_XD3_XDFFQ_SB r0 *1 0,0
Ccc_XD2_nt_XD3_XDFFQ_SB XD2_nt XD3_XDFFQ_SB 1.8151e-17
* device instance cc_XD2_nt_XD3_XDFFQ_SFB r0 *1 0,0
Ccc_XD2_nt_XD3_XDFFQ_SFB XD2_nt XD3_XDFFQ_SFB 1.21e-17
* device instance cc_XD2_nt_XD3_XN2_mid1 r0 *1 0,0
Ccc_XD2_nt_XD3_XN2_mid1 XD2_nt XD3_XN2_mid1 1.21e-17
* device instance cc_XD2_nt_XD3_XN3_mid1 r0 *1 0,0
Ccc_XD2_nt_XD3_XN3_mid1 XD2_nt XD3_XN3_mid1 1.21e-17
* device instance cc_XD2_nt_XD3_XN3_mid2 r0 *1 0,0
Ccc_XD2_nt_XD3_XN3_mid2 XD2_nt XD3_XN3_mid2 1.21e-17
* device instance cc_XD2_nt_XD3_dmodout r0 *1 0,0
Ccc_XD2_nt_XD3_dmodout XD2_nt XD3_dmodout 1.21e-17
* device instance cc_XD2_nt_XD3_dq r0 *1 0,0
Ccc_XD2_nt_XD3_dq XD2_nt XD3_dq 1.8151e-17
* device instance cc_XD2_nt_XD3_nm r0 *1 0,0
Ccc_XD2_nt_XD3_nm XD2_nt XD3_nm 1.21e-17
* device instance cc_XD2_nt_XD3_nt r0 *1 0,0
Ccc_XD2_nt_XD3_nt XD2_nt XD3_nt 1.21e-17
* device instance cc_XD2_nt_XD3_t1 r0 *1 0,0
Ccc_XD2_nt_XD3_t1 XD2_nt XD3_t1 1.21e-17
* device instance cc_XD2_nt_XD4_XDFFM_CKBB r0 *1 0,0
Ccc_XD2_nt_XD4_XDFFM_CKBB XD2_nt XD4_XDFFM_CKBB 1.8151e-17
* device instance cc_XD2_nt_XD4_XDFFM_CLKB r0 *1 0,0
Ccc_XD2_nt_XD4_XDFFM_CLKB XD2_nt XD4_XDFFM_CLKB 2.4201e-17
* device instance cc_XD2_nt_XD4_XDFFM_M r0 *1 0,0
Ccc_XD2_nt_XD4_XDFFM_M XD2_nt XD4_XDFFM_M 2.4201e-17
* device instance cc_XD2_nt_XD4_XDFFM_MB r0 *1 0,0
Ccc_XD2_nt_XD4_XDFFM_MB XD2_nt XD4_XDFFM_MB 1.21e-17
* device instance cc_XD2_nt_XD4_XDFFM_MFB r0 *1 0,0
Ccc_XD2_nt_XD4_XDFFM_MFB XD2_nt XD4_XDFFM_MFB 1.21e-17
* device instance cc_XD2_nt_XD4_XDFFM_S r0 *1 0,0
Ccc_XD2_nt_XD4_XDFFM_S XD2_nt XD4_XDFFM_S 1.8151e-17
* device instance cc_XD2_nt_XD4_XDFFM_SB r0 *1 0,0
Ccc_XD2_nt_XD4_XDFFM_SB XD2_nt XD4_XDFFM_SB 1.8151e-17
* device instance cc_XD2_nt_XD4_XDFFM_SFB r0 *1 0,0
Ccc_XD2_nt_XD4_XDFFM_SFB XD2_nt XD4_XDFFM_SFB 1.21e-17
* device instance cc_XD2_nt_XD4_XDFFQ_CKBB r0 *1 0,0
Ccc_XD2_nt_XD4_XDFFQ_CKBB XD2_nt XD4_XDFFQ_CKBB 1.8151e-17
* device instance cc_XD2_nt_XD4_XDFFQ_CLKB r0 *1 0,0
Ccc_XD2_nt_XD4_XDFFQ_CLKB XD2_nt XD4_XDFFQ_CLKB 2.4201e-17
* device instance cc_XD2_nt_XD4_XDFFQ_M r0 *1 0,0
Ccc_XD2_nt_XD4_XDFFQ_M XD2_nt XD4_XDFFQ_M 2.4201e-17
* device instance cc_XD2_nt_XD4_XDFFQ_MB r0 *1 0,0
Ccc_XD2_nt_XD4_XDFFQ_MB XD2_nt XD4_XDFFQ_MB 1.21e-17
* device instance cc_XD2_nt_XD4_XDFFQ_MFB r0 *1 0,0
Ccc_XD2_nt_XD4_XDFFQ_MFB XD2_nt XD4_XDFFQ_MFB 1.21e-17
* device instance cc_XD2_nt_XD4_XDFFQ_S r0 *1 0,0
Ccc_XD2_nt_XD4_XDFFQ_S XD2_nt XD4_XDFFQ_S 1.8151e-17
* device instance cc_XD2_nt_XD4_XDFFQ_SB r0 *1 0,0
Ccc_XD2_nt_XD4_XDFFQ_SB XD2_nt XD4_XDFFQ_SB 1.8151e-17
* device instance cc_XD2_nt_XD4_XDFFQ_SFB r0 *1 0,0
Ccc_XD2_nt_XD4_XDFFQ_SFB XD2_nt XD4_XDFFQ_SFB 1.21e-17
* device instance cc_XD2_nt_XD4_XN2_mid1 r0 *1 0,0
Ccc_XD2_nt_XD4_XN2_mid1 XD2_nt XD4_XN2_mid1 1.21e-17
* device instance cc_XD2_nt_XD4_XN3_mid1 r0 *1 0,0
Ccc_XD2_nt_XD4_XN3_mid1 XD2_nt XD4_XN3_mid1 1.21e-17
* device instance cc_XD2_nt_XD4_XN3_mid2 r0 *1 0,0
Ccc_XD2_nt_XD4_XN3_mid2 XD2_nt XD4_XN3_mid2 1.21e-17
* device instance cc_XD2_nt_XD4_dmodout r0 *1 0,0
Ccc_XD2_nt_XD4_dmodout XD2_nt XD4_dmodout 1.21e-17
* device instance cc_XD2_nt_XD4_dq r0 *1 0,0
Ccc_XD2_nt_XD4_dq XD2_nt XD4_dq 1.8151e-17
* device instance cc_XD2_nt_XD4_nm r0 *1 0,0
Ccc_XD2_nt_XD4_nm XD2_nt XD4_nm 1.21e-17
* device instance cc_XD2_nt_XD4_nt r0 *1 0,0
Ccc_XD2_nt_XD4_nt XD2_nt XD4_nt 1.21e-17
* device instance cc_XD2_nt_XD4_t1 r0 *1 0,0
Ccc_XD2_nt_XD4_t1 XD2_nt XD4_t1 1.21e-17
* device instance cc_XD2_nt_XD5_XDFFM_CKBB r0 *1 0,0
Ccc_XD2_nt_XD5_XDFFM_CKBB XD2_nt XD5_XDFFM_CKBB 1.8151e-17
* device instance cc_XD2_nt_XD5_XDFFM_CLKB r0 *1 0,0
Ccc_XD2_nt_XD5_XDFFM_CLKB XD2_nt XD5_XDFFM_CLKB 2.4201e-17
* device instance cc_XD2_nt_XD5_XDFFM_M r0 *1 0,0
Ccc_XD2_nt_XD5_XDFFM_M XD2_nt XD5_XDFFM_M 2.4201e-17
* device instance cc_XD2_nt_XD5_XDFFM_MB r0 *1 0,0
Ccc_XD2_nt_XD5_XDFFM_MB XD2_nt XD5_XDFFM_MB 1.21e-17
* device instance cc_XD2_nt_XD5_XDFFM_MFB r0 *1 0,0
Ccc_XD2_nt_XD5_XDFFM_MFB XD2_nt XD5_XDFFM_MFB 1.21e-17
* device instance cc_XD2_nt_XD5_XDFFM_S r0 *1 0,0
Ccc_XD2_nt_XD5_XDFFM_S XD2_nt XD5_XDFFM_S 1.8151e-17
* device instance cc_XD2_nt_XD5_XDFFM_SB r0 *1 0,0
Ccc_XD2_nt_XD5_XDFFM_SB XD2_nt XD5_XDFFM_SB 1.8151e-17
* device instance cc_XD2_nt_XD5_XDFFM_SFB r0 *1 0,0
Ccc_XD2_nt_XD5_XDFFM_SFB XD2_nt XD5_XDFFM_SFB 1.21e-17
* device instance cc_XD2_nt_XD5_XDFFQ_CKBB r0 *1 0,0
Ccc_XD2_nt_XD5_XDFFQ_CKBB XD2_nt XD5_XDFFQ_CKBB 1.8151e-17
* device instance cc_XD2_nt_XD5_XDFFQ_CLKB r0 *1 0,0
Ccc_XD2_nt_XD5_XDFFQ_CLKB XD2_nt XD5_XDFFQ_CLKB 2.4201e-17
* device instance cc_XD2_nt_XD5_XDFFQ_M r0 *1 0,0
Ccc_XD2_nt_XD5_XDFFQ_M XD2_nt XD5_XDFFQ_M 2.4201e-17
* device instance cc_XD2_nt_XD5_XDFFQ_MB r0 *1 0,0
Ccc_XD2_nt_XD5_XDFFQ_MB XD2_nt XD5_XDFFQ_MB 1.21e-17
* device instance cc_XD2_nt_XD5_XDFFQ_MFB r0 *1 0,0
Ccc_XD2_nt_XD5_XDFFQ_MFB XD2_nt XD5_XDFFQ_MFB 1.21e-17
* device instance cc_XD2_nt_XD5_XDFFQ_S r0 *1 0,0
Ccc_XD2_nt_XD5_XDFFQ_S XD2_nt XD5_XDFFQ_S 1.8151e-17
* device instance cc_XD2_nt_XD5_XDFFQ_SB r0 *1 0,0
Ccc_XD2_nt_XD5_XDFFQ_SB XD2_nt XD5_XDFFQ_SB 1.8151e-17
* device instance cc_XD2_nt_XD5_XDFFQ_SFB r0 *1 0,0
Ccc_XD2_nt_XD5_XDFFQ_SFB XD2_nt XD5_XDFFQ_SFB 1.21e-17
* device instance cc_XD2_nt_XD5_XN2_mid1 r0 *1 0,0
Ccc_XD2_nt_XD5_XN2_mid1 XD2_nt XD5_XN2_mid1 1.21e-17
* device instance cc_XD2_nt_XD5_XN3_mid1 r0 *1 0,0
Ccc_XD2_nt_XD5_XN3_mid1 XD2_nt XD5_XN3_mid1 1.21e-17
* device instance cc_XD2_nt_XD5_XN3_mid2 r0 *1 0,0
Ccc_XD2_nt_XD5_XN3_mid2 XD2_nt XD5_XN3_mid2 1.21e-17
* device instance cc_XD2_nt_XD5_dmodout r0 *1 0,0
Ccc_XD2_nt_XD5_dmodout XD2_nt XD5_dmodout 1.21e-17
* device instance cc_XD2_nt_XD5_dq r0 *1 0,0
Ccc_XD2_nt_XD5_dq XD2_nt XD5_dq 1.8151e-17
* device instance cc_XD2_nt_XD5_nm r0 *1 0,0
Ccc_XD2_nt_XD5_nm XD2_nt XD5_nm 1.21e-17
* device instance cc_XD2_nt_XD5_nt r0 *1 0,0
Ccc_XD2_nt_XD5_nt XD2_nt XD5_nt 1.21e-17
* device instance cc_XD2_nt_XD5_t1 r0 *1 0,0
Ccc_XD2_nt_XD5_t1 XD2_nt XD5_t1 1.21e-17
* device instance cc_XD2_nt_XFRT_CKBB r0 *1 0,0
Ccc_XD2_nt_XFRT_CKBB XD2_nt XFRT_CKBB 1.8151e-17
* device instance cc_XD2_nt_XFRT_CLKB r0 *1 0,0
Ccc_XD2_nt_XFRT_CLKB XD2_nt XFRT_CLKB 2.4201e-17
* device instance cc_XD2_nt_XFRT_M r0 *1 0,0
Ccc_XD2_nt_XFRT_M XD2_nt XFRT_M 2.4201e-17
* device instance cc_XD2_nt_XFRT_MB r0 *1 0,0
Ccc_XD2_nt_XFRT_MB XD2_nt XFRT_MB 1.21e-17
* device instance cc_XD2_nt_XFRT_MFB r0 *1 0,0
Ccc_XD2_nt_XFRT_MFB XD2_nt XFRT_MFB 1.21e-17
* device instance cc_XD2_nt_XFRT_S r0 *1 0,0
Ccc_XD2_nt_XFRT_S XD2_nt XFRT_S 1.8151e-17
* device instance cc_XD2_nt_XFRT_SB r0 *1 0,0
Ccc_XD2_nt_XFRT_SB XD2_nt XFRT_SB 1.8151e-17
* device instance cc_XD2_nt_XFRT_SFB r0 *1 0,0
Ccc_XD2_nt_XFRT_SFB XD2_nt XFRT_SFB 1.21e-17
* device instance cc_XD2_nt_ck1 r0 *1 0,0
Ccc_XD2_nt_ck1 XD2_nt ck1 3.0251e-17
* device instance cc_XD2_nt_ck2 r0 *1 0,0
Ccc_XD2_nt_ck2 XD2_nt ck2 3.0251e-17
* device instance cc_XD2_nt_ck3 r0 *1 0,0
Ccc_XD2_nt_ck3 XD2_nt ck3 3.0251e-17
* device instance cc_XD2_nt_ck4 r0 *1 0,0
Ccc_XD2_nt_ck4 XD2_nt ck4 3.0251e-17
* device instance cc_XD2_nt_ck5 r0 *1 0,0
Ccc_XD2_nt_ck5 XD2_nt ck5 3.0251e-17
* device instance cc_XD2_nt_mod0 r0 *1 0,0
Ccc_XD2_nt_mod0 XD2_nt mod0 2.4201e-17
* device instance cc_XD2_nt_mod1 r0 *1 0,0
Ccc_XD2_nt_mod1 XD2_nt mod1 3.0251e-17
* device instance cc_XD2_nt_mod2 r0 *1 0,0
Ccc_XD2_nt_mod2 XD2_nt mod2 2.4201e-17
* device instance cc_XD2_nt_mod3 r0 *1 0,0
Ccc_XD2_nt_mod3 XD2_nt mod3 2.4201e-17
* device instance cc_XD2_nt_mod4 r0 *1 0,0
Ccc_XD2_nt_mod4 XD2_nt mod4 2.4201e-17
* device instance cc_XD2_nt_net1 r0 *1 0,0
Ccc_XD2_nt_net1 XD2_nt net1 1.21e-17
* device instance cc_XD2_t1_XD3_XDFFM_CKBB r0 *1 0,0
Ccc_XD2_t1_XD3_XDFFM_CKBB XD2_t1 XD3_XDFFM_CKBB 1.8151e-17
* device instance cc_XD2_t1_XD3_XDFFM_CLKB r0 *1 0,0
Ccc_XD2_t1_XD3_XDFFM_CLKB XD2_t1 XD3_XDFFM_CLKB 2.4201e-17
* device instance cc_XD2_t1_XD3_XDFFM_M r0 *1 0,0
Ccc_XD2_t1_XD3_XDFFM_M XD2_t1 XD3_XDFFM_M 2.4201e-17
* device instance cc_XD2_t1_XD3_XDFFM_MB r0 *1 0,0
Ccc_XD2_t1_XD3_XDFFM_MB XD2_t1 XD3_XDFFM_MB 1.21e-17
* device instance cc_XD2_t1_XD3_XDFFM_MFB r0 *1 0,0
Ccc_XD2_t1_XD3_XDFFM_MFB XD2_t1 XD3_XDFFM_MFB 1.21e-17
* device instance cc_XD2_t1_XD3_XDFFM_S r0 *1 0,0
Ccc_XD2_t1_XD3_XDFFM_S XD2_t1 XD3_XDFFM_S 1.8151e-17
* device instance cc_XD2_t1_XD3_XDFFM_SB r0 *1 0,0
Ccc_XD2_t1_XD3_XDFFM_SB XD2_t1 XD3_XDFFM_SB 1.8151e-17
* device instance cc_XD2_t1_XD3_XDFFM_SFB r0 *1 0,0
Ccc_XD2_t1_XD3_XDFFM_SFB XD2_t1 XD3_XDFFM_SFB 1.21e-17
* device instance cc_XD2_t1_XD3_XDFFQ_CKBB r0 *1 0,0
Ccc_XD2_t1_XD3_XDFFQ_CKBB XD2_t1 XD3_XDFFQ_CKBB 1.8151e-17
* device instance cc_XD2_t1_XD3_XDFFQ_CLKB r0 *1 0,0
Ccc_XD2_t1_XD3_XDFFQ_CLKB XD2_t1 XD3_XDFFQ_CLKB 2.4201e-17
* device instance cc_XD2_t1_XD3_XDFFQ_M r0 *1 0,0
Ccc_XD2_t1_XD3_XDFFQ_M XD2_t1 XD3_XDFFQ_M 2.4201e-17
* device instance cc_XD2_t1_XD3_XDFFQ_MB r0 *1 0,0
Ccc_XD2_t1_XD3_XDFFQ_MB XD2_t1 XD3_XDFFQ_MB 1.21e-17
* device instance cc_XD2_t1_XD3_XDFFQ_MFB r0 *1 0,0
Ccc_XD2_t1_XD3_XDFFQ_MFB XD2_t1 XD3_XDFFQ_MFB 1.21e-17
* device instance cc_XD2_t1_XD3_XDFFQ_S r0 *1 0,0
Ccc_XD2_t1_XD3_XDFFQ_S XD2_t1 XD3_XDFFQ_S 1.8151e-17
* device instance cc_XD2_t1_XD3_XDFFQ_SB r0 *1 0,0
Ccc_XD2_t1_XD3_XDFFQ_SB XD2_t1 XD3_XDFFQ_SB 1.8151e-17
* device instance cc_XD2_t1_XD3_XDFFQ_SFB r0 *1 0,0
Ccc_XD2_t1_XD3_XDFFQ_SFB XD2_t1 XD3_XDFFQ_SFB 1.21e-17
* device instance cc_XD2_t1_XD3_XN2_mid1 r0 *1 0,0
Ccc_XD2_t1_XD3_XN2_mid1 XD2_t1 XD3_XN2_mid1 1.21e-17
* device instance cc_XD2_t1_XD3_XN3_mid1 r0 *1 0,0
Ccc_XD2_t1_XD3_XN3_mid1 XD2_t1 XD3_XN3_mid1 1.21e-17
* device instance cc_XD2_t1_XD3_XN3_mid2 r0 *1 0,0
Ccc_XD2_t1_XD3_XN3_mid2 XD2_t1 XD3_XN3_mid2 1.21e-17
* device instance cc_XD2_t1_XD3_dmodout r0 *1 0,0
Ccc_XD2_t1_XD3_dmodout XD2_t1 XD3_dmodout 1.21e-17
* device instance cc_XD2_t1_XD3_dq r0 *1 0,0
Ccc_XD2_t1_XD3_dq XD2_t1 XD3_dq 1.8151e-17
* device instance cc_XD2_t1_XD3_nm r0 *1 0,0
Ccc_XD2_t1_XD3_nm XD2_t1 XD3_nm 1.21e-17
* device instance cc_XD2_t1_XD3_nt r0 *1 0,0
Ccc_XD2_t1_XD3_nt XD2_t1 XD3_nt 1.21e-17
* device instance cc_XD2_t1_XD3_t1 r0 *1 0,0
Ccc_XD2_t1_XD3_t1 XD2_t1 XD3_t1 1.21e-17
* device instance cc_XD2_t1_XD4_XDFFM_CKBB r0 *1 0,0
Ccc_XD2_t1_XD4_XDFFM_CKBB XD2_t1 XD4_XDFFM_CKBB 1.8151e-17
* device instance cc_XD2_t1_XD4_XDFFM_CLKB r0 *1 0,0
Ccc_XD2_t1_XD4_XDFFM_CLKB XD2_t1 XD4_XDFFM_CLKB 2.4201e-17
* device instance cc_XD2_t1_XD4_XDFFM_M r0 *1 0,0
Ccc_XD2_t1_XD4_XDFFM_M XD2_t1 XD4_XDFFM_M 2.4201e-17
* device instance cc_XD2_t1_XD4_XDFFM_MB r0 *1 0,0
Ccc_XD2_t1_XD4_XDFFM_MB XD2_t1 XD4_XDFFM_MB 1.21e-17
* device instance cc_XD2_t1_XD4_XDFFM_MFB r0 *1 0,0
Ccc_XD2_t1_XD4_XDFFM_MFB XD2_t1 XD4_XDFFM_MFB 1.21e-17
* device instance cc_XD2_t1_XD4_XDFFM_S r0 *1 0,0
Ccc_XD2_t1_XD4_XDFFM_S XD2_t1 XD4_XDFFM_S 1.8151e-17
* device instance cc_XD2_t1_XD4_XDFFM_SB r0 *1 0,0
Ccc_XD2_t1_XD4_XDFFM_SB XD2_t1 XD4_XDFFM_SB 1.8151e-17
* device instance cc_XD2_t1_XD4_XDFFM_SFB r0 *1 0,0
Ccc_XD2_t1_XD4_XDFFM_SFB XD2_t1 XD4_XDFFM_SFB 1.21e-17
* device instance cc_XD2_t1_XD4_XDFFQ_CKBB r0 *1 0,0
Ccc_XD2_t1_XD4_XDFFQ_CKBB XD2_t1 XD4_XDFFQ_CKBB 1.8151e-17
* device instance cc_XD2_t1_XD4_XDFFQ_CLKB r0 *1 0,0
Ccc_XD2_t1_XD4_XDFFQ_CLKB XD2_t1 XD4_XDFFQ_CLKB 2.4201e-17
* device instance cc_XD2_t1_XD4_XDFFQ_M r0 *1 0,0
Ccc_XD2_t1_XD4_XDFFQ_M XD2_t1 XD4_XDFFQ_M 2.4201e-17
* device instance cc_XD2_t1_XD4_XDFFQ_MB r0 *1 0,0
Ccc_XD2_t1_XD4_XDFFQ_MB XD2_t1 XD4_XDFFQ_MB 1.21e-17
* device instance cc_XD2_t1_XD4_XDFFQ_MFB r0 *1 0,0
Ccc_XD2_t1_XD4_XDFFQ_MFB XD2_t1 XD4_XDFFQ_MFB 1.21e-17
* device instance cc_XD2_t1_XD4_XDFFQ_S r0 *1 0,0
Ccc_XD2_t1_XD4_XDFFQ_S XD2_t1 XD4_XDFFQ_S 1.8151e-17
* device instance cc_XD2_t1_XD4_XDFFQ_SB r0 *1 0,0
Ccc_XD2_t1_XD4_XDFFQ_SB XD2_t1 XD4_XDFFQ_SB 1.8151e-17
* device instance cc_XD2_t1_XD4_XDFFQ_SFB r0 *1 0,0
Ccc_XD2_t1_XD4_XDFFQ_SFB XD2_t1 XD4_XDFFQ_SFB 1.21e-17
* device instance cc_XD2_t1_XD4_XN2_mid1 r0 *1 0,0
Ccc_XD2_t1_XD4_XN2_mid1 XD2_t1 XD4_XN2_mid1 1.21e-17
* device instance cc_XD2_t1_XD4_XN3_mid1 r0 *1 0,0
Ccc_XD2_t1_XD4_XN3_mid1 XD2_t1 XD4_XN3_mid1 1.21e-17
* device instance cc_XD2_t1_XD4_XN3_mid2 r0 *1 0,0
Ccc_XD2_t1_XD4_XN3_mid2 XD2_t1 XD4_XN3_mid2 1.21e-17
* device instance cc_XD2_t1_XD4_dmodout r0 *1 0,0
Ccc_XD2_t1_XD4_dmodout XD2_t1 XD4_dmodout 1.21e-17
* device instance cc_XD2_t1_XD4_dq r0 *1 0,0
Ccc_XD2_t1_XD4_dq XD2_t1 XD4_dq 1.8151e-17
* device instance cc_XD2_t1_XD4_nm r0 *1 0,0
Ccc_XD2_t1_XD4_nm XD2_t1 XD4_nm 1.21e-17
* device instance cc_XD2_t1_XD4_nt r0 *1 0,0
Ccc_XD2_t1_XD4_nt XD2_t1 XD4_nt 1.21e-17
* device instance cc_XD2_t1_XD4_t1 r0 *1 0,0
Ccc_XD2_t1_XD4_t1 XD2_t1 XD4_t1 1.21e-17
* device instance cc_XD2_t1_XD5_XDFFM_CKBB r0 *1 0,0
Ccc_XD2_t1_XD5_XDFFM_CKBB XD2_t1 XD5_XDFFM_CKBB 1.8151e-17
* device instance cc_XD2_t1_XD5_XDFFM_CLKB r0 *1 0,0
Ccc_XD2_t1_XD5_XDFFM_CLKB XD2_t1 XD5_XDFFM_CLKB 2.4201e-17
* device instance cc_XD2_t1_XD5_XDFFM_M r0 *1 0,0
Ccc_XD2_t1_XD5_XDFFM_M XD2_t1 XD5_XDFFM_M 2.4201e-17
* device instance cc_XD2_t1_XD5_XDFFM_MB r0 *1 0,0
Ccc_XD2_t1_XD5_XDFFM_MB XD2_t1 XD5_XDFFM_MB 1.21e-17
* device instance cc_XD2_t1_XD5_XDFFM_MFB r0 *1 0,0
Ccc_XD2_t1_XD5_XDFFM_MFB XD2_t1 XD5_XDFFM_MFB 1.21e-17
* device instance cc_XD2_t1_XD5_XDFFM_S r0 *1 0,0
Ccc_XD2_t1_XD5_XDFFM_S XD2_t1 XD5_XDFFM_S 1.8151e-17
* device instance cc_XD2_t1_XD5_XDFFM_SB r0 *1 0,0
Ccc_XD2_t1_XD5_XDFFM_SB XD2_t1 XD5_XDFFM_SB 1.8151e-17
* device instance cc_XD2_t1_XD5_XDFFM_SFB r0 *1 0,0
Ccc_XD2_t1_XD5_XDFFM_SFB XD2_t1 XD5_XDFFM_SFB 1.21e-17
* device instance cc_XD2_t1_XD5_XDFFQ_CKBB r0 *1 0,0
Ccc_XD2_t1_XD5_XDFFQ_CKBB XD2_t1 XD5_XDFFQ_CKBB 1.8151e-17
* device instance cc_XD2_t1_XD5_XDFFQ_CLKB r0 *1 0,0
Ccc_XD2_t1_XD5_XDFFQ_CLKB XD2_t1 XD5_XDFFQ_CLKB 2.4201e-17
* device instance cc_XD2_t1_XD5_XDFFQ_M r0 *1 0,0
Ccc_XD2_t1_XD5_XDFFQ_M XD2_t1 XD5_XDFFQ_M 2.4201e-17
* device instance cc_XD2_t1_XD5_XDFFQ_MB r0 *1 0,0
Ccc_XD2_t1_XD5_XDFFQ_MB XD2_t1 XD5_XDFFQ_MB 1.21e-17
* device instance cc_XD2_t1_XD5_XDFFQ_MFB r0 *1 0,0
Ccc_XD2_t1_XD5_XDFFQ_MFB XD2_t1 XD5_XDFFQ_MFB 1.21e-17
* device instance cc_XD2_t1_XD5_XDFFQ_S r0 *1 0,0
Ccc_XD2_t1_XD5_XDFFQ_S XD2_t1 XD5_XDFFQ_S 1.8151e-17
* device instance cc_XD2_t1_XD5_XDFFQ_SB r0 *1 0,0
Ccc_XD2_t1_XD5_XDFFQ_SB XD2_t1 XD5_XDFFQ_SB 1.8151e-17
* device instance cc_XD2_t1_XD5_XDFFQ_SFB r0 *1 0,0
Ccc_XD2_t1_XD5_XDFFQ_SFB XD2_t1 XD5_XDFFQ_SFB 1.21e-17
* device instance cc_XD2_t1_XD5_XN2_mid1 r0 *1 0,0
Ccc_XD2_t1_XD5_XN2_mid1 XD2_t1 XD5_XN2_mid1 1.21e-17
* device instance cc_XD2_t1_XD5_XN3_mid1 r0 *1 0,0
Ccc_XD2_t1_XD5_XN3_mid1 XD2_t1 XD5_XN3_mid1 1.21e-17
* device instance cc_XD2_t1_XD5_XN3_mid2 r0 *1 0,0
Ccc_XD2_t1_XD5_XN3_mid2 XD2_t1 XD5_XN3_mid2 1.21e-17
* device instance cc_XD2_t1_XD5_dmodout r0 *1 0,0
Ccc_XD2_t1_XD5_dmodout XD2_t1 XD5_dmodout 1.21e-17
* device instance cc_XD2_t1_XD5_dq r0 *1 0,0
Ccc_XD2_t1_XD5_dq XD2_t1 XD5_dq 1.8151e-17
* device instance cc_XD2_t1_XD5_nm r0 *1 0,0
Ccc_XD2_t1_XD5_nm XD2_t1 XD5_nm 1.21e-17
* device instance cc_XD2_t1_XD5_nt r0 *1 0,0
Ccc_XD2_t1_XD5_nt XD2_t1 XD5_nt 1.21e-17
* device instance cc_XD2_t1_XD5_t1 r0 *1 0,0
Ccc_XD2_t1_XD5_t1 XD2_t1 XD5_t1 1.21e-17
* device instance cc_XD2_t1_XFRT_CKBB r0 *1 0,0
Ccc_XD2_t1_XFRT_CKBB XD2_t1 XFRT_CKBB 1.8151e-17
* device instance cc_XD2_t1_XFRT_CLKB r0 *1 0,0
Ccc_XD2_t1_XFRT_CLKB XD2_t1 XFRT_CLKB 2.4201e-17
* device instance cc_XD2_t1_XFRT_M r0 *1 0,0
Ccc_XD2_t1_XFRT_M XD2_t1 XFRT_M 2.4201e-17
* device instance cc_XD2_t1_XFRT_MB r0 *1 0,0
Ccc_XD2_t1_XFRT_MB XD2_t1 XFRT_MB 1.21e-17
* device instance cc_XD2_t1_XFRT_MFB r0 *1 0,0
Ccc_XD2_t1_XFRT_MFB XD2_t1 XFRT_MFB 1.21e-17
* device instance cc_XD2_t1_XFRT_S r0 *1 0,0
Ccc_XD2_t1_XFRT_S XD2_t1 XFRT_S 1.8151e-17
* device instance cc_XD2_t1_XFRT_SB r0 *1 0,0
Ccc_XD2_t1_XFRT_SB XD2_t1 XFRT_SB 1.8151e-17
* device instance cc_XD2_t1_XFRT_SFB r0 *1 0,0
Ccc_XD2_t1_XFRT_SFB XD2_t1 XFRT_SFB 1.21e-17
* device instance cc_XD2_t1_ck1 r0 *1 0,0
Ccc_XD2_t1_ck1 XD2_t1 ck1 3.0251e-17
* device instance cc_XD2_t1_ck2 r0 *1 0,0
Ccc_XD2_t1_ck2 XD2_t1 ck2 3.0251e-17
* device instance cc_XD2_t1_ck3 r0 *1 0,0
Ccc_XD2_t1_ck3 XD2_t1 ck3 3.6302e-17
* device instance cc_XD2_t1_ck4 r0 *1 0,0
Ccc_XD2_t1_ck4 XD2_t1 ck4 3.0251e-17
* device instance cc_XD2_t1_ck5 r0 *1 0,0
Ccc_XD2_t1_ck5 XD2_t1 ck5 3.0251e-17
* device instance cc_XD2_t1_mod0 r0 *1 0,0
Ccc_XD2_t1_mod0 XD2_t1 mod0 2.4201e-17
* device instance cc_XD2_t1_mod1 r0 *1 0,0
Ccc_XD2_t1_mod1 XD2_t1 mod1 2.4201e-17
* device instance cc_XD2_t1_mod2 r0 *1 0,0
Ccc_XD2_t1_mod2 XD2_t1 mod2 2.4201e-17
* device instance cc_XD2_t1_mod3 r0 *1 0,0
Ccc_XD2_t1_mod3 XD2_t1 mod3 2.4201e-17
* device instance cc_XD2_t1_mod4 r0 *1 0,0
Ccc_XD2_t1_mod4 XD2_t1 mod4 2.4201e-17
* device instance cc_XD2_t1_net1 r0 *1 0,0
Ccc_XD2_t1_net1 XD2_t1 net1 1.21e-17
* device instance cc_XD3_XDFFM_CKBB_XD3_XDFFM_CLKB r0 *1 0,0
Ccc_XD3_XDFFM_CKBB_XD3_XDFFM_CLKB XD3_XDFFM_CKBB XD3_XDFFM_CLKB 3.6302e-17
* device instance cc_XD3_XDFFM_CKBB_XD3_XDFFM_M r0 *1 0,0
Ccc_XD3_XDFFM_CKBB_XD3_XDFFM_M XD3_XDFFM_CKBB XD3_XDFFM_M 4.8402e-17
* device instance cc_XD3_XDFFM_CKBB_XD3_XDFFM_MB r0 *1 0,0
Ccc_XD3_XDFFM_CKBB_XD3_XDFFM_MB XD3_XDFFM_CKBB XD3_XDFFM_MB 2.4201e-17
* device instance cc_XD3_XDFFM_CKBB_XD3_XDFFM_MFB r0 *1 0,0
Ccc_XD3_XDFFM_CKBB_XD3_XDFFM_MFB XD3_XDFFM_CKBB XD3_XDFFM_MFB 2.4201e-17
* device instance cc_XD3_XDFFM_CKBB_XD3_XDFFM_S r0 *1 0,0
Ccc_XD3_XDFFM_CKBB_XD3_XDFFM_S XD3_XDFFM_CKBB XD3_XDFFM_S 3.0251e-17
* device instance cc_XD3_XDFFM_CKBB_XD3_XDFFM_SB r0 *1 0,0
Ccc_XD3_XDFFM_CKBB_XD3_XDFFM_SB XD3_XDFFM_CKBB XD3_XDFFM_SB 3.0251e-17
* device instance cc_XD3_XDFFM_CKBB_XD3_XDFFM_SFB r0 *1 0,0
Ccc_XD3_XDFFM_CKBB_XD3_XDFFM_SFB XD3_XDFFM_CKBB XD3_XDFFM_SFB 1.8151e-17
* device instance cc_XD3_XDFFM_CKBB_XD3_XDFFQ_CKBB r0 *1 0,0
Ccc_XD3_XDFFM_CKBB_XD3_XDFFQ_CKBB XD3_XDFFM_CKBB XD3_XDFFQ_CKBB 1.8151e-17
* device instance cc_XD3_XDFFM_CKBB_XD3_XDFFQ_CLKB r0 *1 0,0
Ccc_XD3_XDFFM_CKBB_XD3_XDFFQ_CLKB XD3_XDFFM_CKBB XD3_XDFFQ_CLKB 2.4201e-17
* device instance cc_XD3_XDFFM_CKBB_XD3_XDFFQ_M r0 *1 0,0
Ccc_XD3_XDFFM_CKBB_XD3_XDFFQ_M XD3_XDFFM_CKBB XD3_XDFFQ_M 2.4201e-17
* device instance cc_XD3_XDFFM_CKBB_XD3_XDFFQ_MB r0 *1 0,0
Ccc_XD3_XDFFM_CKBB_XD3_XDFFQ_MB XD3_XDFFM_CKBB XD3_XDFFQ_MB 1.21e-17
* device instance cc_XD3_XDFFM_CKBB_XD3_XDFFQ_MFB r0 *1 0,0
Ccc_XD3_XDFFM_CKBB_XD3_XDFFQ_MFB XD3_XDFFM_CKBB XD3_XDFFQ_MFB 1.21e-17
* device instance cc_XD3_XDFFM_CKBB_XD3_XDFFQ_S r0 *1 0,0
Ccc_XD3_XDFFM_CKBB_XD3_XDFFQ_S XD3_XDFFM_CKBB XD3_XDFFQ_S 1.8151e-17
* device instance cc_XD3_XDFFM_CKBB_XD3_XDFFQ_SB r0 *1 0,0
Ccc_XD3_XDFFM_CKBB_XD3_XDFFQ_SB XD3_XDFFM_CKBB XD3_XDFFQ_SB 1.8151e-17
* device instance cc_XD3_XDFFM_CKBB_XD3_XDFFQ_SFB r0 *1 0,0
Ccc_XD3_XDFFM_CKBB_XD3_XDFFQ_SFB XD3_XDFFM_CKBB XD3_XDFFQ_SFB 1.21e-17
* device instance cc_XD3_XDFFM_CKBB_XD3_XNOR_midp r0 *1 0,0
Ccc_XD3_XDFFM_CKBB_XD3_XNOR_midp XD3_XDFFM_CKBB XD3_XNOR_midp 1.21e-17
* device instance cc_XD3_XDFFM_CKBB_XD3_dmodout r0 *1 0,0
Ccc_XD3_XDFFM_CKBB_XD3_dmodout XD3_XDFFM_CKBB XD3_dmodout 1.8151e-17
* device instance cc_XD3_XDFFM_CKBB_XD3_dq r0 *1 0,0
Ccc_XD3_XDFFM_CKBB_XD3_dq XD3_XDFFM_CKBB XD3_dq 1.21e-17
* device instance cc_XD3_XDFFM_CKBB_XD3_nm r0 *1 0,0
Ccc_XD3_XDFFM_CKBB_XD3_nm XD3_XDFFM_CKBB XD3_nm 1.8151e-17
* device instance cc_XD3_XDFFM_CKBB_XD3_nt r0 *1 0,0
Ccc_XD3_XDFFM_CKBB_XD3_nt XD3_XDFFM_CKBB XD3_nt 2.4201e-17
* device instance cc_XD3_XDFFM_CKBB_XD3_t1 r0 *1 0,0
Ccc_XD3_XDFFM_CKBB_XD3_t1 XD3_XDFFM_CKBB XD3_t1 1.21e-17
* device instance cc_XD3_XDFFM_CKBB_XD4_XDFFM_CKBB r0 *1 0,0
Ccc_XD3_XDFFM_CKBB_XD4_XDFFM_CKBB XD3_XDFFM_CKBB XD4_XDFFM_CKBB 1.8151e-17
* device instance cc_XD3_XDFFM_CKBB_XD4_XDFFM_CLKB r0 *1 0,0
Ccc_XD3_XDFFM_CKBB_XD4_XDFFM_CLKB XD3_XDFFM_CKBB XD4_XDFFM_CLKB 2.4201e-17
* device instance cc_XD3_XDFFM_CKBB_XD4_XDFFM_M r0 *1 0,0
Ccc_XD3_XDFFM_CKBB_XD4_XDFFM_M XD3_XDFFM_CKBB XD4_XDFFM_M 2.4201e-17
* device instance cc_XD3_XDFFM_CKBB_XD4_XDFFM_MB r0 *1 0,0
Ccc_XD3_XDFFM_CKBB_XD4_XDFFM_MB XD3_XDFFM_CKBB XD4_XDFFM_MB 1.21e-17
* device instance cc_XD3_XDFFM_CKBB_XD4_XDFFM_MFB r0 *1 0,0
Ccc_XD3_XDFFM_CKBB_XD4_XDFFM_MFB XD3_XDFFM_CKBB XD4_XDFFM_MFB 1.21e-17
* device instance cc_XD3_XDFFM_CKBB_XD4_XDFFM_S r0 *1 0,0
Ccc_XD3_XDFFM_CKBB_XD4_XDFFM_S XD3_XDFFM_CKBB XD4_XDFFM_S 1.8151e-17
* device instance cc_XD3_XDFFM_CKBB_XD4_XDFFM_SB r0 *1 0,0
Ccc_XD3_XDFFM_CKBB_XD4_XDFFM_SB XD3_XDFFM_CKBB XD4_XDFFM_SB 1.8151e-17
* device instance cc_XD3_XDFFM_CKBB_XD4_XDFFM_SFB r0 *1 0,0
Ccc_XD3_XDFFM_CKBB_XD4_XDFFM_SFB XD3_XDFFM_CKBB XD4_XDFFM_SFB 1.21e-17
* device instance cc_XD3_XDFFM_CKBB_XD4_XDFFQ_CKBB r0 *1 0,0
Ccc_XD3_XDFFM_CKBB_XD4_XDFFQ_CKBB XD3_XDFFM_CKBB XD4_XDFFQ_CKBB 1.8151e-17
* device instance cc_XD3_XDFFM_CKBB_XD4_XDFFQ_CLKB r0 *1 0,0
Ccc_XD3_XDFFM_CKBB_XD4_XDFFQ_CLKB XD3_XDFFM_CKBB XD4_XDFFQ_CLKB 2.4201e-17
* device instance cc_XD3_XDFFM_CKBB_XD4_XDFFQ_M r0 *1 0,0
Ccc_XD3_XDFFM_CKBB_XD4_XDFFQ_M XD3_XDFFM_CKBB XD4_XDFFQ_M 2.4201e-17
* device instance cc_XD3_XDFFM_CKBB_XD4_XDFFQ_MB r0 *1 0,0
Ccc_XD3_XDFFM_CKBB_XD4_XDFFQ_MB XD3_XDFFM_CKBB XD4_XDFFQ_MB 1.21e-17
* device instance cc_XD3_XDFFM_CKBB_XD4_XDFFQ_MFB r0 *1 0,0
Ccc_XD3_XDFFM_CKBB_XD4_XDFFQ_MFB XD3_XDFFM_CKBB XD4_XDFFQ_MFB 1.21e-17
* device instance cc_XD3_XDFFM_CKBB_XD4_XDFFQ_S r0 *1 0,0
Ccc_XD3_XDFFM_CKBB_XD4_XDFFQ_S XD3_XDFFM_CKBB XD4_XDFFQ_S 1.8151e-17
* device instance cc_XD3_XDFFM_CKBB_XD4_XDFFQ_SB r0 *1 0,0
Ccc_XD3_XDFFM_CKBB_XD4_XDFFQ_SB XD3_XDFFM_CKBB XD4_XDFFQ_SB 1.8151e-17
* device instance cc_XD3_XDFFM_CKBB_XD4_XDFFQ_SFB r0 *1 0,0
Ccc_XD3_XDFFM_CKBB_XD4_XDFFQ_SFB XD3_XDFFM_CKBB XD4_XDFFQ_SFB 1.21e-17
* device instance cc_XD3_XDFFM_CKBB_XD4_XN2_mid1 r0 *1 0,0
Ccc_XD3_XDFFM_CKBB_XD4_XN2_mid1 XD3_XDFFM_CKBB XD4_XN2_mid1 1.21e-17
* device instance cc_XD3_XDFFM_CKBB_XD4_XN3_mid1 r0 *1 0,0
Ccc_XD3_XDFFM_CKBB_XD4_XN3_mid1 XD3_XDFFM_CKBB XD4_XN3_mid1 1.21e-17
* device instance cc_XD3_XDFFM_CKBB_XD4_XN3_mid2 r0 *1 0,0
Ccc_XD3_XDFFM_CKBB_XD4_XN3_mid2 XD3_XDFFM_CKBB XD4_XN3_mid2 1.21e-17
* device instance cc_XD3_XDFFM_CKBB_XD4_dmodout r0 *1 0,0
Ccc_XD3_XDFFM_CKBB_XD4_dmodout XD3_XDFFM_CKBB XD4_dmodout 1.21e-17
* device instance cc_XD3_XDFFM_CKBB_XD4_dq r0 *1 0,0
Ccc_XD3_XDFFM_CKBB_XD4_dq XD3_XDFFM_CKBB XD4_dq 1.8151e-17
* device instance cc_XD3_XDFFM_CKBB_XD4_nm r0 *1 0,0
Ccc_XD3_XDFFM_CKBB_XD4_nm XD3_XDFFM_CKBB XD4_nm 1.21e-17
* device instance cc_XD3_XDFFM_CKBB_XD4_nt r0 *1 0,0
Ccc_XD3_XDFFM_CKBB_XD4_nt XD3_XDFFM_CKBB XD4_nt 1.21e-17
* device instance cc_XD3_XDFFM_CKBB_XD4_t1 r0 *1 0,0
Ccc_XD3_XDFFM_CKBB_XD4_t1 XD3_XDFFM_CKBB XD4_t1 1.21e-17
* device instance cc_XD3_XDFFM_CKBB_XD5_XDFFM_CKBB r0 *1 0,0
Ccc_XD3_XDFFM_CKBB_XD5_XDFFM_CKBB XD3_XDFFM_CKBB XD5_XDFFM_CKBB 1.8151e-17
* device instance cc_XD3_XDFFM_CKBB_XD5_XDFFM_CLKB r0 *1 0,0
Ccc_XD3_XDFFM_CKBB_XD5_XDFFM_CLKB XD3_XDFFM_CKBB XD5_XDFFM_CLKB 2.4201e-17
* device instance cc_XD3_XDFFM_CKBB_XD5_XDFFM_M r0 *1 0,0
Ccc_XD3_XDFFM_CKBB_XD5_XDFFM_M XD3_XDFFM_CKBB XD5_XDFFM_M 2.4201e-17
* device instance cc_XD3_XDFFM_CKBB_XD5_XDFFM_MB r0 *1 0,0
Ccc_XD3_XDFFM_CKBB_XD5_XDFFM_MB XD3_XDFFM_CKBB XD5_XDFFM_MB 1.21e-17
* device instance cc_XD3_XDFFM_CKBB_XD5_XDFFM_MFB r0 *1 0,0
Ccc_XD3_XDFFM_CKBB_XD5_XDFFM_MFB XD3_XDFFM_CKBB XD5_XDFFM_MFB 1.21e-17
* device instance cc_XD3_XDFFM_CKBB_XD5_XDFFM_S r0 *1 0,0
Ccc_XD3_XDFFM_CKBB_XD5_XDFFM_S XD3_XDFFM_CKBB XD5_XDFFM_S 1.8151e-17
* device instance cc_XD3_XDFFM_CKBB_XD5_XDFFM_SB r0 *1 0,0
Ccc_XD3_XDFFM_CKBB_XD5_XDFFM_SB XD3_XDFFM_CKBB XD5_XDFFM_SB 1.8151e-17
* device instance cc_XD3_XDFFM_CKBB_XD5_XDFFM_SFB r0 *1 0,0
Ccc_XD3_XDFFM_CKBB_XD5_XDFFM_SFB XD3_XDFFM_CKBB XD5_XDFFM_SFB 1.21e-17
* device instance cc_XD3_XDFFM_CKBB_XD5_XDFFQ_CKBB r0 *1 0,0
Ccc_XD3_XDFFM_CKBB_XD5_XDFFQ_CKBB XD3_XDFFM_CKBB XD5_XDFFQ_CKBB 1.8151e-17
* device instance cc_XD3_XDFFM_CKBB_XD5_XDFFQ_CLKB r0 *1 0,0
Ccc_XD3_XDFFM_CKBB_XD5_XDFFQ_CLKB XD3_XDFFM_CKBB XD5_XDFFQ_CLKB 2.4201e-17
* device instance cc_XD3_XDFFM_CKBB_XD5_XDFFQ_M r0 *1 0,0
Ccc_XD3_XDFFM_CKBB_XD5_XDFFQ_M XD3_XDFFM_CKBB XD5_XDFFQ_M 2.4201e-17
* device instance cc_XD3_XDFFM_CKBB_XD5_XDFFQ_MB r0 *1 0,0
Ccc_XD3_XDFFM_CKBB_XD5_XDFFQ_MB XD3_XDFFM_CKBB XD5_XDFFQ_MB 1.21e-17
* device instance cc_XD3_XDFFM_CKBB_XD5_XDFFQ_MFB r0 *1 0,0
Ccc_XD3_XDFFM_CKBB_XD5_XDFFQ_MFB XD3_XDFFM_CKBB XD5_XDFFQ_MFB 1.21e-17
* device instance cc_XD3_XDFFM_CKBB_XD5_XDFFQ_S r0 *1 0,0
Ccc_XD3_XDFFM_CKBB_XD5_XDFFQ_S XD3_XDFFM_CKBB XD5_XDFFQ_S 1.8151e-17
* device instance cc_XD3_XDFFM_CKBB_XD5_XDFFQ_SB r0 *1 0,0
Ccc_XD3_XDFFM_CKBB_XD5_XDFFQ_SB XD3_XDFFM_CKBB XD5_XDFFQ_SB 1.8151e-17
* device instance cc_XD3_XDFFM_CKBB_XD5_XDFFQ_SFB r0 *1 0,0
Ccc_XD3_XDFFM_CKBB_XD5_XDFFQ_SFB XD3_XDFFM_CKBB XD5_XDFFQ_SFB 1.21e-17
* device instance cc_XD3_XDFFM_CKBB_XD5_XN2_mid1 r0 *1 0,0
Ccc_XD3_XDFFM_CKBB_XD5_XN2_mid1 XD3_XDFFM_CKBB XD5_XN2_mid1 1.21e-17
* device instance cc_XD3_XDFFM_CKBB_XD5_XN3_mid1 r0 *1 0,0
Ccc_XD3_XDFFM_CKBB_XD5_XN3_mid1 XD3_XDFFM_CKBB XD5_XN3_mid1 1.21e-17
* device instance cc_XD3_XDFFM_CKBB_XD5_XN3_mid2 r0 *1 0,0
Ccc_XD3_XDFFM_CKBB_XD5_XN3_mid2 XD3_XDFFM_CKBB XD5_XN3_mid2 1.21e-17
* device instance cc_XD3_XDFFM_CKBB_XD5_dmodout r0 *1 0,0
Ccc_XD3_XDFFM_CKBB_XD5_dmodout XD3_XDFFM_CKBB XD5_dmodout 1.21e-17
* device instance cc_XD3_XDFFM_CKBB_XD5_dq r0 *1 0,0
Ccc_XD3_XDFFM_CKBB_XD5_dq XD3_XDFFM_CKBB XD5_dq 1.8151e-17
* device instance cc_XD3_XDFFM_CKBB_XD5_nm r0 *1 0,0
Ccc_XD3_XDFFM_CKBB_XD5_nm XD3_XDFFM_CKBB XD5_nm 1.21e-17
* device instance cc_XD3_XDFFM_CKBB_XD5_nt r0 *1 0,0
Ccc_XD3_XDFFM_CKBB_XD5_nt XD3_XDFFM_CKBB XD5_nt 1.21e-17
* device instance cc_XD3_XDFFM_CKBB_XD5_t1 r0 *1 0,0
Ccc_XD3_XDFFM_CKBB_XD5_t1 XD3_XDFFM_CKBB XD5_t1 1.21e-17
* device instance cc_XD3_XDFFM_CKBB_XFRT_CKBB r0 *1 0,0
Ccc_XD3_XDFFM_CKBB_XFRT_CKBB XD3_XDFFM_CKBB XFRT_CKBB 1.8151e-17
* device instance cc_XD3_XDFFM_CKBB_XFRT_CLKB r0 *1 0,0
Ccc_XD3_XDFFM_CKBB_XFRT_CLKB XD3_XDFFM_CKBB XFRT_CLKB 2.4201e-17
* device instance cc_XD3_XDFFM_CKBB_XFRT_M r0 *1 0,0
Ccc_XD3_XDFFM_CKBB_XFRT_M XD3_XDFFM_CKBB XFRT_M 2.4201e-17
* device instance cc_XD3_XDFFM_CKBB_XFRT_MB r0 *1 0,0
Ccc_XD3_XDFFM_CKBB_XFRT_MB XD3_XDFFM_CKBB XFRT_MB 1.21e-17
* device instance cc_XD3_XDFFM_CKBB_XFRT_MFB r0 *1 0,0
Ccc_XD3_XDFFM_CKBB_XFRT_MFB XD3_XDFFM_CKBB XFRT_MFB 1.21e-17
* device instance cc_XD3_XDFFM_CKBB_XFRT_S r0 *1 0,0
Ccc_XD3_XDFFM_CKBB_XFRT_S XD3_XDFFM_CKBB XFRT_S 1.8151e-17
* device instance cc_XD3_XDFFM_CKBB_XFRT_SB r0 *1 0,0
Ccc_XD3_XDFFM_CKBB_XFRT_SB XD3_XDFFM_CKBB XFRT_SB 1.8151e-17
* device instance cc_XD3_XDFFM_CKBB_XFRT_SFB r0 *1 0,0
Ccc_XD3_XDFFM_CKBB_XFRT_SFB XD3_XDFFM_CKBB XFRT_SFB 1.21e-17
* device instance cc_XD3_XDFFM_CKBB_ck1 r0 *1 0,0
Ccc_XD3_XDFFM_CKBB_ck1 XD3_XDFFM_CKBB ck1 3.0251e-17
* device instance cc_XD3_XDFFM_CKBB_ck2 r0 *1 0,0
Ccc_XD3_XDFFM_CKBB_ck2 XD3_XDFFM_CKBB ck2 3.0251e-17
* device instance cc_XD3_XDFFM_CKBB_ck3 r0 *1 0,0
Ccc_XD3_XDFFM_CKBB_ck3 XD3_XDFFM_CKBB ck3 3.0251e-17
* device instance cc_XD3_XDFFM_CKBB_ck4 r0 *1 0,0
Ccc_XD3_XDFFM_CKBB_ck4 XD3_XDFFM_CKBB ck4 3.0251e-17
* device instance cc_XD3_XDFFM_CKBB_ck5 r0 *1 0,0
Ccc_XD3_XDFFM_CKBB_ck5 XD3_XDFFM_CKBB ck5 3.0251e-17
* device instance cc_XD3_XDFFM_CKBB_mod0 r0 *1 0,0
Ccc_XD3_XDFFM_CKBB_mod0 XD3_XDFFM_CKBB mod0 2.4201e-17
* device instance cc_XD3_XDFFM_CKBB_mod1 r0 *1 0,0
Ccc_XD3_XDFFM_CKBB_mod1 XD3_XDFFM_CKBB mod1 2.4201e-17
* device instance cc_XD3_XDFFM_CKBB_mod2 r0 *1 0,0
Ccc_XD3_XDFFM_CKBB_mod2 XD3_XDFFM_CKBB mod2 2.4201e-17
* device instance cc_XD3_XDFFM_CKBB_mod3 r0 *1 0,0
Ccc_XD3_XDFFM_CKBB_mod3 XD3_XDFFM_CKBB mod3 2.4201e-17
* device instance cc_XD3_XDFFM_CKBB_mod4 r0 *1 0,0
Ccc_XD3_XDFFM_CKBB_mod4 XD3_XDFFM_CKBB mod4 2.4201e-17
* device instance cc_XD3_XDFFM_CKBB_net1 r0 *1 0,0
Ccc_XD3_XDFFM_CKBB_net1 XD3_XDFFM_CKBB net1 1.21e-17
* device instance cc_XD3_XDFFM_CLKB_XD3_XDFFM_M r0 *1 0,0
Ccc_XD3_XDFFM_CLKB_XD3_XDFFM_M XD3_XDFFM_CLKB XD3_XDFFM_M 4.2352e-17
* device instance cc_XD3_XDFFM_CLKB_XD3_XDFFM_MB r0 *1 0,0
Ccc_XD3_XDFFM_CLKB_XD3_XDFFM_MB XD3_XDFFM_CLKB XD3_XDFFM_MB 2.4201e-17
* device instance cc_XD3_XDFFM_CLKB_XD3_XDFFM_MFB r0 *1 0,0
Ccc_XD3_XDFFM_CLKB_XD3_XDFFM_MFB XD3_XDFFM_CLKB XD3_XDFFM_MFB 2.4201e-17
* device instance cc_XD3_XDFFM_CLKB_XD3_XDFFM_S r0 *1 0,0
Ccc_XD3_XDFFM_CLKB_XD3_XDFFM_S XD3_XDFFM_CLKB XD3_XDFFM_S 1.8151e-17
* device instance cc_XD3_XDFFM_CLKB_XD3_XDFFM_SB r0 *1 0,0
Ccc_XD3_XDFFM_CLKB_XD3_XDFFM_SB XD3_XDFFM_CLKB XD3_XDFFM_SB 1.8151e-17
* device instance cc_XD3_XDFFM_CLKB_XD3_XDFFM_SFB r0 *1 0,0
Ccc_XD3_XDFFM_CLKB_XD3_XDFFM_SFB XD3_XDFFM_CLKB XD3_XDFFM_SFB 1.21e-17
* device instance cc_XD3_XDFFM_CLKB_XD3_XDFFQ_CKBB r0 *1 0,0
Ccc_XD3_XDFFM_CLKB_XD3_XDFFQ_CKBB XD3_XDFFM_CLKB XD3_XDFFQ_CKBB 1.8151e-17
* device instance cc_XD3_XDFFM_CLKB_XD3_XDFFQ_CLKB r0 *1 0,0
Ccc_XD3_XDFFM_CLKB_XD3_XDFFQ_CLKB XD3_XDFFM_CLKB XD3_XDFFQ_CLKB 2.4201e-17
* device instance cc_XD3_XDFFM_CLKB_XD3_XDFFQ_M r0 *1 0,0
Ccc_XD3_XDFFM_CLKB_XD3_XDFFQ_M XD3_XDFFM_CLKB XD3_XDFFQ_M 2.4201e-17
* device instance cc_XD3_XDFFM_CLKB_XD3_XDFFQ_MB r0 *1 0,0
Ccc_XD3_XDFFM_CLKB_XD3_XDFFQ_MB XD3_XDFFM_CLKB XD3_XDFFQ_MB 1.21e-17
* device instance cc_XD3_XDFFM_CLKB_XD3_XDFFQ_MFB r0 *1 0,0
Ccc_XD3_XDFFM_CLKB_XD3_XDFFQ_MFB XD3_XDFFM_CLKB XD3_XDFFQ_MFB 1.21e-17
* device instance cc_XD3_XDFFM_CLKB_XD3_XDFFQ_S r0 *1 0,0
Ccc_XD3_XDFFM_CLKB_XD3_XDFFQ_S XD3_XDFFM_CLKB XD3_XDFFQ_S 1.8151e-17
* device instance cc_XD3_XDFFM_CLKB_XD3_XDFFQ_SB r0 *1 0,0
Ccc_XD3_XDFFM_CLKB_XD3_XDFFQ_SB XD3_XDFFM_CLKB XD3_XDFFQ_SB 1.8151e-17
* device instance cc_XD3_XDFFM_CLKB_XD3_XDFFQ_SFB r0 *1 0,0
Ccc_XD3_XDFFM_CLKB_XD3_XDFFQ_SFB XD3_XDFFM_CLKB XD3_XDFFQ_SFB 1.21e-17
* device instance cc_XD3_XDFFM_CLKB_XD3_XNOR_midp r0 *1 0,0
Ccc_XD3_XDFFM_CLKB_XD3_XNOR_midp XD3_XDFFM_CLKB XD3_XNOR_midp 1.21e-17
* device instance cc_XD3_XDFFM_CLKB_XD3_dmodout r0 *1 0,0
Ccc_XD3_XDFFM_CLKB_XD3_dmodout XD3_XDFFM_CLKB XD3_dmodout 1.8151e-17
* device instance cc_XD3_XDFFM_CLKB_XD3_dq r0 *1 0,0
Ccc_XD3_XDFFM_CLKB_XD3_dq XD3_XDFFM_CLKB XD3_dq 1.21e-17
* device instance cc_XD3_XDFFM_CLKB_XD3_nm r0 *1 0,0
Ccc_XD3_XDFFM_CLKB_XD3_nm XD3_XDFFM_CLKB XD3_nm 1.8151e-17
* device instance cc_XD3_XDFFM_CLKB_XD3_nt r0 *1 0,0
Ccc_XD3_XDFFM_CLKB_XD3_nt XD3_XDFFM_CLKB XD3_nt 2.4201e-17
* device instance cc_XD3_XDFFM_CLKB_XD3_t1 r0 *1 0,0
Ccc_XD3_XDFFM_CLKB_XD3_t1 XD3_XDFFM_CLKB XD3_t1 1.21e-17
* device instance cc_XD3_XDFFM_CLKB_XD4_XDFFM_CKBB r0 *1 0,0
Ccc_XD3_XDFFM_CLKB_XD4_XDFFM_CKBB XD3_XDFFM_CLKB XD4_XDFFM_CKBB 1.8151e-17
* device instance cc_XD3_XDFFM_CLKB_XD4_XDFFM_CLKB r0 *1 0,0
Ccc_XD3_XDFFM_CLKB_XD4_XDFFM_CLKB XD3_XDFFM_CLKB XD4_XDFFM_CLKB 2.4201e-17
* device instance cc_XD3_XDFFM_CLKB_XD4_XDFFM_M r0 *1 0,0
Ccc_XD3_XDFFM_CLKB_XD4_XDFFM_M XD3_XDFFM_CLKB XD4_XDFFM_M 2.4201e-17
* device instance cc_XD3_XDFFM_CLKB_XD4_XDFFM_MB r0 *1 0,0
Ccc_XD3_XDFFM_CLKB_XD4_XDFFM_MB XD3_XDFFM_CLKB XD4_XDFFM_MB 1.21e-17
* device instance cc_XD3_XDFFM_CLKB_XD4_XDFFM_MFB r0 *1 0,0
Ccc_XD3_XDFFM_CLKB_XD4_XDFFM_MFB XD3_XDFFM_CLKB XD4_XDFFM_MFB 1.21e-17
* device instance cc_XD3_XDFFM_CLKB_XD4_XDFFM_S r0 *1 0,0
Ccc_XD3_XDFFM_CLKB_XD4_XDFFM_S XD3_XDFFM_CLKB XD4_XDFFM_S 1.8151e-17
* device instance cc_XD3_XDFFM_CLKB_XD4_XDFFM_SB r0 *1 0,0
Ccc_XD3_XDFFM_CLKB_XD4_XDFFM_SB XD3_XDFFM_CLKB XD4_XDFFM_SB 1.8151e-17
* device instance cc_XD3_XDFFM_CLKB_XD4_XDFFM_SFB r0 *1 0,0
Ccc_XD3_XDFFM_CLKB_XD4_XDFFM_SFB XD3_XDFFM_CLKB XD4_XDFFM_SFB 1.21e-17
* device instance cc_XD3_XDFFM_CLKB_XD4_XDFFQ_CKBB r0 *1 0,0
Ccc_XD3_XDFFM_CLKB_XD4_XDFFQ_CKBB XD3_XDFFM_CLKB XD4_XDFFQ_CKBB 1.8151e-17
* device instance cc_XD3_XDFFM_CLKB_XD4_XDFFQ_CLKB r0 *1 0,0
Ccc_XD3_XDFFM_CLKB_XD4_XDFFQ_CLKB XD3_XDFFM_CLKB XD4_XDFFQ_CLKB 2.4201e-17
* device instance cc_XD3_XDFFM_CLKB_XD4_XDFFQ_M r0 *1 0,0
Ccc_XD3_XDFFM_CLKB_XD4_XDFFQ_M XD3_XDFFM_CLKB XD4_XDFFQ_M 2.4201e-17
* device instance cc_XD3_XDFFM_CLKB_XD4_XDFFQ_MB r0 *1 0,0
Ccc_XD3_XDFFM_CLKB_XD4_XDFFQ_MB XD3_XDFFM_CLKB XD4_XDFFQ_MB 1.21e-17
* device instance cc_XD3_XDFFM_CLKB_XD4_XDFFQ_MFB r0 *1 0,0
Ccc_XD3_XDFFM_CLKB_XD4_XDFFQ_MFB XD3_XDFFM_CLKB XD4_XDFFQ_MFB 1.21e-17
* device instance cc_XD3_XDFFM_CLKB_XD4_XDFFQ_S r0 *1 0,0
Ccc_XD3_XDFFM_CLKB_XD4_XDFFQ_S XD3_XDFFM_CLKB XD4_XDFFQ_S 1.8151e-17
* device instance cc_XD3_XDFFM_CLKB_XD4_XDFFQ_SB r0 *1 0,0
Ccc_XD3_XDFFM_CLKB_XD4_XDFFQ_SB XD3_XDFFM_CLKB XD4_XDFFQ_SB 1.8151e-17
* device instance cc_XD3_XDFFM_CLKB_XD4_XDFFQ_SFB r0 *1 0,0
Ccc_XD3_XDFFM_CLKB_XD4_XDFFQ_SFB XD3_XDFFM_CLKB XD4_XDFFQ_SFB 1.21e-17
* device instance cc_XD3_XDFFM_CLKB_XD4_XN2_mid1 r0 *1 0,0
Ccc_XD3_XDFFM_CLKB_XD4_XN2_mid1 XD3_XDFFM_CLKB XD4_XN2_mid1 1.21e-17
* device instance cc_XD3_XDFFM_CLKB_XD4_XN3_mid1 r0 *1 0,0
Ccc_XD3_XDFFM_CLKB_XD4_XN3_mid1 XD3_XDFFM_CLKB XD4_XN3_mid1 1.21e-17
* device instance cc_XD3_XDFFM_CLKB_XD4_XN3_mid2 r0 *1 0,0
Ccc_XD3_XDFFM_CLKB_XD4_XN3_mid2 XD3_XDFFM_CLKB XD4_XN3_mid2 1.21e-17
* device instance cc_XD3_XDFFM_CLKB_XD4_dmodout r0 *1 0,0
Ccc_XD3_XDFFM_CLKB_XD4_dmodout XD3_XDFFM_CLKB XD4_dmodout 1.21e-17
* device instance cc_XD3_XDFFM_CLKB_XD4_dq r0 *1 0,0
Ccc_XD3_XDFFM_CLKB_XD4_dq XD3_XDFFM_CLKB XD4_dq 1.8151e-17
* device instance cc_XD3_XDFFM_CLKB_XD4_nm r0 *1 0,0
Ccc_XD3_XDFFM_CLKB_XD4_nm XD3_XDFFM_CLKB XD4_nm 1.21e-17
* device instance cc_XD3_XDFFM_CLKB_XD4_nt r0 *1 0,0
Ccc_XD3_XDFFM_CLKB_XD4_nt XD3_XDFFM_CLKB XD4_nt 1.21e-17
* device instance cc_XD3_XDFFM_CLKB_XD4_t1 r0 *1 0,0
Ccc_XD3_XDFFM_CLKB_XD4_t1 XD3_XDFFM_CLKB XD4_t1 1.21e-17
* device instance cc_XD3_XDFFM_CLKB_XD5_XDFFM_CKBB r0 *1 0,0
Ccc_XD3_XDFFM_CLKB_XD5_XDFFM_CKBB XD3_XDFFM_CLKB XD5_XDFFM_CKBB 1.8151e-17
* device instance cc_XD3_XDFFM_CLKB_XD5_XDFFM_CLKB r0 *1 0,0
Ccc_XD3_XDFFM_CLKB_XD5_XDFFM_CLKB XD3_XDFFM_CLKB XD5_XDFFM_CLKB 2.4201e-17
* device instance cc_XD3_XDFFM_CLKB_XD5_XDFFM_M r0 *1 0,0
Ccc_XD3_XDFFM_CLKB_XD5_XDFFM_M XD3_XDFFM_CLKB XD5_XDFFM_M 2.4201e-17
* device instance cc_XD3_XDFFM_CLKB_XD5_XDFFM_MB r0 *1 0,0
Ccc_XD3_XDFFM_CLKB_XD5_XDFFM_MB XD3_XDFFM_CLKB XD5_XDFFM_MB 1.21e-17
* device instance cc_XD3_XDFFM_CLKB_XD5_XDFFM_MFB r0 *1 0,0
Ccc_XD3_XDFFM_CLKB_XD5_XDFFM_MFB XD3_XDFFM_CLKB XD5_XDFFM_MFB 1.21e-17
* device instance cc_XD3_XDFFM_CLKB_XD5_XDFFM_S r0 *1 0,0
Ccc_XD3_XDFFM_CLKB_XD5_XDFFM_S XD3_XDFFM_CLKB XD5_XDFFM_S 1.8151e-17
* device instance cc_XD3_XDFFM_CLKB_XD5_XDFFM_SB r0 *1 0,0
Ccc_XD3_XDFFM_CLKB_XD5_XDFFM_SB XD3_XDFFM_CLKB XD5_XDFFM_SB 1.8151e-17
* device instance cc_XD3_XDFFM_CLKB_XD5_XDFFM_SFB r0 *1 0,0
Ccc_XD3_XDFFM_CLKB_XD5_XDFFM_SFB XD3_XDFFM_CLKB XD5_XDFFM_SFB 1.21e-17
* device instance cc_XD3_XDFFM_CLKB_XD5_XDFFQ_CKBB r0 *1 0,0
Ccc_XD3_XDFFM_CLKB_XD5_XDFFQ_CKBB XD3_XDFFM_CLKB XD5_XDFFQ_CKBB 1.8151e-17
* device instance cc_XD3_XDFFM_CLKB_XD5_XDFFQ_CLKB r0 *1 0,0
Ccc_XD3_XDFFM_CLKB_XD5_XDFFQ_CLKB XD3_XDFFM_CLKB XD5_XDFFQ_CLKB 2.4201e-17
* device instance cc_XD3_XDFFM_CLKB_XD5_XDFFQ_M r0 *1 0,0
Ccc_XD3_XDFFM_CLKB_XD5_XDFFQ_M XD3_XDFFM_CLKB XD5_XDFFQ_M 2.4201e-17
* device instance cc_XD3_XDFFM_CLKB_XD5_XDFFQ_MB r0 *1 0,0
Ccc_XD3_XDFFM_CLKB_XD5_XDFFQ_MB XD3_XDFFM_CLKB XD5_XDFFQ_MB 1.21e-17
* device instance cc_XD3_XDFFM_CLKB_XD5_XDFFQ_MFB r0 *1 0,0
Ccc_XD3_XDFFM_CLKB_XD5_XDFFQ_MFB XD3_XDFFM_CLKB XD5_XDFFQ_MFB 1.21e-17
* device instance cc_XD3_XDFFM_CLKB_XD5_XDFFQ_S r0 *1 0,0
Ccc_XD3_XDFFM_CLKB_XD5_XDFFQ_S XD3_XDFFM_CLKB XD5_XDFFQ_S 1.8151e-17
* device instance cc_XD3_XDFFM_CLKB_XD5_XDFFQ_SB r0 *1 0,0
Ccc_XD3_XDFFM_CLKB_XD5_XDFFQ_SB XD3_XDFFM_CLKB XD5_XDFFQ_SB 1.8151e-17
* device instance cc_XD3_XDFFM_CLKB_XD5_XDFFQ_SFB r0 *1 0,0
Ccc_XD3_XDFFM_CLKB_XD5_XDFFQ_SFB XD3_XDFFM_CLKB XD5_XDFFQ_SFB 1.21e-17
* device instance cc_XD3_XDFFM_CLKB_XD5_XN2_mid1 r0 *1 0,0
Ccc_XD3_XDFFM_CLKB_XD5_XN2_mid1 XD3_XDFFM_CLKB XD5_XN2_mid1 1.21e-17
* device instance cc_XD3_XDFFM_CLKB_XD5_XN3_mid1 r0 *1 0,0
Ccc_XD3_XDFFM_CLKB_XD5_XN3_mid1 XD3_XDFFM_CLKB XD5_XN3_mid1 1.21e-17
* device instance cc_XD3_XDFFM_CLKB_XD5_XN3_mid2 r0 *1 0,0
Ccc_XD3_XDFFM_CLKB_XD5_XN3_mid2 XD3_XDFFM_CLKB XD5_XN3_mid2 1.21e-17
* device instance cc_XD3_XDFFM_CLKB_XD5_dmodout r0 *1 0,0
Ccc_XD3_XDFFM_CLKB_XD5_dmodout XD3_XDFFM_CLKB XD5_dmodout 1.21e-17
* device instance cc_XD3_XDFFM_CLKB_XD5_dq r0 *1 0,0
Ccc_XD3_XDFFM_CLKB_XD5_dq XD3_XDFFM_CLKB XD5_dq 1.8151e-17
* device instance cc_XD3_XDFFM_CLKB_XD5_nm r0 *1 0,0
Ccc_XD3_XDFFM_CLKB_XD5_nm XD3_XDFFM_CLKB XD5_nm 1.21e-17
* device instance cc_XD3_XDFFM_CLKB_XD5_nt r0 *1 0,0
Ccc_XD3_XDFFM_CLKB_XD5_nt XD3_XDFFM_CLKB XD5_nt 1.21e-17
* device instance cc_XD3_XDFFM_CLKB_XD5_t1 r0 *1 0,0
Ccc_XD3_XDFFM_CLKB_XD5_t1 XD3_XDFFM_CLKB XD5_t1 1.21e-17
* device instance cc_XD3_XDFFM_CLKB_XFRT_CKBB r0 *1 0,0
Ccc_XD3_XDFFM_CLKB_XFRT_CKBB XD3_XDFFM_CLKB XFRT_CKBB 1.8151e-17
* device instance cc_XD3_XDFFM_CLKB_XFRT_CLKB r0 *1 0,0
Ccc_XD3_XDFFM_CLKB_XFRT_CLKB XD3_XDFFM_CLKB XFRT_CLKB 2.4201e-17
* device instance cc_XD3_XDFFM_CLKB_XFRT_M r0 *1 0,0
Ccc_XD3_XDFFM_CLKB_XFRT_M XD3_XDFFM_CLKB XFRT_M 2.4201e-17
* device instance cc_XD3_XDFFM_CLKB_XFRT_MB r0 *1 0,0
Ccc_XD3_XDFFM_CLKB_XFRT_MB XD3_XDFFM_CLKB XFRT_MB 1.21e-17
* device instance cc_XD3_XDFFM_CLKB_XFRT_MFB r0 *1 0,0
Ccc_XD3_XDFFM_CLKB_XFRT_MFB XD3_XDFFM_CLKB XFRT_MFB 1.21e-17
* device instance cc_XD3_XDFFM_CLKB_XFRT_S r0 *1 0,0
Ccc_XD3_XDFFM_CLKB_XFRT_S XD3_XDFFM_CLKB XFRT_S 1.8151e-17
* device instance cc_XD3_XDFFM_CLKB_XFRT_SB r0 *1 0,0
Ccc_XD3_XDFFM_CLKB_XFRT_SB XD3_XDFFM_CLKB XFRT_SB 1.8151e-17
* device instance cc_XD3_XDFFM_CLKB_XFRT_SFB r0 *1 0,0
Ccc_XD3_XDFFM_CLKB_XFRT_SFB XD3_XDFFM_CLKB XFRT_SFB 1.21e-17
* device instance cc_XD3_XDFFM_CLKB_ck1 r0 *1 0,0
Ccc_XD3_XDFFM_CLKB_ck1 XD3_XDFFM_CLKB ck1 3.0251e-17
* device instance cc_XD3_XDFFM_CLKB_ck2 r0 *1 0,0
Ccc_XD3_XDFFM_CLKB_ck2 XD3_XDFFM_CLKB ck2 3.0251e-17
* device instance cc_XD3_XDFFM_CLKB_ck3 r0 *1 0,0
Ccc_XD3_XDFFM_CLKB_ck3 XD3_XDFFM_CLKB ck3 3.0251e-17
* device instance cc_XD3_XDFFM_CLKB_ck4 r0 *1 0,0
Ccc_XD3_XDFFM_CLKB_ck4 XD3_XDFFM_CLKB ck4 3.0251e-17
* device instance cc_XD3_XDFFM_CLKB_ck5 r0 *1 0,0
Ccc_XD3_XDFFM_CLKB_ck5 XD3_XDFFM_CLKB ck5 3.0251e-17
* device instance cc_XD3_XDFFM_CLKB_mod0 r0 *1 0,0
Ccc_XD3_XDFFM_CLKB_mod0 XD3_XDFFM_CLKB mod0 2.4201e-17
* device instance cc_XD3_XDFFM_CLKB_mod1 r0 *1 0,0
Ccc_XD3_XDFFM_CLKB_mod1 XD3_XDFFM_CLKB mod1 2.4201e-17
* device instance cc_XD3_XDFFM_CLKB_mod2 r0 *1 0,0
Ccc_XD3_XDFFM_CLKB_mod2 XD3_XDFFM_CLKB mod2 2.4201e-17
* device instance cc_XD3_XDFFM_CLKB_mod3 r0 *1 0,0
Ccc_XD3_XDFFM_CLKB_mod3 XD3_XDFFM_CLKB mod3 2.4201e-17
* device instance cc_XD3_XDFFM_CLKB_mod4 r0 *1 0,0
Ccc_XD3_XDFFM_CLKB_mod4 XD3_XDFFM_CLKB mod4 2.4201e-17
* device instance cc_XD3_XDFFM_CLKB_net1 r0 *1 0,0
Ccc_XD3_XDFFM_CLKB_net1 XD3_XDFFM_CLKB net1 1.21e-17
* device instance cc_XD3_XDFFM_M_XD3_XDFFM_MB r0 *1 0,0
Ccc_XD3_XDFFM_M_XD3_XDFFM_MB XD3_XDFFM_M XD3_XDFFM_MB 2.4201e-17
* device instance cc_XD3_XDFFM_M_XD3_XDFFM_MFB r0 *1 0,0
Ccc_XD3_XDFFM_M_XD3_XDFFM_MFB XD3_XDFFM_M XD3_XDFFM_MFB 3.4688e-17
* device instance cc_XD3_XDFFM_M_XD3_XDFFM_S r0 *1 0,0
Ccc_XD3_XDFFM_M_XD3_XDFFM_S XD3_XDFFM_M XD3_XDFFM_S 2.8638e-17
* device instance cc_XD3_XDFFM_M_XD3_XDFFM_SB r0 *1 0,0
Ccc_XD3_XDFFM_M_XD3_XDFFM_SB XD3_XDFFM_M XD3_XDFFM_SB 1.8151e-17
* device instance cc_XD3_XDFFM_M_XD3_XDFFM_SFB r0 *1 0,0
Ccc_XD3_XDFFM_M_XD3_XDFFM_SFB XD3_XDFFM_M XD3_XDFFM_SFB 1.21e-17
* device instance cc_XD3_XDFFM_M_XD3_XDFFQ_CKBB r0 *1 0,0
Ccc_XD3_XDFFM_M_XD3_XDFFQ_CKBB XD3_XDFFM_M XD3_XDFFQ_CKBB 1.8151e-17
* device instance cc_XD3_XDFFM_M_XD3_XDFFQ_CLKB r0 *1 0,0
Ccc_XD3_XDFFM_M_XD3_XDFFQ_CLKB XD3_XDFFM_M XD3_XDFFQ_CLKB 2.4201e-17
* device instance cc_XD3_XDFFM_M_XD3_XDFFQ_M r0 *1 0,0
Ccc_XD3_XDFFM_M_XD3_XDFFQ_M XD3_XDFFM_M XD3_XDFFQ_M 2.4201e-17
* device instance cc_XD3_XDFFM_M_XD3_XDFFQ_MB r0 *1 0,0
Ccc_XD3_XDFFM_M_XD3_XDFFQ_MB XD3_XDFFM_M XD3_XDFFQ_MB 1.21e-17
* device instance cc_XD3_XDFFM_M_XD3_XDFFQ_MFB r0 *1 0,0
Ccc_XD3_XDFFM_M_XD3_XDFFQ_MFB XD3_XDFFM_M XD3_XDFFQ_MFB 1.21e-17
* device instance cc_XD3_XDFFM_M_XD3_XDFFQ_S r0 *1 0,0
Ccc_XD3_XDFFM_M_XD3_XDFFQ_S XD3_XDFFM_M XD3_XDFFQ_S 1.8151e-17
* device instance cc_XD3_XDFFM_M_XD3_XDFFQ_SB r0 *1 0,0
Ccc_XD3_XDFFM_M_XD3_XDFFQ_SB XD3_XDFFM_M XD3_XDFFQ_SB 1.8151e-17
* device instance cc_XD3_XDFFM_M_XD3_XDFFQ_SFB r0 *1 0,0
Ccc_XD3_XDFFM_M_XD3_XDFFQ_SFB XD3_XDFFM_M XD3_XDFFQ_SFB 1.21e-17
* device instance cc_XD3_XDFFM_M_XD3_XNOR_midp r0 *1 0,0
Ccc_XD3_XDFFM_M_XD3_XNOR_midp XD3_XDFFM_M XD3_XNOR_midp 1.21e-17
* device instance cc_XD3_XDFFM_M_XD3_dmodout r0 *1 0,0
Ccc_XD3_XDFFM_M_XD3_dmodout XD3_XDFFM_M XD3_dmodout 2.8638e-17
* device instance cc_XD3_XDFFM_M_XD3_dq r0 *1 0,0
Ccc_XD3_XDFFM_M_XD3_dq XD3_XDFFM_M XD3_dq 1.21e-17
* device instance cc_XD3_XDFFM_M_XD3_nm r0 *1 0,0
Ccc_XD3_XDFFM_M_XD3_nm XD3_XDFFM_M XD3_nm 1.8151e-17
* device instance cc_XD3_XDFFM_M_XD3_nt r0 *1 0,0
Ccc_XD3_XDFFM_M_XD3_nt XD3_XDFFM_M XD3_nt 2.4201e-17
* device instance cc_XD3_XDFFM_M_XD3_t1 r0 *1 0,0
Ccc_XD3_XDFFM_M_XD3_t1 XD3_XDFFM_M XD3_t1 1.21e-17
* device instance cc_XD3_XDFFM_M_XD4_XDFFM_CKBB r0 *1 0,0
Ccc_XD3_XDFFM_M_XD4_XDFFM_CKBB XD3_XDFFM_M XD4_XDFFM_CKBB 1.8151e-17
* device instance cc_XD3_XDFFM_M_XD4_XDFFM_CLKB r0 *1 0,0
Ccc_XD3_XDFFM_M_XD4_XDFFM_CLKB XD3_XDFFM_M XD4_XDFFM_CLKB 2.4201e-17
* device instance cc_XD3_XDFFM_M_XD4_XDFFM_M r0 *1 0,0
Ccc_XD3_XDFFM_M_XD4_XDFFM_M XD3_XDFFM_M XD4_XDFFM_M 2.4201e-17
* device instance cc_XD3_XDFFM_M_XD4_XDFFM_MB r0 *1 0,0
Ccc_XD3_XDFFM_M_XD4_XDFFM_MB XD3_XDFFM_M XD4_XDFFM_MB 1.21e-17
* device instance cc_XD3_XDFFM_M_XD4_XDFFM_MFB r0 *1 0,0
Ccc_XD3_XDFFM_M_XD4_XDFFM_MFB XD3_XDFFM_M XD4_XDFFM_MFB 1.21e-17
* device instance cc_XD3_XDFFM_M_XD4_XDFFM_S r0 *1 0,0
Ccc_XD3_XDFFM_M_XD4_XDFFM_S XD3_XDFFM_M XD4_XDFFM_S 1.8151e-17
* device instance cc_XD3_XDFFM_M_XD4_XDFFM_SB r0 *1 0,0
Ccc_XD3_XDFFM_M_XD4_XDFFM_SB XD3_XDFFM_M XD4_XDFFM_SB 1.8151e-17
* device instance cc_XD3_XDFFM_M_XD4_XDFFM_SFB r0 *1 0,0
Ccc_XD3_XDFFM_M_XD4_XDFFM_SFB XD3_XDFFM_M XD4_XDFFM_SFB 1.21e-17
* device instance cc_XD3_XDFFM_M_XD4_XDFFQ_CKBB r0 *1 0,0
Ccc_XD3_XDFFM_M_XD4_XDFFQ_CKBB XD3_XDFFM_M XD4_XDFFQ_CKBB 1.8151e-17
* device instance cc_XD3_XDFFM_M_XD4_XDFFQ_CLKB r0 *1 0,0
Ccc_XD3_XDFFM_M_XD4_XDFFQ_CLKB XD3_XDFFM_M XD4_XDFFQ_CLKB 2.4201e-17
* device instance cc_XD3_XDFFM_M_XD4_XDFFQ_M r0 *1 0,0
Ccc_XD3_XDFFM_M_XD4_XDFFQ_M XD3_XDFFM_M XD4_XDFFQ_M 2.4201e-17
* device instance cc_XD3_XDFFM_M_XD4_XDFFQ_MB r0 *1 0,0
Ccc_XD3_XDFFM_M_XD4_XDFFQ_MB XD3_XDFFM_M XD4_XDFFQ_MB 1.21e-17
* device instance cc_XD3_XDFFM_M_XD4_XDFFQ_MFB r0 *1 0,0
Ccc_XD3_XDFFM_M_XD4_XDFFQ_MFB XD3_XDFFM_M XD4_XDFFQ_MFB 1.21e-17
* device instance cc_XD3_XDFFM_M_XD4_XDFFQ_S r0 *1 0,0
Ccc_XD3_XDFFM_M_XD4_XDFFQ_S XD3_XDFFM_M XD4_XDFFQ_S 1.8151e-17
* device instance cc_XD3_XDFFM_M_XD4_XDFFQ_SB r0 *1 0,0
Ccc_XD3_XDFFM_M_XD4_XDFFQ_SB XD3_XDFFM_M XD4_XDFFQ_SB 1.8151e-17
* device instance cc_XD3_XDFFM_M_XD4_XDFFQ_SFB r0 *1 0,0
Ccc_XD3_XDFFM_M_XD4_XDFFQ_SFB XD3_XDFFM_M XD4_XDFFQ_SFB 1.21e-17
* device instance cc_XD3_XDFFM_M_XD4_XN2_mid1 r0 *1 0,0
Ccc_XD3_XDFFM_M_XD4_XN2_mid1 XD3_XDFFM_M XD4_XN2_mid1 1.21e-17
* device instance cc_XD3_XDFFM_M_XD4_XN3_mid1 r0 *1 0,0
Ccc_XD3_XDFFM_M_XD4_XN3_mid1 XD3_XDFFM_M XD4_XN3_mid1 1.21e-17
* device instance cc_XD3_XDFFM_M_XD4_XN3_mid2 r0 *1 0,0
Ccc_XD3_XDFFM_M_XD4_XN3_mid2 XD3_XDFFM_M XD4_XN3_mid2 1.21e-17
* device instance cc_XD3_XDFFM_M_XD4_dmodout r0 *1 0,0
Ccc_XD3_XDFFM_M_XD4_dmodout XD3_XDFFM_M XD4_dmodout 1.21e-17
* device instance cc_XD3_XDFFM_M_XD4_dq r0 *1 0,0
Ccc_XD3_XDFFM_M_XD4_dq XD3_XDFFM_M XD4_dq 1.8151e-17
* device instance cc_XD3_XDFFM_M_XD4_nm r0 *1 0,0
Ccc_XD3_XDFFM_M_XD4_nm XD3_XDFFM_M XD4_nm 1.21e-17
* device instance cc_XD3_XDFFM_M_XD4_nt r0 *1 0,0
Ccc_XD3_XDFFM_M_XD4_nt XD3_XDFFM_M XD4_nt 1.21e-17
* device instance cc_XD3_XDFFM_M_XD4_t1 r0 *1 0,0
Ccc_XD3_XDFFM_M_XD4_t1 XD3_XDFFM_M XD4_t1 1.21e-17
* device instance cc_XD3_XDFFM_M_XD5_XDFFM_CKBB r0 *1 0,0
Ccc_XD3_XDFFM_M_XD5_XDFFM_CKBB XD3_XDFFM_M XD5_XDFFM_CKBB 1.8151e-17
* device instance cc_XD3_XDFFM_M_XD5_XDFFM_CLKB r0 *1 0,0
Ccc_XD3_XDFFM_M_XD5_XDFFM_CLKB XD3_XDFFM_M XD5_XDFFM_CLKB 2.4201e-17
* device instance cc_XD3_XDFFM_M_XD5_XDFFM_M r0 *1 0,0
Ccc_XD3_XDFFM_M_XD5_XDFFM_M XD3_XDFFM_M XD5_XDFFM_M 2.4201e-17
* device instance cc_XD3_XDFFM_M_XD5_XDFFM_MB r0 *1 0,0
Ccc_XD3_XDFFM_M_XD5_XDFFM_MB XD3_XDFFM_M XD5_XDFFM_MB 1.21e-17
* device instance cc_XD3_XDFFM_M_XD5_XDFFM_MFB r0 *1 0,0
Ccc_XD3_XDFFM_M_XD5_XDFFM_MFB XD3_XDFFM_M XD5_XDFFM_MFB 1.21e-17
* device instance cc_XD3_XDFFM_M_XD5_XDFFM_S r0 *1 0,0
Ccc_XD3_XDFFM_M_XD5_XDFFM_S XD3_XDFFM_M XD5_XDFFM_S 1.8151e-17
* device instance cc_XD3_XDFFM_M_XD5_XDFFM_SB r0 *1 0,0
Ccc_XD3_XDFFM_M_XD5_XDFFM_SB XD3_XDFFM_M XD5_XDFFM_SB 1.8151e-17
* device instance cc_XD3_XDFFM_M_XD5_XDFFM_SFB r0 *1 0,0
Ccc_XD3_XDFFM_M_XD5_XDFFM_SFB XD3_XDFFM_M XD5_XDFFM_SFB 1.21e-17
* device instance cc_XD3_XDFFM_M_XD5_XDFFQ_CKBB r0 *1 0,0
Ccc_XD3_XDFFM_M_XD5_XDFFQ_CKBB XD3_XDFFM_M XD5_XDFFQ_CKBB 1.8151e-17
* device instance cc_XD3_XDFFM_M_XD5_XDFFQ_CLKB r0 *1 0,0
Ccc_XD3_XDFFM_M_XD5_XDFFQ_CLKB XD3_XDFFM_M XD5_XDFFQ_CLKB 2.4201e-17
* device instance cc_XD3_XDFFM_M_XD5_XDFFQ_M r0 *1 0,0
Ccc_XD3_XDFFM_M_XD5_XDFFQ_M XD3_XDFFM_M XD5_XDFFQ_M 2.4201e-17
* device instance cc_XD3_XDFFM_M_XD5_XDFFQ_MB r0 *1 0,0
Ccc_XD3_XDFFM_M_XD5_XDFFQ_MB XD3_XDFFM_M XD5_XDFFQ_MB 1.21e-17
* device instance cc_XD3_XDFFM_M_XD5_XDFFQ_MFB r0 *1 0,0
Ccc_XD3_XDFFM_M_XD5_XDFFQ_MFB XD3_XDFFM_M XD5_XDFFQ_MFB 1.21e-17
* device instance cc_XD3_XDFFM_M_XD5_XDFFQ_S r0 *1 0,0
Ccc_XD3_XDFFM_M_XD5_XDFFQ_S XD3_XDFFM_M XD5_XDFFQ_S 1.8151e-17
* device instance cc_XD3_XDFFM_M_XD5_XDFFQ_SB r0 *1 0,0
Ccc_XD3_XDFFM_M_XD5_XDFFQ_SB XD3_XDFFM_M XD5_XDFFQ_SB 1.8151e-17
* device instance cc_XD3_XDFFM_M_XD5_XDFFQ_SFB r0 *1 0,0
Ccc_XD3_XDFFM_M_XD5_XDFFQ_SFB XD3_XDFFM_M XD5_XDFFQ_SFB 1.21e-17
* device instance cc_XD3_XDFFM_M_XD5_XN2_mid1 r0 *1 0,0
Ccc_XD3_XDFFM_M_XD5_XN2_mid1 XD3_XDFFM_M XD5_XN2_mid1 1.21e-17
* device instance cc_XD3_XDFFM_M_XD5_XN3_mid1 r0 *1 0,0
Ccc_XD3_XDFFM_M_XD5_XN3_mid1 XD3_XDFFM_M XD5_XN3_mid1 1.21e-17
* device instance cc_XD3_XDFFM_M_XD5_XN3_mid2 r0 *1 0,0
Ccc_XD3_XDFFM_M_XD5_XN3_mid2 XD3_XDFFM_M XD5_XN3_mid2 1.21e-17
* device instance cc_XD3_XDFFM_M_XD5_dmodout r0 *1 0,0
Ccc_XD3_XDFFM_M_XD5_dmodout XD3_XDFFM_M XD5_dmodout 1.21e-17
* device instance cc_XD3_XDFFM_M_XD5_dq r0 *1 0,0
Ccc_XD3_XDFFM_M_XD5_dq XD3_XDFFM_M XD5_dq 1.8151e-17
* device instance cc_XD3_XDFFM_M_XD5_nm r0 *1 0,0
Ccc_XD3_XDFFM_M_XD5_nm XD3_XDFFM_M XD5_nm 1.21e-17
* device instance cc_XD3_XDFFM_M_XD5_nt r0 *1 0,0
Ccc_XD3_XDFFM_M_XD5_nt XD3_XDFFM_M XD5_nt 1.21e-17
* device instance cc_XD3_XDFFM_M_XD5_t1 r0 *1 0,0
Ccc_XD3_XDFFM_M_XD5_t1 XD3_XDFFM_M XD5_t1 1.21e-17
* device instance cc_XD3_XDFFM_M_XFRT_CKBB r0 *1 0,0
Ccc_XD3_XDFFM_M_XFRT_CKBB XD3_XDFFM_M XFRT_CKBB 1.8151e-17
* device instance cc_XD3_XDFFM_M_XFRT_CLKB r0 *1 0,0
Ccc_XD3_XDFFM_M_XFRT_CLKB XD3_XDFFM_M XFRT_CLKB 2.4201e-17
* device instance cc_XD3_XDFFM_M_XFRT_M r0 *1 0,0
Ccc_XD3_XDFFM_M_XFRT_M XD3_XDFFM_M XFRT_M 2.4201e-17
* device instance cc_XD3_XDFFM_M_XFRT_MB r0 *1 0,0
Ccc_XD3_XDFFM_M_XFRT_MB XD3_XDFFM_M XFRT_MB 1.21e-17
* device instance cc_XD3_XDFFM_M_XFRT_MFB r0 *1 0,0
Ccc_XD3_XDFFM_M_XFRT_MFB XD3_XDFFM_M XFRT_MFB 1.21e-17
* device instance cc_XD3_XDFFM_M_XFRT_S r0 *1 0,0
Ccc_XD3_XDFFM_M_XFRT_S XD3_XDFFM_M XFRT_S 1.8151e-17
* device instance cc_XD3_XDFFM_M_XFRT_SB r0 *1 0,0
Ccc_XD3_XDFFM_M_XFRT_SB XD3_XDFFM_M XFRT_SB 1.8151e-17
* device instance cc_XD3_XDFFM_M_XFRT_SFB r0 *1 0,0
Ccc_XD3_XDFFM_M_XFRT_SFB XD3_XDFFM_M XFRT_SFB 1.21e-17
* device instance cc_XD3_XDFFM_M_ck1 r0 *1 0,0
Ccc_XD3_XDFFM_M_ck1 XD3_XDFFM_M ck1 3.0251e-17
* device instance cc_XD3_XDFFM_M_ck2 r0 *1 0,0
Ccc_XD3_XDFFM_M_ck2 XD3_XDFFM_M ck2 3.0251e-17
* device instance cc_XD3_XDFFM_M_ck3 r0 *1 0,0
Ccc_XD3_XDFFM_M_ck3 XD3_XDFFM_M ck3 3.0251e-17
* device instance cc_XD3_XDFFM_M_ck4 r0 *1 0,0
Ccc_XD3_XDFFM_M_ck4 XD3_XDFFM_M ck4 3.0251e-17
* device instance cc_XD3_XDFFM_M_ck5 r0 *1 0,0
Ccc_XD3_XDFFM_M_ck5 XD3_XDFFM_M ck5 3.0251e-17
* device instance cc_XD3_XDFFM_M_mod0 r0 *1 0,0
Ccc_XD3_XDFFM_M_mod0 XD3_XDFFM_M mod0 2.4201e-17
* device instance cc_XD3_XDFFM_M_mod1 r0 *1 0,0
Ccc_XD3_XDFFM_M_mod1 XD3_XDFFM_M mod1 2.4201e-17
* device instance cc_XD3_XDFFM_M_mod2 r0 *1 0,0
Ccc_XD3_XDFFM_M_mod2 XD3_XDFFM_M mod2 2.4201e-17
* device instance cc_XD3_XDFFM_M_mod3 r0 *1 0,0
Ccc_XD3_XDFFM_M_mod3 XD3_XDFFM_M mod3 2.4201e-17
* device instance cc_XD3_XDFFM_M_mod4 r0 *1 0,0
Ccc_XD3_XDFFM_M_mod4 XD3_XDFFM_M mod4 2.4201e-17
* device instance cc_XD3_XDFFM_M_net1 r0 *1 0,0
Ccc_XD3_XDFFM_M_net1 XD3_XDFFM_M net1 1.21e-17
* device instance cc_XD3_XDFFM_MB_XD3_XDFFM_MFB r0 *1 0,0
Ccc_XD3_XDFFM_MB_XD3_XDFFM_MFB XD3_XDFFM_MB XD3_XDFFM_MFB 1.21e-17
* device instance cc_XD3_XDFFM_MB_XD3_XDFFM_S r0 *1 0,0
Ccc_XD3_XDFFM_MB_XD3_XDFFM_S XD3_XDFFM_MB XD3_XDFFM_S 1.8151e-17
* device instance cc_XD3_XDFFM_MB_XD3_XDFFM_SB r0 *1 0,0
Ccc_XD3_XDFFM_MB_XD3_XDFFM_SB XD3_XDFFM_MB XD3_XDFFM_SB 1.8151e-17
* device instance cc_XD3_XDFFM_MB_XD3_XDFFM_SFB r0 *1 0,0
Ccc_XD3_XDFFM_MB_XD3_XDFFM_SFB XD3_XDFFM_MB XD3_XDFFM_SFB 1.21e-17
* device instance cc_XD3_XDFFM_MB_XD3_XDFFQ_CKBB r0 *1 0,0
Ccc_XD3_XDFFM_MB_XD3_XDFFQ_CKBB XD3_XDFFM_MB XD3_XDFFQ_CKBB 1.8151e-17
* device instance cc_XD3_XDFFM_MB_XD3_XDFFQ_CLKB r0 *1 0,0
Ccc_XD3_XDFFM_MB_XD3_XDFFQ_CLKB XD3_XDFFM_MB XD3_XDFFQ_CLKB 2.4201e-17
* device instance cc_XD3_XDFFM_MB_XD3_XDFFQ_M r0 *1 0,0
Ccc_XD3_XDFFM_MB_XD3_XDFFQ_M XD3_XDFFM_MB XD3_XDFFQ_M 2.4201e-17
* device instance cc_XD3_XDFFM_MB_XD3_XDFFQ_MB r0 *1 0,0
Ccc_XD3_XDFFM_MB_XD3_XDFFQ_MB XD3_XDFFM_MB XD3_XDFFQ_MB 1.21e-17
* device instance cc_XD3_XDFFM_MB_XD3_XDFFQ_MFB r0 *1 0,0
Ccc_XD3_XDFFM_MB_XD3_XDFFQ_MFB XD3_XDFFM_MB XD3_XDFFQ_MFB 1.21e-17
* device instance cc_XD3_XDFFM_MB_XD3_XDFFQ_S r0 *1 0,0
Ccc_XD3_XDFFM_MB_XD3_XDFFQ_S XD3_XDFFM_MB XD3_XDFFQ_S 1.8151e-17
* device instance cc_XD3_XDFFM_MB_XD3_XDFFQ_SB r0 *1 0,0
Ccc_XD3_XDFFM_MB_XD3_XDFFQ_SB XD3_XDFFM_MB XD3_XDFFQ_SB 1.8151e-17
* device instance cc_XD3_XDFFM_MB_XD3_XDFFQ_SFB r0 *1 0,0
Ccc_XD3_XDFFM_MB_XD3_XDFFQ_SFB XD3_XDFFM_MB XD3_XDFFQ_SFB 1.21e-17
* device instance cc_XD3_XDFFM_MB_XD3_XNOR_midp r0 *1 0,0
Ccc_XD3_XDFFM_MB_XD3_XNOR_midp XD3_XDFFM_MB XD3_XNOR_midp 1.21e-17
* device instance cc_XD3_XDFFM_MB_XD3_dmodout r0 *1 0,0
Ccc_XD3_XDFFM_MB_XD3_dmodout XD3_XDFFM_MB XD3_dmodout 1.21e-17
* device instance cc_XD3_XDFFM_MB_XD3_dq r0 *1 0,0
Ccc_XD3_XDFFM_MB_XD3_dq XD3_XDFFM_MB XD3_dq 1.21e-17
* device instance cc_XD3_XDFFM_MB_XD3_nm r0 *1 0,0
Ccc_XD3_XDFFM_MB_XD3_nm XD3_XDFFM_MB XD3_nm 1.8151e-17
* device instance cc_XD3_XDFFM_MB_XD3_nt r0 *1 0,0
Ccc_XD3_XDFFM_MB_XD3_nt XD3_XDFFM_MB XD3_nt 2.4201e-17
* device instance cc_XD3_XDFFM_MB_XD3_t1 r0 *1 0,0
Ccc_XD3_XDFFM_MB_XD3_t1 XD3_XDFFM_MB XD3_t1 1.21e-17
* device instance cc_XD3_XDFFM_MB_XD4_XDFFM_CKBB r0 *1 0,0
Ccc_XD3_XDFFM_MB_XD4_XDFFM_CKBB XD3_XDFFM_MB XD4_XDFFM_CKBB 1.8151e-17
* device instance cc_XD3_XDFFM_MB_XD4_XDFFM_CLKB r0 *1 0,0
Ccc_XD3_XDFFM_MB_XD4_XDFFM_CLKB XD3_XDFFM_MB XD4_XDFFM_CLKB 2.4201e-17
* device instance cc_XD3_XDFFM_MB_XD4_XDFFM_M r0 *1 0,0
Ccc_XD3_XDFFM_MB_XD4_XDFFM_M XD3_XDFFM_MB XD4_XDFFM_M 2.4201e-17
* device instance cc_XD3_XDFFM_MB_XD4_XDFFM_MB r0 *1 0,0
Ccc_XD3_XDFFM_MB_XD4_XDFFM_MB XD3_XDFFM_MB XD4_XDFFM_MB 1.21e-17
* device instance cc_XD3_XDFFM_MB_XD4_XDFFM_MFB r0 *1 0,0
Ccc_XD3_XDFFM_MB_XD4_XDFFM_MFB XD3_XDFFM_MB XD4_XDFFM_MFB 1.21e-17
* device instance cc_XD3_XDFFM_MB_XD4_XDFFM_S r0 *1 0,0
Ccc_XD3_XDFFM_MB_XD4_XDFFM_S XD3_XDFFM_MB XD4_XDFFM_S 1.8151e-17
* device instance cc_XD3_XDFFM_MB_XD4_XDFFM_SB r0 *1 0,0
Ccc_XD3_XDFFM_MB_XD4_XDFFM_SB XD3_XDFFM_MB XD4_XDFFM_SB 1.8151e-17
* device instance cc_XD3_XDFFM_MB_XD4_XDFFM_SFB r0 *1 0,0
Ccc_XD3_XDFFM_MB_XD4_XDFFM_SFB XD3_XDFFM_MB XD4_XDFFM_SFB 1.21e-17
* device instance cc_XD3_XDFFM_MB_XD4_XDFFQ_CKBB r0 *1 0,0
Ccc_XD3_XDFFM_MB_XD4_XDFFQ_CKBB XD3_XDFFM_MB XD4_XDFFQ_CKBB 1.8151e-17
* device instance cc_XD3_XDFFM_MB_XD4_XDFFQ_CLKB r0 *1 0,0
Ccc_XD3_XDFFM_MB_XD4_XDFFQ_CLKB XD3_XDFFM_MB XD4_XDFFQ_CLKB 2.4201e-17
* device instance cc_XD3_XDFFM_MB_XD4_XDFFQ_M r0 *1 0,0
Ccc_XD3_XDFFM_MB_XD4_XDFFQ_M XD3_XDFFM_MB XD4_XDFFQ_M 2.4201e-17
* device instance cc_XD3_XDFFM_MB_XD4_XDFFQ_MB r0 *1 0,0
Ccc_XD3_XDFFM_MB_XD4_XDFFQ_MB XD3_XDFFM_MB XD4_XDFFQ_MB 1.21e-17
* device instance cc_XD3_XDFFM_MB_XD4_XDFFQ_MFB r0 *1 0,0
Ccc_XD3_XDFFM_MB_XD4_XDFFQ_MFB XD3_XDFFM_MB XD4_XDFFQ_MFB 1.21e-17
* device instance cc_XD3_XDFFM_MB_XD4_XDFFQ_S r0 *1 0,0
Ccc_XD3_XDFFM_MB_XD4_XDFFQ_S XD3_XDFFM_MB XD4_XDFFQ_S 1.8151e-17
* device instance cc_XD3_XDFFM_MB_XD4_XDFFQ_SB r0 *1 0,0
Ccc_XD3_XDFFM_MB_XD4_XDFFQ_SB XD3_XDFFM_MB XD4_XDFFQ_SB 1.8151e-17
* device instance cc_XD3_XDFFM_MB_XD4_XDFFQ_SFB r0 *1 0,0
Ccc_XD3_XDFFM_MB_XD4_XDFFQ_SFB XD3_XDFFM_MB XD4_XDFFQ_SFB 1.21e-17
* device instance cc_XD3_XDFFM_MB_XD4_XN2_mid1 r0 *1 0,0
Ccc_XD3_XDFFM_MB_XD4_XN2_mid1 XD3_XDFFM_MB XD4_XN2_mid1 1.21e-17
* device instance cc_XD3_XDFFM_MB_XD4_XN3_mid1 r0 *1 0,0
Ccc_XD3_XDFFM_MB_XD4_XN3_mid1 XD3_XDFFM_MB XD4_XN3_mid1 1.21e-17
* device instance cc_XD3_XDFFM_MB_XD4_XN3_mid2 r0 *1 0,0
Ccc_XD3_XDFFM_MB_XD4_XN3_mid2 XD3_XDFFM_MB XD4_XN3_mid2 1.21e-17
* device instance cc_XD3_XDFFM_MB_XD4_dmodout r0 *1 0,0
Ccc_XD3_XDFFM_MB_XD4_dmodout XD3_XDFFM_MB XD4_dmodout 1.21e-17
* device instance cc_XD3_XDFFM_MB_XD4_dq r0 *1 0,0
Ccc_XD3_XDFFM_MB_XD4_dq XD3_XDFFM_MB XD4_dq 1.8151e-17
* device instance cc_XD3_XDFFM_MB_XD4_nm r0 *1 0,0
Ccc_XD3_XDFFM_MB_XD4_nm XD3_XDFFM_MB XD4_nm 1.21e-17
* device instance cc_XD3_XDFFM_MB_XD4_nt r0 *1 0,0
Ccc_XD3_XDFFM_MB_XD4_nt XD3_XDFFM_MB XD4_nt 1.21e-17
* device instance cc_XD3_XDFFM_MB_XD4_t1 r0 *1 0,0
Ccc_XD3_XDFFM_MB_XD4_t1 XD3_XDFFM_MB XD4_t1 1.21e-17
* device instance cc_XD3_XDFFM_MB_XD5_XDFFM_CKBB r0 *1 0,0
Ccc_XD3_XDFFM_MB_XD5_XDFFM_CKBB XD3_XDFFM_MB XD5_XDFFM_CKBB 1.8151e-17
* device instance cc_XD3_XDFFM_MB_XD5_XDFFM_CLKB r0 *1 0,0
Ccc_XD3_XDFFM_MB_XD5_XDFFM_CLKB XD3_XDFFM_MB XD5_XDFFM_CLKB 2.4201e-17
* device instance cc_XD3_XDFFM_MB_XD5_XDFFM_M r0 *1 0,0
Ccc_XD3_XDFFM_MB_XD5_XDFFM_M XD3_XDFFM_MB XD5_XDFFM_M 2.4201e-17
* device instance cc_XD3_XDFFM_MB_XD5_XDFFM_MB r0 *1 0,0
Ccc_XD3_XDFFM_MB_XD5_XDFFM_MB XD3_XDFFM_MB XD5_XDFFM_MB 1.21e-17
* device instance cc_XD3_XDFFM_MB_XD5_XDFFM_MFB r0 *1 0,0
Ccc_XD3_XDFFM_MB_XD5_XDFFM_MFB XD3_XDFFM_MB XD5_XDFFM_MFB 1.21e-17
* device instance cc_XD3_XDFFM_MB_XD5_XDFFM_S r0 *1 0,0
Ccc_XD3_XDFFM_MB_XD5_XDFFM_S XD3_XDFFM_MB XD5_XDFFM_S 1.8151e-17
* device instance cc_XD3_XDFFM_MB_XD5_XDFFM_SB r0 *1 0,0
Ccc_XD3_XDFFM_MB_XD5_XDFFM_SB XD3_XDFFM_MB XD5_XDFFM_SB 1.8151e-17
* device instance cc_XD3_XDFFM_MB_XD5_XDFFM_SFB r0 *1 0,0
Ccc_XD3_XDFFM_MB_XD5_XDFFM_SFB XD3_XDFFM_MB XD5_XDFFM_SFB 1.21e-17
* device instance cc_XD3_XDFFM_MB_XD5_XDFFQ_CKBB r0 *1 0,0
Ccc_XD3_XDFFM_MB_XD5_XDFFQ_CKBB XD3_XDFFM_MB XD5_XDFFQ_CKBB 1.8151e-17
* device instance cc_XD3_XDFFM_MB_XD5_XDFFQ_CLKB r0 *1 0,0
Ccc_XD3_XDFFM_MB_XD5_XDFFQ_CLKB XD3_XDFFM_MB XD5_XDFFQ_CLKB 2.4201e-17
* device instance cc_XD3_XDFFM_MB_XD5_XDFFQ_M r0 *1 0,0
Ccc_XD3_XDFFM_MB_XD5_XDFFQ_M XD3_XDFFM_MB XD5_XDFFQ_M 2.4201e-17
* device instance cc_XD3_XDFFM_MB_XD5_XDFFQ_MB r0 *1 0,0
Ccc_XD3_XDFFM_MB_XD5_XDFFQ_MB XD3_XDFFM_MB XD5_XDFFQ_MB 1.21e-17
* device instance cc_XD3_XDFFM_MB_XD5_XDFFQ_MFB r0 *1 0,0
Ccc_XD3_XDFFM_MB_XD5_XDFFQ_MFB XD3_XDFFM_MB XD5_XDFFQ_MFB 1.21e-17
* device instance cc_XD3_XDFFM_MB_XD5_XDFFQ_S r0 *1 0,0
Ccc_XD3_XDFFM_MB_XD5_XDFFQ_S XD3_XDFFM_MB XD5_XDFFQ_S 1.8151e-17
* device instance cc_XD3_XDFFM_MB_XD5_XDFFQ_SB r0 *1 0,0
Ccc_XD3_XDFFM_MB_XD5_XDFFQ_SB XD3_XDFFM_MB XD5_XDFFQ_SB 1.8151e-17
* device instance cc_XD3_XDFFM_MB_XD5_XDFFQ_SFB r0 *1 0,0
Ccc_XD3_XDFFM_MB_XD5_XDFFQ_SFB XD3_XDFFM_MB XD5_XDFFQ_SFB 1.21e-17
* device instance cc_XD3_XDFFM_MB_XD5_XN2_mid1 r0 *1 0,0
Ccc_XD3_XDFFM_MB_XD5_XN2_mid1 XD3_XDFFM_MB XD5_XN2_mid1 1.21e-17
* device instance cc_XD3_XDFFM_MB_XD5_XN3_mid1 r0 *1 0,0
Ccc_XD3_XDFFM_MB_XD5_XN3_mid1 XD3_XDFFM_MB XD5_XN3_mid1 1.21e-17
* device instance cc_XD3_XDFFM_MB_XD5_XN3_mid2 r0 *1 0,0
Ccc_XD3_XDFFM_MB_XD5_XN3_mid2 XD3_XDFFM_MB XD5_XN3_mid2 1.21e-17
* device instance cc_XD3_XDFFM_MB_XD5_dmodout r0 *1 0,0
Ccc_XD3_XDFFM_MB_XD5_dmodout XD3_XDFFM_MB XD5_dmodout 1.21e-17
* device instance cc_XD3_XDFFM_MB_XD5_dq r0 *1 0,0
Ccc_XD3_XDFFM_MB_XD5_dq XD3_XDFFM_MB XD5_dq 1.8151e-17
* device instance cc_XD3_XDFFM_MB_XD5_nm r0 *1 0,0
Ccc_XD3_XDFFM_MB_XD5_nm XD3_XDFFM_MB XD5_nm 1.21e-17
* device instance cc_XD3_XDFFM_MB_XD5_nt r0 *1 0,0
Ccc_XD3_XDFFM_MB_XD5_nt XD3_XDFFM_MB XD5_nt 1.21e-17
* device instance cc_XD3_XDFFM_MB_XD5_t1 r0 *1 0,0
Ccc_XD3_XDFFM_MB_XD5_t1 XD3_XDFFM_MB XD5_t1 1.21e-17
* device instance cc_XD3_XDFFM_MB_XFRT_CKBB r0 *1 0,0
Ccc_XD3_XDFFM_MB_XFRT_CKBB XD3_XDFFM_MB XFRT_CKBB 1.8151e-17
* device instance cc_XD3_XDFFM_MB_XFRT_CLKB r0 *1 0,0
Ccc_XD3_XDFFM_MB_XFRT_CLKB XD3_XDFFM_MB XFRT_CLKB 2.4201e-17
* device instance cc_XD3_XDFFM_MB_XFRT_M r0 *1 0,0
Ccc_XD3_XDFFM_MB_XFRT_M XD3_XDFFM_MB XFRT_M 2.4201e-17
* device instance cc_XD3_XDFFM_MB_XFRT_MB r0 *1 0,0
Ccc_XD3_XDFFM_MB_XFRT_MB XD3_XDFFM_MB XFRT_MB 1.21e-17
* device instance cc_XD3_XDFFM_MB_XFRT_MFB r0 *1 0,0
Ccc_XD3_XDFFM_MB_XFRT_MFB XD3_XDFFM_MB XFRT_MFB 1.21e-17
* device instance cc_XD3_XDFFM_MB_XFRT_S r0 *1 0,0
Ccc_XD3_XDFFM_MB_XFRT_S XD3_XDFFM_MB XFRT_S 1.8151e-17
* device instance cc_XD3_XDFFM_MB_XFRT_SB r0 *1 0,0
Ccc_XD3_XDFFM_MB_XFRT_SB XD3_XDFFM_MB XFRT_SB 1.8151e-17
* device instance cc_XD3_XDFFM_MB_XFRT_SFB r0 *1 0,0
Ccc_XD3_XDFFM_MB_XFRT_SFB XD3_XDFFM_MB XFRT_SFB 1.21e-17
* device instance cc_XD3_XDFFM_MB_ck1 r0 *1 0,0
Ccc_XD3_XDFFM_MB_ck1 XD3_XDFFM_MB ck1 3.0251e-17
* device instance cc_XD3_XDFFM_MB_ck2 r0 *1 0,0
Ccc_XD3_XDFFM_MB_ck2 XD3_XDFFM_MB ck2 3.0251e-17
* device instance cc_XD3_XDFFM_MB_ck3 r0 *1 0,0
Ccc_XD3_XDFFM_MB_ck3 XD3_XDFFM_MB ck3 3.0251e-17
* device instance cc_XD3_XDFFM_MB_ck4 r0 *1 0,0
Ccc_XD3_XDFFM_MB_ck4 XD3_XDFFM_MB ck4 3.0251e-17
* device instance cc_XD3_XDFFM_MB_ck5 r0 *1 0,0
Ccc_XD3_XDFFM_MB_ck5 XD3_XDFFM_MB ck5 3.0251e-17
* device instance cc_XD3_XDFFM_MB_mod0 r0 *1 0,0
Ccc_XD3_XDFFM_MB_mod0 XD3_XDFFM_MB mod0 2.4201e-17
* device instance cc_XD3_XDFFM_MB_mod1 r0 *1 0,0
Ccc_XD3_XDFFM_MB_mod1 XD3_XDFFM_MB mod1 2.4201e-17
* device instance cc_XD3_XDFFM_MB_mod2 r0 *1 0,0
Ccc_XD3_XDFFM_MB_mod2 XD3_XDFFM_MB mod2 2.4201e-17
* device instance cc_XD3_XDFFM_MB_mod3 r0 *1 0,0
Ccc_XD3_XDFFM_MB_mod3 XD3_XDFFM_MB mod3 2.4201e-17
* device instance cc_XD3_XDFFM_MB_mod4 r0 *1 0,0
Ccc_XD3_XDFFM_MB_mod4 XD3_XDFFM_MB mod4 2.4201e-17
* device instance cc_XD3_XDFFM_MB_net1 r0 *1 0,0
Ccc_XD3_XDFFM_MB_net1 XD3_XDFFM_MB net1 1.21e-17
* device instance cc_XD3_XDFFM_MFB_XD3_XDFFM_S r0 *1 0,0
Ccc_XD3_XDFFM_MFB_XD3_XDFFM_S XD3_XDFFM_MFB XD3_XDFFM_S 1.8151e-17
* device instance cc_XD3_XDFFM_MFB_XD3_XDFFM_SB r0 *1 0,0
Ccc_XD3_XDFFM_MFB_XD3_XDFFM_SB XD3_XDFFM_MFB XD3_XDFFM_SB 1.8151e-17
* device instance cc_XD3_XDFFM_MFB_XD3_XDFFM_SFB r0 *1 0,0
Ccc_XD3_XDFFM_MFB_XD3_XDFFM_SFB XD3_XDFFM_MFB XD3_XDFFM_SFB 1.21e-17
* device instance cc_XD3_XDFFM_MFB_XD3_XDFFQ_CKBB r0 *1 0,0
Ccc_XD3_XDFFM_MFB_XD3_XDFFQ_CKBB XD3_XDFFM_MFB XD3_XDFFQ_CKBB 1.8151e-17
* device instance cc_XD3_XDFFM_MFB_XD3_XDFFQ_CLKB r0 *1 0,0
Ccc_XD3_XDFFM_MFB_XD3_XDFFQ_CLKB XD3_XDFFM_MFB XD3_XDFFQ_CLKB 2.4201e-17
* device instance cc_XD3_XDFFM_MFB_XD3_XDFFQ_M r0 *1 0,0
Ccc_XD3_XDFFM_MFB_XD3_XDFFQ_M XD3_XDFFM_MFB XD3_XDFFQ_M 2.4201e-17
* device instance cc_XD3_XDFFM_MFB_XD3_XDFFQ_MB r0 *1 0,0
Ccc_XD3_XDFFM_MFB_XD3_XDFFQ_MB XD3_XDFFM_MFB XD3_XDFFQ_MB 1.21e-17
* device instance cc_XD3_XDFFM_MFB_XD3_XDFFQ_MFB r0 *1 0,0
Ccc_XD3_XDFFM_MFB_XD3_XDFFQ_MFB XD3_XDFFM_MFB XD3_XDFFQ_MFB 1.21e-17
* device instance cc_XD3_XDFFM_MFB_XD3_XDFFQ_S r0 *1 0,0
Ccc_XD3_XDFFM_MFB_XD3_XDFFQ_S XD3_XDFFM_MFB XD3_XDFFQ_S 1.8151e-17
* device instance cc_XD3_XDFFM_MFB_XD3_XDFFQ_SB r0 *1 0,0
Ccc_XD3_XDFFM_MFB_XD3_XDFFQ_SB XD3_XDFFM_MFB XD3_XDFFQ_SB 1.8151e-17
* device instance cc_XD3_XDFFM_MFB_XD3_XDFFQ_SFB r0 *1 0,0
Ccc_XD3_XDFFM_MFB_XD3_XDFFQ_SFB XD3_XDFFM_MFB XD3_XDFFQ_SFB 1.21e-17
* device instance cc_XD3_XDFFM_MFB_XD3_XNOR_midp r0 *1 0,0
Ccc_XD3_XDFFM_MFB_XD3_XNOR_midp XD3_XDFFM_MFB XD3_XNOR_midp 1.21e-17
* device instance cc_XD3_XDFFM_MFB_XD3_dmodout r0 *1 0,0
Ccc_XD3_XDFFM_MFB_XD3_dmodout XD3_XDFFM_MFB XD3_dmodout 1.21e-17
* device instance cc_XD3_XDFFM_MFB_XD3_dq r0 *1 0,0
Ccc_XD3_XDFFM_MFB_XD3_dq XD3_XDFFM_MFB XD3_dq 1.21e-17
* device instance cc_XD3_XDFFM_MFB_XD3_nm r0 *1 0,0
Ccc_XD3_XDFFM_MFB_XD3_nm XD3_XDFFM_MFB XD3_nm 1.8151e-17
* device instance cc_XD3_XDFFM_MFB_XD3_nt r0 *1 0,0
Ccc_XD3_XDFFM_MFB_XD3_nt XD3_XDFFM_MFB XD3_nt 2.4201e-17
* device instance cc_XD3_XDFFM_MFB_XD3_t1 r0 *1 0,0
Ccc_XD3_XDFFM_MFB_XD3_t1 XD3_XDFFM_MFB XD3_t1 1.21e-17
* device instance cc_XD3_XDFFM_MFB_XD4_XDFFM_CKBB r0 *1 0,0
Ccc_XD3_XDFFM_MFB_XD4_XDFFM_CKBB XD3_XDFFM_MFB XD4_XDFFM_CKBB 1.8151e-17
* device instance cc_XD3_XDFFM_MFB_XD4_XDFFM_CLKB r0 *1 0,0
Ccc_XD3_XDFFM_MFB_XD4_XDFFM_CLKB XD3_XDFFM_MFB XD4_XDFFM_CLKB 2.4201e-17
* device instance cc_XD3_XDFFM_MFB_XD4_XDFFM_M r0 *1 0,0
Ccc_XD3_XDFFM_MFB_XD4_XDFFM_M XD3_XDFFM_MFB XD4_XDFFM_M 2.4201e-17
* device instance cc_XD3_XDFFM_MFB_XD4_XDFFM_MB r0 *1 0,0
Ccc_XD3_XDFFM_MFB_XD4_XDFFM_MB XD3_XDFFM_MFB XD4_XDFFM_MB 1.21e-17
* device instance cc_XD3_XDFFM_MFB_XD4_XDFFM_MFB r0 *1 0,0
Ccc_XD3_XDFFM_MFB_XD4_XDFFM_MFB XD3_XDFFM_MFB XD4_XDFFM_MFB 1.21e-17
* device instance cc_XD3_XDFFM_MFB_XD4_XDFFM_S r0 *1 0,0
Ccc_XD3_XDFFM_MFB_XD4_XDFFM_S XD3_XDFFM_MFB XD4_XDFFM_S 1.8151e-17
* device instance cc_XD3_XDFFM_MFB_XD4_XDFFM_SB r0 *1 0,0
Ccc_XD3_XDFFM_MFB_XD4_XDFFM_SB XD3_XDFFM_MFB XD4_XDFFM_SB 1.8151e-17
* device instance cc_XD3_XDFFM_MFB_XD4_XDFFM_SFB r0 *1 0,0
Ccc_XD3_XDFFM_MFB_XD4_XDFFM_SFB XD3_XDFFM_MFB XD4_XDFFM_SFB 1.21e-17
* device instance cc_XD3_XDFFM_MFB_XD4_XDFFQ_CKBB r0 *1 0,0
Ccc_XD3_XDFFM_MFB_XD4_XDFFQ_CKBB XD3_XDFFM_MFB XD4_XDFFQ_CKBB 1.8151e-17
* device instance cc_XD3_XDFFM_MFB_XD4_XDFFQ_CLKB r0 *1 0,0
Ccc_XD3_XDFFM_MFB_XD4_XDFFQ_CLKB XD3_XDFFM_MFB XD4_XDFFQ_CLKB 2.4201e-17
* device instance cc_XD3_XDFFM_MFB_XD4_XDFFQ_M r0 *1 0,0
Ccc_XD3_XDFFM_MFB_XD4_XDFFQ_M XD3_XDFFM_MFB XD4_XDFFQ_M 2.4201e-17
* device instance cc_XD3_XDFFM_MFB_XD4_XDFFQ_MB r0 *1 0,0
Ccc_XD3_XDFFM_MFB_XD4_XDFFQ_MB XD3_XDFFM_MFB XD4_XDFFQ_MB 1.21e-17
* device instance cc_XD3_XDFFM_MFB_XD4_XDFFQ_MFB r0 *1 0,0
Ccc_XD3_XDFFM_MFB_XD4_XDFFQ_MFB XD3_XDFFM_MFB XD4_XDFFQ_MFB 1.21e-17
* device instance cc_XD3_XDFFM_MFB_XD4_XDFFQ_S r0 *1 0,0
Ccc_XD3_XDFFM_MFB_XD4_XDFFQ_S XD3_XDFFM_MFB XD4_XDFFQ_S 1.8151e-17
* device instance cc_XD3_XDFFM_MFB_XD4_XDFFQ_SB r0 *1 0,0
Ccc_XD3_XDFFM_MFB_XD4_XDFFQ_SB XD3_XDFFM_MFB XD4_XDFFQ_SB 1.8151e-17
* device instance cc_XD3_XDFFM_MFB_XD4_XDFFQ_SFB r0 *1 0,0
Ccc_XD3_XDFFM_MFB_XD4_XDFFQ_SFB XD3_XDFFM_MFB XD4_XDFFQ_SFB 1.21e-17
* device instance cc_XD3_XDFFM_MFB_XD4_XN2_mid1 r0 *1 0,0
Ccc_XD3_XDFFM_MFB_XD4_XN2_mid1 XD3_XDFFM_MFB XD4_XN2_mid1 1.21e-17
* device instance cc_XD3_XDFFM_MFB_XD4_XN3_mid1 r0 *1 0,0
Ccc_XD3_XDFFM_MFB_XD4_XN3_mid1 XD3_XDFFM_MFB XD4_XN3_mid1 1.21e-17
* device instance cc_XD3_XDFFM_MFB_XD4_XN3_mid2 r0 *1 0,0
Ccc_XD3_XDFFM_MFB_XD4_XN3_mid2 XD3_XDFFM_MFB XD4_XN3_mid2 1.21e-17
* device instance cc_XD3_XDFFM_MFB_XD4_dmodout r0 *1 0,0
Ccc_XD3_XDFFM_MFB_XD4_dmodout XD3_XDFFM_MFB XD4_dmodout 1.21e-17
* device instance cc_XD3_XDFFM_MFB_XD4_dq r0 *1 0,0
Ccc_XD3_XDFFM_MFB_XD4_dq XD3_XDFFM_MFB XD4_dq 1.8151e-17
* device instance cc_XD3_XDFFM_MFB_XD4_nm r0 *1 0,0
Ccc_XD3_XDFFM_MFB_XD4_nm XD3_XDFFM_MFB XD4_nm 1.21e-17
* device instance cc_XD3_XDFFM_MFB_XD4_nt r0 *1 0,0
Ccc_XD3_XDFFM_MFB_XD4_nt XD3_XDFFM_MFB XD4_nt 1.21e-17
* device instance cc_XD3_XDFFM_MFB_XD4_t1 r0 *1 0,0
Ccc_XD3_XDFFM_MFB_XD4_t1 XD3_XDFFM_MFB XD4_t1 1.21e-17
* device instance cc_XD3_XDFFM_MFB_XD5_XDFFM_CKBB r0 *1 0,0
Ccc_XD3_XDFFM_MFB_XD5_XDFFM_CKBB XD3_XDFFM_MFB XD5_XDFFM_CKBB 1.8151e-17
* device instance cc_XD3_XDFFM_MFB_XD5_XDFFM_CLKB r0 *1 0,0
Ccc_XD3_XDFFM_MFB_XD5_XDFFM_CLKB XD3_XDFFM_MFB XD5_XDFFM_CLKB 2.4201e-17
* device instance cc_XD3_XDFFM_MFB_XD5_XDFFM_M r0 *1 0,0
Ccc_XD3_XDFFM_MFB_XD5_XDFFM_M XD3_XDFFM_MFB XD5_XDFFM_M 2.4201e-17
* device instance cc_XD3_XDFFM_MFB_XD5_XDFFM_MB r0 *1 0,0
Ccc_XD3_XDFFM_MFB_XD5_XDFFM_MB XD3_XDFFM_MFB XD5_XDFFM_MB 1.21e-17
* device instance cc_XD3_XDFFM_MFB_XD5_XDFFM_MFB r0 *1 0,0
Ccc_XD3_XDFFM_MFB_XD5_XDFFM_MFB XD3_XDFFM_MFB XD5_XDFFM_MFB 1.21e-17
* device instance cc_XD3_XDFFM_MFB_XD5_XDFFM_S r0 *1 0,0
Ccc_XD3_XDFFM_MFB_XD5_XDFFM_S XD3_XDFFM_MFB XD5_XDFFM_S 1.8151e-17
* device instance cc_XD3_XDFFM_MFB_XD5_XDFFM_SB r0 *1 0,0
Ccc_XD3_XDFFM_MFB_XD5_XDFFM_SB XD3_XDFFM_MFB XD5_XDFFM_SB 1.8151e-17
* device instance cc_XD3_XDFFM_MFB_XD5_XDFFM_SFB r0 *1 0,0
Ccc_XD3_XDFFM_MFB_XD5_XDFFM_SFB XD3_XDFFM_MFB XD5_XDFFM_SFB 1.21e-17
* device instance cc_XD3_XDFFM_MFB_XD5_XDFFQ_CKBB r0 *1 0,0
Ccc_XD3_XDFFM_MFB_XD5_XDFFQ_CKBB XD3_XDFFM_MFB XD5_XDFFQ_CKBB 1.8151e-17
* device instance cc_XD3_XDFFM_MFB_XD5_XDFFQ_CLKB r0 *1 0,0
Ccc_XD3_XDFFM_MFB_XD5_XDFFQ_CLKB XD3_XDFFM_MFB XD5_XDFFQ_CLKB 2.4201e-17
* device instance cc_XD3_XDFFM_MFB_XD5_XDFFQ_M r0 *1 0,0
Ccc_XD3_XDFFM_MFB_XD5_XDFFQ_M XD3_XDFFM_MFB XD5_XDFFQ_M 2.4201e-17
* device instance cc_XD3_XDFFM_MFB_XD5_XDFFQ_MB r0 *1 0,0
Ccc_XD3_XDFFM_MFB_XD5_XDFFQ_MB XD3_XDFFM_MFB XD5_XDFFQ_MB 1.21e-17
* device instance cc_XD3_XDFFM_MFB_XD5_XDFFQ_MFB r0 *1 0,0
Ccc_XD3_XDFFM_MFB_XD5_XDFFQ_MFB XD3_XDFFM_MFB XD5_XDFFQ_MFB 1.21e-17
* device instance cc_XD3_XDFFM_MFB_XD5_XDFFQ_S r0 *1 0,0
Ccc_XD3_XDFFM_MFB_XD5_XDFFQ_S XD3_XDFFM_MFB XD5_XDFFQ_S 1.8151e-17
* device instance cc_XD3_XDFFM_MFB_XD5_XDFFQ_SB r0 *1 0,0
Ccc_XD3_XDFFM_MFB_XD5_XDFFQ_SB XD3_XDFFM_MFB XD5_XDFFQ_SB 1.8151e-17
* device instance cc_XD3_XDFFM_MFB_XD5_XDFFQ_SFB r0 *1 0,0
Ccc_XD3_XDFFM_MFB_XD5_XDFFQ_SFB XD3_XDFFM_MFB XD5_XDFFQ_SFB 1.21e-17
* device instance cc_XD3_XDFFM_MFB_XD5_XN2_mid1 r0 *1 0,0
Ccc_XD3_XDFFM_MFB_XD5_XN2_mid1 XD3_XDFFM_MFB XD5_XN2_mid1 1.21e-17
* device instance cc_XD3_XDFFM_MFB_XD5_XN3_mid1 r0 *1 0,0
Ccc_XD3_XDFFM_MFB_XD5_XN3_mid1 XD3_XDFFM_MFB XD5_XN3_mid1 1.21e-17
* device instance cc_XD3_XDFFM_MFB_XD5_XN3_mid2 r0 *1 0,0
Ccc_XD3_XDFFM_MFB_XD5_XN3_mid2 XD3_XDFFM_MFB XD5_XN3_mid2 1.21e-17
* device instance cc_XD3_XDFFM_MFB_XD5_dmodout r0 *1 0,0
Ccc_XD3_XDFFM_MFB_XD5_dmodout XD3_XDFFM_MFB XD5_dmodout 1.21e-17
* device instance cc_XD3_XDFFM_MFB_XD5_dq r0 *1 0,0
Ccc_XD3_XDFFM_MFB_XD5_dq XD3_XDFFM_MFB XD5_dq 1.8151e-17
* device instance cc_XD3_XDFFM_MFB_XD5_nm r0 *1 0,0
Ccc_XD3_XDFFM_MFB_XD5_nm XD3_XDFFM_MFB XD5_nm 1.21e-17
* device instance cc_XD3_XDFFM_MFB_XD5_nt r0 *1 0,0
Ccc_XD3_XDFFM_MFB_XD5_nt XD3_XDFFM_MFB XD5_nt 1.21e-17
* device instance cc_XD3_XDFFM_MFB_XD5_t1 r0 *1 0,0
Ccc_XD3_XDFFM_MFB_XD5_t1 XD3_XDFFM_MFB XD5_t1 1.21e-17
* device instance cc_XD3_XDFFM_MFB_XFRT_CKBB r0 *1 0,0
Ccc_XD3_XDFFM_MFB_XFRT_CKBB XD3_XDFFM_MFB XFRT_CKBB 1.8151e-17
* device instance cc_XD3_XDFFM_MFB_XFRT_CLKB r0 *1 0,0
Ccc_XD3_XDFFM_MFB_XFRT_CLKB XD3_XDFFM_MFB XFRT_CLKB 2.4201e-17
* device instance cc_XD3_XDFFM_MFB_XFRT_M r0 *1 0,0
Ccc_XD3_XDFFM_MFB_XFRT_M XD3_XDFFM_MFB XFRT_M 2.4201e-17
* device instance cc_XD3_XDFFM_MFB_XFRT_MB r0 *1 0,0
Ccc_XD3_XDFFM_MFB_XFRT_MB XD3_XDFFM_MFB XFRT_MB 1.21e-17
* device instance cc_XD3_XDFFM_MFB_XFRT_MFB r0 *1 0,0
Ccc_XD3_XDFFM_MFB_XFRT_MFB XD3_XDFFM_MFB XFRT_MFB 1.21e-17
* device instance cc_XD3_XDFFM_MFB_XFRT_S r0 *1 0,0
Ccc_XD3_XDFFM_MFB_XFRT_S XD3_XDFFM_MFB XFRT_S 1.8151e-17
* device instance cc_XD3_XDFFM_MFB_XFRT_SB r0 *1 0,0
Ccc_XD3_XDFFM_MFB_XFRT_SB XD3_XDFFM_MFB XFRT_SB 1.8151e-17
* device instance cc_XD3_XDFFM_MFB_XFRT_SFB r0 *1 0,0
Ccc_XD3_XDFFM_MFB_XFRT_SFB XD3_XDFFM_MFB XFRT_SFB 1.21e-17
* device instance cc_XD3_XDFFM_MFB_ck1 r0 *1 0,0
Ccc_XD3_XDFFM_MFB_ck1 XD3_XDFFM_MFB ck1 3.0251e-17
* device instance cc_XD3_XDFFM_MFB_ck2 r0 *1 0,0
Ccc_XD3_XDFFM_MFB_ck2 XD3_XDFFM_MFB ck2 3.0251e-17
* device instance cc_XD3_XDFFM_MFB_ck3 r0 *1 0,0
Ccc_XD3_XDFFM_MFB_ck3 XD3_XDFFM_MFB ck3 3.0251e-17
* device instance cc_XD3_XDFFM_MFB_ck4 r0 *1 0,0
Ccc_XD3_XDFFM_MFB_ck4 XD3_XDFFM_MFB ck4 3.0251e-17
* device instance cc_XD3_XDFFM_MFB_ck5 r0 *1 0,0
Ccc_XD3_XDFFM_MFB_ck5 XD3_XDFFM_MFB ck5 3.0251e-17
* device instance cc_XD3_XDFFM_MFB_mod0 r0 *1 0,0
Ccc_XD3_XDFFM_MFB_mod0 XD3_XDFFM_MFB mod0 2.4201e-17
* device instance cc_XD3_XDFFM_MFB_mod1 r0 *1 0,0
Ccc_XD3_XDFFM_MFB_mod1 XD3_XDFFM_MFB mod1 2.4201e-17
* device instance cc_XD3_XDFFM_MFB_mod2 r0 *1 0,0
Ccc_XD3_XDFFM_MFB_mod2 XD3_XDFFM_MFB mod2 2.4201e-17
* device instance cc_XD3_XDFFM_MFB_mod3 r0 *1 0,0
Ccc_XD3_XDFFM_MFB_mod3 XD3_XDFFM_MFB mod3 2.4201e-17
* device instance cc_XD3_XDFFM_MFB_mod4 r0 *1 0,0
Ccc_XD3_XDFFM_MFB_mod4 XD3_XDFFM_MFB mod4 2.4201e-17
* device instance cc_XD3_XDFFM_MFB_net1 r0 *1 0,0
Ccc_XD3_XDFFM_MFB_net1 XD3_XDFFM_MFB net1 1.21e-17
* device instance cc_XD3_XDFFM_S_XD3_XDFFM_SB r0 *1 0,0
Ccc_XD3_XDFFM_S_XD3_XDFFM_SB XD3_XDFFM_S XD3_XDFFM_SB 3.0251e-17
* device instance cc_XD3_XDFFM_S_XD3_XDFFM_SFB r0 *1 0,0
Ccc_XD3_XDFFM_S_XD3_XDFFM_SFB XD3_XDFFM_S XD3_XDFFM_SFB 3.4688e-17
* device instance cc_XD3_XDFFM_S_XD3_XDFFQ_CKBB r0 *1 0,0
Ccc_XD3_XDFFM_S_XD3_XDFFQ_CKBB XD3_XDFFM_S XD3_XDFFQ_CKBB 1.8151e-17
* device instance cc_XD3_XDFFM_S_XD3_XDFFQ_CLKB r0 *1 0,0
Ccc_XD3_XDFFM_S_XD3_XDFFQ_CLKB XD3_XDFFM_S XD3_XDFFQ_CLKB 2.4201e-17
* device instance cc_XD3_XDFFM_S_XD3_XDFFQ_M r0 *1 0,0
Ccc_XD3_XDFFM_S_XD3_XDFFQ_M XD3_XDFFM_S XD3_XDFFQ_M 2.4201e-17
* device instance cc_XD3_XDFFM_S_XD3_XDFFQ_MB r0 *1 0,0
Ccc_XD3_XDFFM_S_XD3_XDFFQ_MB XD3_XDFFM_S XD3_XDFFQ_MB 1.21e-17
* device instance cc_XD3_XDFFM_S_XD3_XDFFQ_MFB r0 *1 0,0
Ccc_XD3_XDFFM_S_XD3_XDFFQ_MFB XD3_XDFFM_S XD3_XDFFQ_MFB 1.21e-17
* device instance cc_XD3_XDFFM_S_XD3_XDFFQ_S r0 *1 0,0
Ccc_XD3_XDFFM_S_XD3_XDFFQ_S XD3_XDFFM_S XD3_XDFFQ_S 1.8151e-17
* device instance cc_XD3_XDFFM_S_XD3_XDFFQ_SB r0 *1 0,0
Ccc_XD3_XDFFM_S_XD3_XDFFQ_SB XD3_XDFFM_S XD3_XDFFQ_SB 1.8151e-17
* device instance cc_XD3_XDFFM_S_XD3_XDFFQ_SFB r0 *1 0,0
Ccc_XD3_XDFFM_S_XD3_XDFFQ_SFB XD3_XDFFM_S XD3_XDFFQ_SFB 1.21e-17
* device instance cc_XD3_XDFFM_S_XD3_XNOR_midp r0 *1 0,0
Ccc_XD3_XDFFM_S_XD3_XNOR_midp XD3_XDFFM_S XD3_XNOR_midp 1.21e-17
* device instance cc_XD3_XDFFM_S_XD3_dmodout r0 *1 0,0
Ccc_XD3_XDFFM_S_XD3_dmodout XD3_XDFFM_S XD3_dmodout 1.21e-17
* device instance cc_XD3_XDFFM_S_XD3_dq r0 *1 0,0
Ccc_XD3_XDFFM_S_XD3_dq XD3_XDFFM_S XD3_dq 1.21e-17
* device instance cc_XD3_XDFFM_S_XD3_nm r0 *1 0,0
Ccc_XD3_XDFFM_S_XD3_nm XD3_XDFFM_S XD3_nm 1.8151e-17
* device instance cc_XD3_XDFFM_S_XD3_nt r0 *1 0,0
Ccc_XD3_XDFFM_S_XD3_nt XD3_XDFFM_S XD3_nt 2.4201e-17
* device instance cc_XD3_XDFFM_S_XD3_t1 r0 *1 0,0
Ccc_XD3_XDFFM_S_XD3_t1 XD3_XDFFM_S XD3_t1 1.21e-17
* device instance cc_XD3_XDFFM_S_XD4_XDFFM_CKBB r0 *1 0,0
Ccc_XD3_XDFFM_S_XD4_XDFFM_CKBB XD3_XDFFM_S XD4_XDFFM_CKBB 1.8151e-17
* device instance cc_XD3_XDFFM_S_XD4_XDFFM_CLKB r0 *1 0,0
Ccc_XD3_XDFFM_S_XD4_XDFFM_CLKB XD3_XDFFM_S XD4_XDFFM_CLKB 2.4201e-17
* device instance cc_XD3_XDFFM_S_XD4_XDFFM_M r0 *1 0,0
Ccc_XD3_XDFFM_S_XD4_XDFFM_M XD3_XDFFM_S XD4_XDFFM_M 2.4201e-17
* device instance cc_XD3_XDFFM_S_XD4_XDFFM_MB r0 *1 0,0
Ccc_XD3_XDFFM_S_XD4_XDFFM_MB XD3_XDFFM_S XD4_XDFFM_MB 1.21e-17
* device instance cc_XD3_XDFFM_S_XD4_XDFFM_MFB r0 *1 0,0
Ccc_XD3_XDFFM_S_XD4_XDFFM_MFB XD3_XDFFM_S XD4_XDFFM_MFB 1.21e-17
* device instance cc_XD3_XDFFM_S_XD4_XDFFM_S r0 *1 0,0
Ccc_XD3_XDFFM_S_XD4_XDFFM_S XD3_XDFFM_S XD4_XDFFM_S 1.8151e-17
* device instance cc_XD3_XDFFM_S_XD4_XDFFM_SB r0 *1 0,0
Ccc_XD3_XDFFM_S_XD4_XDFFM_SB XD3_XDFFM_S XD4_XDFFM_SB 1.8151e-17
* device instance cc_XD3_XDFFM_S_XD4_XDFFM_SFB r0 *1 0,0
Ccc_XD3_XDFFM_S_XD4_XDFFM_SFB XD3_XDFFM_S XD4_XDFFM_SFB 1.21e-17
* device instance cc_XD3_XDFFM_S_XD4_XDFFQ_CKBB r0 *1 0,0
Ccc_XD3_XDFFM_S_XD4_XDFFQ_CKBB XD3_XDFFM_S XD4_XDFFQ_CKBB 1.8151e-17
* device instance cc_XD3_XDFFM_S_XD4_XDFFQ_CLKB r0 *1 0,0
Ccc_XD3_XDFFM_S_XD4_XDFFQ_CLKB XD3_XDFFM_S XD4_XDFFQ_CLKB 2.4201e-17
* device instance cc_XD3_XDFFM_S_XD4_XDFFQ_M r0 *1 0,0
Ccc_XD3_XDFFM_S_XD4_XDFFQ_M XD3_XDFFM_S XD4_XDFFQ_M 2.4201e-17
* device instance cc_XD3_XDFFM_S_XD4_XDFFQ_MB r0 *1 0,0
Ccc_XD3_XDFFM_S_XD4_XDFFQ_MB XD3_XDFFM_S XD4_XDFFQ_MB 1.21e-17
* device instance cc_XD3_XDFFM_S_XD4_XDFFQ_MFB r0 *1 0,0
Ccc_XD3_XDFFM_S_XD4_XDFFQ_MFB XD3_XDFFM_S XD4_XDFFQ_MFB 1.21e-17
* device instance cc_XD3_XDFFM_S_XD4_XDFFQ_S r0 *1 0,0
Ccc_XD3_XDFFM_S_XD4_XDFFQ_S XD3_XDFFM_S XD4_XDFFQ_S 1.8151e-17
* device instance cc_XD3_XDFFM_S_XD4_XDFFQ_SB r0 *1 0,0
Ccc_XD3_XDFFM_S_XD4_XDFFQ_SB XD3_XDFFM_S XD4_XDFFQ_SB 1.8151e-17
* device instance cc_XD3_XDFFM_S_XD4_XDFFQ_SFB r0 *1 0,0
Ccc_XD3_XDFFM_S_XD4_XDFFQ_SFB XD3_XDFFM_S XD4_XDFFQ_SFB 1.21e-17
* device instance cc_XD3_XDFFM_S_XD4_XN2_mid1 r0 *1 0,0
Ccc_XD3_XDFFM_S_XD4_XN2_mid1 XD3_XDFFM_S XD4_XN2_mid1 1.21e-17
* device instance cc_XD3_XDFFM_S_XD4_XN3_mid1 r0 *1 0,0
Ccc_XD3_XDFFM_S_XD4_XN3_mid1 XD3_XDFFM_S XD4_XN3_mid1 1.21e-17
* device instance cc_XD3_XDFFM_S_XD4_XN3_mid2 r0 *1 0,0
Ccc_XD3_XDFFM_S_XD4_XN3_mid2 XD3_XDFFM_S XD4_XN3_mid2 1.21e-17
* device instance cc_XD3_XDFFM_S_XD4_dmodout r0 *1 0,0
Ccc_XD3_XDFFM_S_XD4_dmodout XD3_XDFFM_S XD4_dmodout 1.21e-17
* device instance cc_XD3_XDFFM_S_XD4_dq r0 *1 0,0
Ccc_XD3_XDFFM_S_XD4_dq XD3_XDFFM_S XD4_dq 1.8151e-17
* device instance cc_XD3_XDFFM_S_XD4_nm r0 *1 0,0
Ccc_XD3_XDFFM_S_XD4_nm XD3_XDFFM_S XD4_nm 1.21e-17
* device instance cc_XD3_XDFFM_S_XD4_nt r0 *1 0,0
Ccc_XD3_XDFFM_S_XD4_nt XD3_XDFFM_S XD4_nt 1.21e-17
* device instance cc_XD3_XDFFM_S_XD4_t1 r0 *1 0,0
Ccc_XD3_XDFFM_S_XD4_t1 XD3_XDFFM_S XD4_t1 1.21e-17
* device instance cc_XD3_XDFFM_S_XD5_XDFFM_CKBB r0 *1 0,0
Ccc_XD3_XDFFM_S_XD5_XDFFM_CKBB XD3_XDFFM_S XD5_XDFFM_CKBB 1.8151e-17
* device instance cc_XD3_XDFFM_S_XD5_XDFFM_CLKB r0 *1 0,0
Ccc_XD3_XDFFM_S_XD5_XDFFM_CLKB XD3_XDFFM_S XD5_XDFFM_CLKB 2.4201e-17
* device instance cc_XD3_XDFFM_S_XD5_XDFFM_M r0 *1 0,0
Ccc_XD3_XDFFM_S_XD5_XDFFM_M XD3_XDFFM_S XD5_XDFFM_M 2.4201e-17
* device instance cc_XD3_XDFFM_S_XD5_XDFFM_MB r0 *1 0,0
Ccc_XD3_XDFFM_S_XD5_XDFFM_MB XD3_XDFFM_S XD5_XDFFM_MB 1.21e-17
* device instance cc_XD3_XDFFM_S_XD5_XDFFM_MFB r0 *1 0,0
Ccc_XD3_XDFFM_S_XD5_XDFFM_MFB XD3_XDFFM_S XD5_XDFFM_MFB 1.21e-17
* device instance cc_XD3_XDFFM_S_XD5_XDFFM_S r0 *1 0,0
Ccc_XD3_XDFFM_S_XD5_XDFFM_S XD3_XDFFM_S XD5_XDFFM_S 1.8151e-17
* device instance cc_XD3_XDFFM_S_XD5_XDFFM_SB r0 *1 0,0
Ccc_XD3_XDFFM_S_XD5_XDFFM_SB XD3_XDFFM_S XD5_XDFFM_SB 1.8151e-17
* device instance cc_XD3_XDFFM_S_XD5_XDFFM_SFB r0 *1 0,0
Ccc_XD3_XDFFM_S_XD5_XDFFM_SFB XD3_XDFFM_S XD5_XDFFM_SFB 1.21e-17
* device instance cc_XD3_XDFFM_S_XD5_XDFFQ_CKBB r0 *1 0,0
Ccc_XD3_XDFFM_S_XD5_XDFFQ_CKBB XD3_XDFFM_S XD5_XDFFQ_CKBB 1.8151e-17
* device instance cc_XD3_XDFFM_S_XD5_XDFFQ_CLKB r0 *1 0,0
Ccc_XD3_XDFFM_S_XD5_XDFFQ_CLKB XD3_XDFFM_S XD5_XDFFQ_CLKB 2.4201e-17
* device instance cc_XD3_XDFFM_S_XD5_XDFFQ_M r0 *1 0,0
Ccc_XD3_XDFFM_S_XD5_XDFFQ_M XD3_XDFFM_S XD5_XDFFQ_M 2.4201e-17
* device instance cc_XD3_XDFFM_S_XD5_XDFFQ_MB r0 *1 0,0
Ccc_XD3_XDFFM_S_XD5_XDFFQ_MB XD3_XDFFM_S XD5_XDFFQ_MB 1.21e-17
* device instance cc_XD3_XDFFM_S_XD5_XDFFQ_MFB r0 *1 0,0
Ccc_XD3_XDFFM_S_XD5_XDFFQ_MFB XD3_XDFFM_S XD5_XDFFQ_MFB 1.21e-17
* device instance cc_XD3_XDFFM_S_XD5_XDFFQ_S r0 *1 0,0
Ccc_XD3_XDFFM_S_XD5_XDFFQ_S XD3_XDFFM_S XD5_XDFFQ_S 1.8151e-17
* device instance cc_XD3_XDFFM_S_XD5_XDFFQ_SB r0 *1 0,0
Ccc_XD3_XDFFM_S_XD5_XDFFQ_SB XD3_XDFFM_S XD5_XDFFQ_SB 1.8151e-17
* device instance cc_XD3_XDFFM_S_XD5_XDFFQ_SFB r0 *1 0,0
Ccc_XD3_XDFFM_S_XD5_XDFFQ_SFB XD3_XDFFM_S XD5_XDFFQ_SFB 1.21e-17
* device instance cc_XD3_XDFFM_S_XD5_XN2_mid1 r0 *1 0,0
Ccc_XD3_XDFFM_S_XD5_XN2_mid1 XD3_XDFFM_S XD5_XN2_mid1 1.21e-17
* device instance cc_XD3_XDFFM_S_XD5_XN3_mid1 r0 *1 0,0
Ccc_XD3_XDFFM_S_XD5_XN3_mid1 XD3_XDFFM_S XD5_XN3_mid1 1.21e-17
* device instance cc_XD3_XDFFM_S_XD5_XN3_mid2 r0 *1 0,0
Ccc_XD3_XDFFM_S_XD5_XN3_mid2 XD3_XDFFM_S XD5_XN3_mid2 1.21e-17
* device instance cc_XD3_XDFFM_S_XD5_dmodout r0 *1 0,0
Ccc_XD3_XDFFM_S_XD5_dmodout XD3_XDFFM_S XD5_dmodout 1.21e-17
* device instance cc_XD3_XDFFM_S_XD5_dq r0 *1 0,0
Ccc_XD3_XDFFM_S_XD5_dq XD3_XDFFM_S XD5_dq 1.8151e-17
* device instance cc_XD3_XDFFM_S_XD5_nm r0 *1 0,0
Ccc_XD3_XDFFM_S_XD5_nm XD3_XDFFM_S XD5_nm 1.21e-17
* device instance cc_XD3_XDFFM_S_XD5_nt r0 *1 0,0
Ccc_XD3_XDFFM_S_XD5_nt XD3_XDFFM_S XD5_nt 1.21e-17
* device instance cc_XD3_XDFFM_S_XD5_t1 r0 *1 0,0
Ccc_XD3_XDFFM_S_XD5_t1 XD3_XDFFM_S XD5_t1 1.21e-17
* device instance cc_XD3_XDFFM_S_XFRT_CKBB r0 *1 0,0
Ccc_XD3_XDFFM_S_XFRT_CKBB XD3_XDFFM_S XFRT_CKBB 1.8151e-17
* device instance cc_XD3_XDFFM_S_XFRT_CLKB r0 *1 0,0
Ccc_XD3_XDFFM_S_XFRT_CLKB XD3_XDFFM_S XFRT_CLKB 2.4201e-17
* device instance cc_XD3_XDFFM_S_XFRT_M r0 *1 0,0
Ccc_XD3_XDFFM_S_XFRT_M XD3_XDFFM_S XFRT_M 2.4201e-17
* device instance cc_XD3_XDFFM_S_XFRT_MB r0 *1 0,0
Ccc_XD3_XDFFM_S_XFRT_MB XD3_XDFFM_S XFRT_MB 1.21e-17
* device instance cc_XD3_XDFFM_S_XFRT_MFB r0 *1 0,0
Ccc_XD3_XDFFM_S_XFRT_MFB XD3_XDFFM_S XFRT_MFB 1.21e-17
* device instance cc_XD3_XDFFM_S_XFRT_S r0 *1 0,0
Ccc_XD3_XDFFM_S_XFRT_S XD3_XDFFM_S XFRT_S 1.8151e-17
* device instance cc_XD3_XDFFM_S_XFRT_SB r0 *1 0,0
Ccc_XD3_XDFFM_S_XFRT_SB XD3_XDFFM_S XFRT_SB 1.8151e-17
* device instance cc_XD3_XDFFM_S_XFRT_SFB r0 *1 0,0
Ccc_XD3_XDFFM_S_XFRT_SFB XD3_XDFFM_S XFRT_SFB 1.21e-17
* device instance cc_XD3_XDFFM_S_ck1 r0 *1 0,0
Ccc_XD3_XDFFM_S_ck1 XD3_XDFFM_S ck1 3.0251e-17
* device instance cc_XD3_XDFFM_S_ck2 r0 *1 0,0
Ccc_XD3_XDFFM_S_ck2 XD3_XDFFM_S ck2 3.0251e-17
* device instance cc_XD3_XDFFM_S_ck3 r0 *1 0,0
Ccc_XD3_XDFFM_S_ck3 XD3_XDFFM_S ck3 3.0251e-17
* device instance cc_XD3_XDFFM_S_ck4 r0 *1 0,0
Ccc_XD3_XDFFM_S_ck4 XD3_XDFFM_S ck4 3.0251e-17
* device instance cc_XD3_XDFFM_S_ck5 r0 *1 0,0
Ccc_XD3_XDFFM_S_ck5 XD3_XDFFM_S ck5 3.0251e-17
* device instance cc_XD3_XDFFM_S_mod0 r0 *1 0,0
Ccc_XD3_XDFFM_S_mod0 XD3_XDFFM_S mod0 2.4201e-17
* device instance cc_XD3_XDFFM_S_mod1 r0 *1 0,0
Ccc_XD3_XDFFM_S_mod1 XD3_XDFFM_S mod1 2.4201e-17
* device instance cc_XD3_XDFFM_S_mod2 r0 *1 0,0
Ccc_XD3_XDFFM_S_mod2 XD3_XDFFM_S mod2 2.4201e-17
* device instance cc_XD3_XDFFM_S_mod3 r0 *1 0,0
Ccc_XD3_XDFFM_S_mod3 XD3_XDFFM_S mod3 2.4201e-17
* device instance cc_XD3_XDFFM_S_mod4 r0 *1 0,0
Ccc_XD3_XDFFM_S_mod4 XD3_XDFFM_S mod4 2.4201e-17
* device instance cc_XD3_XDFFM_S_net1 r0 *1 0,0
Ccc_XD3_XDFFM_S_net1 XD3_XDFFM_S net1 1.21e-17
* device instance cc_XD3_XDFFM_SB_XD3_XDFFM_SFB r0 *1 0,0
Ccc_XD3_XDFFM_SB_XD3_XDFFM_SFB XD3_XDFFM_SB XD3_XDFFM_SFB 2.4201e-17
* device instance cc_XD3_XDFFM_SB_XD3_XDFFQ_CKBB r0 *1 0,0
Ccc_XD3_XDFFM_SB_XD3_XDFFQ_CKBB XD3_XDFFM_SB XD3_XDFFQ_CKBB 1.8151e-17
* device instance cc_XD3_XDFFM_SB_XD3_XDFFQ_CLKB r0 *1 0,0
Ccc_XD3_XDFFM_SB_XD3_XDFFQ_CLKB XD3_XDFFM_SB XD3_XDFFQ_CLKB 2.4201e-17
* device instance cc_XD3_XDFFM_SB_XD3_XDFFQ_M r0 *1 0,0
Ccc_XD3_XDFFM_SB_XD3_XDFFQ_M XD3_XDFFM_SB XD3_XDFFQ_M 2.4201e-17
* device instance cc_XD3_XDFFM_SB_XD3_XDFFQ_MB r0 *1 0,0
Ccc_XD3_XDFFM_SB_XD3_XDFFQ_MB XD3_XDFFM_SB XD3_XDFFQ_MB 1.21e-17
* device instance cc_XD3_XDFFM_SB_XD3_XDFFQ_MFB r0 *1 0,0
Ccc_XD3_XDFFM_SB_XD3_XDFFQ_MFB XD3_XDFFM_SB XD3_XDFFQ_MFB 1.21e-17
* device instance cc_XD3_XDFFM_SB_XD3_XDFFQ_S r0 *1 0,0
Ccc_XD3_XDFFM_SB_XD3_XDFFQ_S XD3_XDFFM_SB XD3_XDFFQ_S 1.8151e-17
* device instance cc_XD3_XDFFM_SB_XD3_XDFFQ_SB r0 *1 0,0
Ccc_XD3_XDFFM_SB_XD3_XDFFQ_SB XD3_XDFFM_SB XD3_XDFFQ_SB 1.8151e-17
* device instance cc_XD3_XDFFM_SB_XD3_XDFFQ_SFB r0 *1 0,0
Ccc_XD3_XDFFM_SB_XD3_XDFFQ_SFB XD3_XDFFM_SB XD3_XDFFQ_SFB 1.21e-17
* device instance cc_XD3_XDFFM_SB_XD3_XNOR_midp r0 *1 0,0
Ccc_XD3_XDFFM_SB_XD3_XNOR_midp XD3_XDFFM_SB XD3_XNOR_midp 1.21e-17
* device instance cc_XD3_XDFFM_SB_XD3_dmodout r0 *1 0,0
Ccc_XD3_XDFFM_SB_XD3_dmodout XD3_XDFFM_SB XD3_dmodout 1.21e-17
* device instance cc_XD3_XDFFM_SB_XD3_dq r0 *1 0,0
Ccc_XD3_XDFFM_SB_XD3_dq XD3_XDFFM_SB XD3_dq 1.21e-17
* device instance cc_XD3_XDFFM_SB_XD3_nm r0 *1 0,0
Ccc_XD3_XDFFM_SB_XD3_nm XD3_XDFFM_SB XD3_nm 1.8151e-17
* device instance cc_XD3_XDFFM_SB_XD3_nt r0 *1 0,0
Ccc_XD3_XDFFM_SB_XD3_nt XD3_XDFFM_SB XD3_nt 2.4201e-17
* device instance cc_XD3_XDFFM_SB_XD3_t1 r0 *1 0,0
Ccc_XD3_XDFFM_SB_XD3_t1 XD3_XDFFM_SB XD3_t1 1.21e-17
* device instance cc_XD3_XDFFM_SB_XD4_XDFFM_CKBB r0 *1 0,0
Ccc_XD3_XDFFM_SB_XD4_XDFFM_CKBB XD3_XDFFM_SB XD4_XDFFM_CKBB 1.8151e-17
* device instance cc_XD3_XDFFM_SB_XD4_XDFFM_CLKB r0 *1 0,0
Ccc_XD3_XDFFM_SB_XD4_XDFFM_CLKB XD3_XDFFM_SB XD4_XDFFM_CLKB 2.4201e-17
* device instance cc_XD3_XDFFM_SB_XD4_XDFFM_M r0 *1 0,0
Ccc_XD3_XDFFM_SB_XD4_XDFFM_M XD3_XDFFM_SB XD4_XDFFM_M 2.4201e-17
* device instance cc_XD3_XDFFM_SB_XD4_XDFFM_MB r0 *1 0,0
Ccc_XD3_XDFFM_SB_XD4_XDFFM_MB XD3_XDFFM_SB XD4_XDFFM_MB 1.21e-17
* device instance cc_XD3_XDFFM_SB_XD4_XDFFM_MFB r0 *1 0,0
Ccc_XD3_XDFFM_SB_XD4_XDFFM_MFB XD3_XDFFM_SB XD4_XDFFM_MFB 1.21e-17
* device instance cc_XD3_XDFFM_SB_XD4_XDFFM_S r0 *1 0,0
Ccc_XD3_XDFFM_SB_XD4_XDFFM_S XD3_XDFFM_SB XD4_XDFFM_S 1.8151e-17
* device instance cc_XD3_XDFFM_SB_XD4_XDFFM_SB r0 *1 0,0
Ccc_XD3_XDFFM_SB_XD4_XDFFM_SB XD3_XDFFM_SB XD4_XDFFM_SB 1.8151e-17
* device instance cc_XD3_XDFFM_SB_XD4_XDFFM_SFB r0 *1 0,0
Ccc_XD3_XDFFM_SB_XD4_XDFFM_SFB XD3_XDFFM_SB XD4_XDFFM_SFB 1.21e-17
* device instance cc_XD3_XDFFM_SB_XD4_XDFFQ_CKBB r0 *1 0,0
Ccc_XD3_XDFFM_SB_XD4_XDFFQ_CKBB XD3_XDFFM_SB XD4_XDFFQ_CKBB 1.8151e-17
* device instance cc_XD3_XDFFM_SB_XD4_XDFFQ_CLKB r0 *1 0,0
Ccc_XD3_XDFFM_SB_XD4_XDFFQ_CLKB XD3_XDFFM_SB XD4_XDFFQ_CLKB 2.4201e-17
* device instance cc_XD3_XDFFM_SB_XD4_XDFFQ_M r0 *1 0,0
Ccc_XD3_XDFFM_SB_XD4_XDFFQ_M XD3_XDFFM_SB XD4_XDFFQ_M 2.4201e-17
* device instance cc_XD3_XDFFM_SB_XD4_XDFFQ_MB r0 *1 0,0
Ccc_XD3_XDFFM_SB_XD4_XDFFQ_MB XD3_XDFFM_SB XD4_XDFFQ_MB 1.21e-17
* device instance cc_XD3_XDFFM_SB_XD4_XDFFQ_MFB r0 *1 0,0
Ccc_XD3_XDFFM_SB_XD4_XDFFQ_MFB XD3_XDFFM_SB XD4_XDFFQ_MFB 1.21e-17
* device instance cc_XD3_XDFFM_SB_XD4_XDFFQ_S r0 *1 0,0
Ccc_XD3_XDFFM_SB_XD4_XDFFQ_S XD3_XDFFM_SB XD4_XDFFQ_S 1.8151e-17
* device instance cc_XD3_XDFFM_SB_XD4_XDFFQ_SB r0 *1 0,0
Ccc_XD3_XDFFM_SB_XD4_XDFFQ_SB XD3_XDFFM_SB XD4_XDFFQ_SB 1.8151e-17
* device instance cc_XD3_XDFFM_SB_XD4_XDFFQ_SFB r0 *1 0,0
Ccc_XD3_XDFFM_SB_XD4_XDFFQ_SFB XD3_XDFFM_SB XD4_XDFFQ_SFB 1.21e-17
* device instance cc_XD3_XDFFM_SB_XD4_XN2_mid1 r0 *1 0,0
Ccc_XD3_XDFFM_SB_XD4_XN2_mid1 XD3_XDFFM_SB XD4_XN2_mid1 1.21e-17
* device instance cc_XD3_XDFFM_SB_XD4_XN3_mid1 r0 *1 0,0
Ccc_XD3_XDFFM_SB_XD4_XN3_mid1 XD3_XDFFM_SB XD4_XN3_mid1 1.21e-17
* device instance cc_XD3_XDFFM_SB_XD4_XN3_mid2 r0 *1 0,0
Ccc_XD3_XDFFM_SB_XD4_XN3_mid2 XD3_XDFFM_SB XD4_XN3_mid2 1.21e-17
* device instance cc_XD3_XDFFM_SB_XD4_dmodout r0 *1 0,0
Ccc_XD3_XDFFM_SB_XD4_dmodout XD3_XDFFM_SB XD4_dmodout 1.21e-17
* device instance cc_XD3_XDFFM_SB_XD4_dq r0 *1 0,0
Ccc_XD3_XDFFM_SB_XD4_dq XD3_XDFFM_SB XD4_dq 1.8151e-17
* device instance cc_XD3_XDFFM_SB_XD4_nm r0 *1 0,0
Ccc_XD3_XDFFM_SB_XD4_nm XD3_XDFFM_SB XD4_nm 1.21e-17
* device instance cc_XD3_XDFFM_SB_XD4_nt r0 *1 0,0
Ccc_XD3_XDFFM_SB_XD4_nt XD3_XDFFM_SB XD4_nt 1.21e-17
* device instance cc_XD3_XDFFM_SB_XD4_t1 r0 *1 0,0
Ccc_XD3_XDFFM_SB_XD4_t1 XD3_XDFFM_SB XD4_t1 1.21e-17
* device instance cc_XD3_XDFFM_SB_XD5_XDFFM_CKBB r0 *1 0,0
Ccc_XD3_XDFFM_SB_XD5_XDFFM_CKBB XD3_XDFFM_SB XD5_XDFFM_CKBB 1.8151e-17
* device instance cc_XD3_XDFFM_SB_XD5_XDFFM_CLKB r0 *1 0,0
Ccc_XD3_XDFFM_SB_XD5_XDFFM_CLKB XD3_XDFFM_SB XD5_XDFFM_CLKB 2.4201e-17
* device instance cc_XD3_XDFFM_SB_XD5_XDFFM_M r0 *1 0,0
Ccc_XD3_XDFFM_SB_XD5_XDFFM_M XD3_XDFFM_SB XD5_XDFFM_M 2.4201e-17
* device instance cc_XD3_XDFFM_SB_XD5_XDFFM_MB r0 *1 0,0
Ccc_XD3_XDFFM_SB_XD5_XDFFM_MB XD3_XDFFM_SB XD5_XDFFM_MB 1.21e-17
* device instance cc_XD3_XDFFM_SB_XD5_XDFFM_MFB r0 *1 0,0
Ccc_XD3_XDFFM_SB_XD5_XDFFM_MFB XD3_XDFFM_SB XD5_XDFFM_MFB 1.21e-17
* device instance cc_XD3_XDFFM_SB_XD5_XDFFM_S r0 *1 0,0
Ccc_XD3_XDFFM_SB_XD5_XDFFM_S XD3_XDFFM_SB XD5_XDFFM_S 1.8151e-17
* device instance cc_XD3_XDFFM_SB_XD5_XDFFM_SB r0 *1 0,0
Ccc_XD3_XDFFM_SB_XD5_XDFFM_SB XD3_XDFFM_SB XD5_XDFFM_SB 1.8151e-17
* device instance cc_XD3_XDFFM_SB_XD5_XDFFM_SFB r0 *1 0,0
Ccc_XD3_XDFFM_SB_XD5_XDFFM_SFB XD3_XDFFM_SB XD5_XDFFM_SFB 1.21e-17
* device instance cc_XD3_XDFFM_SB_XD5_XDFFQ_CKBB r0 *1 0,0
Ccc_XD3_XDFFM_SB_XD5_XDFFQ_CKBB XD3_XDFFM_SB XD5_XDFFQ_CKBB 1.8151e-17
* device instance cc_XD3_XDFFM_SB_XD5_XDFFQ_CLKB r0 *1 0,0
Ccc_XD3_XDFFM_SB_XD5_XDFFQ_CLKB XD3_XDFFM_SB XD5_XDFFQ_CLKB 2.4201e-17
* device instance cc_XD3_XDFFM_SB_XD5_XDFFQ_M r0 *1 0,0
Ccc_XD3_XDFFM_SB_XD5_XDFFQ_M XD3_XDFFM_SB XD5_XDFFQ_M 2.4201e-17
* device instance cc_XD3_XDFFM_SB_XD5_XDFFQ_MB r0 *1 0,0
Ccc_XD3_XDFFM_SB_XD5_XDFFQ_MB XD3_XDFFM_SB XD5_XDFFQ_MB 1.21e-17
* device instance cc_XD3_XDFFM_SB_XD5_XDFFQ_MFB r0 *1 0,0
Ccc_XD3_XDFFM_SB_XD5_XDFFQ_MFB XD3_XDFFM_SB XD5_XDFFQ_MFB 1.21e-17
* device instance cc_XD3_XDFFM_SB_XD5_XDFFQ_S r0 *1 0,0
Ccc_XD3_XDFFM_SB_XD5_XDFFQ_S XD3_XDFFM_SB XD5_XDFFQ_S 1.8151e-17
* device instance cc_XD3_XDFFM_SB_XD5_XDFFQ_SB r0 *1 0,0
Ccc_XD3_XDFFM_SB_XD5_XDFFQ_SB XD3_XDFFM_SB XD5_XDFFQ_SB 1.8151e-17
* device instance cc_XD3_XDFFM_SB_XD5_XDFFQ_SFB r0 *1 0,0
Ccc_XD3_XDFFM_SB_XD5_XDFFQ_SFB XD3_XDFFM_SB XD5_XDFFQ_SFB 1.21e-17
* device instance cc_XD3_XDFFM_SB_XD5_XN2_mid1 r0 *1 0,0
Ccc_XD3_XDFFM_SB_XD5_XN2_mid1 XD3_XDFFM_SB XD5_XN2_mid1 1.21e-17
* device instance cc_XD3_XDFFM_SB_XD5_XN3_mid1 r0 *1 0,0
Ccc_XD3_XDFFM_SB_XD5_XN3_mid1 XD3_XDFFM_SB XD5_XN3_mid1 1.21e-17
* device instance cc_XD3_XDFFM_SB_XD5_XN3_mid2 r0 *1 0,0
Ccc_XD3_XDFFM_SB_XD5_XN3_mid2 XD3_XDFFM_SB XD5_XN3_mid2 1.21e-17
* device instance cc_XD3_XDFFM_SB_XD5_dmodout r0 *1 0,0
Ccc_XD3_XDFFM_SB_XD5_dmodout XD3_XDFFM_SB XD5_dmodout 1.21e-17
* device instance cc_XD3_XDFFM_SB_XD5_dq r0 *1 0,0
Ccc_XD3_XDFFM_SB_XD5_dq XD3_XDFFM_SB XD5_dq 1.8151e-17
* device instance cc_XD3_XDFFM_SB_XD5_nm r0 *1 0,0
Ccc_XD3_XDFFM_SB_XD5_nm XD3_XDFFM_SB XD5_nm 1.21e-17
* device instance cc_XD3_XDFFM_SB_XD5_nt r0 *1 0,0
Ccc_XD3_XDFFM_SB_XD5_nt XD3_XDFFM_SB XD5_nt 1.21e-17
* device instance cc_XD3_XDFFM_SB_XD5_t1 r0 *1 0,0
Ccc_XD3_XDFFM_SB_XD5_t1 XD3_XDFFM_SB XD5_t1 1.21e-17
* device instance cc_XD3_XDFFM_SB_XFRT_CKBB r0 *1 0,0
Ccc_XD3_XDFFM_SB_XFRT_CKBB XD3_XDFFM_SB XFRT_CKBB 1.8151e-17
* device instance cc_XD3_XDFFM_SB_XFRT_CLKB r0 *1 0,0
Ccc_XD3_XDFFM_SB_XFRT_CLKB XD3_XDFFM_SB XFRT_CLKB 2.4201e-17
* device instance cc_XD3_XDFFM_SB_XFRT_M r0 *1 0,0
Ccc_XD3_XDFFM_SB_XFRT_M XD3_XDFFM_SB XFRT_M 2.4201e-17
* device instance cc_XD3_XDFFM_SB_XFRT_MB r0 *1 0,0
Ccc_XD3_XDFFM_SB_XFRT_MB XD3_XDFFM_SB XFRT_MB 1.21e-17
* device instance cc_XD3_XDFFM_SB_XFRT_MFB r0 *1 0,0
Ccc_XD3_XDFFM_SB_XFRT_MFB XD3_XDFFM_SB XFRT_MFB 1.21e-17
* device instance cc_XD3_XDFFM_SB_XFRT_S r0 *1 0,0
Ccc_XD3_XDFFM_SB_XFRT_S XD3_XDFFM_SB XFRT_S 1.8151e-17
* device instance cc_XD3_XDFFM_SB_XFRT_SB r0 *1 0,0
Ccc_XD3_XDFFM_SB_XFRT_SB XD3_XDFFM_SB XFRT_SB 1.8151e-17
* device instance cc_XD3_XDFFM_SB_XFRT_SFB r0 *1 0,0
Ccc_XD3_XDFFM_SB_XFRT_SFB XD3_XDFFM_SB XFRT_SFB 1.21e-17
* device instance cc_XD3_XDFFM_SB_ck1 r0 *1 0,0
Ccc_XD3_XDFFM_SB_ck1 XD3_XDFFM_SB ck1 3.0251e-17
* device instance cc_XD3_XDFFM_SB_ck2 r0 *1 0,0
Ccc_XD3_XDFFM_SB_ck2 XD3_XDFFM_SB ck2 3.0251e-17
* device instance cc_XD3_XDFFM_SB_ck3 r0 *1 0,0
Ccc_XD3_XDFFM_SB_ck3 XD3_XDFFM_SB ck3 3.0251e-17
* device instance cc_XD3_XDFFM_SB_ck4 r0 *1 0,0
Ccc_XD3_XDFFM_SB_ck4 XD3_XDFFM_SB ck4 3.0251e-17
* device instance cc_XD3_XDFFM_SB_ck5 r0 *1 0,0
Ccc_XD3_XDFFM_SB_ck5 XD3_XDFFM_SB ck5 3.0251e-17
* device instance cc_XD3_XDFFM_SB_mod0 r0 *1 0,0
Ccc_XD3_XDFFM_SB_mod0 XD3_XDFFM_SB mod0 2.4201e-17
* device instance cc_XD3_XDFFM_SB_mod1 r0 *1 0,0
Ccc_XD3_XDFFM_SB_mod1 XD3_XDFFM_SB mod1 2.4201e-17
* device instance cc_XD3_XDFFM_SB_mod2 r0 *1 0,0
Ccc_XD3_XDFFM_SB_mod2 XD3_XDFFM_SB mod2 2.4201e-17
* device instance cc_XD3_XDFFM_SB_mod3 r0 *1 0,0
Ccc_XD3_XDFFM_SB_mod3 XD3_XDFFM_SB mod3 2.4201e-17
* device instance cc_XD3_XDFFM_SB_mod4 r0 *1 0,0
Ccc_XD3_XDFFM_SB_mod4 XD3_XDFFM_SB mod4 2.4201e-17
* device instance cc_XD3_XDFFM_SB_net1 r0 *1 0,0
Ccc_XD3_XDFFM_SB_net1 XD3_XDFFM_SB net1 1.21e-17
* device instance cc_XD3_XDFFM_SFB_XD3_XDFFQ_CKBB r0 *1 0,0
Ccc_XD3_XDFFM_SFB_XD3_XDFFQ_CKBB XD3_XDFFM_SFB XD3_XDFFQ_CKBB 1.8151e-17
* device instance cc_XD3_XDFFM_SFB_XD3_XDFFQ_CLKB r0 *1 0,0
Ccc_XD3_XDFFM_SFB_XD3_XDFFQ_CLKB XD3_XDFFM_SFB XD3_XDFFQ_CLKB 2.4201e-17
* device instance cc_XD3_XDFFM_SFB_XD3_XDFFQ_M r0 *1 0,0
Ccc_XD3_XDFFM_SFB_XD3_XDFFQ_M XD3_XDFFM_SFB XD3_XDFFQ_M 2.4201e-17
* device instance cc_XD3_XDFFM_SFB_XD3_XDFFQ_MB r0 *1 0,0
Ccc_XD3_XDFFM_SFB_XD3_XDFFQ_MB XD3_XDFFM_SFB XD3_XDFFQ_MB 1.21e-17
* device instance cc_XD3_XDFFM_SFB_XD3_XDFFQ_MFB r0 *1 0,0
Ccc_XD3_XDFFM_SFB_XD3_XDFFQ_MFB XD3_XDFFM_SFB XD3_XDFFQ_MFB 1.21e-17
* device instance cc_XD3_XDFFM_SFB_XD3_XDFFQ_S r0 *1 0,0
Ccc_XD3_XDFFM_SFB_XD3_XDFFQ_S XD3_XDFFM_SFB XD3_XDFFQ_S 1.8151e-17
* device instance cc_XD3_XDFFM_SFB_XD3_XDFFQ_SB r0 *1 0,0
Ccc_XD3_XDFFM_SFB_XD3_XDFFQ_SB XD3_XDFFM_SFB XD3_XDFFQ_SB 1.8151e-17
* device instance cc_XD3_XDFFM_SFB_XD3_XDFFQ_SFB r0 *1 0,0
Ccc_XD3_XDFFM_SFB_XD3_XDFFQ_SFB XD3_XDFFM_SFB XD3_XDFFQ_SFB 1.21e-17
* device instance cc_XD3_XDFFM_SFB_XD3_XNOR_midp r0 *1 0,0
Ccc_XD3_XDFFM_SFB_XD3_XNOR_midp XD3_XDFFM_SFB XD3_XNOR_midp 1.21e-17
* device instance cc_XD3_XDFFM_SFB_XD3_dmodout r0 *1 0,0
Ccc_XD3_XDFFM_SFB_XD3_dmodout XD3_XDFFM_SFB XD3_dmodout 1.21e-17
* device instance cc_XD3_XDFFM_SFB_XD3_dq r0 *1 0,0
Ccc_XD3_XDFFM_SFB_XD3_dq XD3_XDFFM_SFB XD3_dq 1.21e-17
* device instance cc_XD3_XDFFM_SFB_XD3_nm r0 *1 0,0
Ccc_XD3_XDFFM_SFB_XD3_nm XD3_XDFFM_SFB XD3_nm 1.8151e-17
* device instance cc_XD3_XDFFM_SFB_XD3_nt r0 *1 0,0
Ccc_XD3_XDFFM_SFB_XD3_nt XD3_XDFFM_SFB XD3_nt 2.4201e-17
* device instance cc_XD3_XDFFM_SFB_XD3_t1 r0 *1 0,0
Ccc_XD3_XDFFM_SFB_XD3_t1 XD3_XDFFM_SFB XD3_t1 1.21e-17
* device instance cc_XD3_XDFFM_SFB_XD4_XDFFM_CKBB r0 *1 0,0
Ccc_XD3_XDFFM_SFB_XD4_XDFFM_CKBB XD3_XDFFM_SFB XD4_XDFFM_CKBB 1.8151e-17
* device instance cc_XD3_XDFFM_SFB_XD4_XDFFM_CLKB r0 *1 0,0
Ccc_XD3_XDFFM_SFB_XD4_XDFFM_CLKB XD3_XDFFM_SFB XD4_XDFFM_CLKB 2.4201e-17
* device instance cc_XD3_XDFFM_SFB_XD4_XDFFM_M r0 *1 0,0
Ccc_XD3_XDFFM_SFB_XD4_XDFFM_M XD3_XDFFM_SFB XD4_XDFFM_M 2.4201e-17
* device instance cc_XD3_XDFFM_SFB_XD4_XDFFM_MB r0 *1 0,0
Ccc_XD3_XDFFM_SFB_XD4_XDFFM_MB XD3_XDFFM_SFB XD4_XDFFM_MB 1.21e-17
* device instance cc_XD3_XDFFM_SFB_XD4_XDFFM_MFB r0 *1 0,0
Ccc_XD3_XDFFM_SFB_XD4_XDFFM_MFB XD3_XDFFM_SFB XD4_XDFFM_MFB 1.21e-17
* device instance cc_XD3_XDFFM_SFB_XD4_XDFFM_S r0 *1 0,0
Ccc_XD3_XDFFM_SFB_XD4_XDFFM_S XD3_XDFFM_SFB XD4_XDFFM_S 1.8151e-17
* device instance cc_XD3_XDFFM_SFB_XD4_XDFFM_SB r0 *1 0,0
Ccc_XD3_XDFFM_SFB_XD4_XDFFM_SB XD3_XDFFM_SFB XD4_XDFFM_SB 1.8151e-17
* device instance cc_XD3_XDFFM_SFB_XD4_XDFFM_SFB r0 *1 0,0
Ccc_XD3_XDFFM_SFB_XD4_XDFFM_SFB XD3_XDFFM_SFB XD4_XDFFM_SFB 1.21e-17
* device instance cc_XD3_XDFFM_SFB_XD4_XDFFQ_CKBB r0 *1 0,0
Ccc_XD3_XDFFM_SFB_XD4_XDFFQ_CKBB XD3_XDFFM_SFB XD4_XDFFQ_CKBB 1.8151e-17
* device instance cc_XD3_XDFFM_SFB_XD4_XDFFQ_CLKB r0 *1 0,0
Ccc_XD3_XDFFM_SFB_XD4_XDFFQ_CLKB XD3_XDFFM_SFB XD4_XDFFQ_CLKB 2.4201e-17
* device instance cc_XD3_XDFFM_SFB_XD4_XDFFQ_M r0 *1 0,0
Ccc_XD3_XDFFM_SFB_XD4_XDFFQ_M XD3_XDFFM_SFB XD4_XDFFQ_M 2.4201e-17
* device instance cc_XD3_XDFFM_SFB_XD4_XDFFQ_MB r0 *1 0,0
Ccc_XD3_XDFFM_SFB_XD4_XDFFQ_MB XD3_XDFFM_SFB XD4_XDFFQ_MB 1.21e-17
* device instance cc_XD3_XDFFM_SFB_XD4_XDFFQ_MFB r0 *1 0,0
Ccc_XD3_XDFFM_SFB_XD4_XDFFQ_MFB XD3_XDFFM_SFB XD4_XDFFQ_MFB 1.21e-17
* device instance cc_XD3_XDFFM_SFB_XD4_XDFFQ_S r0 *1 0,0
Ccc_XD3_XDFFM_SFB_XD4_XDFFQ_S XD3_XDFFM_SFB XD4_XDFFQ_S 1.8151e-17
* device instance cc_XD3_XDFFM_SFB_XD4_XDFFQ_SB r0 *1 0,0
Ccc_XD3_XDFFM_SFB_XD4_XDFFQ_SB XD3_XDFFM_SFB XD4_XDFFQ_SB 1.8151e-17
* device instance cc_XD3_XDFFM_SFB_XD4_XDFFQ_SFB r0 *1 0,0
Ccc_XD3_XDFFM_SFB_XD4_XDFFQ_SFB XD3_XDFFM_SFB XD4_XDFFQ_SFB 1.21e-17
* device instance cc_XD3_XDFFM_SFB_XD4_XN2_mid1 r0 *1 0,0
Ccc_XD3_XDFFM_SFB_XD4_XN2_mid1 XD3_XDFFM_SFB XD4_XN2_mid1 1.21e-17
* device instance cc_XD3_XDFFM_SFB_XD4_XN3_mid1 r0 *1 0,0
Ccc_XD3_XDFFM_SFB_XD4_XN3_mid1 XD3_XDFFM_SFB XD4_XN3_mid1 1.21e-17
* device instance cc_XD3_XDFFM_SFB_XD4_XN3_mid2 r0 *1 0,0
Ccc_XD3_XDFFM_SFB_XD4_XN3_mid2 XD3_XDFFM_SFB XD4_XN3_mid2 1.21e-17
* device instance cc_XD3_XDFFM_SFB_XD4_dmodout r0 *1 0,0
Ccc_XD3_XDFFM_SFB_XD4_dmodout XD3_XDFFM_SFB XD4_dmodout 1.21e-17
* device instance cc_XD3_XDFFM_SFB_XD4_dq r0 *1 0,0
Ccc_XD3_XDFFM_SFB_XD4_dq XD3_XDFFM_SFB XD4_dq 1.8151e-17
* device instance cc_XD3_XDFFM_SFB_XD4_nm r0 *1 0,0
Ccc_XD3_XDFFM_SFB_XD4_nm XD3_XDFFM_SFB XD4_nm 1.21e-17
* device instance cc_XD3_XDFFM_SFB_XD4_nt r0 *1 0,0
Ccc_XD3_XDFFM_SFB_XD4_nt XD3_XDFFM_SFB XD4_nt 1.21e-17
* device instance cc_XD3_XDFFM_SFB_XD4_t1 r0 *1 0,0
Ccc_XD3_XDFFM_SFB_XD4_t1 XD3_XDFFM_SFB XD4_t1 1.21e-17
* device instance cc_XD3_XDFFM_SFB_XD5_XDFFM_CKBB r0 *1 0,0
Ccc_XD3_XDFFM_SFB_XD5_XDFFM_CKBB XD3_XDFFM_SFB XD5_XDFFM_CKBB 1.8151e-17
* device instance cc_XD3_XDFFM_SFB_XD5_XDFFM_CLKB r0 *1 0,0
Ccc_XD3_XDFFM_SFB_XD5_XDFFM_CLKB XD3_XDFFM_SFB XD5_XDFFM_CLKB 2.4201e-17
* device instance cc_XD3_XDFFM_SFB_XD5_XDFFM_M r0 *1 0,0
Ccc_XD3_XDFFM_SFB_XD5_XDFFM_M XD3_XDFFM_SFB XD5_XDFFM_M 2.4201e-17
* device instance cc_XD3_XDFFM_SFB_XD5_XDFFM_MB r0 *1 0,0
Ccc_XD3_XDFFM_SFB_XD5_XDFFM_MB XD3_XDFFM_SFB XD5_XDFFM_MB 1.21e-17
* device instance cc_XD3_XDFFM_SFB_XD5_XDFFM_MFB r0 *1 0,0
Ccc_XD3_XDFFM_SFB_XD5_XDFFM_MFB XD3_XDFFM_SFB XD5_XDFFM_MFB 1.21e-17
* device instance cc_XD3_XDFFM_SFB_XD5_XDFFM_S r0 *1 0,0
Ccc_XD3_XDFFM_SFB_XD5_XDFFM_S XD3_XDFFM_SFB XD5_XDFFM_S 1.8151e-17
* device instance cc_XD3_XDFFM_SFB_XD5_XDFFM_SB r0 *1 0,0
Ccc_XD3_XDFFM_SFB_XD5_XDFFM_SB XD3_XDFFM_SFB XD5_XDFFM_SB 1.8151e-17
* device instance cc_XD3_XDFFM_SFB_XD5_XDFFM_SFB r0 *1 0,0
Ccc_XD3_XDFFM_SFB_XD5_XDFFM_SFB XD3_XDFFM_SFB XD5_XDFFM_SFB 1.21e-17
* device instance cc_XD3_XDFFM_SFB_XD5_XDFFQ_CKBB r0 *1 0,0
Ccc_XD3_XDFFM_SFB_XD5_XDFFQ_CKBB XD3_XDFFM_SFB XD5_XDFFQ_CKBB 1.8151e-17
* device instance cc_XD3_XDFFM_SFB_XD5_XDFFQ_CLKB r0 *1 0,0
Ccc_XD3_XDFFM_SFB_XD5_XDFFQ_CLKB XD3_XDFFM_SFB XD5_XDFFQ_CLKB 2.4201e-17
* device instance cc_XD3_XDFFM_SFB_XD5_XDFFQ_M r0 *1 0,0
Ccc_XD3_XDFFM_SFB_XD5_XDFFQ_M XD3_XDFFM_SFB XD5_XDFFQ_M 2.4201e-17
* device instance cc_XD3_XDFFM_SFB_XD5_XDFFQ_MB r0 *1 0,0
Ccc_XD3_XDFFM_SFB_XD5_XDFFQ_MB XD3_XDFFM_SFB XD5_XDFFQ_MB 1.21e-17
* device instance cc_XD3_XDFFM_SFB_XD5_XDFFQ_MFB r0 *1 0,0
Ccc_XD3_XDFFM_SFB_XD5_XDFFQ_MFB XD3_XDFFM_SFB XD5_XDFFQ_MFB 1.21e-17
* device instance cc_XD3_XDFFM_SFB_XD5_XDFFQ_S r0 *1 0,0
Ccc_XD3_XDFFM_SFB_XD5_XDFFQ_S XD3_XDFFM_SFB XD5_XDFFQ_S 1.8151e-17
* device instance cc_XD3_XDFFM_SFB_XD5_XDFFQ_SB r0 *1 0,0
Ccc_XD3_XDFFM_SFB_XD5_XDFFQ_SB XD3_XDFFM_SFB XD5_XDFFQ_SB 1.8151e-17
* device instance cc_XD3_XDFFM_SFB_XD5_XDFFQ_SFB r0 *1 0,0
Ccc_XD3_XDFFM_SFB_XD5_XDFFQ_SFB XD3_XDFFM_SFB XD5_XDFFQ_SFB 1.21e-17
* device instance cc_XD3_XDFFM_SFB_XD5_XN2_mid1 r0 *1 0,0
Ccc_XD3_XDFFM_SFB_XD5_XN2_mid1 XD3_XDFFM_SFB XD5_XN2_mid1 1.21e-17
* device instance cc_XD3_XDFFM_SFB_XD5_XN3_mid1 r0 *1 0,0
Ccc_XD3_XDFFM_SFB_XD5_XN3_mid1 XD3_XDFFM_SFB XD5_XN3_mid1 1.21e-17
* device instance cc_XD3_XDFFM_SFB_XD5_XN3_mid2 r0 *1 0,0
Ccc_XD3_XDFFM_SFB_XD5_XN3_mid2 XD3_XDFFM_SFB XD5_XN3_mid2 1.21e-17
* device instance cc_XD3_XDFFM_SFB_XD5_dmodout r0 *1 0,0
Ccc_XD3_XDFFM_SFB_XD5_dmodout XD3_XDFFM_SFB XD5_dmodout 1.21e-17
* device instance cc_XD3_XDFFM_SFB_XD5_dq r0 *1 0,0
Ccc_XD3_XDFFM_SFB_XD5_dq XD3_XDFFM_SFB XD5_dq 1.8151e-17
* device instance cc_XD3_XDFFM_SFB_XD5_nm r0 *1 0,0
Ccc_XD3_XDFFM_SFB_XD5_nm XD3_XDFFM_SFB XD5_nm 1.21e-17
* device instance cc_XD3_XDFFM_SFB_XD5_nt r0 *1 0,0
Ccc_XD3_XDFFM_SFB_XD5_nt XD3_XDFFM_SFB XD5_nt 1.21e-17
* device instance cc_XD3_XDFFM_SFB_XD5_t1 r0 *1 0,0
Ccc_XD3_XDFFM_SFB_XD5_t1 XD3_XDFFM_SFB XD5_t1 1.21e-17
* device instance cc_XD3_XDFFM_SFB_XFRT_CKBB r0 *1 0,0
Ccc_XD3_XDFFM_SFB_XFRT_CKBB XD3_XDFFM_SFB XFRT_CKBB 1.8151e-17
* device instance cc_XD3_XDFFM_SFB_XFRT_CLKB r0 *1 0,0
Ccc_XD3_XDFFM_SFB_XFRT_CLKB XD3_XDFFM_SFB XFRT_CLKB 2.4201e-17
* device instance cc_XD3_XDFFM_SFB_XFRT_M r0 *1 0,0
Ccc_XD3_XDFFM_SFB_XFRT_M XD3_XDFFM_SFB XFRT_M 2.4201e-17
* device instance cc_XD3_XDFFM_SFB_XFRT_MB r0 *1 0,0
Ccc_XD3_XDFFM_SFB_XFRT_MB XD3_XDFFM_SFB XFRT_MB 1.21e-17
* device instance cc_XD3_XDFFM_SFB_XFRT_MFB r0 *1 0,0
Ccc_XD3_XDFFM_SFB_XFRT_MFB XD3_XDFFM_SFB XFRT_MFB 1.21e-17
* device instance cc_XD3_XDFFM_SFB_XFRT_S r0 *1 0,0
Ccc_XD3_XDFFM_SFB_XFRT_S XD3_XDFFM_SFB XFRT_S 1.8151e-17
* device instance cc_XD3_XDFFM_SFB_XFRT_SB r0 *1 0,0
Ccc_XD3_XDFFM_SFB_XFRT_SB XD3_XDFFM_SFB XFRT_SB 1.8151e-17
* device instance cc_XD3_XDFFM_SFB_XFRT_SFB r0 *1 0,0
Ccc_XD3_XDFFM_SFB_XFRT_SFB XD3_XDFFM_SFB XFRT_SFB 1.21e-17
* device instance cc_XD3_XDFFM_SFB_ck1 r0 *1 0,0
Ccc_XD3_XDFFM_SFB_ck1 XD3_XDFFM_SFB ck1 3.0251e-17
* device instance cc_XD3_XDFFM_SFB_ck2 r0 *1 0,0
Ccc_XD3_XDFFM_SFB_ck2 XD3_XDFFM_SFB ck2 3.0251e-17
* device instance cc_XD3_XDFFM_SFB_ck3 r0 *1 0,0
Ccc_XD3_XDFFM_SFB_ck3 XD3_XDFFM_SFB ck3 3.0251e-17
* device instance cc_XD3_XDFFM_SFB_ck4 r0 *1 0,0
Ccc_XD3_XDFFM_SFB_ck4 XD3_XDFFM_SFB ck4 3.0251e-17
* device instance cc_XD3_XDFFM_SFB_ck5 r0 *1 0,0
Ccc_XD3_XDFFM_SFB_ck5 XD3_XDFFM_SFB ck5 3.0251e-17
* device instance cc_XD3_XDFFM_SFB_mod0 r0 *1 0,0
Ccc_XD3_XDFFM_SFB_mod0 XD3_XDFFM_SFB mod0 2.4201e-17
* device instance cc_XD3_XDFFM_SFB_mod1 r0 *1 0,0
Ccc_XD3_XDFFM_SFB_mod1 XD3_XDFFM_SFB mod1 2.4201e-17
* device instance cc_XD3_XDFFM_SFB_mod2 r0 *1 0,0
Ccc_XD3_XDFFM_SFB_mod2 XD3_XDFFM_SFB mod2 2.4201e-17
* device instance cc_XD3_XDFFM_SFB_mod3 r0 *1 0,0
Ccc_XD3_XDFFM_SFB_mod3 XD3_XDFFM_SFB mod3 2.4201e-17
* device instance cc_XD3_XDFFM_SFB_mod4 r0 *1 0,0
Ccc_XD3_XDFFM_SFB_mod4 XD3_XDFFM_SFB mod4 2.4201e-17
* device instance cc_XD3_XDFFM_SFB_net1 r0 *1 0,0
Ccc_XD3_XDFFM_SFB_net1 XD3_XDFFM_SFB net1 1.21e-17
* device instance cc_XD3_XDFFQ_CKBB_XD3_XDFFQ_CLKB r0 *1 0,0
Ccc_XD3_XDFFQ_CKBB_XD3_XDFFQ_CLKB XD3_XDFFQ_CKBB XD3_XDFFQ_CLKB 3.6302e-17
* device instance cc_XD3_XDFFQ_CKBB_XD3_XDFFQ_M r0 *1 0,0
Ccc_XD3_XDFFQ_CKBB_XD3_XDFFQ_M XD3_XDFFQ_CKBB XD3_XDFFQ_M 4.8402e-17
* device instance cc_XD3_XDFFQ_CKBB_XD3_XDFFQ_MB r0 *1 0,0
Ccc_XD3_XDFFQ_CKBB_XD3_XDFFQ_MB XD3_XDFFQ_CKBB XD3_XDFFQ_MB 2.4201e-17
* device instance cc_XD3_XDFFQ_CKBB_XD3_XDFFQ_MFB r0 *1 0,0
Ccc_XD3_XDFFQ_CKBB_XD3_XDFFQ_MFB XD3_XDFFQ_CKBB XD3_XDFFQ_MFB 2.4201e-17
* device instance cc_XD3_XDFFQ_CKBB_XD3_XDFFQ_S r0 *1 0,0
Ccc_XD3_XDFFQ_CKBB_XD3_XDFFQ_S XD3_XDFFQ_CKBB XD3_XDFFQ_S 3.0251e-17
* device instance cc_XD3_XDFFQ_CKBB_XD3_XDFFQ_SB r0 *1 0,0
Ccc_XD3_XDFFQ_CKBB_XD3_XDFFQ_SB XD3_XDFFQ_CKBB XD3_XDFFQ_SB 3.0251e-17
* device instance cc_XD3_XDFFQ_CKBB_XD3_XDFFQ_SFB r0 *1 0,0
Ccc_XD3_XDFFQ_CKBB_XD3_XDFFQ_SFB XD3_XDFFQ_CKBB XD3_XDFFQ_SFB 1.8151e-17
* device instance cc_XD3_XDFFQ_CKBB_XD3_XN2_mid1 r0 *1 0,0
Ccc_XD3_XDFFQ_CKBB_XD3_XN2_mid1 XD3_XDFFQ_CKBB XD3_XN2_mid1 1.21e-17
* device instance cc_XD3_XDFFQ_CKBB_XD3_XNOR_midp r0 *1 0,0
Ccc_XD3_XDFFQ_CKBB_XD3_XNOR_midp XD3_XDFFQ_CKBB XD3_XNOR_midp 1.21e-17
* device instance cc_XD3_XDFFQ_CKBB_XD3_dmodout r0 *1 0,0
Ccc_XD3_XDFFQ_CKBB_XD3_dmodout XD3_XDFFQ_CKBB XD3_dmodout 1.21e-17
* device instance cc_XD3_XDFFQ_CKBB_XD3_dq r0 *1 0,0
Ccc_XD3_XDFFQ_CKBB_XD3_dq XD3_XDFFQ_CKBB XD3_dq 1.8151e-17
* device instance cc_XD3_XDFFQ_CKBB_XD3_nm r0 *1 0,0
Ccc_XD3_XDFFQ_CKBB_XD3_nm XD3_XDFFQ_CKBB XD3_nm 1.21e-17
* device instance cc_XD3_XDFFQ_CKBB_XD3_nt r0 *1 0,0
Ccc_XD3_XDFFQ_CKBB_XD3_nt XD3_XDFFQ_CKBB XD3_nt 2.4201e-17
* device instance cc_XD3_XDFFQ_CKBB_XD3_t1 r0 *1 0,0
Ccc_XD3_XDFFQ_CKBB_XD3_t1 XD3_XDFFQ_CKBB XD3_t1 1.21e-17
* device instance cc_XD3_XDFFQ_CKBB_XD4_XDFFM_CKBB r0 *1 0,0
Ccc_XD3_XDFFQ_CKBB_XD4_XDFFM_CKBB XD3_XDFFQ_CKBB XD4_XDFFM_CKBB 1.8151e-17
* device instance cc_XD3_XDFFQ_CKBB_XD4_XDFFM_CLKB r0 *1 0,0
Ccc_XD3_XDFFQ_CKBB_XD4_XDFFM_CLKB XD3_XDFFQ_CKBB XD4_XDFFM_CLKB 2.4201e-17
* device instance cc_XD3_XDFFQ_CKBB_XD4_XDFFM_M r0 *1 0,0
Ccc_XD3_XDFFQ_CKBB_XD4_XDFFM_M XD3_XDFFQ_CKBB XD4_XDFFM_M 2.4201e-17
* device instance cc_XD3_XDFFQ_CKBB_XD4_XDFFM_MB r0 *1 0,0
Ccc_XD3_XDFFQ_CKBB_XD4_XDFFM_MB XD3_XDFFQ_CKBB XD4_XDFFM_MB 1.21e-17
* device instance cc_XD3_XDFFQ_CKBB_XD4_XDFFM_MFB r0 *1 0,0
Ccc_XD3_XDFFQ_CKBB_XD4_XDFFM_MFB XD3_XDFFQ_CKBB XD4_XDFFM_MFB 1.21e-17
* device instance cc_XD3_XDFFQ_CKBB_XD4_XDFFM_S r0 *1 0,0
Ccc_XD3_XDFFQ_CKBB_XD4_XDFFM_S XD3_XDFFQ_CKBB XD4_XDFFM_S 1.8151e-17
* device instance cc_XD3_XDFFQ_CKBB_XD4_XDFFM_SB r0 *1 0,0
Ccc_XD3_XDFFQ_CKBB_XD4_XDFFM_SB XD3_XDFFQ_CKBB XD4_XDFFM_SB 1.8151e-17
* device instance cc_XD3_XDFFQ_CKBB_XD4_XDFFM_SFB r0 *1 0,0
Ccc_XD3_XDFFQ_CKBB_XD4_XDFFM_SFB XD3_XDFFQ_CKBB XD4_XDFFM_SFB 1.21e-17
* device instance cc_XD3_XDFFQ_CKBB_XD4_XDFFQ_CKBB r0 *1 0,0
Ccc_XD3_XDFFQ_CKBB_XD4_XDFFQ_CKBB XD3_XDFFQ_CKBB XD4_XDFFQ_CKBB 1.8151e-17
* device instance cc_XD3_XDFFQ_CKBB_XD4_XDFFQ_CLKB r0 *1 0,0
Ccc_XD3_XDFFQ_CKBB_XD4_XDFFQ_CLKB XD3_XDFFQ_CKBB XD4_XDFFQ_CLKB 2.4201e-17
* device instance cc_XD3_XDFFQ_CKBB_XD4_XDFFQ_M r0 *1 0,0
Ccc_XD3_XDFFQ_CKBB_XD4_XDFFQ_M XD3_XDFFQ_CKBB XD4_XDFFQ_M 2.4201e-17
* device instance cc_XD3_XDFFQ_CKBB_XD4_XDFFQ_MB r0 *1 0,0
Ccc_XD3_XDFFQ_CKBB_XD4_XDFFQ_MB XD3_XDFFQ_CKBB XD4_XDFFQ_MB 1.21e-17
* device instance cc_XD3_XDFFQ_CKBB_XD4_XDFFQ_MFB r0 *1 0,0
Ccc_XD3_XDFFQ_CKBB_XD4_XDFFQ_MFB XD3_XDFFQ_CKBB XD4_XDFFQ_MFB 1.21e-17
* device instance cc_XD3_XDFFQ_CKBB_XD4_XDFFQ_S r0 *1 0,0
Ccc_XD3_XDFFQ_CKBB_XD4_XDFFQ_S XD3_XDFFQ_CKBB XD4_XDFFQ_S 1.8151e-17
* device instance cc_XD3_XDFFQ_CKBB_XD4_XDFFQ_SB r0 *1 0,0
Ccc_XD3_XDFFQ_CKBB_XD4_XDFFQ_SB XD3_XDFFQ_CKBB XD4_XDFFQ_SB 1.8151e-17
* device instance cc_XD3_XDFFQ_CKBB_XD4_XDFFQ_SFB r0 *1 0,0
Ccc_XD3_XDFFQ_CKBB_XD4_XDFFQ_SFB XD3_XDFFQ_CKBB XD4_XDFFQ_SFB 1.21e-17
* device instance cc_XD3_XDFFQ_CKBB_XD4_XN2_mid1 r0 *1 0,0
Ccc_XD3_XDFFQ_CKBB_XD4_XN2_mid1 XD3_XDFFQ_CKBB XD4_XN2_mid1 1.21e-17
* device instance cc_XD3_XDFFQ_CKBB_XD4_XN3_mid1 r0 *1 0,0
Ccc_XD3_XDFFQ_CKBB_XD4_XN3_mid1 XD3_XDFFQ_CKBB XD4_XN3_mid1 1.21e-17
* device instance cc_XD3_XDFFQ_CKBB_XD4_XN3_mid2 r0 *1 0,0
Ccc_XD3_XDFFQ_CKBB_XD4_XN3_mid2 XD3_XDFFQ_CKBB XD4_XN3_mid2 1.21e-17
* device instance cc_XD3_XDFFQ_CKBB_XD4_dmodout r0 *1 0,0
Ccc_XD3_XDFFQ_CKBB_XD4_dmodout XD3_XDFFQ_CKBB XD4_dmodout 1.21e-17
* device instance cc_XD3_XDFFQ_CKBB_XD4_dq r0 *1 0,0
Ccc_XD3_XDFFQ_CKBB_XD4_dq XD3_XDFFQ_CKBB XD4_dq 1.8151e-17
* device instance cc_XD3_XDFFQ_CKBB_XD4_nm r0 *1 0,0
Ccc_XD3_XDFFQ_CKBB_XD4_nm XD3_XDFFQ_CKBB XD4_nm 1.21e-17
* device instance cc_XD3_XDFFQ_CKBB_XD4_nt r0 *1 0,0
Ccc_XD3_XDFFQ_CKBB_XD4_nt XD3_XDFFQ_CKBB XD4_nt 1.21e-17
* device instance cc_XD3_XDFFQ_CKBB_XD4_t1 r0 *1 0,0
Ccc_XD3_XDFFQ_CKBB_XD4_t1 XD3_XDFFQ_CKBB XD4_t1 1.21e-17
* device instance cc_XD3_XDFFQ_CKBB_XD5_XDFFM_CKBB r0 *1 0,0
Ccc_XD3_XDFFQ_CKBB_XD5_XDFFM_CKBB XD3_XDFFQ_CKBB XD5_XDFFM_CKBB 1.8151e-17
* device instance cc_XD3_XDFFQ_CKBB_XD5_XDFFM_CLKB r0 *1 0,0
Ccc_XD3_XDFFQ_CKBB_XD5_XDFFM_CLKB XD3_XDFFQ_CKBB XD5_XDFFM_CLKB 2.4201e-17
* device instance cc_XD3_XDFFQ_CKBB_XD5_XDFFM_M r0 *1 0,0
Ccc_XD3_XDFFQ_CKBB_XD5_XDFFM_M XD3_XDFFQ_CKBB XD5_XDFFM_M 2.4201e-17
* device instance cc_XD3_XDFFQ_CKBB_XD5_XDFFM_MB r0 *1 0,0
Ccc_XD3_XDFFQ_CKBB_XD5_XDFFM_MB XD3_XDFFQ_CKBB XD5_XDFFM_MB 1.21e-17
* device instance cc_XD3_XDFFQ_CKBB_XD5_XDFFM_MFB r0 *1 0,0
Ccc_XD3_XDFFQ_CKBB_XD5_XDFFM_MFB XD3_XDFFQ_CKBB XD5_XDFFM_MFB 1.21e-17
* device instance cc_XD3_XDFFQ_CKBB_XD5_XDFFM_S r0 *1 0,0
Ccc_XD3_XDFFQ_CKBB_XD5_XDFFM_S XD3_XDFFQ_CKBB XD5_XDFFM_S 1.8151e-17
* device instance cc_XD3_XDFFQ_CKBB_XD5_XDFFM_SB r0 *1 0,0
Ccc_XD3_XDFFQ_CKBB_XD5_XDFFM_SB XD3_XDFFQ_CKBB XD5_XDFFM_SB 1.8151e-17
* device instance cc_XD3_XDFFQ_CKBB_XD5_XDFFM_SFB r0 *1 0,0
Ccc_XD3_XDFFQ_CKBB_XD5_XDFFM_SFB XD3_XDFFQ_CKBB XD5_XDFFM_SFB 1.21e-17
* device instance cc_XD3_XDFFQ_CKBB_XD5_XDFFQ_CKBB r0 *1 0,0
Ccc_XD3_XDFFQ_CKBB_XD5_XDFFQ_CKBB XD3_XDFFQ_CKBB XD5_XDFFQ_CKBB 1.8151e-17
* device instance cc_XD3_XDFFQ_CKBB_XD5_XDFFQ_CLKB r0 *1 0,0
Ccc_XD3_XDFFQ_CKBB_XD5_XDFFQ_CLKB XD3_XDFFQ_CKBB XD5_XDFFQ_CLKB 2.4201e-17
* device instance cc_XD3_XDFFQ_CKBB_XD5_XDFFQ_M r0 *1 0,0
Ccc_XD3_XDFFQ_CKBB_XD5_XDFFQ_M XD3_XDFFQ_CKBB XD5_XDFFQ_M 2.4201e-17
* device instance cc_XD3_XDFFQ_CKBB_XD5_XDFFQ_MB r0 *1 0,0
Ccc_XD3_XDFFQ_CKBB_XD5_XDFFQ_MB XD3_XDFFQ_CKBB XD5_XDFFQ_MB 1.21e-17
* device instance cc_XD3_XDFFQ_CKBB_XD5_XDFFQ_MFB r0 *1 0,0
Ccc_XD3_XDFFQ_CKBB_XD5_XDFFQ_MFB XD3_XDFFQ_CKBB XD5_XDFFQ_MFB 1.21e-17
* device instance cc_XD3_XDFFQ_CKBB_XD5_XDFFQ_S r0 *1 0,0
Ccc_XD3_XDFFQ_CKBB_XD5_XDFFQ_S XD3_XDFFQ_CKBB XD5_XDFFQ_S 1.8151e-17
* device instance cc_XD3_XDFFQ_CKBB_XD5_XDFFQ_SB r0 *1 0,0
Ccc_XD3_XDFFQ_CKBB_XD5_XDFFQ_SB XD3_XDFFQ_CKBB XD5_XDFFQ_SB 1.8151e-17
* device instance cc_XD3_XDFFQ_CKBB_XD5_XDFFQ_SFB r0 *1 0,0
Ccc_XD3_XDFFQ_CKBB_XD5_XDFFQ_SFB XD3_XDFFQ_CKBB XD5_XDFFQ_SFB 1.21e-17
* device instance cc_XD3_XDFFQ_CKBB_XD5_XN2_mid1 r0 *1 0,0
Ccc_XD3_XDFFQ_CKBB_XD5_XN2_mid1 XD3_XDFFQ_CKBB XD5_XN2_mid1 1.21e-17
* device instance cc_XD3_XDFFQ_CKBB_XD5_XN3_mid1 r0 *1 0,0
Ccc_XD3_XDFFQ_CKBB_XD5_XN3_mid1 XD3_XDFFQ_CKBB XD5_XN3_mid1 1.21e-17
* device instance cc_XD3_XDFFQ_CKBB_XD5_XN3_mid2 r0 *1 0,0
Ccc_XD3_XDFFQ_CKBB_XD5_XN3_mid2 XD3_XDFFQ_CKBB XD5_XN3_mid2 1.21e-17
* device instance cc_XD3_XDFFQ_CKBB_XD5_dmodout r0 *1 0,0
Ccc_XD3_XDFFQ_CKBB_XD5_dmodout XD3_XDFFQ_CKBB XD5_dmodout 1.21e-17
* device instance cc_XD3_XDFFQ_CKBB_XD5_dq r0 *1 0,0
Ccc_XD3_XDFFQ_CKBB_XD5_dq XD3_XDFFQ_CKBB XD5_dq 1.8151e-17
* device instance cc_XD3_XDFFQ_CKBB_XD5_nm r0 *1 0,0
Ccc_XD3_XDFFQ_CKBB_XD5_nm XD3_XDFFQ_CKBB XD5_nm 1.21e-17
* device instance cc_XD3_XDFFQ_CKBB_XD5_nt r0 *1 0,0
Ccc_XD3_XDFFQ_CKBB_XD5_nt XD3_XDFFQ_CKBB XD5_nt 1.21e-17
* device instance cc_XD3_XDFFQ_CKBB_XD5_t1 r0 *1 0,0
Ccc_XD3_XDFFQ_CKBB_XD5_t1 XD3_XDFFQ_CKBB XD5_t1 1.21e-17
* device instance cc_XD3_XDFFQ_CKBB_XFRT_CKBB r0 *1 0,0
Ccc_XD3_XDFFQ_CKBB_XFRT_CKBB XD3_XDFFQ_CKBB XFRT_CKBB 1.8151e-17
* device instance cc_XD3_XDFFQ_CKBB_XFRT_CLKB r0 *1 0,0
Ccc_XD3_XDFFQ_CKBB_XFRT_CLKB XD3_XDFFQ_CKBB XFRT_CLKB 2.4201e-17
* device instance cc_XD3_XDFFQ_CKBB_XFRT_M r0 *1 0,0
Ccc_XD3_XDFFQ_CKBB_XFRT_M XD3_XDFFQ_CKBB XFRT_M 2.4201e-17
* device instance cc_XD3_XDFFQ_CKBB_XFRT_MB r0 *1 0,0
Ccc_XD3_XDFFQ_CKBB_XFRT_MB XD3_XDFFQ_CKBB XFRT_MB 1.21e-17
* device instance cc_XD3_XDFFQ_CKBB_XFRT_MFB r0 *1 0,0
Ccc_XD3_XDFFQ_CKBB_XFRT_MFB XD3_XDFFQ_CKBB XFRT_MFB 1.21e-17
* device instance cc_XD3_XDFFQ_CKBB_XFRT_S r0 *1 0,0
Ccc_XD3_XDFFQ_CKBB_XFRT_S XD3_XDFFQ_CKBB XFRT_S 1.8151e-17
* device instance cc_XD3_XDFFQ_CKBB_XFRT_SB r0 *1 0,0
Ccc_XD3_XDFFQ_CKBB_XFRT_SB XD3_XDFFQ_CKBB XFRT_SB 1.8151e-17
* device instance cc_XD3_XDFFQ_CKBB_XFRT_SFB r0 *1 0,0
Ccc_XD3_XDFFQ_CKBB_XFRT_SFB XD3_XDFFQ_CKBB XFRT_SFB 1.21e-17
* device instance cc_XD3_XDFFQ_CKBB_ck1 r0 *1 0,0
Ccc_XD3_XDFFQ_CKBB_ck1 XD3_XDFFQ_CKBB ck1 3.0251e-17
* device instance cc_XD3_XDFFQ_CKBB_ck2 r0 *1 0,0
Ccc_XD3_XDFFQ_CKBB_ck2 XD3_XDFFQ_CKBB ck2 3.0251e-17
* device instance cc_XD3_XDFFQ_CKBB_ck3 r0 *1 0,0
Ccc_XD3_XDFFQ_CKBB_ck3 XD3_XDFFQ_CKBB ck3 3.0251e-17
* device instance cc_XD3_XDFFQ_CKBB_ck4 r0 *1 0,0
Ccc_XD3_XDFFQ_CKBB_ck4 XD3_XDFFQ_CKBB ck4 3.0251e-17
* device instance cc_XD3_XDFFQ_CKBB_ck5 r0 *1 0,0
Ccc_XD3_XDFFQ_CKBB_ck5 XD3_XDFFQ_CKBB ck5 3.0251e-17
* device instance cc_XD3_XDFFQ_CKBB_mod0 r0 *1 0,0
Ccc_XD3_XDFFQ_CKBB_mod0 XD3_XDFFQ_CKBB mod0 2.4201e-17
* device instance cc_XD3_XDFFQ_CKBB_mod1 r0 *1 0,0
Ccc_XD3_XDFFQ_CKBB_mod1 XD3_XDFFQ_CKBB mod1 2.4201e-17
* device instance cc_XD3_XDFFQ_CKBB_mod2 r0 *1 0,0
Ccc_XD3_XDFFQ_CKBB_mod2 XD3_XDFFQ_CKBB mod2 2.4201e-17
* device instance cc_XD3_XDFFQ_CKBB_mod3 r0 *1 0,0
Ccc_XD3_XDFFQ_CKBB_mod3 XD3_XDFFQ_CKBB mod3 2.4201e-17
* device instance cc_XD3_XDFFQ_CKBB_mod4 r0 *1 0,0
Ccc_XD3_XDFFQ_CKBB_mod4 XD3_XDFFQ_CKBB mod4 2.4201e-17
* device instance cc_XD3_XDFFQ_CKBB_net1 r0 *1 0,0
Ccc_XD3_XDFFQ_CKBB_net1 XD3_XDFFQ_CKBB net1 1.21e-17
* device instance cc_XD3_XDFFQ_CLKB_XD3_XDFFQ_M r0 *1 0,0
Ccc_XD3_XDFFQ_CLKB_XD3_XDFFQ_M XD3_XDFFQ_CLKB XD3_XDFFQ_M 4.2352e-17
* device instance cc_XD3_XDFFQ_CLKB_XD3_XDFFQ_MB r0 *1 0,0
Ccc_XD3_XDFFQ_CLKB_XD3_XDFFQ_MB XD3_XDFFQ_CLKB XD3_XDFFQ_MB 2.4201e-17
* device instance cc_XD3_XDFFQ_CLKB_XD3_XDFFQ_MFB r0 *1 0,0
Ccc_XD3_XDFFQ_CLKB_XD3_XDFFQ_MFB XD3_XDFFQ_CLKB XD3_XDFFQ_MFB 2.4201e-17
* device instance cc_XD3_XDFFQ_CLKB_XD3_XDFFQ_S r0 *1 0,0
Ccc_XD3_XDFFQ_CLKB_XD3_XDFFQ_S XD3_XDFFQ_CLKB XD3_XDFFQ_S 1.8151e-17
* device instance cc_XD3_XDFFQ_CLKB_XD3_XDFFQ_SB r0 *1 0,0
Ccc_XD3_XDFFQ_CLKB_XD3_XDFFQ_SB XD3_XDFFQ_CLKB XD3_XDFFQ_SB 1.8151e-17
* device instance cc_XD3_XDFFQ_CLKB_XD3_XDFFQ_SFB r0 *1 0,0
Ccc_XD3_XDFFQ_CLKB_XD3_XDFFQ_SFB XD3_XDFFQ_CLKB XD3_XDFFQ_SFB 1.21e-17
* device instance cc_XD3_XDFFQ_CLKB_XD3_XN2_mid1 r0 *1 0,0
Ccc_XD3_XDFFQ_CLKB_XD3_XN2_mid1 XD3_XDFFQ_CLKB XD3_XN2_mid1 1.21e-17
* device instance cc_XD3_XDFFQ_CLKB_XD3_XNOR_midp r0 *1 0,0
Ccc_XD3_XDFFQ_CLKB_XD3_XNOR_midp XD3_XDFFQ_CLKB XD3_XNOR_midp 1.21e-17
* device instance cc_XD3_XDFFQ_CLKB_XD3_dmodout r0 *1 0,0
Ccc_XD3_XDFFQ_CLKB_XD3_dmodout XD3_XDFFQ_CLKB XD3_dmodout 1.21e-17
* device instance cc_XD3_XDFFQ_CLKB_XD3_dq r0 *1 0,0
Ccc_XD3_XDFFQ_CLKB_XD3_dq XD3_XDFFQ_CLKB XD3_dq 1.8151e-17
* device instance cc_XD3_XDFFQ_CLKB_XD3_nm r0 *1 0,0
Ccc_XD3_XDFFQ_CLKB_XD3_nm XD3_XDFFQ_CLKB XD3_nm 1.21e-17
* device instance cc_XD3_XDFFQ_CLKB_XD3_nt r0 *1 0,0
Ccc_XD3_XDFFQ_CLKB_XD3_nt XD3_XDFFQ_CLKB XD3_nt 2.4201e-17
* device instance cc_XD3_XDFFQ_CLKB_XD3_t1 r0 *1 0,0
Ccc_XD3_XDFFQ_CLKB_XD3_t1 XD3_XDFFQ_CLKB XD3_t1 1.21e-17
* device instance cc_XD3_XDFFQ_CLKB_XD4_XDFFM_CKBB r0 *1 0,0
Ccc_XD3_XDFFQ_CLKB_XD4_XDFFM_CKBB XD3_XDFFQ_CLKB XD4_XDFFM_CKBB 1.8151e-17
* device instance cc_XD3_XDFFQ_CLKB_XD4_XDFFM_CLKB r0 *1 0,0
Ccc_XD3_XDFFQ_CLKB_XD4_XDFFM_CLKB XD3_XDFFQ_CLKB XD4_XDFFM_CLKB 2.4201e-17
* device instance cc_XD3_XDFFQ_CLKB_XD4_XDFFM_M r0 *1 0,0
Ccc_XD3_XDFFQ_CLKB_XD4_XDFFM_M XD3_XDFFQ_CLKB XD4_XDFFM_M 2.4201e-17
* device instance cc_XD3_XDFFQ_CLKB_XD4_XDFFM_MB r0 *1 0,0
Ccc_XD3_XDFFQ_CLKB_XD4_XDFFM_MB XD3_XDFFQ_CLKB XD4_XDFFM_MB 1.21e-17
* device instance cc_XD3_XDFFQ_CLKB_XD4_XDFFM_MFB r0 *1 0,0
Ccc_XD3_XDFFQ_CLKB_XD4_XDFFM_MFB XD3_XDFFQ_CLKB XD4_XDFFM_MFB 1.21e-17
* device instance cc_XD3_XDFFQ_CLKB_XD4_XDFFM_S r0 *1 0,0
Ccc_XD3_XDFFQ_CLKB_XD4_XDFFM_S XD3_XDFFQ_CLKB XD4_XDFFM_S 1.8151e-17
* device instance cc_XD3_XDFFQ_CLKB_XD4_XDFFM_SB r0 *1 0,0
Ccc_XD3_XDFFQ_CLKB_XD4_XDFFM_SB XD3_XDFFQ_CLKB XD4_XDFFM_SB 1.8151e-17
* device instance cc_XD3_XDFFQ_CLKB_XD4_XDFFM_SFB r0 *1 0,0
Ccc_XD3_XDFFQ_CLKB_XD4_XDFFM_SFB XD3_XDFFQ_CLKB XD4_XDFFM_SFB 1.21e-17
* device instance cc_XD3_XDFFQ_CLKB_XD4_XDFFQ_CKBB r0 *1 0,0
Ccc_XD3_XDFFQ_CLKB_XD4_XDFFQ_CKBB XD3_XDFFQ_CLKB XD4_XDFFQ_CKBB 1.8151e-17
* device instance cc_XD3_XDFFQ_CLKB_XD4_XDFFQ_CLKB r0 *1 0,0
Ccc_XD3_XDFFQ_CLKB_XD4_XDFFQ_CLKB XD3_XDFFQ_CLKB XD4_XDFFQ_CLKB 2.4201e-17
* device instance cc_XD3_XDFFQ_CLKB_XD4_XDFFQ_M r0 *1 0,0
Ccc_XD3_XDFFQ_CLKB_XD4_XDFFQ_M XD3_XDFFQ_CLKB XD4_XDFFQ_M 2.4201e-17
* device instance cc_XD3_XDFFQ_CLKB_XD4_XDFFQ_MB r0 *1 0,0
Ccc_XD3_XDFFQ_CLKB_XD4_XDFFQ_MB XD3_XDFFQ_CLKB XD4_XDFFQ_MB 1.21e-17
* device instance cc_XD3_XDFFQ_CLKB_XD4_XDFFQ_MFB r0 *1 0,0
Ccc_XD3_XDFFQ_CLKB_XD4_XDFFQ_MFB XD3_XDFFQ_CLKB XD4_XDFFQ_MFB 1.21e-17
* device instance cc_XD3_XDFFQ_CLKB_XD4_XDFFQ_S r0 *1 0,0
Ccc_XD3_XDFFQ_CLKB_XD4_XDFFQ_S XD3_XDFFQ_CLKB XD4_XDFFQ_S 1.8151e-17
* device instance cc_XD3_XDFFQ_CLKB_XD4_XDFFQ_SB r0 *1 0,0
Ccc_XD3_XDFFQ_CLKB_XD4_XDFFQ_SB XD3_XDFFQ_CLKB XD4_XDFFQ_SB 1.8151e-17
* device instance cc_XD3_XDFFQ_CLKB_XD4_XDFFQ_SFB r0 *1 0,0
Ccc_XD3_XDFFQ_CLKB_XD4_XDFFQ_SFB XD3_XDFFQ_CLKB XD4_XDFFQ_SFB 1.21e-17
* device instance cc_XD3_XDFFQ_CLKB_XD4_XN2_mid1 r0 *1 0,0
Ccc_XD3_XDFFQ_CLKB_XD4_XN2_mid1 XD3_XDFFQ_CLKB XD4_XN2_mid1 1.21e-17
* device instance cc_XD3_XDFFQ_CLKB_XD4_XN3_mid1 r0 *1 0,0
Ccc_XD3_XDFFQ_CLKB_XD4_XN3_mid1 XD3_XDFFQ_CLKB XD4_XN3_mid1 1.21e-17
* device instance cc_XD3_XDFFQ_CLKB_XD4_XN3_mid2 r0 *1 0,0
Ccc_XD3_XDFFQ_CLKB_XD4_XN3_mid2 XD3_XDFFQ_CLKB XD4_XN3_mid2 1.21e-17
* device instance cc_XD3_XDFFQ_CLKB_XD4_dmodout r0 *1 0,0
Ccc_XD3_XDFFQ_CLKB_XD4_dmodout XD3_XDFFQ_CLKB XD4_dmodout 1.21e-17
* device instance cc_XD3_XDFFQ_CLKB_XD4_dq r0 *1 0,0
Ccc_XD3_XDFFQ_CLKB_XD4_dq XD3_XDFFQ_CLKB XD4_dq 1.8151e-17
* device instance cc_XD3_XDFFQ_CLKB_XD4_nm r0 *1 0,0
Ccc_XD3_XDFFQ_CLKB_XD4_nm XD3_XDFFQ_CLKB XD4_nm 1.21e-17
* device instance cc_XD3_XDFFQ_CLKB_XD4_nt r0 *1 0,0
Ccc_XD3_XDFFQ_CLKB_XD4_nt XD3_XDFFQ_CLKB XD4_nt 1.21e-17
* device instance cc_XD3_XDFFQ_CLKB_XD4_t1 r0 *1 0,0
Ccc_XD3_XDFFQ_CLKB_XD4_t1 XD3_XDFFQ_CLKB XD4_t1 1.21e-17
* device instance cc_XD3_XDFFQ_CLKB_XD5_XDFFM_CKBB r0 *1 0,0
Ccc_XD3_XDFFQ_CLKB_XD5_XDFFM_CKBB XD3_XDFFQ_CLKB XD5_XDFFM_CKBB 1.8151e-17
* device instance cc_XD3_XDFFQ_CLKB_XD5_XDFFM_CLKB r0 *1 0,0
Ccc_XD3_XDFFQ_CLKB_XD5_XDFFM_CLKB XD3_XDFFQ_CLKB XD5_XDFFM_CLKB 2.4201e-17
* device instance cc_XD3_XDFFQ_CLKB_XD5_XDFFM_M r0 *1 0,0
Ccc_XD3_XDFFQ_CLKB_XD5_XDFFM_M XD3_XDFFQ_CLKB XD5_XDFFM_M 2.4201e-17
* device instance cc_XD3_XDFFQ_CLKB_XD5_XDFFM_MB r0 *1 0,0
Ccc_XD3_XDFFQ_CLKB_XD5_XDFFM_MB XD3_XDFFQ_CLKB XD5_XDFFM_MB 1.21e-17
* device instance cc_XD3_XDFFQ_CLKB_XD5_XDFFM_MFB r0 *1 0,0
Ccc_XD3_XDFFQ_CLKB_XD5_XDFFM_MFB XD3_XDFFQ_CLKB XD5_XDFFM_MFB 1.21e-17
* device instance cc_XD3_XDFFQ_CLKB_XD5_XDFFM_S r0 *1 0,0
Ccc_XD3_XDFFQ_CLKB_XD5_XDFFM_S XD3_XDFFQ_CLKB XD5_XDFFM_S 1.8151e-17
* device instance cc_XD3_XDFFQ_CLKB_XD5_XDFFM_SB r0 *1 0,0
Ccc_XD3_XDFFQ_CLKB_XD5_XDFFM_SB XD3_XDFFQ_CLKB XD5_XDFFM_SB 1.8151e-17
* device instance cc_XD3_XDFFQ_CLKB_XD5_XDFFM_SFB r0 *1 0,0
Ccc_XD3_XDFFQ_CLKB_XD5_XDFFM_SFB XD3_XDFFQ_CLKB XD5_XDFFM_SFB 1.21e-17
* device instance cc_XD3_XDFFQ_CLKB_XD5_XDFFQ_CKBB r0 *1 0,0
Ccc_XD3_XDFFQ_CLKB_XD5_XDFFQ_CKBB XD3_XDFFQ_CLKB XD5_XDFFQ_CKBB 1.8151e-17
* device instance cc_XD3_XDFFQ_CLKB_XD5_XDFFQ_CLKB r0 *1 0,0
Ccc_XD3_XDFFQ_CLKB_XD5_XDFFQ_CLKB XD3_XDFFQ_CLKB XD5_XDFFQ_CLKB 2.4201e-17
* device instance cc_XD3_XDFFQ_CLKB_XD5_XDFFQ_M r0 *1 0,0
Ccc_XD3_XDFFQ_CLKB_XD5_XDFFQ_M XD3_XDFFQ_CLKB XD5_XDFFQ_M 2.4201e-17
* device instance cc_XD3_XDFFQ_CLKB_XD5_XDFFQ_MB r0 *1 0,0
Ccc_XD3_XDFFQ_CLKB_XD5_XDFFQ_MB XD3_XDFFQ_CLKB XD5_XDFFQ_MB 1.21e-17
* device instance cc_XD3_XDFFQ_CLKB_XD5_XDFFQ_MFB r0 *1 0,0
Ccc_XD3_XDFFQ_CLKB_XD5_XDFFQ_MFB XD3_XDFFQ_CLKB XD5_XDFFQ_MFB 1.21e-17
* device instance cc_XD3_XDFFQ_CLKB_XD5_XDFFQ_S r0 *1 0,0
Ccc_XD3_XDFFQ_CLKB_XD5_XDFFQ_S XD3_XDFFQ_CLKB XD5_XDFFQ_S 1.8151e-17
* device instance cc_XD3_XDFFQ_CLKB_XD5_XDFFQ_SB r0 *1 0,0
Ccc_XD3_XDFFQ_CLKB_XD5_XDFFQ_SB XD3_XDFFQ_CLKB XD5_XDFFQ_SB 1.8151e-17
* device instance cc_XD3_XDFFQ_CLKB_XD5_XDFFQ_SFB r0 *1 0,0
Ccc_XD3_XDFFQ_CLKB_XD5_XDFFQ_SFB XD3_XDFFQ_CLKB XD5_XDFFQ_SFB 1.21e-17
* device instance cc_XD3_XDFFQ_CLKB_XD5_XN2_mid1 r0 *1 0,0
Ccc_XD3_XDFFQ_CLKB_XD5_XN2_mid1 XD3_XDFFQ_CLKB XD5_XN2_mid1 1.21e-17
* device instance cc_XD3_XDFFQ_CLKB_XD5_XN3_mid1 r0 *1 0,0
Ccc_XD3_XDFFQ_CLKB_XD5_XN3_mid1 XD3_XDFFQ_CLKB XD5_XN3_mid1 1.21e-17
* device instance cc_XD3_XDFFQ_CLKB_XD5_XN3_mid2 r0 *1 0,0
Ccc_XD3_XDFFQ_CLKB_XD5_XN3_mid2 XD3_XDFFQ_CLKB XD5_XN3_mid2 1.21e-17
* device instance cc_XD3_XDFFQ_CLKB_XD5_dmodout r0 *1 0,0
Ccc_XD3_XDFFQ_CLKB_XD5_dmodout XD3_XDFFQ_CLKB XD5_dmodout 1.21e-17
* device instance cc_XD3_XDFFQ_CLKB_XD5_dq r0 *1 0,0
Ccc_XD3_XDFFQ_CLKB_XD5_dq XD3_XDFFQ_CLKB XD5_dq 1.8151e-17
* device instance cc_XD3_XDFFQ_CLKB_XD5_nm r0 *1 0,0
Ccc_XD3_XDFFQ_CLKB_XD5_nm XD3_XDFFQ_CLKB XD5_nm 1.21e-17
* device instance cc_XD3_XDFFQ_CLKB_XD5_nt r0 *1 0,0
Ccc_XD3_XDFFQ_CLKB_XD5_nt XD3_XDFFQ_CLKB XD5_nt 1.21e-17
* device instance cc_XD3_XDFFQ_CLKB_XD5_t1 r0 *1 0,0
Ccc_XD3_XDFFQ_CLKB_XD5_t1 XD3_XDFFQ_CLKB XD5_t1 1.21e-17
* device instance cc_XD3_XDFFQ_CLKB_XFRT_CKBB r0 *1 0,0
Ccc_XD3_XDFFQ_CLKB_XFRT_CKBB XD3_XDFFQ_CLKB XFRT_CKBB 1.8151e-17
* device instance cc_XD3_XDFFQ_CLKB_XFRT_CLKB r0 *1 0,0
Ccc_XD3_XDFFQ_CLKB_XFRT_CLKB XD3_XDFFQ_CLKB XFRT_CLKB 2.4201e-17
* device instance cc_XD3_XDFFQ_CLKB_XFRT_M r0 *1 0,0
Ccc_XD3_XDFFQ_CLKB_XFRT_M XD3_XDFFQ_CLKB XFRT_M 2.4201e-17
* device instance cc_XD3_XDFFQ_CLKB_XFRT_MB r0 *1 0,0
Ccc_XD3_XDFFQ_CLKB_XFRT_MB XD3_XDFFQ_CLKB XFRT_MB 1.21e-17
* device instance cc_XD3_XDFFQ_CLKB_XFRT_MFB r0 *1 0,0
Ccc_XD3_XDFFQ_CLKB_XFRT_MFB XD3_XDFFQ_CLKB XFRT_MFB 1.21e-17
* device instance cc_XD3_XDFFQ_CLKB_XFRT_S r0 *1 0,0
Ccc_XD3_XDFFQ_CLKB_XFRT_S XD3_XDFFQ_CLKB XFRT_S 1.8151e-17
* device instance cc_XD3_XDFFQ_CLKB_XFRT_SB r0 *1 0,0
Ccc_XD3_XDFFQ_CLKB_XFRT_SB XD3_XDFFQ_CLKB XFRT_SB 1.8151e-17
* device instance cc_XD3_XDFFQ_CLKB_XFRT_SFB r0 *1 0,0
Ccc_XD3_XDFFQ_CLKB_XFRT_SFB XD3_XDFFQ_CLKB XFRT_SFB 1.21e-17
* device instance cc_XD3_XDFFQ_CLKB_ck1 r0 *1 0,0
Ccc_XD3_XDFFQ_CLKB_ck1 XD3_XDFFQ_CLKB ck1 3.0251e-17
* device instance cc_XD3_XDFFQ_CLKB_ck2 r0 *1 0,0
Ccc_XD3_XDFFQ_CLKB_ck2 XD3_XDFFQ_CLKB ck2 3.0251e-17
* device instance cc_XD3_XDFFQ_CLKB_ck3 r0 *1 0,0
Ccc_XD3_XDFFQ_CLKB_ck3 XD3_XDFFQ_CLKB ck3 3.0251e-17
* device instance cc_XD3_XDFFQ_CLKB_ck4 r0 *1 0,0
Ccc_XD3_XDFFQ_CLKB_ck4 XD3_XDFFQ_CLKB ck4 3.0251e-17
* device instance cc_XD3_XDFFQ_CLKB_ck5 r0 *1 0,0
Ccc_XD3_XDFFQ_CLKB_ck5 XD3_XDFFQ_CLKB ck5 3.0251e-17
* device instance cc_XD3_XDFFQ_CLKB_mod0 r0 *1 0,0
Ccc_XD3_XDFFQ_CLKB_mod0 XD3_XDFFQ_CLKB mod0 2.4201e-17
* device instance cc_XD3_XDFFQ_CLKB_mod1 r0 *1 0,0
Ccc_XD3_XDFFQ_CLKB_mod1 XD3_XDFFQ_CLKB mod1 2.4201e-17
* device instance cc_XD3_XDFFQ_CLKB_mod2 r0 *1 0,0
Ccc_XD3_XDFFQ_CLKB_mod2 XD3_XDFFQ_CLKB mod2 2.4201e-17
* device instance cc_XD3_XDFFQ_CLKB_mod3 r0 *1 0,0
Ccc_XD3_XDFFQ_CLKB_mod3 XD3_XDFFQ_CLKB mod3 2.4201e-17
* device instance cc_XD3_XDFFQ_CLKB_mod4 r0 *1 0,0
Ccc_XD3_XDFFQ_CLKB_mod4 XD3_XDFFQ_CLKB mod4 2.4201e-17
* device instance cc_XD3_XDFFQ_CLKB_net1 r0 *1 0,0
Ccc_XD3_XDFFQ_CLKB_net1 XD3_XDFFQ_CLKB net1 1.21e-17
* device instance cc_XD3_XDFFQ_M_XD3_XDFFQ_MB r0 *1 0,0
Ccc_XD3_XDFFQ_M_XD3_XDFFQ_MB XD3_XDFFQ_M XD3_XDFFQ_MB 2.4201e-17
* device instance cc_XD3_XDFFQ_M_XD3_XDFFQ_MFB r0 *1 0,0
Ccc_XD3_XDFFQ_M_XD3_XDFFQ_MFB XD3_XDFFQ_M XD3_XDFFQ_MFB 3.4688e-17
* device instance cc_XD3_XDFFQ_M_XD3_XDFFQ_S r0 *1 0,0
Ccc_XD3_XDFFQ_M_XD3_XDFFQ_S XD3_XDFFQ_M XD3_XDFFQ_S 2.8638e-17
* device instance cc_XD3_XDFFQ_M_XD3_XDFFQ_SB r0 *1 0,0
Ccc_XD3_XDFFQ_M_XD3_XDFFQ_SB XD3_XDFFQ_M XD3_XDFFQ_SB 1.8151e-17
* device instance cc_XD3_XDFFQ_M_XD3_XDFFQ_SFB r0 *1 0,0
Ccc_XD3_XDFFQ_M_XD3_XDFFQ_SFB XD3_XDFFQ_M XD3_XDFFQ_SFB 1.21e-17
* device instance cc_XD3_XDFFQ_M_XD3_XN2_mid1 r0 *1 0,0
Ccc_XD3_XDFFQ_M_XD3_XN2_mid1 XD3_XDFFQ_M XD3_XN2_mid1 1.21e-17
* device instance cc_XD3_XDFFQ_M_XD3_XNOR_midp r0 *1 0,0
Ccc_XD3_XDFFQ_M_XD3_XNOR_midp XD3_XDFFQ_M XD3_XNOR_midp 1.21e-17
* device instance cc_XD3_XDFFQ_M_XD3_dmodout r0 *1 0,0
Ccc_XD3_XDFFQ_M_XD3_dmodout XD3_XDFFQ_M XD3_dmodout 1.21e-17
* device instance cc_XD3_XDFFQ_M_XD3_dq r0 *1 0,0
Ccc_XD3_XDFFQ_M_XD3_dq XD3_XDFFQ_M XD3_dq 2.8638e-17
* device instance cc_XD3_XDFFQ_M_XD3_nm r0 *1 0,0
Ccc_XD3_XDFFQ_M_XD3_nm XD3_XDFFQ_M XD3_nm 1.21e-17
* device instance cc_XD3_XDFFQ_M_XD3_nt r0 *1 0,0
Ccc_XD3_XDFFQ_M_XD3_nt XD3_XDFFQ_M XD3_nt 2.4201e-17
* device instance cc_XD3_XDFFQ_M_XD3_t1 r0 *1 0,0
Ccc_XD3_XDFFQ_M_XD3_t1 XD3_XDFFQ_M XD3_t1 1.21e-17
* device instance cc_XD3_XDFFQ_M_XD4_XDFFM_CKBB r0 *1 0,0
Ccc_XD3_XDFFQ_M_XD4_XDFFM_CKBB XD3_XDFFQ_M XD4_XDFFM_CKBB 1.8151e-17
* device instance cc_XD3_XDFFQ_M_XD4_XDFFM_CLKB r0 *1 0,0
Ccc_XD3_XDFFQ_M_XD4_XDFFM_CLKB XD3_XDFFQ_M XD4_XDFFM_CLKB 2.4201e-17
* device instance cc_XD3_XDFFQ_M_XD4_XDFFM_M r0 *1 0,0
Ccc_XD3_XDFFQ_M_XD4_XDFFM_M XD3_XDFFQ_M XD4_XDFFM_M 2.4201e-17
* device instance cc_XD3_XDFFQ_M_XD4_XDFFM_MB r0 *1 0,0
Ccc_XD3_XDFFQ_M_XD4_XDFFM_MB XD3_XDFFQ_M XD4_XDFFM_MB 1.21e-17
* device instance cc_XD3_XDFFQ_M_XD4_XDFFM_MFB r0 *1 0,0
Ccc_XD3_XDFFQ_M_XD4_XDFFM_MFB XD3_XDFFQ_M XD4_XDFFM_MFB 1.21e-17
* device instance cc_XD3_XDFFQ_M_XD4_XDFFM_S r0 *1 0,0
Ccc_XD3_XDFFQ_M_XD4_XDFFM_S XD3_XDFFQ_M XD4_XDFFM_S 1.8151e-17
* device instance cc_XD3_XDFFQ_M_XD4_XDFFM_SB r0 *1 0,0
Ccc_XD3_XDFFQ_M_XD4_XDFFM_SB XD3_XDFFQ_M XD4_XDFFM_SB 1.8151e-17
* device instance cc_XD3_XDFFQ_M_XD4_XDFFM_SFB r0 *1 0,0
Ccc_XD3_XDFFQ_M_XD4_XDFFM_SFB XD3_XDFFQ_M XD4_XDFFM_SFB 1.21e-17
* device instance cc_XD3_XDFFQ_M_XD4_XDFFQ_CKBB r0 *1 0,0
Ccc_XD3_XDFFQ_M_XD4_XDFFQ_CKBB XD3_XDFFQ_M XD4_XDFFQ_CKBB 1.8151e-17
* device instance cc_XD3_XDFFQ_M_XD4_XDFFQ_CLKB r0 *1 0,0
Ccc_XD3_XDFFQ_M_XD4_XDFFQ_CLKB XD3_XDFFQ_M XD4_XDFFQ_CLKB 2.4201e-17
* device instance cc_XD3_XDFFQ_M_XD4_XDFFQ_M r0 *1 0,0
Ccc_XD3_XDFFQ_M_XD4_XDFFQ_M XD3_XDFFQ_M XD4_XDFFQ_M 2.4201e-17
* device instance cc_XD3_XDFFQ_M_XD4_XDFFQ_MB r0 *1 0,0
Ccc_XD3_XDFFQ_M_XD4_XDFFQ_MB XD3_XDFFQ_M XD4_XDFFQ_MB 1.21e-17
* device instance cc_XD3_XDFFQ_M_XD4_XDFFQ_MFB r0 *1 0,0
Ccc_XD3_XDFFQ_M_XD4_XDFFQ_MFB XD3_XDFFQ_M XD4_XDFFQ_MFB 1.21e-17
* device instance cc_XD3_XDFFQ_M_XD4_XDFFQ_S r0 *1 0,0
Ccc_XD3_XDFFQ_M_XD4_XDFFQ_S XD3_XDFFQ_M XD4_XDFFQ_S 1.8151e-17
* device instance cc_XD3_XDFFQ_M_XD4_XDFFQ_SB r0 *1 0,0
Ccc_XD3_XDFFQ_M_XD4_XDFFQ_SB XD3_XDFFQ_M XD4_XDFFQ_SB 1.8151e-17
* device instance cc_XD3_XDFFQ_M_XD4_XDFFQ_SFB r0 *1 0,0
Ccc_XD3_XDFFQ_M_XD4_XDFFQ_SFB XD3_XDFFQ_M XD4_XDFFQ_SFB 1.21e-17
* device instance cc_XD3_XDFFQ_M_XD4_XN2_mid1 r0 *1 0,0
Ccc_XD3_XDFFQ_M_XD4_XN2_mid1 XD3_XDFFQ_M XD4_XN2_mid1 1.21e-17
* device instance cc_XD3_XDFFQ_M_XD4_XN3_mid1 r0 *1 0,0
Ccc_XD3_XDFFQ_M_XD4_XN3_mid1 XD3_XDFFQ_M XD4_XN3_mid1 1.21e-17
* device instance cc_XD3_XDFFQ_M_XD4_XN3_mid2 r0 *1 0,0
Ccc_XD3_XDFFQ_M_XD4_XN3_mid2 XD3_XDFFQ_M XD4_XN3_mid2 1.21e-17
* device instance cc_XD3_XDFFQ_M_XD4_dmodout r0 *1 0,0
Ccc_XD3_XDFFQ_M_XD4_dmodout XD3_XDFFQ_M XD4_dmodout 1.21e-17
* device instance cc_XD3_XDFFQ_M_XD4_dq r0 *1 0,0
Ccc_XD3_XDFFQ_M_XD4_dq XD3_XDFFQ_M XD4_dq 1.8151e-17
* device instance cc_XD3_XDFFQ_M_XD4_nm r0 *1 0,0
Ccc_XD3_XDFFQ_M_XD4_nm XD3_XDFFQ_M XD4_nm 1.21e-17
* device instance cc_XD3_XDFFQ_M_XD4_nt r0 *1 0,0
Ccc_XD3_XDFFQ_M_XD4_nt XD3_XDFFQ_M XD4_nt 1.21e-17
* device instance cc_XD3_XDFFQ_M_XD4_t1 r0 *1 0,0
Ccc_XD3_XDFFQ_M_XD4_t1 XD3_XDFFQ_M XD4_t1 1.21e-17
* device instance cc_XD3_XDFFQ_M_XD5_XDFFM_CKBB r0 *1 0,0
Ccc_XD3_XDFFQ_M_XD5_XDFFM_CKBB XD3_XDFFQ_M XD5_XDFFM_CKBB 1.8151e-17
* device instance cc_XD3_XDFFQ_M_XD5_XDFFM_CLKB r0 *1 0,0
Ccc_XD3_XDFFQ_M_XD5_XDFFM_CLKB XD3_XDFFQ_M XD5_XDFFM_CLKB 2.4201e-17
* device instance cc_XD3_XDFFQ_M_XD5_XDFFM_M r0 *1 0,0
Ccc_XD3_XDFFQ_M_XD5_XDFFM_M XD3_XDFFQ_M XD5_XDFFM_M 2.4201e-17
* device instance cc_XD3_XDFFQ_M_XD5_XDFFM_MB r0 *1 0,0
Ccc_XD3_XDFFQ_M_XD5_XDFFM_MB XD3_XDFFQ_M XD5_XDFFM_MB 1.21e-17
* device instance cc_XD3_XDFFQ_M_XD5_XDFFM_MFB r0 *1 0,0
Ccc_XD3_XDFFQ_M_XD5_XDFFM_MFB XD3_XDFFQ_M XD5_XDFFM_MFB 1.21e-17
* device instance cc_XD3_XDFFQ_M_XD5_XDFFM_S r0 *1 0,0
Ccc_XD3_XDFFQ_M_XD5_XDFFM_S XD3_XDFFQ_M XD5_XDFFM_S 1.8151e-17
* device instance cc_XD3_XDFFQ_M_XD5_XDFFM_SB r0 *1 0,0
Ccc_XD3_XDFFQ_M_XD5_XDFFM_SB XD3_XDFFQ_M XD5_XDFFM_SB 1.8151e-17
* device instance cc_XD3_XDFFQ_M_XD5_XDFFM_SFB r0 *1 0,0
Ccc_XD3_XDFFQ_M_XD5_XDFFM_SFB XD3_XDFFQ_M XD5_XDFFM_SFB 1.21e-17
* device instance cc_XD3_XDFFQ_M_XD5_XDFFQ_CKBB r0 *1 0,0
Ccc_XD3_XDFFQ_M_XD5_XDFFQ_CKBB XD3_XDFFQ_M XD5_XDFFQ_CKBB 1.8151e-17
* device instance cc_XD3_XDFFQ_M_XD5_XDFFQ_CLKB r0 *1 0,0
Ccc_XD3_XDFFQ_M_XD5_XDFFQ_CLKB XD3_XDFFQ_M XD5_XDFFQ_CLKB 2.4201e-17
* device instance cc_XD3_XDFFQ_M_XD5_XDFFQ_M r0 *1 0,0
Ccc_XD3_XDFFQ_M_XD5_XDFFQ_M XD3_XDFFQ_M XD5_XDFFQ_M 2.4201e-17
* device instance cc_XD3_XDFFQ_M_XD5_XDFFQ_MB r0 *1 0,0
Ccc_XD3_XDFFQ_M_XD5_XDFFQ_MB XD3_XDFFQ_M XD5_XDFFQ_MB 1.21e-17
* device instance cc_XD3_XDFFQ_M_XD5_XDFFQ_MFB r0 *1 0,0
Ccc_XD3_XDFFQ_M_XD5_XDFFQ_MFB XD3_XDFFQ_M XD5_XDFFQ_MFB 1.21e-17
* device instance cc_XD3_XDFFQ_M_XD5_XDFFQ_S r0 *1 0,0
Ccc_XD3_XDFFQ_M_XD5_XDFFQ_S XD3_XDFFQ_M XD5_XDFFQ_S 1.8151e-17
* device instance cc_XD3_XDFFQ_M_XD5_XDFFQ_SB r0 *1 0,0
Ccc_XD3_XDFFQ_M_XD5_XDFFQ_SB XD3_XDFFQ_M XD5_XDFFQ_SB 1.8151e-17
* device instance cc_XD3_XDFFQ_M_XD5_XDFFQ_SFB r0 *1 0,0
Ccc_XD3_XDFFQ_M_XD5_XDFFQ_SFB XD3_XDFFQ_M XD5_XDFFQ_SFB 1.21e-17
* device instance cc_XD3_XDFFQ_M_XD5_XN2_mid1 r0 *1 0,0
Ccc_XD3_XDFFQ_M_XD5_XN2_mid1 XD3_XDFFQ_M XD5_XN2_mid1 1.21e-17
* device instance cc_XD3_XDFFQ_M_XD5_XN3_mid1 r0 *1 0,0
Ccc_XD3_XDFFQ_M_XD5_XN3_mid1 XD3_XDFFQ_M XD5_XN3_mid1 1.21e-17
* device instance cc_XD3_XDFFQ_M_XD5_XN3_mid2 r0 *1 0,0
Ccc_XD3_XDFFQ_M_XD5_XN3_mid2 XD3_XDFFQ_M XD5_XN3_mid2 1.21e-17
* device instance cc_XD3_XDFFQ_M_XD5_dmodout r0 *1 0,0
Ccc_XD3_XDFFQ_M_XD5_dmodout XD3_XDFFQ_M XD5_dmodout 1.21e-17
* device instance cc_XD3_XDFFQ_M_XD5_dq r0 *1 0,0
Ccc_XD3_XDFFQ_M_XD5_dq XD3_XDFFQ_M XD5_dq 1.8151e-17
* device instance cc_XD3_XDFFQ_M_XD5_nm r0 *1 0,0
Ccc_XD3_XDFFQ_M_XD5_nm XD3_XDFFQ_M XD5_nm 1.21e-17
* device instance cc_XD3_XDFFQ_M_XD5_nt r0 *1 0,0
Ccc_XD3_XDFFQ_M_XD5_nt XD3_XDFFQ_M XD5_nt 1.21e-17
* device instance cc_XD3_XDFFQ_M_XD5_t1 r0 *1 0,0
Ccc_XD3_XDFFQ_M_XD5_t1 XD3_XDFFQ_M XD5_t1 1.21e-17
* device instance cc_XD3_XDFFQ_M_XFRT_CKBB r0 *1 0,0
Ccc_XD3_XDFFQ_M_XFRT_CKBB XD3_XDFFQ_M XFRT_CKBB 1.8151e-17
* device instance cc_XD3_XDFFQ_M_XFRT_CLKB r0 *1 0,0
Ccc_XD3_XDFFQ_M_XFRT_CLKB XD3_XDFFQ_M XFRT_CLKB 2.4201e-17
* device instance cc_XD3_XDFFQ_M_XFRT_M r0 *1 0,0
Ccc_XD3_XDFFQ_M_XFRT_M XD3_XDFFQ_M XFRT_M 2.4201e-17
* device instance cc_XD3_XDFFQ_M_XFRT_MB r0 *1 0,0
Ccc_XD3_XDFFQ_M_XFRT_MB XD3_XDFFQ_M XFRT_MB 1.21e-17
* device instance cc_XD3_XDFFQ_M_XFRT_MFB r0 *1 0,0
Ccc_XD3_XDFFQ_M_XFRT_MFB XD3_XDFFQ_M XFRT_MFB 1.21e-17
* device instance cc_XD3_XDFFQ_M_XFRT_S r0 *1 0,0
Ccc_XD3_XDFFQ_M_XFRT_S XD3_XDFFQ_M XFRT_S 1.8151e-17
* device instance cc_XD3_XDFFQ_M_XFRT_SB r0 *1 0,0
Ccc_XD3_XDFFQ_M_XFRT_SB XD3_XDFFQ_M XFRT_SB 1.8151e-17
* device instance cc_XD3_XDFFQ_M_XFRT_SFB r0 *1 0,0
Ccc_XD3_XDFFQ_M_XFRT_SFB XD3_XDFFQ_M XFRT_SFB 1.21e-17
* device instance cc_XD3_XDFFQ_M_ck1 r0 *1 0,0
Ccc_XD3_XDFFQ_M_ck1 XD3_XDFFQ_M ck1 3.0251e-17
* device instance cc_XD3_XDFFQ_M_ck2 r0 *1 0,0
Ccc_XD3_XDFFQ_M_ck2 XD3_XDFFQ_M ck2 3.0251e-17
* device instance cc_XD3_XDFFQ_M_ck3 r0 *1 0,0
Ccc_XD3_XDFFQ_M_ck3 XD3_XDFFQ_M ck3 3.0251e-17
* device instance cc_XD3_XDFFQ_M_ck4 r0 *1 0,0
Ccc_XD3_XDFFQ_M_ck4 XD3_XDFFQ_M ck4 3.0251e-17
* device instance cc_XD3_XDFFQ_M_ck5 r0 *1 0,0
Ccc_XD3_XDFFQ_M_ck5 XD3_XDFFQ_M ck5 3.0251e-17
* device instance cc_XD3_XDFFQ_M_mod0 r0 *1 0,0
Ccc_XD3_XDFFQ_M_mod0 XD3_XDFFQ_M mod0 2.4201e-17
* device instance cc_XD3_XDFFQ_M_mod1 r0 *1 0,0
Ccc_XD3_XDFFQ_M_mod1 XD3_XDFFQ_M mod1 2.4201e-17
* device instance cc_XD3_XDFFQ_M_mod2 r0 *1 0,0
Ccc_XD3_XDFFQ_M_mod2 XD3_XDFFQ_M mod2 2.4201e-17
* device instance cc_XD3_XDFFQ_M_mod3 r0 *1 0,0
Ccc_XD3_XDFFQ_M_mod3 XD3_XDFFQ_M mod3 2.4201e-17
* device instance cc_XD3_XDFFQ_M_mod4 r0 *1 0,0
Ccc_XD3_XDFFQ_M_mod4 XD3_XDFFQ_M mod4 2.4201e-17
* device instance cc_XD3_XDFFQ_M_net1 r0 *1 0,0
Ccc_XD3_XDFFQ_M_net1 XD3_XDFFQ_M net1 1.21e-17
* device instance cc_XD3_XDFFQ_MB_XD3_XDFFQ_MFB r0 *1 0,0
Ccc_XD3_XDFFQ_MB_XD3_XDFFQ_MFB XD3_XDFFQ_MB XD3_XDFFQ_MFB 1.21e-17
* device instance cc_XD3_XDFFQ_MB_XD3_XDFFQ_S r0 *1 0,0
Ccc_XD3_XDFFQ_MB_XD3_XDFFQ_S XD3_XDFFQ_MB XD3_XDFFQ_S 1.8151e-17
* device instance cc_XD3_XDFFQ_MB_XD3_XDFFQ_SB r0 *1 0,0
Ccc_XD3_XDFFQ_MB_XD3_XDFFQ_SB XD3_XDFFQ_MB XD3_XDFFQ_SB 1.8151e-17
* device instance cc_XD3_XDFFQ_MB_XD3_XDFFQ_SFB r0 *1 0,0
Ccc_XD3_XDFFQ_MB_XD3_XDFFQ_SFB XD3_XDFFQ_MB XD3_XDFFQ_SFB 1.21e-17
* device instance cc_XD3_XDFFQ_MB_XD3_XN2_mid1 r0 *1 0,0
Ccc_XD3_XDFFQ_MB_XD3_XN2_mid1 XD3_XDFFQ_MB XD3_XN2_mid1 1.21e-17
* device instance cc_XD3_XDFFQ_MB_XD3_XNOR_midp r0 *1 0,0
Ccc_XD3_XDFFQ_MB_XD3_XNOR_midp XD3_XDFFQ_MB XD3_XNOR_midp 1.21e-17
* device instance cc_XD3_XDFFQ_MB_XD3_dmodout r0 *1 0,0
Ccc_XD3_XDFFQ_MB_XD3_dmodout XD3_XDFFQ_MB XD3_dmodout 1.21e-17
* device instance cc_XD3_XDFFQ_MB_XD3_dq r0 *1 0,0
Ccc_XD3_XDFFQ_MB_XD3_dq XD3_XDFFQ_MB XD3_dq 1.21e-17
* device instance cc_XD3_XDFFQ_MB_XD3_nm r0 *1 0,0
Ccc_XD3_XDFFQ_MB_XD3_nm XD3_XDFFQ_MB XD3_nm 1.21e-17
* device instance cc_XD3_XDFFQ_MB_XD3_nt r0 *1 0,0
Ccc_XD3_XDFFQ_MB_XD3_nt XD3_XDFFQ_MB XD3_nt 2.4201e-17
* device instance cc_XD3_XDFFQ_MB_XD3_t1 r0 *1 0,0
Ccc_XD3_XDFFQ_MB_XD3_t1 XD3_XDFFQ_MB XD3_t1 1.21e-17
* device instance cc_XD3_XDFFQ_MB_XD4_XDFFM_CKBB r0 *1 0,0
Ccc_XD3_XDFFQ_MB_XD4_XDFFM_CKBB XD3_XDFFQ_MB XD4_XDFFM_CKBB 1.8151e-17
* device instance cc_XD3_XDFFQ_MB_XD4_XDFFM_CLKB r0 *1 0,0
Ccc_XD3_XDFFQ_MB_XD4_XDFFM_CLKB XD3_XDFFQ_MB XD4_XDFFM_CLKB 2.4201e-17
* device instance cc_XD3_XDFFQ_MB_XD4_XDFFM_M r0 *1 0,0
Ccc_XD3_XDFFQ_MB_XD4_XDFFM_M XD3_XDFFQ_MB XD4_XDFFM_M 2.4201e-17
* device instance cc_XD3_XDFFQ_MB_XD4_XDFFM_MB r0 *1 0,0
Ccc_XD3_XDFFQ_MB_XD4_XDFFM_MB XD3_XDFFQ_MB XD4_XDFFM_MB 1.21e-17
* device instance cc_XD3_XDFFQ_MB_XD4_XDFFM_MFB r0 *1 0,0
Ccc_XD3_XDFFQ_MB_XD4_XDFFM_MFB XD3_XDFFQ_MB XD4_XDFFM_MFB 1.21e-17
* device instance cc_XD3_XDFFQ_MB_XD4_XDFFM_S r0 *1 0,0
Ccc_XD3_XDFFQ_MB_XD4_XDFFM_S XD3_XDFFQ_MB XD4_XDFFM_S 1.8151e-17
* device instance cc_XD3_XDFFQ_MB_XD4_XDFFM_SB r0 *1 0,0
Ccc_XD3_XDFFQ_MB_XD4_XDFFM_SB XD3_XDFFQ_MB XD4_XDFFM_SB 1.8151e-17
* device instance cc_XD3_XDFFQ_MB_XD4_XDFFM_SFB r0 *1 0,0
Ccc_XD3_XDFFQ_MB_XD4_XDFFM_SFB XD3_XDFFQ_MB XD4_XDFFM_SFB 1.21e-17
* device instance cc_XD3_XDFFQ_MB_XD4_XDFFQ_CKBB r0 *1 0,0
Ccc_XD3_XDFFQ_MB_XD4_XDFFQ_CKBB XD3_XDFFQ_MB XD4_XDFFQ_CKBB 1.8151e-17
* device instance cc_XD3_XDFFQ_MB_XD4_XDFFQ_CLKB r0 *1 0,0
Ccc_XD3_XDFFQ_MB_XD4_XDFFQ_CLKB XD3_XDFFQ_MB XD4_XDFFQ_CLKB 2.4201e-17
* device instance cc_XD3_XDFFQ_MB_XD4_XDFFQ_M r0 *1 0,0
Ccc_XD3_XDFFQ_MB_XD4_XDFFQ_M XD3_XDFFQ_MB XD4_XDFFQ_M 2.4201e-17
* device instance cc_XD3_XDFFQ_MB_XD4_XDFFQ_MB r0 *1 0,0
Ccc_XD3_XDFFQ_MB_XD4_XDFFQ_MB XD3_XDFFQ_MB XD4_XDFFQ_MB 1.21e-17
* device instance cc_XD3_XDFFQ_MB_XD4_XDFFQ_MFB r0 *1 0,0
Ccc_XD3_XDFFQ_MB_XD4_XDFFQ_MFB XD3_XDFFQ_MB XD4_XDFFQ_MFB 1.21e-17
* device instance cc_XD3_XDFFQ_MB_XD4_XDFFQ_S r0 *1 0,0
Ccc_XD3_XDFFQ_MB_XD4_XDFFQ_S XD3_XDFFQ_MB XD4_XDFFQ_S 1.8151e-17
* device instance cc_XD3_XDFFQ_MB_XD4_XDFFQ_SB r0 *1 0,0
Ccc_XD3_XDFFQ_MB_XD4_XDFFQ_SB XD3_XDFFQ_MB XD4_XDFFQ_SB 1.8151e-17
* device instance cc_XD3_XDFFQ_MB_XD4_XDFFQ_SFB r0 *1 0,0
Ccc_XD3_XDFFQ_MB_XD4_XDFFQ_SFB XD3_XDFFQ_MB XD4_XDFFQ_SFB 1.21e-17
* device instance cc_XD3_XDFFQ_MB_XD4_XN2_mid1 r0 *1 0,0
Ccc_XD3_XDFFQ_MB_XD4_XN2_mid1 XD3_XDFFQ_MB XD4_XN2_mid1 1.21e-17
* device instance cc_XD3_XDFFQ_MB_XD4_XN3_mid1 r0 *1 0,0
Ccc_XD3_XDFFQ_MB_XD4_XN3_mid1 XD3_XDFFQ_MB XD4_XN3_mid1 1.21e-17
* device instance cc_XD3_XDFFQ_MB_XD4_XN3_mid2 r0 *1 0,0
Ccc_XD3_XDFFQ_MB_XD4_XN3_mid2 XD3_XDFFQ_MB XD4_XN3_mid2 1.21e-17
* device instance cc_XD3_XDFFQ_MB_XD4_dmodout r0 *1 0,0
Ccc_XD3_XDFFQ_MB_XD4_dmodout XD3_XDFFQ_MB XD4_dmodout 1.21e-17
* device instance cc_XD3_XDFFQ_MB_XD4_dq r0 *1 0,0
Ccc_XD3_XDFFQ_MB_XD4_dq XD3_XDFFQ_MB XD4_dq 1.8151e-17
* device instance cc_XD3_XDFFQ_MB_XD4_nm r0 *1 0,0
Ccc_XD3_XDFFQ_MB_XD4_nm XD3_XDFFQ_MB XD4_nm 1.21e-17
* device instance cc_XD3_XDFFQ_MB_XD4_nt r0 *1 0,0
Ccc_XD3_XDFFQ_MB_XD4_nt XD3_XDFFQ_MB XD4_nt 1.21e-17
* device instance cc_XD3_XDFFQ_MB_XD4_t1 r0 *1 0,0
Ccc_XD3_XDFFQ_MB_XD4_t1 XD3_XDFFQ_MB XD4_t1 1.21e-17
* device instance cc_XD3_XDFFQ_MB_XD5_XDFFM_CKBB r0 *1 0,0
Ccc_XD3_XDFFQ_MB_XD5_XDFFM_CKBB XD3_XDFFQ_MB XD5_XDFFM_CKBB 1.8151e-17
* device instance cc_XD3_XDFFQ_MB_XD5_XDFFM_CLKB r0 *1 0,0
Ccc_XD3_XDFFQ_MB_XD5_XDFFM_CLKB XD3_XDFFQ_MB XD5_XDFFM_CLKB 2.4201e-17
* device instance cc_XD3_XDFFQ_MB_XD5_XDFFM_M r0 *1 0,0
Ccc_XD3_XDFFQ_MB_XD5_XDFFM_M XD3_XDFFQ_MB XD5_XDFFM_M 2.4201e-17
* device instance cc_XD3_XDFFQ_MB_XD5_XDFFM_MB r0 *1 0,0
Ccc_XD3_XDFFQ_MB_XD5_XDFFM_MB XD3_XDFFQ_MB XD5_XDFFM_MB 1.21e-17
* device instance cc_XD3_XDFFQ_MB_XD5_XDFFM_MFB r0 *1 0,0
Ccc_XD3_XDFFQ_MB_XD5_XDFFM_MFB XD3_XDFFQ_MB XD5_XDFFM_MFB 1.21e-17
* device instance cc_XD3_XDFFQ_MB_XD5_XDFFM_S r0 *1 0,0
Ccc_XD3_XDFFQ_MB_XD5_XDFFM_S XD3_XDFFQ_MB XD5_XDFFM_S 1.8151e-17
* device instance cc_XD3_XDFFQ_MB_XD5_XDFFM_SB r0 *1 0,0
Ccc_XD3_XDFFQ_MB_XD5_XDFFM_SB XD3_XDFFQ_MB XD5_XDFFM_SB 1.8151e-17
* device instance cc_XD3_XDFFQ_MB_XD5_XDFFM_SFB r0 *1 0,0
Ccc_XD3_XDFFQ_MB_XD5_XDFFM_SFB XD3_XDFFQ_MB XD5_XDFFM_SFB 1.21e-17
* device instance cc_XD3_XDFFQ_MB_XD5_XDFFQ_CKBB r0 *1 0,0
Ccc_XD3_XDFFQ_MB_XD5_XDFFQ_CKBB XD3_XDFFQ_MB XD5_XDFFQ_CKBB 1.8151e-17
* device instance cc_XD3_XDFFQ_MB_XD5_XDFFQ_CLKB r0 *1 0,0
Ccc_XD3_XDFFQ_MB_XD5_XDFFQ_CLKB XD3_XDFFQ_MB XD5_XDFFQ_CLKB 2.4201e-17
* device instance cc_XD3_XDFFQ_MB_XD5_XDFFQ_M r0 *1 0,0
Ccc_XD3_XDFFQ_MB_XD5_XDFFQ_M XD3_XDFFQ_MB XD5_XDFFQ_M 2.4201e-17
* device instance cc_XD3_XDFFQ_MB_XD5_XDFFQ_MB r0 *1 0,0
Ccc_XD3_XDFFQ_MB_XD5_XDFFQ_MB XD3_XDFFQ_MB XD5_XDFFQ_MB 1.21e-17
* device instance cc_XD3_XDFFQ_MB_XD5_XDFFQ_MFB r0 *1 0,0
Ccc_XD3_XDFFQ_MB_XD5_XDFFQ_MFB XD3_XDFFQ_MB XD5_XDFFQ_MFB 1.21e-17
* device instance cc_XD3_XDFFQ_MB_XD5_XDFFQ_S r0 *1 0,0
Ccc_XD3_XDFFQ_MB_XD5_XDFFQ_S XD3_XDFFQ_MB XD5_XDFFQ_S 1.8151e-17
* device instance cc_XD3_XDFFQ_MB_XD5_XDFFQ_SB r0 *1 0,0
Ccc_XD3_XDFFQ_MB_XD5_XDFFQ_SB XD3_XDFFQ_MB XD5_XDFFQ_SB 1.8151e-17
* device instance cc_XD3_XDFFQ_MB_XD5_XDFFQ_SFB r0 *1 0,0
Ccc_XD3_XDFFQ_MB_XD5_XDFFQ_SFB XD3_XDFFQ_MB XD5_XDFFQ_SFB 1.21e-17
* device instance cc_XD3_XDFFQ_MB_XD5_XN2_mid1 r0 *1 0,0
Ccc_XD3_XDFFQ_MB_XD5_XN2_mid1 XD3_XDFFQ_MB XD5_XN2_mid1 1.21e-17
* device instance cc_XD3_XDFFQ_MB_XD5_XN3_mid1 r0 *1 0,0
Ccc_XD3_XDFFQ_MB_XD5_XN3_mid1 XD3_XDFFQ_MB XD5_XN3_mid1 1.21e-17
* device instance cc_XD3_XDFFQ_MB_XD5_XN3_mid2 r0 *1 0,0
Ccc_XD3_XDFFQ_MB_XD5_XN3_mid2 XD3_XDFFQ_MB XD5_XN3_mid2 1.21e-17
* device instance cc_XD3_XDFFQ_MB_XD5_dmodout r0 *1 0,0
Ccc_XD3_XDFFQ_MB_XD5_dmodout XD3_XDFFQ_MB XD5_dmodout 1.21e-17
* device instance cc_XD3_XDFFQ_MB_XD5_dq r0 *1 0,0
Ccc_XD3_XDFFQ_MB_XD5_dq XD3_XDFFQ_MB XD5_dq 1.8151e-17
* device instance cc_XD3_XDFFQ_MB_XD5_nm r0 *1 0,0
Ccc_XD3_XDFFQ_MB_XD5_nm XD3_XDFFQ_MB XD5_nm 1.21e-17
* device instance cc_XD3_XDFFQ_MB_XD5_nt r0 *1 0,0
Ccc_XD3_XDFFQ_MB_XD5_nt XD3_XDFFQ_MB XD5_nt 1.21e-17
* device instance cc_XD3_XDFFQ_MB_XD5_t1 r0 *1 0,0
Ccc_XD3_XDFFQ_MB_XD5_t1 XD3_XDFFQ_MB XD5_t1 1.21e-17
* device instance cc_XD3_XDFFQ_MB_XFRT_CKBB r0 *1 0,0
Ccc_XD3_XDFFQ_MB_XFRT_CKBB XD3_XDFFQ_MB XFRT_CKBB 1.8151e-17
* device instance cc_XD3_XDFFQ_MB_XFRT_CLKB r0 *1 0,0
Ccc_XD3_XDFFQ_MB_XFRT_CLKB XD3_XDFFQ_MB XFRT_CLKB 2.4201e-17
* device instance cc_XD3_XDFFQ_MB_XFRT_M r0 *1 0,0
Ccc_XD3_XDFFQ_MB_XFRT_M XD3_XDFFQ_MB XFRT_M 2.4201e-17
* device instance cc_XD3_XDFFQ_MB_XFRT_MB r0 *1 0,0
Ccc_XD3_XDFFQ_MB_XFRT_MB XD3_XDFFQ_MB XFRT_MB 1.21e-17
* device instance cc_XD3_XDFFQ_MB_XFRT_MFB r0 *1 0,0
Ccc_XD3_XDFFQ_MB_XFRT_MFB XD3_XDFFQ_MB XFRT_MFB 1.21e-17
* device instance cc_XD3_XDFFQ_MB_XFRT_S r0 *1 0,0
Ccc_XD3_XDFFQ_MB_XFRT_S XD3_XDFFQ_MB XFRT_S 1.8151e-17
* device instance cc_XD3_XDFFQ_MB_XFRT_SB r0 *1 0,0
Ccc_XD3_XDFFQ_MB_XFRT_SB XD3_XDFFQ_MB XFRT_SB 1.8151e-17
* device instance cc_XD3_XDFFQ_MB_XFRT_SFB r0 *1 0,0
Ccc_XD3_XDFFQ_MB_XFRT_SFB XD3_XDFFQ_MB XFRT_SFB 1.21e-17
* device instance cc_XD3_XDFFQ_MB_ck1 r0 *1 0,0
Ccc_XD3_XDFFQ_MB_ck1 XD3_XDFFQ_MB ck1 3.0251e-17
* device instance cc_XD3_XDFFQ_MB_ck2 r0 *1 0,0
Ccc_XD3_XDFFQ_MB_ck2 XD3_XDFFQ_MB ck2 3.0251e-17
* device instance cc_XD3_XDFFQ_MB_ck3 r0 *1 0,0
Ccc_XD3_XDFFQ_MB_ck3 XD3_XDFFQ_MB ck3 3.0251e-17
* device instance cc_XD3_XDFFQ_MB_ck4 r0 *1 0,0
Ccc_XD3_XDFFQ_MB_ck4 XD3_XDFFQ_MB ck4 3.0251e-17
* device instance cc_XD3_XDFFQ_MB_ck5 r0 *1 0,0
Ccc_XD3_XDFFQ_MB_ck5 XD3_XDFFQ_MB ck5 3.0251e-17
* device instance cc_XD3_XDFFQ_MB_mod0 r0 *1 0,0
Ccc_XD3_XDFFQ_MB_mod0 XD3_XDFFQ_MB mod0 2.4201e-17
* device instance cc_XD3_XDFFQ_MB_mod1 r0 *1 0,0
Ccc_XD3_XDFFQ_MB_mod1 XD3_XDFFQ_MB mod1 2.4201e-17
* device instance cc_XD3_XDFFQ_MB_mod2 r0 *1 0,0
Ccc_XD3_XDFFQ_MB_mod2 XD3_XDFFQ_MB mod2 2.4201e-17
* device instance cc_XD3_XDFFQ_MB_mod3 r0 *1 0,0
Ccc_XD3_XDFFQ_MB_mod3 XD3_XDFFQ_MB mod3 2.4201e-17
* device instance cc_XD3_XDFFQ_MB_mod4 r0 *1 0,0
Ccc_XD3_XDFFQ_MB_mod4 XD3_XDFFQ_MB mod4 2.4201e-17
* device instance cc_XD3_XDFFQ_MB_net1 r0 *1 0,0
Ccc_XD3_XDFFQ_MB_net1 XD3_XDFFQ_MB net1 1.21e-17
* device instance cc_XD3_XDFFQ_MFB_XD3_XDFFQ_S r0 *1 0,0
Ccc_XD3_XDFFQ_MFB_XD3_XDFFQ_S XD3_XDFFQ_MFB XD3_XDFFQ_S 1.8151e-17
* device instance cc_XD3_XDFFQ_MFB_XD3_XDFFQ_SB r0 *1 0,0
Ccc_XD3_XDFFQ_MFB_XD3_XDFFQ_SB XD3_XDFFQ_MFB XD3_XDFFQ_SB 1.8151e-17
* device instance cc_XD3_XDFFQ_MFB_XD3_XDFFQ_SFB r0 *1 0,0
Ccc_XD3_XDFFQ_MFB_XD3_XDFFQ_SFB XD3_XDFFQ_MFB XD3_XDFFQ_SFB 1.21e-17
* device instance cc_XD3_XDFFQ_MFB_XD3_XN2_mid1 r0 *1 0,0
Ccc_XD3_XDFFQ_MFB_XD3_XN2_mid1 XD3_XDFFQ_MFB XD3_XN2_mid1 1.21e-17
* device instance cc_XD3_XDFFQ_MFB_XD3_XNOR_midp r0 *1 0,0
Ccc_XD3_XDFFQ_MFB_XD3_XNOR_midp XD3_XDFFQ_MFB XD3_XNOR_midp 1.21e-17
* device instance cc_XD3_XDFFQ_MFB_XD3_dmodout r0 *1 0,0
Ccc_XD3_XDFFQ_MFB_XD3_dmodout XD3_XDFFQ_MFB XD3_dmodout 1.21e-17
* device instance cc_XD3_XDFFQ_MFB_XD3_dq r0 *1 0,0
Ccc_XD3_XDFFQ_MFB_XD3_dq XD3_XDFFQ_MFB XD3_dq 1.21e-17
* device instance cc_XD3_XDFFQ_MFB_XD3_nm r0 *1 0,0
Ccc_XD3_XDFFQ_MFB_XD3_nm XD3_XDFFQ_MFB XD3_nm 1.21e-17
* device instance cc_XD3_XDFFQ_MFB_XD3_nt r0 *1 0,0
Ccc_XD3_XDFFQ_MFB_XD3_nt XD3_XDFFQ_MFB XD3_nt 2.4201e-17
* device instance cc_XD3_XDFFQ_MFB_XD3_t1 r0 *1 0,0
Ccc_XD3_XDFFQ_MFB_XD3_t1 XD3_XDFFQ_MFB XD3_t1 1.21e-17
* device instance cc_XD3_XDFFQ_MFB_XD4_XDFFM_CKBB r0 *1 0,0
Ccc_XD3_XDFFQ_MFB_XD4_XDFFM_CKBB XD3_XDFFQ_MFB XD4_XDFFM_CKBB 1.8151e-17
* device instance cc_XD3_XDFFQ_MFB_XD4_XDFFM_CLKB r0 *1 0,0
Ccc_XD3_XDFFQ_MFB_XD4_XDFFM_CLKB XD3_XDFFQ_MFB XD4_XDFFM_CLKB 2.4201e-17
* device instance cc_XD3_XDFFQ_MFB_XD4_XDFFM_M r0 *1 0,0
Ccc_XD3_XDFFQ_MFB_XD4_XDFFM_M XD3_XDFFQ_MFB XD4_XDFFM_M 2.4201e-17
* device instance cc_XD3_XDFFQ_MFB_XD4_XDFFM_MB r0 *1 0,0
Ccc_XD3_XDFFQ_MFB_XD4_XDFFM_MB XD3_XDFFQ_MFB XD4_XDFFM_MB 1.21e-17
* device instance cc_XD3_XDFFQ_MFB_XD4_XDFFM_MFB r0 *1 0,0
Ccc_XD3_XDFFQ_MFB_XD4_XDFFM_MFB XD3_XDFFQ_MFB XD4_XDFFM_MFB 1.21e-17
* device instance cc_XD3_XDFFQ_MFB_XD4_XDFFM_S r0 *1 0,0
Ccc_XD3_XDFFQ_MFB_XD4_XDFFM_S XD3_XDFFQ_MFB XD4_XDFFM_S 1.8151e-17
* device instance cc_XD3_XDFFQ_MFB_XD4_XDFFM_SB r0 *1 0,0
Ccc_XD3_XDFFQ_MFB_XD4_XDFFM_SB XD3_XDFFQ_MFB XD4_XDFFM_SB 1.8151e-17
* device instance cc_XD3_XDFFQ_MFB_XD4_XDFFM_SFB r0 *1 0,0
Ccc_XD3_XDFFQ_MFB_XD4_XDFFM_SFB XD3_XDFFQ_MFB XD4_XDFFM_SFB 1.21e-17
* device instance cc_XD3_XDFFQ_MFB_XD4_XDFFQ_CKBB r0 *1 0,0
Ccc_XD3_XDFFQ_MFB_XD4_XDFFQ_CKBB XD3_XDFFQ_MFB XD4_XDFFQ_CKBB 1.8151e-17
* device instance cc_XD3_XDFFQ_MFB_XD4_XDFFQ_CLKB r0 *1 0,0
Ccc_XD3_XDFFQ_MFB_XD4_XDFFQ_CLKB XD3_XDFFQ_MFB XD4_XDFFQ_CLKB 2.4201e-17
* device instance cc_XD3_XDFFQ_MFB_XD4_XDFFQ_M r0 *1 0,0
Ccc_XD3_XDFFQ_MFB_XD4_XDFFQ_M XD3_XDFFQ_MFB XD4_XDFFQ_M 2.4201e-17
* device instance cc_XD3_XDFFQ_MFB_XD4_XDFFQ_MB r0 *1 0,0
Ccc_XD3_XDFFQ_MFB_XD4_XDFFQ_MB XD3_XDFFQ_MFB XD4_XDFFQ_MB 1.21e-17
* device instance cc_XD3_XDFFQ_MFB_XD4_XDFFQ_MFB r0 *1 0,0
Ccc_XD3_XDFFQ_MFB_XD4_XDFFQ_MFB XD3_XDFFQ_MFB XD4_XDFFQ_MFB 1.21e-17
* device instance cc_XD3_XDFFQ_MFB_XD4_XDFFQ_S r0 *1 0,0
Ccc_XD3_XDFFQ_MFB_XD4_XDFFQ_S XD3_XDFFQ_MFB XD4_XDFFQ_S 1.8151e-17
* device instance cc_XD3_XDFFQ_MFB_XD4_XDFFQ_SB r0 *1 0,0
Ccc_XD3_XDFFQ_MFB_XD4_XDFFQ_SB XD3_XDFFQ_MFB XD4_XDFFQ_SB 1.8151e-17
* device instance cc_XD3_XDFFQ_MFB_XD4_XDFFQ_SFB r0 *1 0,0
Ccc_XD3_XDFFQ_MFB_XD4_XDFFQ_SFB XD3_XDFFQ_MFB XD4_XDFFQ_SFB 1.21e-17
* device instance cc_XD3_XDFFQ_MFB_XD4_XN2_mid1 r0 *1 0,0
Ccc_XD3_XDFFQ_MFB_XD4_XN2_mid1 XD3_XDFFQ_MFB XD4_XN2_mid1 1.21e-17
* device instance cc_XD3_XDFFQ_MFB_XD4_XN3_mid1 r0 *1 0,0
Ccc_XD3_XDFFQ_MFB_XD4_XN3_mid1 XD3_XDFFQ_MFB XD4_XN3_mid1 1.21e-17
* device instance cc_XD3_XDFFQ_MFB_XD4_XN3_mid2 r0 *1 0,0
Ccc_XD3_XDFFQ_MFB_XD4_XN3_mid2 XD3_XDFFQ_MFB XD4_XN3_mid2 1.21e-17
* device instance cc_XD3_XDFFQ_MFB_XD4_dmodout r0 *1 0,0
Ccc_XD3_XDFFQ_MFB_XD4_dmodout XD3_XDFFQ_MFB XD4_dmodout 1.21e-17
* device instance cc_XD3_XDFFQ_MFB_XD4_dq r0 *1 0,0
Ccc_XD3_XDFFQ_MFB_XD4_dq XD3_XDFFQ_MFB XD4_dq 1.8151e-17
* device instance cc_XD3_XDFFQ_MFB_XD4_nm r0 *1 0,0
Ccc_XD3_XDFFQ_MFB_XD4_nm XD3_XDFFQ_MFB XD4_nm 1.21e-17
* device instance cc_XD3_XDFFQ_MFB_XD4_nt r0 *1 0,0
Ccc_XD3_XDFFQ_MFB_XD4_nt XD3_XDFFQ_MFB XD4_nt 1.21e-17
* device instance cc_XD3_XDFFQ_MFB_XD4_t1 r0 *1 0,0
Ccc_XD3_XDFFQ_MFB_XD4_t1 XD3_XDFFQ_MFB XD4_t1 1.21e-17
* device instance cc_XD3_XDFFQ_MFB_XD5_XDFFM_CKBB r0 *1 0,0
Ccc_XD3_XDFFQ_MFB_XD5_XDFFM_CKBB XD3_XDFFQ_MFB XD5_XDFFM_CKBB 1.8151e-17
* device instance cc_XD3_XDFFQ_MFB_XD5_XDFFM_CLKB r0 *1 0,0
Ccc_XD3_XDFFQ_MFB_XD5_XDFFM_CLKB XD3_XDFFQ_MFB XD5_XDFFM_CLKB 2.4201e-17
* device instance cc_XD3_XDFFQ_MFB_XD5_XDFFM_M r0 *1 0,0
Ccc_XD3_XDFFQ_MFB_XD5_XDFFM_M XD3_XDFFQ_MFB XD5_XDFFM_M 2.4201e-17
* device instance cc_XD3_XDFFQ_MFB_XD5_XDFFM_MB r0 *1 0,0
Ccc_XD3_XDFFQ_MFB_XD5_XDFFM_MB XD3_XDFFQ_MFB XD5_XDFFM_MB 1.21e-17
* device instance cc_XD3_XDFFQ_MFB_XD5_XDFFM_MFB r0 *1 0,0
Ccc_XD3_XDFFQ_MFB_XD5_XDFFM_MFB XD3_XDFFQ_MFB XD5_XDFFM_MFB 1.21e-17
* device instance cc_XD3_XDFFQ_MFB_XD5_XDFFM_S r0 *1 0,0
Ccc_XD3_XDFFQ_MFB_XD5_XDFFM_S XD3_XDFFQ_MFB XD5_XDFFM_S 1.8151e-17
* device instance cc_XD3_XDFFQ_MFB_XD5_XDFFM_SB r0 *1 0,0
Ccc_XD3_XDFFQ_MFB_XD5_XDFFM_SB XD3_XDFFQ_MFB XD5_XDFFM_SB 1.8151e-17
* device instance cc_XD3_XDFFQ_MFB_XD5_XDFFM_SFB r0 *1 0,0
Ccc_XD3_XDFFQ_MFB_XD5_XDFFM_SFB XD3_XDFFQ_MFB XD5_XDFFM_SFB 1.21e-17
* device instance cc_XD3_XDFFQ_MFB_XD5_XDFFQ_CKBB r0 *1 0,0
Ccc_XD3_XDFFQ_MFB_XD5_XDFFQ_CKBB XD3_XDFFQ_MFB XD5_XDFFQ_CKBB 1.8151e-17
* device instance cc_XD3_XDFFQ_MFB_XD5_XDFFQ_CLKB r0 *1 0,0
Ccc_XD3_XDFFQ_MFB_XD5_XDFFQ_CLKB XD3_XDFFQ_MFB XD5_XDFFQ_CLKB 2.4201e-17
* device instance cc_XD3_XDFFQ_MFB_XD5_XDFFQ_M r0 *1 0,0
Ccc_XD3_XDFFQ_MFB_XD5_XDFFQ_M XD3_XDFFQ_MFB XD5_XDFFQ_M 2.4201e-17
* device instance cc_XD3_XDFFQ_MFB_XD5_XDFFQ_MB r0 *1 0,0
Ccc_XD3_XDFFQ_MFB_XD5_XDFFQ_MB XD3_XDFFQ_MFB XD5_XDFFQ_MB 1.21e-17
* device instance cc_XD3_XDFFQ_MFB_XD5_XDFFQ_MFB r0 *1 0,0
Ccc_XD3_XDFFQ_MFB_XD5_XDFFQ_MFB XD3_XDFFQ_MFB XD5_XDFFQ_MFB 1.21e-17
* device instance cc_XD3_XDFFQ_MFB_XD5_XDFFQ_S r0 *1 0,0
Ccc_XD3_XDFFQ_MFB_XD5_XDFFQ_S XD3_XDFFQ_MFB XD5_XDFFQ_S 1.8151e-17
* device instance cc_XD3_XDFFQ_MFB_XD5_XDFFQ_SB r0 *1 0,0
Ccc_XD3_XDFFQ_MFB_XD5_XDFFQ_SB XD3_XDFFQ_MFB XD5_XDFFQ_SB 1.8151e-17
* device instance cc_XD3_XDFFQ_MFB_XD5_XDFFQ_SFB r0 *1 0,0
Ccc_XD3_XDFFQ_MFB_XD5_XDFFQ_SFB XD3_XDFFQ_MFB XD5_XDFFQ_SFB 1.21e-17
* device instance cc_XD3_XDFFQ_MFB_XD5_XN2_mid1 r0 *1 0,0
Ccc_XD3_XDFFQ_MFB_XD5_XN2_mid1 XD3_XDFFQ_MFB XD5_XN2_mid1 1.21e-17
* device instance cc_XD3_XDFFQ_MFB_XD5_XN3_mid1 r0 *1 0,0
Ccc_XD3_XDFFQ_MFB_XD5_XN3_mid1 XD3_XDFFQ_MFB XD5_XN3_mid1 1.21e-17
* device instance cc_XD3_XDFFQ_MFB_XD5_XN3_mid2 r0 *1 0,0
Ccc_XD3_XDFFQ_MFB_XD5_XN3_mid2 XD3_XDFFQ_MFB XD5_XN3_mid2 1.21e-17
* device instance cc_XD3_XDFFQ_MFB_XD5_dmodout r0 *1 0,0
Ccc_XD3_XDFFQ_MFB_XD5_dmodout XD3_XDFFQ_MFB XD5_dmodout 1.21e-17
* device instance cc_XD3_XDFFQ_MFB_XD5_dq r0 *1 0,0
Ccc_XD3_XDFFQ_MFB_XD5_dq XD3_XDFFQ_MFB XD5_dq 1.8151e-17
* device instance cc_XD3_XDFFQ_MFB_XD5_nm r0 *1 0,0
Ccc_XD3_XDFFQ_MFB_XD5_nm XD3_XDFFQ_MFB XD5_nm 1.21e-17
* device instance cc_XD3_XDFFQ_MFB_XD5_nt r0 *1 0,0
Ccc_XD3_XDFFQ_MFB_XD5_nt XD3_XDFFQ_MFB XD5_nt 1.21e-17
* device instance cc_XD3_XDFFQ_MFB_XD5_t1 r0 *1 0,0
Ccc_XD3_XDFFQ_MFB_XD5_t1 XD3_XDFFQ_MFB XD5_t1 1.21e-17
* device instance cc_XD3_XDFFQ_MFB_XFRT_CKBB r0 *1 0,0
Ccc_XD3_XDFFQ_MFB_XFRT_CKBB XD3_XDFFQ_MFB XFRT_CKBB 1.8151e-17
* device instance cc_XD3_XDFFQ_MFB_XFRT_CLKB r0 *1 0,0
Ccc_XD3_XDFFQ_MFB_XFRT_CLKB XD3_XDFFQ_MFB XFRT_CLKB 2.4201e-17
* device instance cc_XD3_XDFFQ_MFB_XFRT_M r0 *1 0,0
Ccc_XD3_XDFFQ_MFB_XFRT_M XD3_XDFFQ_MFB XFRT_M 2.4201e-17
* device instance cc_XD3_XDFFQ_MFB_XFRT_MB r0 *1 0,0
Ccc_XD3_XDFFQ_MFB_XFRT_MB XD3_XDFFQ_MFB XFRT_MB 1.21e-17
* device instance cc_XD3_XDFFQ_MFB_XFRT_MFB r0 *1 0,0
Ccc_XD3_XDFFQ_MFB_XFRT_MFB XD3_XDFFQ_MFB XFRT_MFB 1.21e-17
* device instance cc_XD3_XDFFQ_MFB_XFRT_S r0 *1 0,0
Ccc_XD3_XDFFQ_MFB_XFRT_S XD3_XDFFQ_MFB XFRT_S 1.8151e-17
* device instance cc_XD3_XDFFQ_MFB_XFRT_SB r0 *1 0,0
Ccc_XD3_XDFFQ_MFB_XFRT_SB XD3_XDFFQ_MFB XFRT_SB 1.8151e-17
* device instance cc_XD3_XDFFQ_MFB_XFRT_SFB r0 *1 0,0
Ccc_XD3_XDFFQ_MFB_XFRT_SFB XD3_XDFFQ_MFB XFRT_SFB 1.21e-17
* device instance cc_XD3_XDFFQ_MFB_ck1 r0 *1 0,0
Ccc_XD3_XDFFQ_MFB_ck1 XD3_XDFFQ_MFB ck1 3.0251e-17
* device instance cc_XD3_XDFFQ_MFB_ck2 r0 *1 0,0
Ccc_XD3_XDFFQ_MFB_ck2 XD3_XDFFQ_MFB ck2 3.0251e-17
* device instance cc_XD3_XDFFQ_MFB_ck3 r0 *1 0,0
Ccc_XD3_XDFFQ_MFB_ck3 XD3_XDFFQ_MFB ck3 3.0251e-17
* device instance cc_XD3_XDFFQ_MFB_ck4 r0 *1 0,0
Ccc_XD3_XDFFQ_MFB_ck4 XD3_XDFFQ_MFB ck4 3.0251e-17
* device instance cc_XD3_XDFFQ_MFB_ck5 r0 *1 0,0
Ccc_XD3_XDFFQ_MFB_ck5 XD3_XDFFQ_MFB ck5 3.0251e-17
* device instance cc_XD3_XDFFQ_MFB_mod0 r0 *1 0,0
Ccc_XD3_XDFFQ_MFB_mod0 XD3_XDFFQ_MFB mod0 2.4201e-17
* device instance cc_XD3_XDFFQ_MFB_mod1 r0 *1 0,0
Ccc_XD3_XDFFQ_MFB_mod1 XD3_XDFFQ_MFB mod1 2.4201e-17
* device instance cc_XD3_XDFFQ_MFB_mod2 r0 *1 0,0
Ccc_XD3_XDFFQ_MFB_mod2 XD3_XDFFQ_MFB mod2 2.4201e-17
* device instance cc_XD3_XDFFQ_MFB_mod3 r0 *1 0,0
Ccc_XD3_XDFFQ_MFB_mod3 XD3_XDFFQ_MFB mod3 2.4201e-17
* device instance cc_XD3_XDFFQ_MFB_mod4 r0 *1 0,0
Ccc_XD3_XDFFQ_MFB_mod4 XD3_XDFFQ_MFB mod4 2.4201e-17
* device instance cc_XD3_XDFFQ_MFB_net1 r0 *1 0,0
Ccc_XD3_XDFFQ_MFB_net1 XD3_XDFFQ_MFB net1 1.21e-17
* device instance cc_XD3_XDFFQ_S_XD3_XDFFQ_SB r0 *1 0,0
Ccc_XD3_XDFFQ_S_XD3_XDFFQ_SB XD3_XDFFQ_S XD3_XDFFQ_SB 3.0251e-17
* device instance cc_XD3_XDFFQ_S_XD3_XDFFQ_SFB r0 *1 0,0
Ccc_XD3_XDFFQ_S_XD3_XDFFQ_SFB XD3_XDFFQ_S XD3_XDFFQ_SFB 3.4688e-17
* device instance cc_XD3_XDFFQ_S_XD3_XN2_mid1 r0 *1 0,0
Ccc_XD3_XDFFQ_S_XD3_XN2_mid1 XD3_XDFFQ_S XD3_XN2_mid1 1.21e-17
* device instance cc_XD3_XDFFQ_S_XD3_XNOR_midp r0 *1 0,0
Ccc_XD3_XDFFQ_S_XD3_XNOR_midp XD3_XDFFQ_S XD3_XNOR_midp 1.21e-17
* device instance cc_XD3_XDFFQ_S_XD3_dmodout r0 *1 0,0
Ccc_XD3_XDFFQ_S_XD3_dmodout XD3_XDFFQ_S XD3_dmodout 1.21e-17
* device instance cc_XD3_XDFFQ_S_XD3_dq r0 *1 0,0
Ccc_XD3_XDFFQ_S_XD3_dq XD3_XDFFQ_S XD3_dq 1.21e-17
* device instance cc_XD3_XDFFQ_S_XD3_nm r0 *1 0,0
Ccc_XD3_XDFFQ_S_XD3_nm XD3_XDFFQ_S XD3_nm 1.21e-17
* device instance cc_XD3_XDFFQ_S_XD3_nt r0 *1 0,0
Ccc_XD3_XDFFQ_S_XD3_nt XD3_XDFFQ_S XD3_nt 2.4201e-17
* device instance cc_XD3_XDFFQ_S_XD3_t1 r0 *1 0,0
Ccc_XD3_XDFFQ_S_XD3_t1 XD3_XDFFQ_S XD3_t1 1.21e-17
* device instance cc_XD3_XDFFQ_S_XD4_XDFFM_CKBB r0 *1 0,0
Ccc_XD3_XDFFQ_S_XD4_XDFFM_CKBB XD3_XDFFQ_S XD4_XDFFM_CKBB 1.8151e-17
* device instance cc_XD3_XDFFQ_S_XD4_XDFFM_CLKB r0 *1 0,0
Ccc_XD3_XDFFQ_S_XD4_XDFFM_CLKB XD3_XDFFQ_S XD4_XDFFM_CLKB 2.4201e-17
* device instance cc_XD3_XDFFQ_S_XD4_XDFFM_M r0 *1 0,0
Ccc_XD3_XDFFQ_S_XD4_XDFFM_M XD3_XDFFQ_S XD4_XDFFM_M 2.4201e-17
* device instance cc_XD3_XDFFQ_S_XD4_XDFFM_MB r0 *1 0,0
Ccc_XD3_XDFFQ_S_XD4_XDFFM_MB XD3_XDFFQ_S XD4_XDFFM_MB 1.21e-17
* device instance cc_XD3_XDFFQ_S_XD4_XDFFM_MFB r0 *1 0,0
Ccc_XD3_XDFFQ_S_XD4_XDFFM_MFB XD3_XDFFQ_S XD4_XDFFM_MFB 1.21e-17
* device instance cc_XD3_XDFFQ_S_XD4_XDFFM_S r0 *1 0,0
Ccc_XD3_XDFFQ_S_XD4_XDFFM_S XD3_XDFFQ_S XD4_XDFFM_S 1.8151e-17
* device instance cc_XD3_XDFFQ_S_XD4_XDFFM_SB r0 *1 0,0
Ccc_XD3_XDFFQ_S_XD4_XDFFM_SB XD3_XDFFQ_S XD4_XDFFM_SB 1.8151e-17
* device instance cc_XD3_XDFFQ_S_XD4_XDFFM_SFB r0 *1 0,0
Ccc_XD3_XDFFQ_S_XD4_XDFFM_SFB XD3_XDFFQ_S XD4_XDFFM_SFB 1.21e-17
* device instance cc_XD3_XDFFQ_S_XD4_XDFFQ_CKBB r0 *1 0,0
Ccc_XD3_XDFFQ_S_XD4_XDFFQ_CKBB XD3_XDFFQ_S XD4_XDFFQ_CKBB 1.8151e-17
* device instance cc_XD3_XDFFQ_S_XD4_XDFFQ_CLKB r0 *1 0,0
Ccc_XD3_XDFFQ_S_XD4_XDFFQ_CLKB XD3_XDFFQ_S XD4_XDFFQ_CLKB 2.4201e-17
* device instance cc_XD3_XDFFQ_S_XD4_XDFFQ_M r0 *1 0,0
Ccc_XD3_XDFFQ_S_XD4_XDFFQ_M XD3_XDFFQ_S XD4_XDFFQ_M 2.4201e-17
* device instance cc_XD3_XDFFQ_S_XD4_XDFFQ_MB r0 *1 0,0
Ccc_XD3_XDFFQ_S_XD4_XDFFQ_MB XD3_XDFFQ_S XD4_XDFFQ_MB 1.21e-17
* device instance cc_XD3_XDFFQ_S_XD4_XDFFQ_MFB r0 *1 0,0
Ccc_XD3_XDFFQ_S_XD4_XDFFQ_MFB XD3_XDFFQ_S XD4_XDFFQ_MFB 1.21e-17
* device instance cc_XD3_XDFFQ_S_XD4_XDFFQ_S r0 *1 0,0
Ccc_XD3_XDFFQ_S_XD4_XDFFQ_S XD3_XDFFQ_S XD4_XDFFQ_S 1.8151e-17
* device instance cc_XD3_XDFFQ_S_XD4_XDFFQ_SB r0 *1 0,0
Ccc_XD3_XDFFQ_S_XD4_XDFFQ_SB XD3_XDFFQ_S XD4_XDFFQ_SB 1.8151e-17
* device instance cc_XD3_XDFFQ_S_XD4_XDFFQ_SFB r0 *1 0,0
Ccc_XD3_XDFFQ_S_XD4_XDFFQ_SFB XD3_XDFFQ_S XD4_XDFFQ_SFB 1.21e-17
* device instance cc_XD3_XDFFQ_S_XD4_XN2_mid1 r0 *1 0,0
Ccc_XD3_XDFFQ_S_XD4_XN2_mid1 XD3_XDFFQ_S XD4_XN2_mid1 1.21e-17
* device instance cc_XD3_XDFFQ_S_XD4_XN3_mid1 r0 *1 0,0
Ccc_XD3_XDFFQ_S_XD4_XN3_mid1 XD3_XDFFQ_S XD4_XN3_mid1 1.21e-17
* device instance cc_XD3_XDFFQ_S_XD4_XN3_mid2 r0 *1 0,0
Ccc_XD3_XDFFQ_S_XD4_XN3_mid2 XD3_XDFFQ_S XD4_XN3_mid2 1.21e-17
* device instance cc_XD3_XDFFQ_S_XD4_dmodout r0 *1 0,0
Ccc_XD3_XDFFQ_S_XD4_dmodout XD3_XDFFQ_S XD4_dmodout 1.21e-17
* device instance cc_XD3_XDFFQ_S_XD4_dq r0 *1 0,0
Ccc_XD3_XDFFQ_S_XD4_dq XD3_XDFFQ_S XD4_dq 1.8151e-17
* device instance cc_XD3_XDFFQ_S_XD4_nm r0 *1 0,0
Ccc_XD3_XDFFQ_S_XD4_nm XD3_XDFFQ_S XD4_nm 1.21e-17
* device instance cc_XD3_XDFFQ_S_XD4_nt r0 *1 0,0
Ccc_XD3_XDFFQ_S_XD4_nt XD3_XDFFQ_S XD4_nt 1.21e-17
* device instance cc_XD3_XDFFQ_S_XD4_t1 r0 *1 0,0
Ccc_XD3_XDFFQ_S_XD4_t1 XD3_XDFFQ_S XD4_t1 1.21e-17
* device instance cc_XD3_XDFFQ_S_XD5_XDFFM_CKBB r0 *1 0,0
Ccc_XD3_XDFFQ_S_XD5_XDFFM_CKBB XD3_XDFFQ_S XD5_XDFFM_CKBB 1.8151e-17
* device instance cc_XD3_XDFFQ_S_XD5_XDFFM_CLKB r0 *1 0,0
Ccc_XD3_XDFFQ_S_XD5_XDFFM_CLKB XD3_XDFFQ_S XD5_XDFFM_CLKB 2.4201e-17
* device instance cc_XD3_XDFFQ_S_XD5_XDFFM_M r0 *1 0,0
Ccc_XD3_XDFFQ_S_XD5_XDFFM_M XD3_XDFFQ_S XD5_XDFFM_M 2.4201e-17
* device instance cc_XD3_XDFFQ_S_XD5_XDFFM_MB r0 *1 0,0
Ccc_XD3_XDFFQ_S_XD5_XDFFM_MB XD3_XDFFQ_S XD5_XDFFM_MB 1.21e-17
* device instance cc_XD3_XDFFQ_S_XD5_XDFFM_MFB r0 *1 0,0
Ccc_XD3_XDFFQ_S_XD5_XDFFM_MFB XD3_XDFFQ_S XD5_XDFFM_MFB 1.21e-17
* device instance cc_XD3_XDFFQ_S_XD5_XDFFM_S r0 *1 0,0
Ccc_XD3_XDFFQ_S_XD5_XDFFM_S XD3_XDFFQ_S XD5_XDFFM_S 1.8151e-17
* device instance cc_XD3_XDFFQ_S_XD5_XDFFM_SB r0 *1 0,0
Ccc_XD3_XDFFQ_S_XD5_XDFFM_SB XD3_XDFFQ_S XD5_XDFFM_SB 1.8151e-17
* device instance cc_XD3_XDFFQ_S_XD5_XDFFM_SFB r0 *1 0,0
Ccc_XD3_XDFFQ_S_XD5_XDFFM_SFB XD3_XDFFQ_S XD5_XDFFM_SFB 1.21e-17
* device instance cc_XD3_XDFFQ_S_XD5_XDFFQ_CKBB r0 *1 0,0
Ccc_XD3_XDFFQ_S_XD5_XDFFQ_CKBB XD3_XDFFQ_S XD5_XDFFQ_CKBB 1.8151e-17
* device instance cc_XD3_XDFFQ_S_XD5_XDFFQ_CLKB r0 *1 0,0
Ccc_XD3_XDFFQ_S_XD5_XDFFQ_CLKB XD3_XDFFQ_S XD5_XDFFQ_CLKB 2.4201e-17
* device instance cc_XD3_XDFFQ_S_XD5_XDFFQ_M r0 *1 0,0
Ccc_XD3_XDFFQ_S_XD5_XDFFQ_M XD3_XDFFQ_S XD5_XDFFQ_M 2.4201e-17
* device instance cc_XD3_XDFFQ_S_XD5_XDFFQ_MB r0 *1 0,0
Ccc_XD3_XDFFQ_S_XD5_XDFFQ_MB XD3_XDFFQ_S XD5_XDFFQ_MB 1.21e-17
* device instance cc_XD3_XDFFQ_S_XD5_XDFFQ_MFB r0 *1 0,0
Ccc_XD3_XDFFQ_S_XD5_XDFFQ_MFB XD3_XDFFQ_S XD5_XDFFQ_MFB 1.21e-17
* device instance cc_XD3_XDFFQ_S_XD5_XDFFQ_S r0 *1 0,0
Ccc_XD3_XDFFQ_S_XD5_XDFFQ_S XD3_XDFFQ_S XD5_XDFFQ_S 1.8151e-17
* device instance cc_XD3_XDFFQ_S_XD5_XDFFQ_SB r0 *1 0,0
Ccc_XD3_XDFFQ_S_XD5_XDFFQ_SB XD3_XDFFQ_S XD5_XDFFQ_SB 1.8151e-17
* device instance cc_XD3_XDFFQ_S_XD5_XDFFQ_SFB r0 *1 0,0
Ccc_XD3_XDFFQ_S_XD5_XDFFQ_SFB XD3_XDFFQ_S XD5_XDFFQ_SFB 1.21e-17
* device instance cc_XD3_XDFFQ_S_XD5_XN2_mid1 r0 *1 0,0
Ccc_XD3_XDFFQ_S_XD5_XN2_mid1 XD3_XDFFQ_S XD5_XN2_mid1 1.21e-17
* device instance cc_XD3_XDFFQ_S_XD5_XN3_mid1 r0 *1 0,0
Ccc_XD3_XDFFQ_S_XD5_XN3_mid1 XD3_XDFFQ_S XD5_XN3_mid1 1.21e-17
* device instance cc_XD3_XDFFQ_S_XD5_XN3_mid2 r0 *1 0,0
Ccc_XD3_XDFFQ_S_XD5_XN3_mid2 XD3_XDFFQ_S XD5_XN3_mid2 1.21e-17
* device instance cc_XD3_XDFFQ_S_XD5_dmodout r0 *1 0,0
Ccc_XD3_XDFFQ_S_XD5_dmodout XD3_XDFFQ_S XD5_dmodout 1.21e-17
* device instance cc_XD3_XDFFQ_S_XD5_dq r0 *1 0,0
Ccc_XD3_XDFFQ_S_XD5_dq XD3_XDFFQ_S XD5_dq 1.8151e-17
* device instance cc_XD3_XDFFQ_S_XD5_nm r0 *1 0,0
Ccc_XD3_XDFFQ_S_XD5_nm XD3_XDFFQ_S XD5_nm 1.21e-17
* device instance cc_XD3_XDFFQ_S_XD5_nt r0 *1 0,0
Ccc_XD3_XDFFQ_S_XD5_nt XD3_XDFFQ_S XD5_nt 1.21e-17
* device instance cc_XD3_XDFFQ_S_XD5_t1 r0 *1 0,0
Ccc_XD3_XDFFQ_S_XD5_t1 XD3_XDFFQ_S XD5_t1 1.21e-17
* device instance cc_XD3_XDFFQ_S_XFRT_CKBB r0 *1 0,0
Ccc_XD3_XDFFQ_S_XFRT_CKBB XD3_XDFFQ_S XFRT_CKBB 1.8151e-17
* device instance cc_XD3_XDFFQ_S_XFRT_CLKB r0 *1 0,0
Ccc_XD3_XDFFQ_S_XFRT_CLKB XD3_XDFFQ_S XFRT_CLKB 2.4201e-17
* device instance cc_XD3_XDFFQ_S_XFRT_M r0 *1 0,0
Ccc_XD3_XDFFQ_S_XFRT_M XD3_XDFFQ_S XFRT_M 2.4201e-17
* device instance cc_XD3_XDFFQ_S_XFRT_MB r0 *1 0,0
Ccc_XD3_XDFFQ_S_XFRT_MB XD3_XDFFQ_S XFRT_MB 1.21e-17
* device instance cc_XD3_XDFFQ_S_XFRT_MFB r0 *1 0,0
Ccc_XD3_XDFFQ_S_XFRT_MFB XD3_XDFFQ_S XFRT_MFB 1.21e-17
* device instance cc_XD3_XDFFQ_S_XFRT_S r0 *1 0,0
Ccc_XD3_XDFFQ_S_XFRT_S XD3_XDFFQ_S XFRT_S 1.8151e-17
* device instance cc_XD3_XDFFQ_S_XFRT_SB r0 *1 0,0
Ccc_XD3_XDFFQ_S_XFRT_SB XD3_XDFFQ_S XFRT_SB 1.8151e-17
* device instance cc_XD3_XDFFQ_S_XFRT_SFB r0 *1 0,0
Ccc_XD3_XDFFQ_S_XFRT_SFB XD3_XDFFQ_S XFRT_SFB 1.21e-17
* device instance cc_XD3_XDFFQ_S_ck1 r0 *1 0,0
Ccc_XD3_XDFFQ_S_ck1 XD3_XDFFQ_S ck1 3.0251e-17
* device instance cc_XD3_XDFFQ_S_ck2 r0 *1 0,0
Ccc_XD3_XDFFQ_S_ck2 XD3_XDFFQ_S ck2 3.0251e-17
* device instance cc_XD3_XDFFQ_S_ck3 r0 *1 0,0
Ccc_XD3_XDFFQ_S_ck3 XD3_XDFFQ_S ck3 3.0251e-17
* device instance cc_XD3_XDFFQ_S_ck4 r0 *1 0,0
Ccc_XD3_XDFFQ_S_ck4 XD3_XDFFQ_S ck4 3.0251e-17
* device instance cc_XD3_XDFFQ_S_ck5 r0 *1 0,0
Ccc_XD3_XDFFQ_S_ck5 XD3_XDFFQ_S ck5 3.0251e-17
* device instance cc_XD3_XDFFQ_S_mod0 r0 *1 0,0
Ccc_XD3_XDFFQ_S_mod0 XD3_XDFFQ_S mod0 2.4201e-17
* device instance cc_XD3_XDFFQ_S_mod1 r0 *1 0,0
Ccc_XD3_XDFFQ_S_mod1 XD3_XDFFQ_S mod1 2.4201e-17
* device instance cc_XD3_XDFFQ_S_mod2 r0 *1 0,0
Ccc_XD3_XDFFQ_S_mod2 XD3_XDFFQ_S mod2 2.4201e-17
* device instance cc_XD3_XDFFQ_S_mod3 r0 *1 0,0
Ccc_XD3_XDFFQ_S_mod3 XD3_XDFFQ_S mod3 2.4201e-17
* device instance cc_XD3_XDFFQ_S_mod4 r0 *1 0,0
Ccc_XD3_XDFFQ_S_mod4 XD3_XDFFQ_S mod4 2.4201e-17
* device instance cc_XD3_XDFFQ_S_net1 r0 *1 0,0
Ccc_XD3_XDFFQ_S_net1 XD3_XDFFQ_S net1 1.21e-17
* device instance cc_XD3_XDFFQ_SB_XD3_XDFFQ_SFB r0 *1 0,0
Ccc_XD3_XDFFQ_SB_XD3_XDFFQ_SFB XD3_XDFFQ_SB XD3_XDFFQ_SFB 2.4201e-17
* device instance cc_XD3_XDFFQ_SB_XD3_XN2_mid1 r0 *1 0,0
Ccc_XD3_XDFFQ_SB_XD3_XN2_mid1 XD3_XDFFQ_SB XD3_XN2_mid1 1.21e-17
* device instance cc_XD3_XDFFQ_SB_XD3_XNOR_midp r0 *1 0,0
Ccc_XD3_XDFFQ_SB_XD3_XNOR_midp XD3_XDFFQ_SB XD3_XNOR_midp 1.21e-17
* device instance cc_XD3_XDFFQ_SB_XD3_dmodout r0 *1 0,0
Ccc_XD3_XDFFQ_SB_XD3_dmodout XD3_XDFFQ_SB XD3_dmodout 1.21e-17
* device instance cc_XD3_XDFFQ_SB_XD3_dq r0 *1 0,0
Ccc_XD3_XDFFQ_SB_XD3_dq XD3_XDFFQ_SB XD3_dq 1.21e-17
* device instance cc_XD3_XDFFQ_SB_XD3_nm r0 *1 0,0
Ccc_XD3_XDFFQ_SB_XD3_nm XD3_XDFFQ_SB XD3_nm 1.21e-17
* device instance cc_XD3_XDFFQ_SB_XD3_nt r0 *1 0,0
Ccc_XD3_XDFFQ_SB_XD3_nt XD3_XDFFQ_SB XD3_nt 2.4201e-17
* device instance cc_XD3_XDFFQ_SB_XD3_t1 r0 *1 0,0
Ccc_XD3_XDFFQ_SB_XD3_t1 XD3_XDFFQ_SB XD3_t1 1.21e-17
* device instance cc_XD3_XDFFQ_SB_XD4_XDFFM_CKBB r0 *1 0,0
Ccc_XD3_XDFFQ_SB_XD4_XDFFM_CKBB XD3_XDFFQ_SB XD4_XDFFM_CKBB 1.8151e-17
* device instance cc_XD3_XDFFQ_SB_XD4_XDFFM_CLKB r0 *1 0,0
Ccc_XD3_XDFFQ_SB_XD4_XDFFM_CLKB XD3_XDFFQ_SB XD4_XDFFM_CLKB 2.4201e-17
* device instance cc_XD3_XDFFQ_SB_XD4_XDFFM_M r0 *1 0,0
Ccc_XD3_XDFFQ_SB_XD4_XDFFM_M XD3_XDFFQ_SB XD4_XDFFM_M 2.4201e-17
* device instance cc_XD3_XDFFQ_SB_XD4_XDFFM_MB r0 *1 0,0
Ccc_XD3_XDFFQ_SB_XD4_XDFFM_MB XD3_XDFFQ_SB XD4_XDFFM_MB 1.21e-17
* device instance cc_XD3_XDFFQ_SB_XD4_XDFFM_MFB r0 *1 0,0
Ccc_XD3_XDFFQ_SB_XD4_XDFFM_MFB XD3_XDFFQ_SB XD4_XDFFM_MFB 1.21e-17
* device instance cc_XD3_XDFFQ_SB_XD4_XDFFM_S r0 *1 0,0
Ccc_XD3_XDFFQ_SB_XD4_XDFFM_S XD3_XDFFQ_SB XD4_XDFFM_S 1.8151e-17
* device instance cc_XD3_XDFFQ_SB_XD4_XDFFM_SB r0 *1 0,0
Ccc_XD3_XDFFQ_SB_XD4_XDFFM_SB XD3_XDFFQ_SB XD4_XDFFM_SB 1.8151e-17
* device instance cc_XD3_XDFFQ_SB_XD4_XDFFM_SFB r0 *1 0,0
Ccc_XD3_XDFFQ_SB_XD4_XDFFM_SFB XD3_XDFFQ_SB XD4_XDFFM_SFB 1.21e-17
* device instance cc_XD3_XDFFQ_SB_XD4_XDFFQ_CKBB r0 *1 0,0
Ccc_XD3_XDFFQ_SB_XD4_XDFFQ_CKBB XD3_XDFFQ_SB XD4_XDFFQ_CKBB 1.8151e-17
* device instance cc_XD3_XDFFQ_SB_XD4_XDFFQ_CLKB r0 *1 0,0
Ccc_XD3_XDFFQ_SB_XD4_XDFFQ_CLKB XD3_XDFFQ_SB XD4_XDFFQ_CLKB 2.4201e-17
* device instance cc_XD3_XDFFQ_SB_XD4_XDFFQ_M r0 *1 0,0
Ccc_XD3_XDFFQ_SB_XD4_XDFFQ_M XD3_XDFFQ_SB XD4_XDFFQ_M 2.4201e-17
* device instance cc_XD3_XDFFQ_SB_XD4_XDFFQ_MB r0 *1 0,0
Ccc_XD3_XDFFQ_SB_XD4_XDFFQ_MB XD3_XDFFQ_SB XD4_XDFFQ_MB 1.21e-17
* device instance cc_XD3_XDFFQ_SB_XD4_XDFFQ_MFB r0 *1 0,0
Ccc_XD3_XDFFQ_SB_XD4_XDFFQ_MFB XD3_XDFFQ_SB XD4_XDFFQ_MFB 1.21e-17
* device instance cc_XD3_XDFFQ_SB_XD4_XDFFQ_S r0 *1 0,0
Ccc_XD3_XDFFQ_SB_XD4_XDFFQ_S XD3_XDFFQ_SB XD4_XDFFQ_S 1.8151e-17
* device instance cc_XD3_XDFFQ_SB_XD4_XDFFQ_SB r0 *1 0,0
Ccc_XD3_XDFFQ_SB_XD4_XDFFQ_SB XD3_XDFFQ_SB XD4_XDFFQ_SB 1.8151e-17
* device instance cc_XD3_XDFFQ_SB_XD4_XDFFQ_SFB r0 *1 0,0
Ccc_XD3_XDFFQ_SB_XD4_XDFFQ_SFB XD3_XDFFQ_SB XD4_XDFFQ_SFB 1.21e-17
* device instance cc_XD3_XDFFQ_SB_XD4_XN2_mid1 r0 *1 0,0
Ccc_XD3_XDFFQ_SB_XD4_XN2_mid1 XD3_XDFFQ_SB XD4_XN2_mid1 1.21e-17
* device instance cc_XD3_XDFFQ_SB_XD4_XN3_mid1 r0 *1 0,0
Ccc_XD3_XDFFQ_SB_XD4_XN3_mid1 XD3_XDFFQ_SB XD4_XN3_mid1 1.21e-17
* device instance cc_XD3_XDFFQ_SB_XD4_XN3_mid2 r0 *1 0,0
Ccc_XD3_XDFFQ_SB_XD4_XN3_mid2 XD3_XDFFQ_SB XD4_XN3_mid2 1.21e-17
* device instance cc_XD3_XDFFQ_SB_XD4_dmodout r0 *1 0,0
Ccc_XD3_XDFFQ_SB_XD4_dmodout XD3_XDFFQ_SB XD4_dmodout 1.21e-17
* device instance cc_XD3_XDFFQ_SB_XD4_dq r0 *1 0,0
Ccc_XD3_XDFFQ_SB_XD4_dq XD3_XDFFQ_SB XD4_dq 1.8151e-17
* device instance cc_XD3_XDFFQ_SB_XD4_nm r0 *1 0,0
Ccc_XD3_XDFFQ_SB_XD4_nm XD3_XDFFQ_SB XD4_nm 1.21e-17
* device instance cc_XD3_XDFFQ_SB_XD4_nt r0 *1 0,0
Ccc_XD3_XDFFQ_SB_XD4_nt XD3_XDFFQ_SB XD4_nt 1.21e-17
* device instance cc_XD3_XDFFQ_SB_XD4_t1 r0 *1 0,0
Ccc_XD3_XDFFQ_SB_XD4_t1 XD3_XDFFQ_SB XD4_t1 1.21e-17
* device instance cc_XD3_XDFFQ_SB_XD5_XDFFM_CKBB r0 *1 0,0
Ccc_XD3_XDFFQ_SB_XD5_XDFFM_CKBB XD3_XDFFQ_SB XD5_XDFFM_CKBB 1.8151e-17
* device instance cc_XD3_XDFFQ_SB_XD5_XDFFM_CLKB r0 *1 0,0
Ccc_XD3_XDFFQ_SB_XD5_XDFFM_CLKB XD3_XDFFQ_SB XD5_XDFFM_CLKB 2.4201e-17
* device instance cc_XD3_XDFFQ_SB_XD5_XDFFM_M r0 *1 0,0
Ccc_XD3_XDFFQ_SB_XD5_XDFFM_M XD3_XDFFQ_SB XD5_XDFFM_M 2.4201e-17
* device instance cc_XD3_XDFFQ_SB_XD5_XDFFM_MB r0 *1 0,0
Ccc_XD3_XDFFQ_SB_XD5_XDFFM_MB XD3_XDFFQ_SB XD5_XDFFM_MB 1.21e-17
* device instance cc_XD3_XDFFQ_SB_XD5_XDFFM_MFB r0 *1 0,0
Ccc_XD3_XDFFQ_SB_XD5_XDFFM_MFB XD3_XDFFQ_SB XD5_XDFFM_MFB 1.21e-17
* device instance cc_XD3_XDFFQ_SB_XD5_XDFFM_S r0 *1 0,0
Ccc_XD3_XDFFQ_SB_XD5_XDFFM_S XD3_XDFFQ_SB XD5_XDFFM_S 1.8151e-17
* device instance cc_XD3_XDFFQ_SB_XD5_XDFFM_SB r0 *1 0,0
Ccc_XD3_XDFFQ_SB_XD5_XDFFM_SB XD3_XDFFQ_SB XD5_XDFFM_SB 1.8151e-17
* device instance cc_XD3_XDFFQ_SB_XD5_XDFFM_SFB r0 *1 0,0
Ccc_XD3_XDFFQ_SB_XD5_XDFFM_SFB XD3_XDFFQ_SB XD5_XDFFM_SFB 1.21e-17
* device instance cc_XD3_XDFFQ_SB_XD5_XDFFQ_CKBB r0 *1 0,0
Ccc_XD3_XDFFQ_SB_XD5_XDFFQ_CKBB XD3_XDFFQ_SB XD5_XDFFQ_CKBB 1.8151e-17
* device instance cc_XD3_XDFFQ_SB_XD5_XDFFQ_CLKB r0 *1 0,0
Ccc_XD3_XDFFQ_SB_XD5_XDFFQ_CLKB XD3_XDFFQ_SB XD5_XDFFQ_CLKB 2.4201e-17
* device instance cc_XD3_XDFFQ_SB_XD5_XDFFQ_M r0 *1 0,0
Ccc_XD3_XDFFQ_SB_XD5_XDFFQ_M XD3_XDFFQ_SB XD5_XDFFQ_M 2.4201e-17
* device instance cc_XD3_XDFFQ_SB_XD5_XDFFQ_MB r0 *1 0,0
Ccc_XD3_XDFFQ_SB_XD5_XDFFQ_MB XD3_XDFFQ_SB XD5_XDFFQ_MB 1.21e-17
* device instance cc_XD3_XDFFQ_SB_XD5_XDFFQ_MFB r0 *1 0,0
Ccc_XD3_XDFFQ_SB_XD5_XDFFQ_MFB XD3_XDFFQ_SB XD5_XDFFQ_MFB 1.21e-17
* device instance cc_XD3_XDFFQ_SB_XD5_XDFFQ_S r0 *1 0,0
Ccc_XD3_XDFFQ_SB_XD5_XDFFQ_S XD3_XDFFQ_SB XD5_XDFFQ_S 1.8151e-17
* device instance cc_XD3_XDFFQ_SB_XD5_XDFFQ_SB r0 *1 0,0
Ccc_XD3_XDFFQ_SB_XD5_XDFFQ_SB XD3_XDFFQ_SB XD5_XDFFQ_SB 1.8151e-17
* device instance cc_XD3_XDFFQ_SB_XD5_XDFFQ_SFB r0 *1 0,0
Ccc_XD3_XDFFQ_SB_XD5_XDFFQ_SFB XD3_XDFFQ_SB XD5_XDFFQ_SFB 1.21e-17
* device instance cc_XD3_XDFFQ_SB_XD5_XN2_mid1 r0 *1 0,0
Ccc_XD3_XDFFQ_SB_XD5_XN2_mid1 XD3_XDFFQ_SB XD5_XN2_mid1 1.21e-17
* device instance cc_XD3_XDFFQ_SB_XD5_XN3_mid1 r0 *1 0,0
Ccc_XD3_XDFFQ_SB_XD5_XN3_mid1 XD3_XDFFQ_SB XD5_XN3_mid1 1.21e-17
* device instance cc_XD3_XDFFQ_SB_XD5_XN3_mid2 r0 *1 0,0
Ccc_XD3_XDFFQ_SB_XD5_XN3_mid2 XD3_XDFFQ_SB XD5_XN3_mid2 1.21e-17
* device instance cc_XD3_XDFFQ_SB_XD5_dmodout r0 *1 0,0
Ccc_XD3_XDFFQ_SB_XD5_dmodout XD3_XDFFQ_SB XD5_dmodout 1.21e-17
* device instance cc_XD3_XDFFQ_SB_XD5_dq r0 *1 0,0
Ccc_XD3_XDFFQ_SB_XD5_dq XD3_XDFFQ_SB XD5_dq 1.8151e-17
* device instance cc_XD3_XDFFQ_SB_XD5_nm r0 *1 0,0
Ccc_XD3_XDFFQ_SB_XD5_nm XD3_XDFFQ_SB XD5_nm 1.21e-17
* device instance cc_XD3_XDFFQ_SB_XD5_nt r0 *1 0,0
Ccc_XD3_XDFFQ_SB_XD5_nt XD3_XDFFQ_SB XD5_nt 1.21e-17
* device instance cc_XD3_XDFFQ_SB_XD5_t1 r0 *1 0,0
Ccc_XD3_XDFFQ_SB_XD5_t1 XD3_XDFFQ_SB XD5_t1 1.21e-17
* device instance cc_XD3_XDFFQ_SB_XFRT_CKBB r0 *1 0,0
Ccc_XD3_XDFFQ_SB_XFRT_CKBB XD3_XDFFQ_SB XFRT_CKBB 1.8151e-17
* device instance cc_XD3_XDFFQ_SB_XFRT_CLKB r0 *1 0,0
Ccc_XD3_XDFFQ_SB_XFRT_CLKB XD3_XDFFQ_SB XFRT_CLKB 2.4201e-17
* device instance cc_XD3_XDFFQ_SB_XFRT_M r0 *1 0,0
Ccc_XD3_XDFFQ_SB_XFRT_M XD3_XDFFQ_SB XFRT_M 2.4201e-17
* device instance cc_XD3_XDFFQ_SB_XFRT_MB r0 *1 0,0
Ccc_XD3_XDFFQ_SB_XFRT_MB XD3_XDFFQ_SB XFRT_MB 1.21e-17
* device instance cc_XD3_XDFFQ_SB_XFRT_MFB r0 *1 0,0
Ccc_XD3_XDFFQ_SB_XFRT_MFB XD3_XDFFQ_SB XFRT_MFB 1.21e-17
* device instance cc_XD3_XDFFQ_SB_XFRT_S r0 *1 0,0
Ccc_XD3_XDFFQ_SB_XFRT_S XD3_XDFFQ_SB XFRT_S 1.8151e-17
* device instance cc_XD3_XDFFQ_SB_XFRT_SB r0 *1 0,0
Ccc_XD3_XDFFQ_SB_XFRT_SB XD3_XDFFQ_SB XFRT_SB 1.8151e-17
* device instance cc_XD3_XDFFQ_SB_XFRT_SFB r0 *1 0,0
Ccc_XD3_XDFFQ_SB_XFRT_SFB XD3_XDFFQ_SB XFRT_SFB 1.21e-17
* device instance cc_XD3_XDFFQ_SB_ck1 r0 *1 0,0
Ccc_XD3_XDFFQ_SB_ck1 XD3_XDFFQ_SB ck1 3.0251e-17
* device instance cc_XD3_XDFFQ_SB_ck2 r0 *1 0,0
Ccc_XD3_XDFFQ_SB_ck2 XD3_XDFFQ_SB ck2 3.0251e-17
* device instance cc_XD3_XDFFQ_SB_ck3 r0 *1 0,0
Ccc_XD3_XDFFQ_SB_ck3 XD3_XDFFQ_SB ck3 3.0251e-17
* device instance cc_XD3_XDFFQ_SB_ck4 r0 *1 0,0
Ccc_XD3_XDFFQ_SB_ck4 XD3_XDFFQ_SB ck4 3.0251e-17
* device instance cc_XD3_XDFFQ_SB_ck5 r0 *1 0,0
Ccc_XD3_XDFFQ_SB_ck5 XD3_XDFFQ_SB ck5 3.0251e-17
* device instance cc_XD3_XDFFQ_SB_mod0 r0 *1 0,0
Ccc_XD3_XDFFQ_SB_mod0 XD3_XDFFQ_SB mod0 2.4201e-17
* device instance cc_XD3_XDFFQ_SB_mod1 r0 *1 0,0
Ccc_XD3_XDFFQ_SB_mod1 XD3_XDFFQ_SB mod1 2.4201e-17
* device instance cc_XD3_XDFFQ_SB_mod2 r0 *1 0,0
Ccc_XD3_XDFFQ_SB_mod2 XD3_XDFFQ_SB mod2 2.4201e-17
* device instance cc_XD3_XDFFQ_SB_mod3 r0 *1 0,0
Ccc_XD3_XDFFQ_SB_mod3 XD3_XDFFQ_SB mod3 2.4201e-17
* device instance cc_XD3_XDFFQ_SB_mod4 r0 *1 0,0
Ccc_XD3_XDFFQ_SB_mod4 XD3_XDFFQ_SB mod4 2.4201e-17
* device instance cc_XD3_XDFFQ_SB_net1 r0 *1 0,0
Ccc_XD3_XDFFQ_SB_net1 XD3_XDFFQ_SB net1 1.21e-17
* device instance cc_XD3_XDFFQ_SFB_XD3_XN2_mid1 r0 *1 0,0
Ccc_XD3_XDFFQ_SFB_XD3_XN2_mid1 XD3_XDFFQ_SFB XD3_XN2_mid1 1.21e-17
* device instance cc_XD3_XDFFQ_SFB_XD3_XNOR_midp r0 *1 0,0
Ccc_XD3_XDFFQ_SFB_XD3_XNOR_midp XD3_XDFFQ_SFB XD3_XNOR_midp 1.21e-17
* device instance cc_XD3_XDFFQ_SFB_XD3_dmodout r0 *1 0,0
Ccc_XD3_XDFFQ_SFB_XD3_dmodout XD3_XDFFQ_SFB XD3_dmodout 1.21e-17
* device instance cc_XD3_XDFFQ_SFB_XD3_dq r0 *1 0,0
Ccc_XD3_XDFFQ_SFB_XD3_dq XD3_XDFFQ_SFB XD3_dq 1.21e-17
* device instance cc_XD3_XDFFQ_SFB_XD3_nm r0 *1 0,0
Ccc_XD3_XDFFQ_SFB_XD3_nm XD3_XDFFQ_SFB XD3_nm 1.21e-17
* device instance cc_XD3_XDFFQ_SFB_XD3_nt r0 *1 0,0
Ccc_XD3_XDFFQ_SFB_XD3_nt XD3_XDFFQ_SFB XD3_nt 2.4201e-17
* device instance cc_XD3_XDFFQ_SFB_XD3_t1 r0 *1 0,0
Ccc_XD3_XDFFQ_SFB_XD3_t1 XD3_XDFFQ_SFB XD3_t1 1.21e-17
* device instance cc_XD3_XDFFQ_SFB_XD4_XDFFM_CKBB r0 *1 0,0
Ccc_XD3_XDFFQ_SFB_XD4_XDFFM_CKBB XD3_XDFFQ_SFB XD4_XDFFM_CKBB 1.8151e-17
* device instance cc_XD3_XDFFQ_SFB_XD4_XDFFM_CLKB r0 *1 0,0
Ccc_XD3_XDFFQ_SFB_XD4_XDFFM_CLKB XD3_XDFFQ_SFB XD4_XDFFM_CLKB 2.4201e-17
* device instance cc_XD3_XDFFQ_SFB_XD4_XDFFM_M r0 *1 0,0
Ccc_XD3_XDFFQ_SFB_XD4_XDFFM_M XD3_XDFFQ_SFB XD4_XDFFM_M 2.4201e-17
* device instance cc_XD3_XDFFQ_SFB_XD4_XDFFM_MB r0 *1 0,0
Ccc_XD3_XDFFQ_SFB_XD4_XDFFM_MB XD3_XDFFQ_SFB XD4_XDFFM_MB 1.21e-17
* device instance cc_XD3_XDFFQ_SFB_XD4_XDFFM_MFB r0 *1 0,0
Ccc_XD3_XDFFQ_SFB_XD4_XDFFM_MFB XD3_XDFFQ_SFB XD4_XDFFM_MFB 1.21e-17
* device instance cc_XD3_XDFFQ_SFB_XD4_XDFFM_S r0 *1 0,0
Ccc_XD3_XDFFQ_SFB_XD4_XDFFM_S XD3_XDFFQ_SFB XD4_XDFFM_S 1.8151e-17
* device instance cc_XD3_XDFFQ_SFB_XD4_XDFFM_SB r0 *1 0,0
Ccc_XD3_XDFFQ_SFB_XD4_XDFFM_SB XD3_XDFFQ_SFB XD4_XDFFM_SB 1.8151e-17
* device instance cc_XD3_XDFFQ_SFB_XD4_XDFFM_SFB r0 *1 0,0
Ccc_XD3_XDFFQ_SFB_XD4_XDFFM_SFB XD3_XDFFQ_SFB XD4_XDFFM_SFB 1.21e-17
* device instance cc_XD3_XDFFQ_SFB_XD4_XDFFQ_CKBB r0 *1 0,0
Ccc_XD3_XDFFQ_SFB_XD4_XDFFQ_CKBB XD3_XDFFQ_SFB XD4_XDFFQ_CKBB 1.8151e-17
* device instance cc_XD3_XDFFQ_SFB_XD4_XDFFQ_CLKB r0 *1 0,0
Ccc_XD3_XDFFQ_SFB_XD4_XDFFQ_CLKB XD3_XDFFQ_SFB XD4_XDFFQ_CLKB 2.4201e-17
* device instance cc_XD3_XDFFQ_SFB_XD4_XDFFQ_M r0 *1 0,0
Ccc_XD3_XDFFQ_SFB_XD4_XDFFQ_M XD3_XDFFQ_SFB XD4_XDFFQ_M 2.4201e-17
* device instance cc_XD3_XDFFQ_SFB_XD4_XDFFQ_MB r0 *1 0,0
Ccc_XD3_XDFFQ_SFB_XD4_XDFFQ_MB XD3_XDFFQ_SFB XD4_XDFFQ_MB 1.21e-17
* device instance cc_XD3_XDFFQ_SFB_XD4_XDFFQ_MFB r0 *1 0,0
Ccc_XD3_XDFFQ_SFB_XD4_XDFFQ_MFB XD3_XDFFQ_SFB XD4_XDFFQ_MFB 1.21e-17
* device instance cc_XD3_XDFFQ_SFB_XD4_XDFFQ_S r0 *1 0,0
Ccc_XD3_XDFFQ_SFB_XD4_XDFFQ_S XD3_XDFFQ_SFB XD4_XDFFQ_S 1.8151e-17
* device instance cc_XD3_XDFFQ_SFB_XD4_XDFFQ_SB r0 *1 0,0
Ccc_XD3_XDFFQ_SFB_XD4_XDFFQ_SB XD3_XDFFQ_SFB XD4_XDFFQ_SB 1.8151e-17
* device instance cc_XD3_XDFFQ_SFB_XD4_XDFFQ_SFB r0 *1 0,0
Ccc_XD3_XDFFQ_SFB_XD4_XDFFQ_SFB XD3_XDFFQ_SFB XD4_XDFFQ_SFB 1.21e-17
* device instance cc_XD3_XDFFQ_SFB_XD4_XN2_mid1 r0 *1 0,0
Ccc_XD3_XDFFQ_SFB_XD4_XN2_mid1 XD3_XDFFQ_SFB XD4_XN2_mid1 1.21e-17
* device instance cc_XD3_XDFFQ_SFB_XD4_XN3_mid1 r0 *1 0,0
Ccc_XD3_XDFFQ_SFB_XD4_XN3_mid1 XD3_XDFFQ_SFB XD4_XN3_mid1 1.21e-17
* device instance cc_XD3_XDFFQ_SFB_XD4_XN3_mid2 r0 *1 0,0
Ccc_XD3_XDFFQ_SFB_XD4_XN3_mid2 XD3_XDFFQ_SFB XD4_XN3_mid2 1.21e-17
* device instance cc_XD3_XDFFQ_SFB_XD4_dmodout r0 *1 0,0
Ccc_XD3_XDFFQ_SFB_XD4_dmodout XD3_XDFFQ_SFB XD4_dmodout 1.21e-17
* device instance cc_XD3_XDFFQ_SFB_XD4_dq r0 *1 0,0
Ccc_XD3_XDFFQ_SFB_XD4_dq XD3_XDFFQ_SFB XD4_dq 1.8151e-17
* device instance cc_XD3_XDFFQ_SFB_XD4_nm r0 *1 0,0
Ccc_XD3_XDFFQ_SFB_XD4_nm XD3_XDFFQ_SFB XD4_nm 1.21e-17
* device instance cc_XD3_XDFFQ_SFB_XD4_nt r0 *1 0,0
Ccc_XD3_XDFFQ_SFB_XD4_nt XD3_XDFFQ_SFB XD4_nt 1.21e-17
* device instance cc_XD3_XDFFQ_SFB_XD4_t1 r0 *1 0,0
Ccc_XD3_XDFFQ_SFB_XD4_t1 XD3_XDFFQ_SFB XD4_t1 1.21e-17
* device instance cc_XD3_XDFFQ_SFB_XD5_XDFFM_CKBB r0 *1 0,0
Ccc_XD3_XDFFQ_SFB_XD5_XDFFM_CKBB XD3_XDFFQ_SFB XD5_XDFFM_CKBB 1.8151e-17
* device instance cc_XD3_XDFFQ_SFB_XD5_XDFFM_CLKB r0 *1 0,0
Ccc_XD3_XDFFQ_SFB_XD5_XDFFM_CLKB XD3_XDFFQ_SFB XD5_XDFFM_CLKB 2.4201e-17
* device instance cc_XD3_XDFFQ_SFB_XD5_XDFFM_M r0 *1 0,0
Ccc_XD3_XDFFQ_SFB_XD5_XDFFM_M XD3_XDFFQ_SFB XD5_XDFFM_M 2.4201e-17
* device instance cc_XD3_XDFFQ_SFB_XD5_XDFFM_MB r0 *1 0,0
Ccc_XD3_XDFFQ_SFB_XD5_XDFFM_MB XD3_XDFFQ_SFB XD5_XDFFM_MB 1.21e-17
* device instance cc_XD3_XDFFQ_SFB_XD5_XDFFM_MFB r0 *1 0,0
Ccc_XD3_XDFFQ_SFB_XD5_XDFFM_MFB XD3_XDFFQ_SFB XD5_XDFFM_MFB 1.21e-17
* device instance cc_XD3_XDFFQ_SFB_XD5_XDFFM_S r0 *1 0,0
Ccc_XD3_XDFFQ_SFB_XD5_XDFFM_S XD3_XDFFQ_SFB XD5_XDFFM_S 1.8151e-17
* device instance cc_XD3_XDFFQ_SFB_XD5_XDFFM_SB r0 *1 0,0
Ccc_XD3_XDFFQ_SFB_XD5_XDFFM_SB XD3_XDFFQ_SFB XD5_XDFFM_SB 1.8151e-17
* device instance cc_XD3_XDFFQ_SFB_XD5_XDFFM_SFB r0 *1 0,0
Ccc_XD3_XDFFQ_SFB_XD5_XDFFM_SFB XD3_XDFFQ_SFB XD5_XDFFM_SFB 1.21e-17
* device instance cc_XD3_XDFFQ_SFB_XD5_XDFFQ_CKBB r0 *1 0,0
Ccc_XD3_XDFFQ_SFB_XD5_XDFFQ_CKBB XD3_XDFFQ_SFB XD5_XDFFQ_CKBB 1.8151e-17
* device instance cc_XD3_XDFFQ_SFB_XD5_XDFFQ_CLKB r0 *1 0,0
Ccc_XD3_XDFFQ_SFB_XD5_XDFFQ_CLKB XD3_XDFFQ_SFB XD5_XDFFQ_CLKB 2.4201e-17
* device instance cc_XD3_XDFFQ_SFB_XD5_XDFFQ_M r0 *1 0,0
Ccc_XD3_XDFFQ_SFB_XD5_XDFFQ_M XD3_XDFFQ_SFB XD5_XDFFQ_M 2.4201e-17
* device instance cc_XD3_XDFFQ_SFB_XD5_XDFFQ_MB r0 *1 0,0
Ccc_XD3_XDFFQ_SFB_XD5_XDFFQ_MB XD3_XDFFQ_SFB XD5_XDFFQ_MB 1.21e-17
* device instance cc_XD3_XDFFQ_SFB_XD5_XDFFQ_MFB r0 *1 0,0
Ccc_XD3_XDFFQ_SFB_XD5_XDFFQ_MFB XD3_XDFFQ_SFB XD5_XDFFQ_MFB 1.21e-17
* device instance cc_XD3_XDFFQ_SFB_XD5_XDFFQ_S r0 *1 0,0
Ccc_XD3_XDFFQ_SFB_XD5_XDFFQ_S XD3_XDFFQ_SFB XD5_XDFFQ_S 1.8151e-17
* device instance cc_XD3_XDFFQ_SFB_XD5_XDFFQ_SB r0 *1 0,0
Ccc_XD3_XDFFQ_SFB_XD5_XDFFQ_SB XD3_XDFFQ_SFB XD5_XDFFQ_SB 1.8151e-17
* device instance cc_XD3_XDFFQ_SFB_XD5_XDFFQ_SFB r0 *1 0,0
Ccc_XD3_XDFFQ_SFB_XD5_XDFFQ_SFB XD3_XDFFQ_SFB XD5_XDFFQ_SFB 1.21e-17
* device instance cc_XD3_XDFFQ_SFB_XD5_XN2_mid1 r0 *1 0,0
Ccc_XD3_XDFFQ_SFB_XD5_XN2_mid1 XD3_XDFFQ_SFB XD5_XN2_mid1 1.21e-17
* device instance cc_XD3_XDFFQ_SFB_XD5_XN3_mid1 r0 *1 0,0
Ccc_XD3_XDFFQ_SFB_XD5_XN3_mid1 XD3_XDFFQ_SFB XD5_XN3_mid1 1.21e-17
* device instance cc_XD3_XDFFQ_SFB_XD5_XN3_mid2 r0 *1 0,0
Ccc_XD3_XDFFQ_SFB_XD5_XN3_mid2 XD3_XDFFQ_SFB XD5_XN3_mid2 1.21e-17
* device instance cc_XD3_XDFFQ_SFB_XD5_dmodout r0 *1 0,0
Ccc_XD3_XDFFQ_SFB_XD5_dmodout XD3_XDFFQ_SFB XD5_dmodout 1.21e-17
* device instance cc_XD3_XDFFQ_SFB_XD5_dq r0 *1 0,0
Ccc_XD3_XDFFQ_SFB_XD5_dq XD3_XDFFQ_SFB XD5_dq 1.8151e-17
* device instance cc_XD3_XDFFQ_SFB_XD5_nm r0 *1 0,0
Ccc_XD3_XDFFQ_SFB_XD5_nm XD3_XDFFQ_SFB XD5_nm 1.21e-17
* device instance cc_XD3_XDFFQ_SFB_XD5_nt r0 *1 0,0
Ccc_XD3_XDFFQ_SFB_XD5_nt XD3_XDFFQ_SFB XD5_nt 1.21e-17
* device instance cc_XD3_XDFFQ_SFB_XD5_t1 r0 *1 0,0
Ccc_XD3_XDFFQ_SFB_XD5_t1 XD3_XDFFQ_SFB XD5_t1 1.21e-17
* device instance cc_XD3_XDFFQ_SFB_XFRT_CKBB r0 *1 0,0
Ccc_XD3_XDFFQ_SFB_XFRT_CKBB XD3_XDFFQ_SFB XFRT_CKBB 1.8151e-17
* device instance cc_XD3_XDFFQ_SFB_XFRT_CLKB r0 *1 0,0
Ccc_XD3_XDFFQ_SFB_XFRT_CLKB XD3_XDFFQ_SFB XFRT_CLKB 2.4201e-17
* device instance cc_XD3_XDFFQ_SFB_XFRT_M r0 *1 0,0
Ccc_XD3_XDFFQ_SFB_XFRT_M XD3_XDFFQ_SFB XFRT_M 2.4201e-17
* device instance cc_XD3_XDFFQ_SFB_XFRT_MB r0 *1 0,0
Ccc_XD3_XDFFQ_SFB_XFRT_MB XD3_XDFFQ_SFB XFRT_MB 1.21e-17
* device instance cc_XD3_XDFFQ_SFB_XFRT_MFB r0 *1 0,0
Ccc_XD3_XDFFQ_SFB_XFRT_MFB XD3_XDFFQ_SFB XFRT_MFB 1.21e-17
* device instance cc_XD3_XDFFQ_SFB_XFRT_S r0 *1 0,0
Ccc_XD3_XDFFQ_SFB_XFRT_S XD3_XDFFQ_SFB XFRT_S 1.8151e-17
* device instance cc_XD3_XDFFQ_SFB_XFRT_SB r0 *1 0,0
Ccc_XD3_XDFFQ_SFB_XFRT_SB XD3_XDFFQ_SFB XFRT_SB 1.8151e-17
* device instance cc_XD3_XDFFQ_SFB_XFRT_SFB r0 *1 0,0
Ccc_XD3_XDFFQ_SFB_XFRT_SFB XD3_XDFFQ_SFB XFRT_SFB 1.21e-17
* device instance cc_XD3_XDFFQ_SFB_ck1 r0 *1 0,0
Ccc_XD3_XDFFQ_SFB_ck1 XD3_XDFFQ_SFB ck1 3.0251e-17
* device instance cc_XD3_XDFFQ_SFB_ck2 r0 *1 0,0
Ccc_XD3_XDFFQ_SFB_ck2 XD3_XDFFQ_SFB ck2 3.0251e-17
* device instance cc_XD3_XDFFQ_SFB_ck3 r0 *1 0,0
Ccc_XD3_XDFFQ_SFB_ck3 XD3_XDFFQ_SFB ck3 3.0251e-17
* device instance cc_XD3_XDFFQ_SFB_ck4 r0 *1 0,0
Ccc_XD3_XDFFQ_SFB_ck4 XD3_XDFFQ_SFB ck4 3.0251e-17
* device instance cc_XD3_XDFFQ_SFB_ck5 r0 *1 0,0
Ccc_XD3_XDFFQ_SFB_ck5 XD3_XDFFQ_SFB ck5 3.0251e-17
* device instance cc_XD3_XDFFQ_SFB_mod0 r0 *1 0,0
Ccc_XD3_XDFFQ_SFB_mod0 XD3_XDFFQ_SFB mod0 2.4201e-17
* device instance cc_XD3_XDFFQ_SFB_mod1 r0 *1 0,0
Ccc_XD3_XDFFQ_SFB_mod1 XD3_XDFFQ_SFB mod1 2.4201e-17
* device instance cc_XD3_XDFFQ_SFB_mod2 r0 *1 0,0
Ccc_XD3_XDFFQ_SFB_mod2 XD3_XDFFQ_SFB mod2 2.4201e-17
* device instance cc_XD3_XDFFQ_SFB_mod3 r0 *1 0,0
Ccc_XD3_XDFFQ_SFB_mod3 XD3_XDFFQ_SFB mod3 2.4201e-17
* device instance cc_XD3_XDFFQ_SFB_mod4 r0 *1 0,0
Ccc_XD3_XDFFQ_SFB_mod4 XD3_XDFFQ_SFB mod4 2.4201e-17
* device instance cc_XD3_XDFFQ_SFB_net1 r0 *1 0,0
Ccc_XD3_XDFFQ_SFB_net1 XD3_XDFFQ_SFB net1 1.21e-17
* device instance cc_XD3_XN2_mid1_XD3_nm r0 *1 0,0
Ccc_XD3_XN2_mid1_XD3_nm XD3_XN2_mid1 XD3_nm 1.1294e-17
* device instance cc_XD3_XN2_mid1_ck4 r0 *1 0,0
Ccc_XD3_XN2_mid1_ck4 XD3_XN2_mid1 ck4 6.05e-18
* device instance cc_XD3_XN3_mid1_XD3_XN3_mid2 r0 *1 0,0
Ccc_XD3_XN3_mid1_XD3_XN3_mid2 XD3_XN3_mid1 XD3_XN3_mid2 1.1294e-17
* device instance cc_XD3_XN3_mid1_XD3_nt r0 *1 0,0
Ccc_XD3_XN3_mid1_XD3_nt XD3_XN3_mid1 XD3_nt 1.1294e-17
* device instance cc_XD3_XN3_mid2_mod2 r0 *1 0,0
Ccc_XD3_XN3_mid2_mod2 XD3_XN3_mid2 mod2 6.05e-18
* device instance cc_XD3_XNOR_midp_XD3_dq r0 *1 0,0
Ccc_XD3_XNOR_midp_XD3_dq XD3_XNOR_midp XD3_dq 5.244e-18
* device instance cc_XD3_XNOR_midp_XD3_t1 r0 *1 0,0
Ccc_XD3_XNOR_midp_XD3_t1 XD3_XNOR_midp XD3_t1 6.05e-18
* device instance cc_XD3_dmodout_XD3_dq r0 *1 0,0
Ccc_XD3_dmodout_XD3_dq XD3_dmodout XD3_dq 1.21e-17
* device instance cc_XD3_dmodout_XD3_nm r0 *1 0,0
Ccc_XD3_dmodout_XD3_nm XD3_dmodout XD3_nm 1.8151e-17
* device instance cc_XD3_dmodout_XD3_nt r0 *1 0,0
Ccc_XD3_dmodout_XD3_nt XD3_dmodout XD3_nt 2.4201e-17
* device instance cc_XD3_dmodout_XD3_t1 r0 *1 0,0
Ccc_XD3_dmodout_XD3_t1 XD3_dmodout XD3_t1 1.21e-17
* device instance cc_XD3_dmodout_XD4_XDFFM_CKBB r0 *1 0,0
Ccc_XD3_dmodout_XD4_XDFFM_CKBB XD3_dmodout XD4_XDFFM_CKBB 1.8151e-17
* device instance cc_XD3_dmodout_XD4_XDFFM_CLKB r0 *1 0,0
Ccc_XD3_dmodout_XD4_XDFFM_CLKB XD3_dmodout XD4_XDFFM_CLKB 2.4201e-17
* device instance cc_XD3_dmodout_XD4_XDFFM_M r0 *1 0,0
Ccc_XD3_dmodout_XD4_XDFFM_M XD3_dmodout XD4_XDFFM_M 2.4201e-17
* device instance cc_XD3_dmodout_XD4_XDFFM_MB r0 *1 0,0
Ccc_XD3_dmodout_XD4_XDFFM_MB XD3_dmodout XD4_XDFFM_MB 1.21e-17
* device instance cc_XD3_dmodout_XD4_XDFFM_MFB r0 *1 0,0
Ccc_XD3_dmodout_XD4_XDFFM_MFB XD3_dmodout XD4_XDFFM_MFB 1.21e-17
* device instance cc_XD3_dmodout_XD4_XDFFM_S r0 *1 0,0
Ccc_XD3_dmodout_XD4_XDFFM_S XD3_dmodout XD4_XDFFM_S 1.8151e-17
* device instance cc_XD3_dmodout_XD4_XDFFM_SB r0 *1 0,0
Ccc_XD3_dmodout_XD4_XDFFM_SB XD3_dmodout XD4_XDFFM_SB 1.8151e-17
* device instance cc_XD3_dmodout_XD4_XDFFM_SFB r0 *1 0,0
Ccc_XD3_dmodout_XD4_XDFFM_SFB XD3_dmodout XD4_XDFFM_SFB 1.21e-17
* device instance cc_XD3_dmodout_XD4_XDFFQ_CKBB r0 *1 0,0
Ccc_XD3_dmodout_XD4_XDFFQ_CKBB XD3_dmodout XD4_XDFFQ_CKBB 1.8151e-17
* device instance cc_XD3_dmodout_XD4_XDFFQ_CLKB r0 *1 0,0
Ccc_XD3_dmodout_XD4_XDFFQ_CLKB XD3_dmodout XD4_XDFFQ_CLKB 2.4201e-17
* device instance cc_XD3_dmodout_XD4_XDFFQ_M r0 *1 0,0
Ccc_XD3_dmodout_XD4_XDFFQ_M XD3_dmodout XD4_XDFFQ_M 2.4201e-17
* device instance cc_XD3_dmodout_XD4_XDFFQ_MB r0 *1 0,0
Ccc_XD3_dmodout_XD4_XDFFQ_MB XD3_dmodout XD4_XDFFQ_MB 1.21e-17
* device instance cc_XD3_dmodout_XD4_XDFFQ_MFB r0 *1 0,0
Ccc_XD3_dmodout_XD4_XDFFQ_MFB XD3_dmodout XD4_XDFFQ_MFB 1.21e-17
* device instance cc_XD3_dmodout_XD4_XDFFQ_S r0 *1 0,0
Ccc_XD3_dmodout_XD4_XDFFQ_S XD3_dmodout XD4_XDFFQ_S 1.8151e-17
* device instance cc_XD3_dmodout_XD4_XDFFQ_SB r0 *1 0,0
Ccc_XD3_dmodout_XD4_XDFFQ_SB XD3_dmodout XD4_XDFFQ_SB 1.8151e-17
* device instance cc_XD3_dmodout_XD4_XDFFQ_SFB r0 *1 0,0
Ccc_XD3_dmodout_XD4_XDFFQ_SFB XD3_dmodout XD4_XDFFQ_SFB 1.21e-17
* device instance cc_XD3_dmodout_XD4_XN2_mid1 r0 *1 0,0
Ccc_XD3_dmodout_XD4_XN2_mid1 XD3_dmodout XD4_XN2_mid1 1.21e-17
* device instance cc_XD3_dmodout_XD4_XN3_mid1 r0 *1 0,0
Ccc_XD3_dmodout_XD4_XN3_mid1 XD3_dmodout XD4_XN3_mid1 1.21e-17
* device instance cc_XD3_dmodout_XD4_XN3_mid2 r0 *1 0,0
Ccc_XD3_dmodout_XD4_XN3_mid2 XD3_dmodout XD4_XN3_mid2 1.21e-17
* device instance cc_XD3_dmodout_XD4_dmodout r0 *1 0,0
Ccc_XD3_dmodout_XD4_dmodout XD3_dmodout XD4_dmodout 1.21e-17
* device instance cc_XD3_dmodout_XD4_dq r0 *1 0,0
Ccc_XD3_dmodout_XD4_dq XD3_dmodout XD4_dq 1.8151e-17
* device instance cc_XD3_dmodout_XD4_nm r0 *1 0,0
Ccc_XD3_dmodout_XD4_nm XD3_dmodout XD4_nm 1.21e-17
* device instance cc_XD3_dmodout_XD4_nt r0 *1 0,0
Ccc_XD3_dmodout_XD4_nt XD3_dmodout XD4_nt 1.21e-17
* device instance cc_XD3_dmodout_XD4_t1 r0 *1 0,0
Ccc_XD3_dmodout_XD4_t1 XD3_dmodout XD4_t1 1.21e-17
* device instance cc_XD3_dmodout_XD5_XDFFM_CKBB r0 *1 0,0
Ccc_XD3_dmodout_XD5_XDFFM_CKBB XD3_dmodout XD5_XDFFM_CKBB 1.8151e-17
* device instance cc_XD3_dmodout_XD5_XDFFM_CLKB r0 *1 0,0
Ccc_XD3_dmodout_XD5_XDFFM_CLKB XD3_dmodout XD5_XDFFM_CLKB 2.4201e-17
* device instance cc_XD3_dmodout_XD5_XDFFM_M r0 *1 0,0
Ccc_XD3_dmodout_XD5_XDFFM_M XD3_dmodout XD5_XDFFM_M 2.4201e-17
* device instance cc_XD3_dmodout_XD5_XDFFM_MB r0 *1 0,0
Ccc_XD3_dmodout_XD5_XDFFM_MB XD3_dmodout XD5_XDFFM_MB 1.21e-17
* device instance cc_XD3_dmodout_XD5_XDFFM_MFB r0 *1 0,0
Ccc_XD3_dmodout_XD5_XDFFM_MFB XD3_dmodout XD5_XDFFM_MFB 1.21e-17
* device instance cc_XD3_dmodout_XD5_XDFFM_S r0 *1 0,0
Ccc_XD3_dmodout_XD5_XDFFM_S XD3_dmodout XD5_XDFFM_S 1.8151e-17
* device instance cc_XD3_dmodout_XD5_XDFFM_SB r0 *1 0,0
Ccc_XD3_dmodout_XD5_XDFFM_SB XD3_dmodout XD5_XDFFM_SB 1.8151e-17
* device instance cc_XD3_dmodout_XD5_XDFFM_SFB r0 *1 0,0
Ccc_XD3_dmodout_XD5_XDFFM_SFB XD3_dmodout XD5_XDFFM_SFB 1.21e-17
* device instance cc_XD3_dmodout_XD5_XDFFQ_CKBB r0 *1 0,0
Ccc_XD3_dmodout_XD5_XDFFQ_CKBB XD3_dmodout XD5_XDFFQ_CKBB 1.8151e-17
* device instance cc_XD3_dmodout_XD5_XDFFQ_CLKB r0 *1 0,0
Ccc_XD3_dmodout_XD5_XDFFQ_CLKB XD3_dmodout XD5_XDFFQ_CLKB 2.4201e-17
* device instance cc_XD3_dmodout_XD5_XDFFQ_M r0 *1 0,0
Ccc_XD3_dmodout_XD5_XDFFQ_M XD3_dmodout XD5_XDFFQ_M 2.4201e-17
* device instance cc_XD3_dmodout_XD5_XDFFQ_MB r0 *1 0,0
Ccc_XD3_dmodout_XD5_XDFFQ_MB XD3_dmodout XD5_XDFFQ_MB 1.21e-17
* device instance cc_XD3_dmodout_XD5_XDFFQ_MFB r0 *1 0,0
Ccc_XD3_dmodout_XD5_XDFFQ_MFB XD3_dmodout XD5_XDFFQ_MFB 1.21e-17
* device instance cc_XD3_dmodout_XD5_XDFFQ_S r0 *1 0,0
Ccc_XD3_dmodout_XD5_XDFFQ_S XD3_dmodout XD5_XDFFQ_S 1.8151e-17
* device instance cc_XD3_dmodout_XD5_XDFFQ_SB r0 *1 0,0
Ccc_XD3_dmodout_XD5_XDFFQ_SB XD3_dmodout XD5_XDFFQ_SB 1.8151e-17
* device instance cc_XD3_dmodout_XD5_XDFFQ_SFB r0 *1 0,0
Ccc_XD3_dmodout_XD5_XDFFQ_SFB XD3_dmodout XD5_XDFFQ_SFB 1.21e-17
* device instance cc_XD3_dmodout_XD5_XN2_mid1 r0 *1 0,0
Ccc_XD3_dmodout_XD5_XN2_mid1 XD3_dmodout XD5_XN2_mid1 1.21e-17
* device instance cc_XD3_dmodout_XD5_XN3_mid1 r0 *1 0,0
Ccc_XD3_dmodout_XD5_XN3_mid1 XD3_dmodout XD5_XN3_mid1 1.21e-17
* device instance cc_XD3_dmodout_XD5_XN3_mid2 r0 *1 0,0
Ccc_XD3_dmodout_XD5_XN3_mid2 XD3_dmodout XD5_XN3_mid2 1.21e-17
* device instance cc_XD3_dmodout_XD5_dmodout r0 *1 0,0
Ccc_XD3_dmodout_XD5_dmodout XD3_dmodout XD5_dmodout 1.21e-17
* device instance cc_XD3_dmodout_XD5_dq r0 *1 0,0
Ccc_XD3_dmodout_XD5_dq XD3_dmodout XD5_dq 1.8151e-17
* device instance cc_XD3_dmodout_XD5_nm r0 *1 0,0
Ccc_XD3_dmodout_XD5_nm XD3_dmodout XD5_nm 1.21e-17
* device instance cc_XD3_dmodout_XD5_nt r0 *1 0,0
Ccc_XD3_dmodout_XD5_nt XD3_dmodout XD5_nt 1.21e-17
* device instance cc_XD3_dmodout_XD5_t1 r0 *1 0,0
Ccc_XD3_dmodout_XD5_t1 XD3_dmodout XD5_t1 1.21e-17
* device instance cc_XD3_dmodout_XFRT_CKBB r0 *1 0,0
Ccc_XD3_dmodout_XFRT_CKBB XD3_dmodout XFRT_CKBB 1.8151e-17
* device instance cc_XD3_dmodout_XFRT_CLKB r0 *1 0,0
Ccc_XD3_dmodout_XFRT_CLKB XD3_dmodout XFRT_CLKB 2.4201e-17
* device instance cc_XD3_dmodout_XFRT_M r0 *1 0,0
Ccc_XD3_dmodout_XFRT_M XD3_dmodout XFRT_M 2.4201e-17
* device instance cc_XD3_dmodout_XFRT_MB r0 *1 0,0
Ccc_XD3_dmodout_XFRT_MB XD3_dmodout XFRT_MB 1.21e-17
* device instance cc_XD3_dmodout_XFRT_MFB r0 *1 0,0
Ccc_XD3_dmodout_XFRT_MFB XD3_dmodout XFRT_MFB 1.21e-17
* device instance cc_XD3_dmodout_XFRT_S r0 *1 0,0
Ccc_XD3_dmodout_XFRT_S XD3_dmodout XFRT_S 1.8151e-17
* device instance cc_XD3_dmodout_XFRT_SB r0 *1 0,0
Ccc_XD3_dmodout_XFRT_SB XD3_dmodout XFRT_SB 1.8151e-17
* device instance cc_XD3_dmodout_XFRT_SFB r0 *1 0,0
Ccc_XD3_dmodout_XFRT_SFB XD3_dmodout XFRT_SFB 1.21e-17
* device instance cc_XD3_dmodout_ck1 r0 *1 0,0
Ccc_XD3_dmodout_ck1 XD3_dmodout ck1 3.0251e-17
* device instance cc_XD3_dmodout_ck2 r0 *1 0,0
Ccc_XD3_dmodout_ck2 XD3_dmodout ck2 3.0251e-17
* device instance cc_XD3_dmodout_ck3 r0 *1 0,0
Ccc_XD3_dmodout_ck3 XD3_dmodout ck3 3.6302e-17
* device instance cc_XD3_dmodout_ck4 r0 *1 0,0
Ccc_XD3_dmodout_ck4 XD3_dmodout ck4 3.0251e-17
* device instance cc_XD3_dmodout_ck5 r0 *1 0,0
Ccc_XD3_dmodout_ck5 XD3_dmodout ck5 3.0251e-17
* device instance cc_XD3_dmodout_mod0 r0 *1 0,0
Ccc_XD3_dmodout_mod0 XD3_dmodout mod0 2.4201e-17
* device instance cc_XD3_dmodout_mod1 r0 *1 0,0
Ccc_XD3_dmodout_mod1 XD3_dmodout mod1 2.4201e-17
* device instance cc_XD3_dmodout_mod2 r0 *1 0,0
Ccc_XD3_dmodout_mod2 XD3_dmodout mod2 2.4201e-17
* device instance cc_XD3_dmodout_mod3 r0 *1 0,0
Ccc_XD3_dmodout_mod3 XD3_dmodout mod3 2.4201e-17
* device instance cc_XD3_dmodout_mod4 r0 *1 0,0
Ccc_XD3_dmodout_mod4 XD3_dmodout mod4 2.4201e-17
* device instance cc_XD3_dmodout_net1 r0 *1 0,0
Ccc_XD3_dmodout_net1 XD3_dmodout net1 1.21e-17
* device instance cc_XD3_dq_XD3_nm r0 *1 0,0
Ccc_XD3_dq_XD3_nm XD3_dq XD3_nm 1.21e-17
* device instance cc_XD3_dq_XD3_nt r0 *1 0,0
Ccc_XD3_dq_XD3_nt XD3_dq XD3_nt 2.4201e-17
* device instance cc_XD3_dq_XD3_t1 r0 *1 0,0
Ccc_XD3_dq_XD3_t1 XD3_dq XD3_t1 1.8151e-17
* device instance cc_XD3_dq_XD4_XDFFM_CKBB r0 *1 0,0
Ccc_XD3_dq_XD4_XDFFM_CKBB XD3_dq XD4_XDFFM_CKBB 1.8151e-17
* device instance cc_XD3_dq_XD4_XDFFM_CLKB r0 *1 0,0
Ccc_XD3_dq_XD4_XDFFM_CLKB XD3_dq XD4_XDFFM_CLKB 2.4201e-17
* device instance cc_XD3_dq_XD4_XDFFM_M r0 *1 0,0
Ccc_XD3_dq_XD4_XDFFM_M XD3_dq XD4_XDFFM_M 2.4201e-17
* device instance cc_XD3_dq_XD4_XDFFM_MB r0 *1 0,0
Ccc_XD3_dq_XD4_XDFFM_MB XD3_dq XD4_XDFFM_MB 1.21e-17
* device instance cc_XD3_dq_XD4_XDFFM_MFB r0 *1 0,0
Ccc_XD3_dq_XD4_XDFFM_MFB XD3_dq XD4_XDFFM_MFB 1.21e-17
* device instance cc_XD3_dq_XD4_XDFFM_S r0 *1 0,0
Ccc_XD3_dq_XD4_XDFFM_S XD3_dq XD4_XDFFM_S 1.8151e-17
* device instance cc_XD3_dq_XD4_XDFFM_SB r0 *1 0,0
Ccc_XD3_dq_XD4_XDFFM_SB XD3_dq XD4_XDFFM_SB 1.8151e-17
* device instance cc_XD3_dq_XD4_XDFFM_SFB r0 *1 0,0
Ccc_XD3_dq_XD4_XDFFM_SFB XD3_dq XD4_XDFFM_SFB 1.21e-17
* device instance cc_XD3_dq_XD4_XDFFQ_CKBB r0 *1 0,0
Ccc_XD3_dq_XD4_XDFFQ_CKBB XD3_dq XD4_XDFFQ_CKBB 1.8151e-17
* device instance cc_XD3_dq_XD4_XDFFQ_CLKB r0 *1 0,0
Ccc_XD3_dq_XD4_XDFFQ_CLKB XD3_dq XD4_XDFFQ_CLKB 2.4201e-17
* device instance cc_XD3_dq_XD4_XDFFQ_M r0 *1 0,0
Ccc_XD3_dq_XD4_XDFFQ_M XD3_dq XD4_XDFFQ_M 2.4201e-17
* device instance cc_XD3_dq_XD4_XDFFQ_MB r0 *1 0,0
Ccc_XD3_dq_XD4_XDFFQ_MB XD3_dq XD4_XDFFQ_MB 1.21e-17
* device instance cc_XD3_dq_XD4_XDFFQ_MFB r0 *1 0,0
Ccc_XD3_dq_XD4_XDFFQ_MFB XD3_dq XD4_XDFFQ_MFB 1.21e-17
* device instance cc_XD3_dq_XD4_XDFFQ_S r0 *1 0,0
Ccc_XD3_dq_XD4_XDFFQ_S XD3_dq XD4_XDFFQ_S 1.8151e-17
* device instance cc_XD3_dq_XD4_XDFFQ_SB r0 *1 0,0
Ccc_XD3_dq_XD4_XDFFQ_SB XD3_dq XD4_XDFFQ_SB 1.8151e-17
* device instance cc_XD3_dq_XD4_XDFFQ_SFB r0 *1 0,0
Ccc_XD3_dq_XD4_XDFFQ_SFB XD3_dq XD4_XDFFQ_SFB 1.21e-17
* device instance cc_XD3_dq_XD4_XN2_mid1 r0 *1 0,0
Ccc_XD3_dq_XD4_XN2_mid1 XD3_dq XD4_XN2_mid1 1.21e-17
* device instance cc_XD3_dq_XD4_XN3_mid1 r0 *1 0,0
Ccc_XD3_dq_XD4_XN3_mid1 XD3_dq XD4_XN3_mid1 1.21e-17
* device instance cc_XD3_dq_XD4_XN3_mid2 r0 *1 0,0
Ccc_XD3_dq_XD4_XN3_mid2 XD3_dq XD4_XN3_mid2 1.21e-17
* device instance cc_XD3_dq_XD4_dmodout r0 *1 0,0
Ccc_XD3_dq_XD4_dmodout XD3_dq XD4_dmodout 1.21e-17
* device instance cc_XD3_dq_XD4_dq r0 *1 0,0
Ccc_XD3_dq_XD4_dq XD3_dq XD4_dq 1.8151e-17
* device instance cc_XD3_dq_XD4_nm r0 *1 0,0
Ccc_XD3_dq_XD4_nm XD3_dq XD4_nm 1.21e-17
* device instance cc_XD3_dq_XD4_nt r0 *1 0,0
Ccc_XD3_dq_XD4_nt XD3_dq XD4_nt 1.21e-17
* device instance cc_XD3_dq_XD4_t1 r0 *1 0,0
Ccc_XD3_dq_XD4_t1 XD3_dq XD4_t1 1.21e-17
* device instance cc_XD3_dq_XD5_XDFFM_CKBB r0 *1 0,0
Ccc_XD3_dq_XD5_XDFFM_CKBB XD3_dq XD5_XDFFM_CKBB 1.8151e-17
* device instance cc_XD3_dq_XD5_XDFFM_CLKB r0 *1 0,0
Ccc_XD3_dq_XD5_XDFFM_CLKB XD3_dq XD5_XDFFM_CLKB 2.4201e-17
* device instance cc_XD3_dq_XD5_XDFFM_M r0 *1 0,0
Ccc_XD3_dq_XD5_XDFFM_M XD3_dq XD5_XDFFM_M 2.4201e-17
* device instance cc_XD3_dq_XD5_XDFFM_MB r0 *1 0,0
Ccc_XD3_dq_XD5_XDFFM_MB XD3_dq XD5_XDFFM_MB 1.21e-17
* device instance cc_XD3_dq_XD5_XDFFM_MFB r0 *1 0,0
Ccc_XD3_dq_XD5_XDFFM_MFB XD3_dq XD5_XDFFM_MFB 1.21e-17
* device instance cc_XD3_dq_XD5_XDFFM_S r0 *1 0,0
Ccc_XD3_dq_XD5_XDFFM_S XD3_dq XD5_XDFFM_S 1.8151e-17
* device instance cc_XD3_dq_XD5_XDFFM_SB r0 *1 0,0
Ccc_XD3_dq_XD5_XDFFM_SB XD3_dq XD5_XDFFM_SB 1.8151e-17
* device instance cc_XD3_dq_XD5_XDFFM_SFB r0 *1 0,0
Ccc_XD3_dq_XD5_XDFFM_SFB XD3_dq XD5_XDFFM_SFB 1.21e-17
* device instance cc_XD3_dq_XD5_XDFFQ_CKBB r0 *1 0,0
Ccc_XD3_dq_XD5_XDFFQ_CKBB XD3_dq XD5_XDFFQ_CKBB 1.8151e-17
* device instance cc_XD3_dq_XD5_XDFFQ_CLKB r0 *1 0,0
Ccc_XD3_dq_XD5_XDFFQ_CLKB XD3_dq XD5_XDFFQ_CLKB 2.4201e-17
* device instance cc_XD3_dq_XD5_XDFFQ_M r0 *1 0,0
Ccc_XD3_dq_XD5_XDFFQ_M XD3_dq XD5_XDFFQ_M 2.4201e-17
* device instance cc_XD3_dq_XD5_XDFFQ_MB r0 *1 0,0
Ccc_XD3_dq_XD5_XDFFQ_MB XD3_dq XD5_XDFFQ_MB 1.21e-17
* device instance cc_XD3_dq_XD5_XDFFQ_MFB r0 *1 0,0
Ccc_XD3_dq_XD5_XDFFQ_MFB XD3_dq XD5_XDFFQ_MFB 1.21e-17
* device instance cc_XD3_dq_XD5_XDFFQ_S r0 *1 0,0
Ccc_XD3_dq_XD5_XDFFQ_S XD3_dq XD5_XDFFQ_S 1.8151e-17
* device instance cc_XD3_dq_XD5_XDFFQ_SB r0 *1 0,0
Ccc_XD3_dq_XD5_XDFFQ_SB XD3_dq XD5_XDFFQ_SB 1.8151e-17
* device instance cc_XD3_dq_XD5_XDFFQ_SFB r0 *1 0,0
Ccc_XD3_dq_XD5_XDFFQ_SFB XD3_dq XD5_XDFFQ_SFB 1.21e-17
* device instance cc_XD3_dq_XD5_XN2_mid1 r0 *1 0,0
Ccc_XD3_dq_XD5_XN2_mid1 XD3_dq XD5_XN2_mid1 1.21e-17
* device instance cc_XD3_dq_XD5_XN3_mid1 r0 *1 0,0
Ccc_XD3_dq_XD5_XN3_mid1 XD3_dq XD5_XN3_mid1 1.21e-17
* device instance cc_XD3_dq_XD5_XN3_mid2 r0 *1 0,0
Ccc_XD3_dq_XD5_XN3_mid2 XD3_dq XD5_XN3_mid2 1.21e-17
* device instance cc_XD3_dq_XD5_dmodout r0 *1 0,0
Ccc_XD3_dq_XD5_dmodout XD3_dq XD5_dmodout 1.21e-17
* device instance cc_XD3_dq_XD5_dq r0 *1 0,0
Ccc_XD3_dq_XD5_dq XD3_dq XD5_dq 1.8151e-17
* device instance cc_XD3_dq_XD5_nm r0 *1 0,0
Ccc_XD3_dq_XD5_nm XD3_dq XD5_nm 1.21e-17
* device instance cc_XD3_dq_XD5_nt r0 *1 0,0
Ccc_XD3_dq_XD5_nt XD3_dq XD5_nt 1.21e-17
* device instance cc_XD3_dq_XD5_t1 r0 *1 0,0
Ccc_XD3_dq_XD5_t1 XD3_dq XD5_t1 1.21e-17
* device instance cc_XD3_dq_XFRT_CKBB r0 *1 0,0
Ccc_XD3_dq_XFRT_CKBB XD3_dq XFRT_CKBB 1.8151e-17
* device instance cc_XD3_dq_XFRT_CLKB r0 *1 0,0
Ccc_XD3_dq_XFRT_CLKB XD3_dq XFRT_CLKB 2.4201e-17
* device instance cc_XD3_dq_XFRT_M r0 *1 0,0
Ccc_XD3_dq_XFRT_M XD3_dq XFRT_M 2.4201e-17
* device instance cc_XD3_dq_XFRT_MB r0 *1 0,0
Ccc_XD3_dq_XFRT_MB XD3_dq XFRT_MB 1.21e-17
* device instance cc_XD3_dq_XFRT_MFB r0 *1 0,0
Ccc_XD3_dq_XFRT_MFB XD3_dq XFRT_MFB 1.21e-17
* device instance cc_XD3_dq_XFRT_S r0 *1 0,0
Ccc_XD3_dq_XFRT_S XD3_dq XFRT_S 1.8151e-17
* device instance cc_XD3_dq_XFRT_SB r0 *1 0,0
Ccc_XD3_dq_XFRT_SB XD3_dq XFRT_SB 1.8151e-17
* device instance cc_XD3_dq_XFRT_SFB r0 *1 0,0
Ccc_XD3_dq_XFRT_SFB XD3_dq XFRT_SFB 1.21e-17
* device instance cc_XD3_dq_ck1 r0 *1 0,0
Ccc_XD3_dq_ck1 XD3_dq ck1 3.0251e-17
* device instance cc_XD3_dq_ck2 r0 *1 0,0
Ccc_XD3_dq_ck2 XD3_dq ck2 3.0251e-17
* device instance cc_XD3_dq_ck3 r0 *1 0,0
Ccc_XD3_dq_ck3 XD3_dq ck3 3.6302e-17
* device instance cc_XD3_dq_ck4 r0 *1 0,0
Ccc_XD3_dq_ck4 XD3_dq ck4 3.0251e-17
* device instance cc_XD3_dq_ck5 r0 *1 0,0
Ccc_XD3_dq_ck5 XD3_dq ck5 3.0251e-17
* device instance cc_XD3_dq_mod0 r0 *1 0,0
Ccc_XD3_dq_mod0 XD3_dq mod0 2.4201e-17
* device instance cc_XD3_dq_mod1 r0 *1 0,0
Ccc_XD3_dq_mod1 XD3_dq mod1 2.4201e-17
* device instance cc_XD3_dq_mod2 r0 *1 0,0
Ccc_XD3_dq_mod2 XD3_dq mod2 2.4201e-17
* device instance cc_XD3_dq_mod3 r0 *1 0,0
Ccc_XD3_dq_mod3 XD3_dq mod3 2.4201e-17
* device instance cc_XD3_dq_mod4 r0 *1 0,0
Ccc_XD3_dq_mod4 XD3_dq mod4 2.4201e-17
* device instance cc_XD3_dq_net1 r0 *1 0,0
Ccc_XD3_dq_net1 XD3_dq net1 1.21e-17
* device instance cc_XD3_nm_XD3_nt r0 *1 0,0
Ccc_XD3_nm_XD3_nt XD3_nm XD3_nt 2.4201e-17
* device instance cc_XD3_nm_XD3_t1 r0 *1 0,0
Ccc_XD3_nm_XD3_t1 XD3_nm XD3_t1 1.21e-17
* device instance cc_XD3_nm_XD4_XDFFM_CKBB r0 *1 0,0
Ccc_XD3_nm_XD4_XDFFM_CKBB XD3_nm XD4_XDFFM_CKBB 1.8151e-17
* device instance cc_XD3_nm_XD4_XDFFM_CLKB r0 *1 0,0
Ccc_XD3_nm_XD4_XDFFM_CLKB XD3_nm XD4_XDFFM_CLKB 2.4201e-17
* device instance cc_XD3_nm_XD4_XDFFM_M r0 *1 0,0
Ccc_XD3_nm_XD4_XDFFM_M XD3_nm XD4_XDFFM_M 2.4201e-17
* device instance cc_XD3_nm_XD4_XDFFM_MB r0 *1 0,0
Ccc_XD3_nm_XD4_XDFFM_MB XD3_nm XD4_XDFFM_MB 1.21e-17
* device instance cc_XD3_nm_XD4_XDFFM_MFB r0 *1 0,0
Ccc_XD3_nm_XD4_XDFFM_MFB XD3_nm XD4_XDFFM_MFB 1.21e-17
* device instance cc_XD3_nm_XD4_XDFFM_S r0 *1 0,0
Ccc_XD3_nm_XD4_XDFFM_S XD3_nm XD4_XDFFM_S 1.8151e-17
* device instance cc_XD3_nm_XD4_XDFFM_SB r0 *1 0,0
Ccc_XD3_nm_XD4_XDFFM_SB XD3_nm XD4_XDFFM_SB 1.8151e-17
* device instance cc_XD3_nm_XD4_XDFFM_SFB r0 *1 0,0
Ccc_XD3_nm_XD4_XDFFM_SFB XD3_nm XD4_XDFFM_SFB 1.21e-17
* device instance cc_XD3_nm_XD4_XDFFQ_CKBB r0 *1 0,0
Ccc_XD3_nm_XD4_XDFFQ_CKBB XD3_nm XD4_XDFFQ_CKBB 1.8151e-17
* device instance cc_XD3_nm_XD4_XDFFQ_CLKB r0 *1 0,0
Ccc_XD3_nm_XD4_XDFFQ_CLKB XD3_nm XD4_XDFFQ_CLKB 2.4201e-17
* device instance cc_XD3_nm_XD4_XDFFQ_M r0 *1 0,0
Ccc_XD3_nm_XD4_XDFFQ_M XD3_nm XD4_XDFFQ_M 2.4201e-17
* device instance cc_XD3_nm_XD4_XDFFQ_MB r0 *1 0,0
Ccc_XD3_nm_XD4_XDFFQ_MB XD3_nm XD4_XDFFQ_MB 1.21e-17
* device instance cc_XD3_nm_XD4_XDFFQ_MFB r0 *1 0,0
Ccc_XD3_nm_XD4_XDFFQ_MFB XD3_nm XD4_XDFFQ_MFB 1.21e-17
* device instance cc_XD3_nm_XD4_XDFFQ_S r0 *1 0,0
Ccc_XD3_nm_XD4_XDFFQ_S XD3_nm XD4_XDFFQ_S 1.8151e-17
* device instance cc_XD3_nm_XD4_XDFFQ_SB r0 *1 0,0
Ccc_XD3_nm_XD4_XDFFQ_SB XD3_nm XD4_XDFFQ_SB 1.8151e-17
* device instance cc_XD3_nm_XD4_XDFFQ_SFB r0 *1 0,0
Ccc_XD3_nm_XD4_XDFFQ_SFB XD3_nm XD4_XDFFQ_SFB 1.21e-17
* device instance cc_XD3_nm_XD4_XN2_mid1 r0 *1 0,0
Ccc_XD3_nm_XD4_XN2_mid1 XD3_nm XD4_XN2_mid1 1.21e-17
* device instance cc_XD3_nm_XD4_XN3_mid1 r0 *1 0,0
Ccc_XD3_nm_XD4_XN3_mid1 XD3_nm XD4_XN3_mid1 1.21e-17
* device instance cc_XD3_nm_XD4_XN3_mid2 r0 *1 0,0
Ccc_XD3_nm_XD4_XN3_mid2 XD3_nm XD4_XN3_mid2 1.21e-17
* device instance cc_XD3_nm_XD4_dmodout r0 *1 0,0
Ccc_XD3_nm_XD4_dmodout XD3_nm XD4_dmodout 1.21e-17
* device instance cc_XD3_nm_XD4_dq r0 *1 0,0
Ccc_XD3_nm_XD4_dq XD3_nm XD4_dq 1.8151e-17
* device instance cc_XD3_nm_XD4_nm r0 *1 0,0
Ccc_XD3_nm_XD4_nm XD3_nm XD4_nm 1.21e-17
* device instance cc_XD3_nm_XD4_nt r0 *1 0,0
Ccc_XD3_nm_XD4_nt XD3_nm XD4_nt 1.21e-17
* device instance cc_XD3_nm_XD4_t1 r0 *1 0,0
Ccc_XD3_nm_XD4_t1 XD3_nm XD4_t1 1.21e-17
* device instance cc_XD3_nm_XD5_XDFFM_CKBB r0 *1 0,0
Ccc_XD3_nm_XD5_XDFFM_CKBB XD3_nm XD5_XDFFM_CKBB 1.8151e-17
* device instance cc_XD3_nm_XD5_XDFFM_CLKB r0 *1 0,0
Ccc_XD3_nm_XD5_XDFFM_CLKB XD3_nm XD5_XDFFM_CLKB 2.4201e-17
* device instance cc_XD3_nm_XD5_XDFFM_M r0 *1 0,0
Ccc_XD3_nm_XD5_XDFFM_M XD3_nm XD5_XDFFM_M 2.4201e-17
* device instance cc_XD3_nm_XD5_XDFFM_MB r0 *1 0,0
Ccc_XD3_nm_XD5_XDFFM_MB XD3_nm XD5_XDFFM_MB 1.21e-17
* device instance cc_XD3_nm_XD5_XDFFM_MFB r0 *1 0,0
Ccc_XD3_nm_XD5_XDFFM_MFB XD3_nm XD5_XDFFM_MFB 1.21e-17
* device instance cc_XD3_nm_XD5_XDFFM_S r0 *1 0,0
Ccc_XD3_nm_XD5_XDFFM_S XD3_nm XD5_XDFFM_S 1.8151e-17
* device instance cc_XD3_nm_XD5_XDFFM_SB r0 *1 0,0
Ccc_XD3_nm_XD5_XDFFM_SB XD3_nm XD5_XDFFM_SB 1.8151e-17
* device instance cc_XD3_nm_XD5_XDFFM_SFB r0 *1 0,0
Ccc_XD3_nm_XD5_XDFFM_SFB XD3_nm XD5_XDFFM_SFB 1.21e-17
* device instance cc_XD3_nm_XD5_XDFFQ_CKBB r0 *1 0,0
Ccc_XD3_nm_XD5_XDFFQ_CKBB XD3_nm XD5_XDFFQ_CKBB 1.8151e-17
* device instance cc_XD3_nm_XD5_XDFFQ_CLKB r0 *1 0,0
Ccc_XD3_nm_XD5_XDFFQ_CLKB XD3_nm XD5_XDFFQ_CLKB 2.4201e-17
* device instance cc_XD3_nm_XD5_XDFFQ_M r0 *1 0,0
Ccc_XD3_nm_XD5_XDFFQ_M XD3_nm XD5_XDFFQ_M 2.4201e-17
* device instance cc_XD3_nm_XD5_XDFFQ_MB r0 *1 0,0
Ccc_XD3_nm_XD5_XDFFQ_MB XD3_nm XD5_XDFFQ_MB 1.21e-17
* device instance cc_XD3_nm_XD5_XDFFQ_MFB r0 *1 0,0
Ccc_XD3_nm_XD5_XDFFQ_MFB XD3_nm XD5_XDFFQ_MFB 1.21e-17
* device instance cc_XD3_nm_XD5_XDFFQ_S r0 *1 0,0
Ccc_XD3_nm_XD5_XDFFQ_S XD3_nm XD5_XDFFQ_S 1.8151e-17
* device instance cc_XD3_nm_XD5_XDFFQ_SB r0 *1 0,0
Ccc_XD3_nm_XD5_XDFFQ_SB XD3_nm XD5_XDFFQ_SB 1.8151e-17
* device instance cc_XD3_nm_XD5_XDFFQ_SFB r0 *1 0,0
Ccc_XD3_nm_XD5_XDFFQ_SFB XD3_nm XD5_XDFFQ_SFB 1.21e-17
* device instance cc_XD3_nm_XD5_XN2_mid1 r0 *1 0,0
Ccc_XD3_nm_XD5_XN2_mid1 XD3_nm XD5_XN2_mid1 1.21e-17
* device instance cc_XD3_nm_XD5_XN3_mid1 r0 *1 0,0
Ccc_XD3_nm_XD5_XN3_mid1 XD3_nm XD5_XN3_mid1 1.21e-17
* device instance cc_XD3_nm_XD5_XN3_mid2 r0 *1 0,0
Ccc_XD3_nm_XD5_XN3_mid2 XD3_nm XD5_XN3_mid2 1.21e-17
* device instance cc_XD3_nm_XD5_dmodout r0 *1 0,0
Ccc_XD3_nm_XD5_dmodout XD3_nm XD5_dmodout 1.21e-17
* device instance cc_XD3_nm_XD5_dq r0 *1 0,0
Ccc_XD3_nm_XD5_dq XD3_nm XD5_dq 1.8151e-17
* device instance cc_XD3_nm_XD5_nm r0 *1 0,0
Ccc_XD3_nm_XD5_nm XD3_nm XD5_nm 1.21e-17
* device instance cc_XD3_nm_XD5_nt r0 *1 0,0
Ccc_XD3_nm_XD5_nt XD3_nm XD5_nt 1.21e-17
* device instance cc_XD3_nm_XD5_t1 r0 *1 0,0
Ccc_XD3_nm_XD5_t1 XD3_nm XD5_t1 1.21e-17
* device instance cc_XD3_nm_XFRT_CKBB r0 *1 0,0
Ccc_XD3_nm_XFRT_CKBB XD3_nm XFRT_CKBB 1.8151e-17
* device instance cc_XD3_nm_XFRT_CLKB r0 *1 0,0
Ccc_XD3_nm_XFRT_CLKB XD3_nm XFRT_CLKB 2.4201e-17
* device instance cc_XD3_nm_XFRT_M r0 *1 0,0
Ccc_XD3_nm_XFRT_M XD3_nm XFRT_M 2.4201e-17
* device instance cc_XD3_nm_XFRT_MB r0 *1 0,0
Ccc_XD3_nm_XFRT_MB XD3_nm XFRT_MB 1.21e-17
* device instance cc_XD3_nm_XFRT_MFB r0 *1 0,0
Ccc_XD3_nm_XFRT_MFB XD3_nm XFRT_MFB 1.21e-17
* device instance cc_XD3_nm_XFRT_S r0 *1 0,0
Ccc_XD3_nm_XFRT_S XD3_nm XFRT_S 1.8151e-17
* device instance cc_XD3_nm_XFRT_SB r0 *1 0,0
Ccc_XD3_nm_XFRT_SB XD3_nm XFRT_SB 1.8151e-17
* device instance cc_XD3_nm_XFRT_SFB r0 *1 0,0
Ccc_XD3_nm_XFRT_SFB XD3_nm XFRT_SFB 1.21e-17
* device instance cc_XD3_nm_ck1 r0 *1 0,0
Ccc_XD3_nm_ck1 XD3_nm ck1 3.0251e-17
* device instance cc_XD3_nm_ck2 r0 *1 0,0
Ccc_XD3_nm_ck2 XD3_nm ck2 3.0251e-17
* device instance cc_XD3_nm_ck3 r0 *1 0,0
Ccc_XD3_nm_ck3 XD3_nm ck3 3.0251e-17
* device instance cc_XD3_nm_ck4 r0 *1 0,0
Ccc_XD3_nm_ck4 XD3_nm ck4 3.6302e-17
* device instance cc_XD3_nm_ck5 r0 *1 0,0
Ccc_XD3_nm_ck5 XD3_nm ck5 3.0251e-17
* device instance cc_XD3_nm_mod0 r0 *1 0,0
Ccc_XD3_nm_mod0 XD3_nm mod0 2.4201e-17
* device instance cc_XD3_nm_mod1 r0 *1 0,0
Ccc_XD3_nm_mod1 XD3_nm mod1 2.4201e-17
* device instance cc_XD3_nm_mod2 r0 *1 0,0
Ccc_XD3_nm_mod2 XD3_nm mod2 2.4201e-17
* device instance cc_XD3_nm_mod3 r0 *1 0,0
Ccc_XD3_nm_mod3 XD3_nm mod3 2.4201e-17
* device instance cc_XD3_nm_mod4 r0 *1 0,0
Ccc_XD3_nm_mod4 XD3_nm mod4 2.4201e-17
* device instance cc_XD3_nm_net1 r0 *1 0,0
Ccc_XD3_nm_net1 XD3_nm net1 1.21e-17
* device instance cc_XD3_nt_XD3_t1 r0 *1 0,0
Ccc_XD3_nt_XD3_t1 XD3_nt XD3_t1 1.21e-17
* device instance cc_XD3_nt_XD4_XDFFM_CKBB r0 *1 0,0
Ccc_XD3_nt_XD4_XDFFM_CKBB XD3_nt XD4_XDFFM_CKBB 1.8151e-17
* device instance cc_XD3_nt_XD4_XDFFM_CLKB r0 *1 0,0
Ccc_XD3_nt_XD4_XDFFM_CLKB XD3_nt XD4_XDFFM_CLKB 2.4201e-17
* device instance cc_XD3_nt_XD4_XDFFM_M r0 *1 0,0
Ccc_XD3_nt_XD4_XDFFM_M XD3_nt XD4_XDFFM_M 2.4201e-17
* device instance cc_XD3_nt_XD4_XDFFM_MB r0 *1 0,0
Ccc_XD3_nt_XD4_XDFFM_MB XD3_nt XD4_XDFFM_MB 1.21e-17
* device instance cc_XD3_nt_XD4_XDFFM_MFB r0 *1 0,0
Ccc_XD3_nt_XD4_XDFFM_MFB XD3_nt XD4_XDFFM_MFB 1.21e-17
* device instance cc_XD3_nt_XD4_XDFFM_S r0 *1 0,0
Ccc_XD3_nt_XD4_XDFFM_S XD3_nt XD4_XDFFM_S 1.8151e-17
* device instance cc_XD3_nt_XD4_XDFFM_SB r0 *1 0,0
Ccc_XD3_nt_XD4_XDFFM_SB XD3_nt XD4_XDFFM_SB 1.8151e-17
* device instance cc_XD3_nt_XD4_XDFFM_SFB r0 *1 0,0
Ccc_XD3_nt_XD4_XDFFM_SFB XD3_nt XD4_XDFFM_SFB 1.21e-17
* device instance cc_XD3_nt_XD4_XDFFQ_CKBB r0 *1 0,0
Ccc_XD3_nt_XD4_XDFFQ_CKBB XD3_nt XD4_XDFFQ_CKBB 1.8151e-17
* device instance cc_XD3_nt_XD4_XDFFQ_CLKB r0 *1 0,0
Ccc_XD3_nt_XD4_XDFFQ_CLKB XD3_nt XD4_XDFFQ_CLKB 2.4201e-17
* device instance cc_XD3_nt_XD4_XDFFQ_M r0 *1 0,0
Ccc_XD3_nt_XD4_XDFFQ_M XD3_nt XD4_XDFFQ_M 2.4201e-17
* device instance cc_XD3_nt_XD4_XDFFQ_MB r0 *1 0,0
Ccc_XD3_nt_XD4_XDFFQ_MB XD3_nt XD4_XDFFQ_MB 1.21e-17
* device instance cc_XD3_nt_XD4_XDFFQ_MFB r0 *1 0,0
Ccc_XD3_nt_XD4_XDFFQ_MFB XD3_nt XD4_XDFFQ_MFB 1.21e-17
* device instance cc_XD3_nt_XD4_XDFFQ_S r0 *1 0,0
Ccc_XD3_nt_XD4_XDFFQ_S XD3_nt XD4_XDFFQ_S 1.8151e-17
* device instance cc_XD3_nt_XD4_XDFFQ_SB r0 *1 0,0
Ccc_XD3_nt_XD4_XDFFQ_SB XD3_nt XD4_XDFFQ_SB 1.8151e-17
* device instance cc_XD3_nt_XD4_XDFFQ_SFB r0 *1 0,0
Ccc_XD3_nt_XD4_XDFFQ_SFB XD3_nt XD4_XDFFQ_SFB 1.21e-17
* device instance cc_XD3_nt_XD4_XN2_mid1 r0 *1 0,0
Ccc_XD3_nt_XD4_XN2_mid1 XD3_nt XD4_XN2_mid1 1.21e-17
* device instance cc_XD3_nt_XD4_XN3_mid1 r0 *1 0,0
Ccc_XD3_nt_XD4_XN3_mid1 XD3_nt XD4_XN3_mid1 1.21e-17
* device instance cc_XD3_nt_XD4_XN3_mid2 r0 *1 0,0
Ccc_XD3_nt_XD4_XN3_mid2 XD3_nt XD4_XN3_mid2 1.21e-17
* device instance cc_XD3_nt_XD4_dmodout r0 *1 0,0
Ccc_XD3_nt_XD4_dmodout XD3_nt XD4_dmodout 1.21e-17
* device instance cc_XD3_nt_XD4_dq r0 *1 0,0
Ccc_XD3_nt_XD4_dq XD3_nt XD4_dq 1.8151e-17
* device instance cc_XD3_nt_XD4_nm r0 *1 0,0
Ccc_XD3_nt_XD4_nm XD3_nt XD4_nm 1.21e-17
* device instance cc_XD3_nt_XD4_nt r0 *1 0,0
Ccc_XD3_nt_XD4_nt XD3_nt XD4_nt 1.21e-17
* device instance cc_XD3_nt_XD4_t1 r0 *1 0,0
Ccc_XD3_nt_XD4_t1 XD3_nt XD4_t1 1.21e-17
* device instance cc_XD3_nt_XD5_XDFFM_CKBB r0 *1 0,0
Ccc_XD3_nt_XD5_XDFFM_CKBB XD3_nt XD5_XDFFM_CKBB 1.8151e-17
* device instance cc_XD3_nt_XD5_XDFFM_CLKB r0 *1 0,0
Ccc_XD3_nt_XD5_XDFFM_CLKB XD3_nt XD5_XDFFM_CLKB 2.4201e-17
* device instance cc_XD3_nt_XD5_XDFFM_M r0 *1 0,0
Ccc_XD3_nt_XD5_XDFFM_M XD3_nt XD5_XDFFM_M 2.4201e-17
* device instance cc_XD3_nt_XD5_XDFFM_MB r0 *1 0,0
Ccc_XD3_nt_XD5_XDFFM_MB XD3_nt XD5_XDFFM_MB 1.21e-17
* device instance cc_XD3_nt_XD5_XDFFM_MFB r0 *1 0,0
Ccc_XD3_nt_XD5_XDFFM_MFB XD3_nt XD5_XDFFM_MFB 1.21e-17
* device instance cc_XD3_nt_XD5_XDFFM_S r0 *1 0,0
Ccc_XD3_nt_XD5_XDFFM_S XD3_nt XD5_XDFFM_S 1.8151e-17
* device instance cc_XD3_nt_XD5_XDFFM_SB r0 *1 0,0
Ccc_XD3_nt_XD5_XDFFM_SB XD3_nt XD5_XDFFM_SB 1.8151e-17
* device instance cc_XD3_nt_XD5_XDFFM_SFB r0 *1 0,0
Ccc_XD3_nt_XD5_XDFFM_SFB XD3_nt XD5_XDFFM_SFB 1.21e-17
* device instance cc_XD3_nt_XD5_XDFFQ_CKBB r0 *1 0,0
Ccc_XD3_nt_XD5_XDFFQ_CKBB XD3_nt XD5_XDFFQ_CKBB 1.8151e-17
* device instance cc_XD3_nt_XD5_XDFFQ_CLKB r0 *1 0,0
Ccc_XD3_nt_XD5_XDFFQ_CLKB XD3_nt XD5_XDFFQ_CLKB 2.4201e-17
* device instance cc_XD3_nt_XD5_XDFFQ_M r0 *1 0,0
Ccc_XD3_nt_XD5_XDFFQ_M XD3_nt XD5_XDFFQ_M 2.4201e-17
* device instance cc_XD3_nt_XD5_XDFFQ_MB r0 *1 0,0
Ccc_XD3_nt_XD5_XDFFQ_MB XD3_nt XD5_XDFFQ_MB 1.21e-17
* device instance cc_XD3_nt_XD5_XDFFQ_MFB r0 *1 0,0
Ccc_XD3_nt_XD5_XDFFQ_MFB XD3_nt XD5_XDFFQ_MFB 1.21e-17
* device instance cc_XD3_nt_XD5_XDFFQ_S r0 *1 0,0
Ccc_XD3_nt_XD5_XDFFQ_S XD3_nt XD5_XDFFQ_S 1.8151e-17
* device instance cc_XD3_nt_XD5_XDFFQ_SB r0 *1 0,0
Ccc_XD3_nt_XD5_XDFFQ_SB XD3_nt XD5_XDFFQ_SB 1.8151e-17
* device instance cc_XD3_nt_XD5_XDFFQ_SFB r0 *1 0,0
Ccc_XD3_nt_XD5_XDFFQ_SFB XD3_nt XD5_XDFFQ_SFB 1.21e-17
* device instance cc_XD3_nt_XD5_XN2_mid1 r0 *1 0,0
Ccc_XD3_nt_XD5_XN2_mid1 XD3_nt XD5_XN2_mid1 1.21e-17
* device instance cc_XD3_nt_XD5_XN3_mid1 r0 *1 0,0
Ccc_XD3_nt_XD5_XN3_mid1 XD3_nt XD5_XN3_mid1 1.21e-17
* device instance cc_XD3_nt_XD5_XN3_mid2 r0 *1 0,0
Ccc_XD3_nt_XD5_XN3_mid2 XD3_nt XD5_XN3_mid2 1.21e-17
* device instance cc_XD3_nt_XD5_dmodout r0 *1 0,0
Ccc_XD3_nt_XD5_dmodout XD3_nt XD5_dmodout 1.21e-17
* device instance cc_XD3_nt_XD5_dq r0 *1 0,0
Ccc_XD3_nt_XD5_dq XD3_nt XD5_dq 1.8151e-17
* device instance cc_XD3_nt_XD5_nm r0 *1 0,0
Ccc_XD3_nt_XD5_nm XD3_nt XD5_nm 1.21e-17
* device instance cc_XD3_nt_XD5_nt r0 *1 0,0
Ccc_XD3_nt_XD5_nt XD3_nt XD5_nt 1.21e-17
* device instance cc_XD3_nt_XD5_t1 r0 *1 0,0
Ccc_XD3_nt_XD5_t1 XD3_nt XD5_t1 1.21e-17
* device instance cc_XD3_nt_XFRT_CKBB r0 *1 0,0
Ccc_XD3_nt_XFRT_CKBB XD3_nt XFRT_CKBB 1.8151e-17
* device instance cc_XD3_nt_XFRT_CLKB r0 *1 0,0
Ccc_XD3_nt_XFRT_CLKB XD3_nt XFRT_CLKB 2.4201e-17
* device instance cc_XD3_nt_XFRT_M r0 *1 0,0
Ccc_XD3_nt_XFRT_M XD3_nt XFRT_M 2.4201e-17
* device instance cc_XD3_nt_XFRT_MB r0 *1 0,0
Ccc_XD3_nt_XFRT_MB XD3_nt XFRT_MB 1.21e-17
* device instance cc_XD3_nt_XFRT_MFB r0 *1 0,0
Ccc_XD3_nt_XFRT_MFB XD3_nt XFRT_MFB 1.21e-17
* device instance cc_XD3_nt_XFRT_S r0 *1 0,0
Ccc_XD3_nt_XFRT_S XD3_nt XFRT_S 1.8151e-17
* device instance cc_XD3_nt_XFRT_SB r0 *1 0,0
Ccc_XD3_nt_XFRT_SB XD3_nt XFRT_SB 1.8151e-17
* device instance cc_XD3_nt_XFRT_SFB r0 *1 0,0
Ccc_XD3_nt_XFRT_SFB XD3_nt XFRT_SFB 1.21e-17
* device instance cc_XD3_nt_ck1 r0 *1 0,0
Ccc_XD3_nt_ck1 XD3_nt ck1 3.0251e-17
* device instance cc_XD3_nt_ck2 r0 *1 0,0
Ccc_XD3_nt_ck2 XD3_nt ck2 3.0251e-17
* device instance cc_XD3_nt_ck3 r0 *1 0,0
Ccc_XD3_nt_ck3 XD3_nt ck3 3.0251e-17
* device instance cc_XD3_nt_ck4 r0 *1 0,0
Ccc_XD3_nt_ck4 XD3_nt ck4 3.0251e-17
* device instance cc_XD3_nt_ck5 r0 *1 0,0
Ccc_XD3_nt_ck5 XD3_nt ck5 3.0251e-17
* device instance cc_XD3_nt_mod0 r0 *1 0,0
Ccc_XD3_nt_mod0 XD3_nt mod0 2.4201e-17
* device instance cc_XD3_nt_mod1 r0 *1 0,0
Ccc_XD3_nt_mod1 XD3_nt mod1 2.4201e-17
* device instance cc_XD3_nt_mod2 r0 *1 0,0
Ccc_XD3_nt_mod2 XD3_nt mod2 3.0251e-17
* device instance cc_XD3_nt_mod3 r0 *1 0,0
Ccc_XD3_nt_mod3 XD3_nt mod3 2.4201e-17
* device instance cc_XD3_nt_mod4 r0 *1 0,0
Ccc_XD3_nt_mod4 XD3_nt mod4 2.4201e-17
* device instance cc_XD3_nt_net1 r0 *1 0,0
Ccc_XD3_nt_net1 XD3_nt net1 1.21e-17
* device instance cc_XD3_t1_XD4_XDFFM_CKBB r0 *1 0,0
Ccc_XD3_t1_XD4_XDFFM_CKBB XD3_t1 XD4_XDFFM_CKBB 1.8151e-17
* device instance cc_XD3_t1_XD4_XDFFM_CLKB r0 *1 0,0
Ccc_XD3_t1_XD4_XDFFM_CLKB XD3_t1 XD4_XDFFM_CLKB 2.4201e-17
* device instance cc_XD3_t1_XD4_XDFFM_M r0 *1 0,0
Ccc_XD3_t1_XD4_XDFFM_M XD3_t1 XD4_XDFFM_M 2.4201e-17
* device instance cc_XD3_t1_XD4_XDFFM_MB r0 *1 0,0
Ccc_XD3_t1_XD4_XDFFM_MB XD3_t1 XD4_XDFFM_MB 1.21e-17
* device instance cc_XD3_t1_XD4_XDFFM_MFB r0 *1 0,0
Ccc_XD3_t1_XD4_XDFFM_MFB XD3_t1 XD4_XDFFM_MFB 1.21e-17
* device instance cc_XD3_t1_XD4_XDFFM_S r0 *1 0,0
Ccc_XD3_t1_XD4_XDFFM_S XD3_t1 XD4_XDFFM_S 1.8151e-17
* device instance cc_XD3_t1_XD4_XDFFM_SB r0 *1 0,0
Ccc_XD3_t1_XD4_XDFFM_SB XD3_t1 XD4_XDFFM_SB 1.8151e-17
* device instance cc_XD3_t1_XD4_XDFFM_SFB r0 *1 0,0
Ccc_XD3_t1_XD4_XDFFM_SFB XD3_t1 XD4_XDFFM_SFB 1.21e-17
* device instance cc_XD3_t1_XD4_XDFFQ_CKBB r0 *1 0,0
Ccc_XD3_t1_XD4_XDFFQ_CKBB XD3_t1 XD4_XDFFQ_CKBB 1.8151e-17
* device instance cc_XD3_t1_XD4_XDFFQ_CLKB r0 *1 0,0
Ccc_XD3_t1_XD4_XDFFQ_CLKB XD3_t1 XD4_XDFFQ_CLKB 2.4201e-17
* device instance cc_XD3_t1_XD4_XDFFQ_M r0 *1 0,0
Ccc_XD3_t1_XD4_XDFFQ_M XD3_t1 XD4_XDFFQ_M 2.4201e-17
* device instance cc_XD3_t1_XD4_XDFFQ_MB r0 *1 0,0
Ccc_XD3_t1_XD4_XDFFQ_MB XD3_t1 XD4_XDFFQ_MB 1.21e-17
* device instance cc_XD3_t1_XD4_XDFFQ_MFB r0 *1 0,0
Ccc_XD3_t1_XD4_XDFFQ_MFB XD3_t1 XD4_XDFFQ_MFB 1.21e-17
* device instance cc_XD3_t1_XD4_XDFFQ_S r0 *1 0,0
Ccc_XD3_t1_XD4_XDFFQ_S XD3_t1 XD4_XDFFQ_S 1.8151e-17
* device instance cc_XD3_t1_XD4_XDFFQ_SB r0 *1 0,0
Ccc_XD3_t1_XD4_XDFFQ_SB XD3_t1 XD4_XDFFQ_SB 1.8151e-17
* device instance cc_XD3_t1_XD4_XDFFQ_SFB r0 *1 0,0
Ccc_XD3_t1_XD4_XDFFQ_SFB XD3_t1 XD4_XDFFQ_SFB 1.21e-17
* device instance cc_XD3_t1_XD4_XN2_mid1 r0 *1 0,0
Ccc_XD3_t1_XD4_XN2_mid1 XD3_t1 XD4_XN2_mid1 1.21e-17
* device instance cc_XD3_t1_XD4_XN3_mid1 r0 *1 0,0
Ccc_XD3_t1_XD4_XN3_mid1 XD3_t1 XD4_XN3_mid1 1.21e-17
* device instance cc_XD3_t1_XD4_XN3_mid2 r0 *1 0,0
Ccc_XD3_t1_XD4_XN3_mid2 XD3_t1 XD4_XN3_mid2 1.21e-17
* device instance cc_XD3_t1_XD4_dmodout r0 *1 0,0
Ccc_XD3_t1_XD4_dmodout XD3_t1 XD4_dmodout 1.21e-17
* device instance cc_XD3_t1_XD4_dq r0 *1 0,0
Ccc_XD3_t1_XD4_dq XD3_t1 XD4_dq 1.8151e-17
* device instance cc_XD3_t1_XD4_nm r0 *1 0,0
Ccc_XD3_t1_XD4_nm XD3_t1 XD4_nm 1.21e-17
* device instance cc_XD3_t1_XD4_nt r0 *1 0,0
Ccc_XD3_t1_XD4_nt XD3_t1 XD4_nt 1.21e-17
* device instance cc_XD3_t1_XD4_t1 r0 *1 0,0
Ccc_XD3_t1_XD4_t1 XD3_t1 XD4_t1 1.21e-17
* device instance cc_XD3_t1_XD5_XDFFM_CKBB r0 *1 0,0
Ccc_XD3_t1_XD5_XDFFM_CKBB XD3_t1 XD5_XDFFM_CKBB 1.8151e-17
* device instance cc_XD3_t1_XD5_XDFFM_CLKB r0 *1 0,0
Ccc_XD3_t1_XD5_XDFFM_CLKB XD3_t1 XD5_XDFFM_CLKB 2.4201e-17
* device instance cc_XD3_t1_XD5_XDFFM_M r0 *1 0,0
Ccc_XD3_t1_XD5_XDFFM_M XD3_t1 XD5_XDFFM_M 2.4201e-17
* device instance cc_XD3_t1_XD5_XDFFM_MB r0 *1 0,0
Ccc_XD3_t1_XD5_XDFFM_MB XD3_t1 XD5_XDFFM_MB 1.21e-17
* device instance cc_XD3_t1_XD5_XDFFM_MFB r0 *1 0,0
Ccc_XD3_t1_XD5_XDFFM_MFB XD3_t1 XD5_XDFFM_MFB 1.21e-17
* device instance cc_XD3_t1_XD5_XDFFM_S r0 *1 0,0
Ccc_XD3_t1_XD5_XDFFM_S XD3_t1 XD5_XDFFM_S 1.8151e-17
* device instance cc_XD3_t1_XD5_XDFFM_SB r0 *1 0,0
Ccc_XD3_t1_XD5_XDFFM_SB XD3_t1 XD5_XDFFM_SB 1.8151e-17
* device instance cc_XD3_t1_XD5_XDFFM_SFB r0 *1 0,0
Ccc_XD3_t1_XD5_XDFFM_SFB XD3_t1 XD5_XDFFM_SFB 1.21e-17
* device instance cc_XD3_t1_XD5_XDFFQ_CKBB r0 *1 0,0
Ccc_XD3_t1_XD5_XDFFQ_CKBB XD3_t1 XD5_XDFFQ_CKBB 1.8151e-17
* device instance cc_XD3_t1_XD5_XDFFQ_CLKB r0 *1 0,0
Ccc_XD3_t1_XD5_XDFFQ_CLKB XD3_t1 XD5_XDFFQ_CLKB 2.4201e-17
* device instance cc_XD3_t1_XD5_XDFFQ_M r0 *1 0,0
Ccc_XD3_t1_XD5_XDFFQ_M XD3_t1 XD5_XDFFQ_M 2.4201e-17
* device instance cc_XD3_t1_XD5_XDFFQ_MB r0 *1 0,0
Ccc_XD3_t1_XD5_XDFFQ_MB XD3_t1 XD5_XDFFQ_MB 1.21e-17
* device instance cc_XD3_t1_XD5_XDFFQ_MFB r0 *1 0,0
Ccc_XD3_t1_XD5_XDFFQ_MFB XD3_t1 XD5_XDFFQ_MFB 1.21e-17
* device instance cc_XD3_t1_XD5_XDFFQ_S r0 *1 0,0
Ccc_XD3_t1_XD5_XDFFQ_S XD3_t1 XD5_XDFFQ_S 1.8151e-17
* device instance cc_XD3_t1_XD5_XDFFQ_SB r0 *1 0,0
Ccc_XD3_t1_XD5_XDFFQ_SB XD3_t1 XD5_XDFFQ_SB 1.8151e-17
* device instance cc_XD3_t1_XD5_XDFFQ_SFB r0 *1 0,0
Ccc_XD3_t1_XD5_XDFFQ_SFB XD3_t1 XD5_XDFFQ_SFB 1.21e-17
* device instance cc_XD3_t1_XD5_XN2_mid1 r0 *1 0,0
Ccc_XD3_t1_XD5_XN2_mid1 XD3_t1 XD5_XN2_mid1 1.21e-17
* device instance cc_XD3_t1_XD5_XN3_mid1 r0 *1 0,0
Ccc_XD3_t1_XD5_XN3_mid1 XD3_t1 XD5_XN3_mid1 1.21e-17
* device instance cc_XD3_t1_XD5_XN3_mid2 r0 *1 0,0
Ccc_XD3_t1_XD5_XN3_mid2 XD3_t1 XD5_XN3_mid2 1.21e-17
* device instance cc_XD3_t1_XD5_dmodout r0 *1 0,0
Ccc_XD3_t1_XD5_dmodout XD3_t1 XD5_dmodout 1.21e-17
* device instance cc_XD3_t1_XD5_dq r0 *1 0,0
Ccc_XD3_t1_XD5_dq XD3_t1 XD5_dq 1.8151e-17
* device instance cc_XD3_t1_XD5_nm r0 *1 0,0
Ccc_XD3_t1_XD5_nm XD3_t1 XD5_nm 1.21e-17
* device instance cc_XD3_t1_XD5_nt r0 *1 0,0
Ccc_XD3_t1_XD5_nt XD3_t1 XD5_nt 1.21e-17
* device instance cc_XD3_t1_XD5_t1 r0 *1 0,0
Ccc_XD3_t1_XD5_t1 XD3_t1 XD5_t1 1.21e-17
* device instance cc_XD3_t1_XFRT_CKBB r0 *1 0,0
Ccc_XD3_t1_XFRT_CKBB XD3_t1 XFRT_CKBB 1.8151e-17
* device instance cc_XD3_t1_XFRT_CLKB r0 *1 0,0
Ccc_XD3_t1_XFRT_CLKB XD3_t1 XFRT_CLKB 2.4201e-17
* device instance cc_XD3_t1_XFRT_M r0 *1 0,0
Ccc_XD3_t1_XFRT_M XD3_t1 XFRT_M 2.4201e-17
* device instance cc_XD3_t1_XFRT_MB r0 *1 0,0
Ccc_XD3_t1_XFRT_MB XD3_t1 XFRT_MB 1.21e-17
* device instance cc_XD3_t1_XFRT_MFB r0 *1 0,0
Ccc_XD3_t1_XFRT_MFB XD3_t1 XFRT_MFB 1.21e-17
* device instance cc_XD3_t1_XFRT_S r0 *1 0,0
Ccc_XD3_t1_XFRT_S XD3_t1 XFRT_S 1.8151e-17
* device instance cc_XD3_t1_XFRT_SB r0 *1 0,0
Ccc_XD3_t1_XFRT_SB XD3_t1 XFRT_SB 1.8151e-17
* device instance cc_XD3_t1_XFRT_SFB r0 *1 0,0
Ccc_XD3_t1_XFRT_SFB XD3_t1 XFRT_SFB 1.21e-17
* device instance cc_XD3_t1_ck1 r0 *1 0,0
Ccc_XD3_t1_ck1 XD3_t1 ck1 3.0251e-17
* device instance cc_XD3_t1_ck2 r0 *1 0,0
Ccc_XD3_t1_ck2 XD3_t1 ck2 3.0251e-17
* device instance cc_XD3_t1_ck3 r0 *1 0,0
Ccc_XD3_t1_ck3 XD3_t1 ck3 3.0251e-17
* device instance cc_XD3_t1_ck4 r0 *1 0,0
Ccc_XD3_t1_ck4 XD3_t1 ck4 3.6302e-17
* device instance cc_XD3_t1_ck5 r0 *1 0,0
Ccc_XD3_t1_ck5 XD3_t1 ck5 3.0251e-17
* device instance cc_XD3_t1_mod0 r0 *1 0,0
Ccc_XD3_t1_mod0 XD3_t1 mod0 2.4201e-17
* device instance cc_XD3_t1_mod1 r0 *1 0,0
Ccc_XD3_t1_mod1 XD3_t1 mod1 2.4201e-17
* device instance cc_XD3_t1_mod2 r0 *1 0,0
Ccc_XD3_t1_mod2 XD3_t1 mod2 2.4201e-17
* device instance cc_XD3_t1_mod3 r0 *1 0,0
Ccc_XD3_t1_mod3 XD3_t1 mod3 2.4201e-17
* device instance cc_XD3_t1_mod4 r0 *1 0,0
Ccc_XD3_t1_mod4 XD3_t1 mod4 2.4201e-17
* device instance cc_XD3_t1_net1 r0 *1 0,0
Ccc_XD3_t1_net1 XD3_t1 net1 1.21e-17
* device instance cc_XD4_XDFFM_CKBB_XD4_XDFFM_CLKB r0 *1 0,0
Ccc_XD4_XDFFM_CKBB_XD4_XDFFM_CLKB XD4_XDFFM_CKBB XD4_XDFFM_CLKB 3.6302e-17
* device instance cc_XD4_XDFFM_CKBB_XD4_XDFFM_M r0 *1 0,0
Ccc_XD4_XDFFM_CKBB_XD4_XDFFM_M XD4_XDFFM_CKBB XD4_XDFFM_M 4.8402e-17
* device instance cc_XD4_XDFFM_CKBB_XD4_XDFFM_MB r0 *1 0,0
Ccc_XD4_XDFFM_CKBB_XD4_XDFFM_MB XD4_XDFFM_CKBB XD4_XDFFM_MB 2.4201e-17
* device instance cc_XD4_XDFFM_CKBB_XD4_XDFFM_MFB r0 *1 0,0
Ccc_XD4_XDFFM_CKBB_XD4_XDFFM_MFB XD4_XDFFM_CKBB XD4_XDFFM_MFB 2.4201e-17
* device instance cc_XD4_XDFFM_CKBB_XD4_XDFFM_S r0 *1 0,0
Ccc_XD4_XDFFM_CKBB_XD4_XDFFM_S XD4_XDFFM_CKBB XD4_XDFFM_S 3.0251e-17
* device instance cc_XD4_XDFFM_CKBB_XD4_XDFFM_SB r0 *1 0,0
Ccc_XD4_XDFFM_CKBB_XD4_XDFFM_SB XD4_XDFFM_CKBB XD4_XDFFM_SB 3.0251e-17
* device instance cc_XD4_XDFFM_CKBB_XD4_XDFFM_SFB r0 *1 0,0
Ccc_XD4_XDFFM_CKBB_XD4_XDFFM_SFB XD4_XDFFM_CKBB XD4_XDFFM_SFB 1.8151e-17
* device instance cc_XD4_XDFFM_CKBB_XD4_XDFFQ_CKBB r0 *1 0,0
Ccc_XD4_XDFFM_CKBB_XD4_XDFFQ_CKBB XD4_XDFFM_CKBB XD4_XDFFQ_CKBB 1.8151e-17
* device instance cc_XD4_XDFFM_CKBB_XD4_XDFFQ_CLKB r0 *1 0,0
Ccc_XD4_XDFFM_CKBB_XD4_XDFFQ_CLKB XD4_XDFFM_CKBB XD4_XDFFQ_CLKB 2.4201e-17
* device instance cc_XD4_XDFFM_CKBB_XD4_XDFFQ_M r0 *1 0,0
Ccc_XD4_XDFFM_CKBB_XD4_XDFFQ_M XD4_XDFFM_CKBB XD4_XDFFQ_M 2.4201e-17
* device instance cc_XD4_XDFFM_CKBB_XD4_XDFFQ_MB r0 *1 0,0
Ccc_XD4_XDFFM_CKBB_XD4_XDFFQ_MB XD4_XDFFM_CKBB XD4_XDFFQ_MB 1.21e-17
* device instance cc_XD4_XDFFM_CKBB_XD4_XDFFQ_MFB r0 *1 0,0
Ccc_XD4_XDFFM_CKBB_XD4_XDFFQ_MFB XD4_XDFFM_CKBB XD4_XDFFQ_MFB 1.21e-17
* device instance cc_XD4_XDFFM_CKBB_XD4_XDFFQ_S r0 *1 0,0
Ccc_XD4_XDFFM_CKBB_XD4_XDFFQ_S XD4_XDFFM_CKBB XD4_XDFFQ_S 1.8151e-17
* device instance cc_XD4_XDFFM_CKBB_XD4_XDFFQ_SB r0 *1 0,0
Ccc_XD4_XDFFM_CKBB_XD4_XDFFQ_SB XD4_XDFFM_CKBB XD4_XDFFQ_SB 1.8151e-17
* device instance cc_XD4_XDFFM_CKBB_XD4_XDFFQ_SFB r0 *1 0,0
Ccc_XD4_XDFFM_CKBB_XD4_XDFFQ_SFB XD4_XDFFM_CKBB XD4_XDFFQ_SFB 1.21e-17
* device instance cc_XD4_XDFFM_CKBB_XD4_XNOR_midp r0 *1 0,0
Ccc_XD4_XDFFM_CKBB_XD4_XNOR_midp XD4_XDFFM_CKBB XD4_XNOR_midp 1.21e-17
* device instance cc_XD4_XDFFM_CKBB_XD4_dmodout r0 *1 0,0
Ccc_XD4_XDFFM_CKBB_XD4_dmodout XD4_XDFFM_CKBB XD4_dmodout 1.8151e-17
* device instance cc_XD4_XDFFM_CKBB_XD4_dq r0 *1 0,0
Ccc_XD4_XDFFM_CKBB_XD4_dq XD4_XDFFM_CKBB XD4_dq 1.21e-17
* device instance cc_XD4_XDFFM_CKBB_XD4_nm r0 *1 0,0
Ccc_XD4_XDFFM_CKBB_XD4_nm XD4_XDFFM_CKBB XD4_nm 1.8151e-17
* device instance cc_XD4_XDFFM_CKBB_XD4_nt r0 *1 0,0
Ccc_XD4_XDFFM_CKBB_XD4_nt XD4_XDFFM_CKBB XD4_nt 2.4201e-17
* device instance cc_XD4_XDFFM_CKBB_XD4_t1 r0 *1 0,0
Ccc_XD4_XDFFM_CKBB_XD4_t1 XD4_XDFFM_CKBB XD4_t1 1.21e-17
* device instance cc_XD4_XDFFM_CKBB_XD5_XDFFM_CKBB r0 *1 0,0
Ccc_XD4_XDFFM_CKBB_XD5_XDFFM_CKBB XD4_XDFFM_CKBB XD5_XDFFM_CKBB 1.8151e-17
* device instance cc_XD4_XDFFM_CKBB_XD5_XDFFM_CLKB r0 *1 0,0
Ccc_XD4_XDFFM_CKBB_XD5_XDFFM_CLKB XD4_XDFFM_CKBB XD5_XDFFM_CLKB 2.4201e-17
* device instance cc_XD4_XDFFM_CKBB_XD5_XDFFM_M r0 *1 0,0
Ccc_XD4_XDFFM_CKBB_XD5_XDFFM_M XD4_XDFFM_CKBB XD5_XDFFM_M 2.4201e-17
* device instance cc_XD4_XDFFM_CKBB_XD5_XDFFM_MB r0 *1 0,0
Ccc_XD4_XDFFM_CKBB_XD5_XDFFM_MB XD4_XDFFM_CKBB XD5_XDFFM_MB 1.21e-17
* device instance cc_XD4_XDFFM_CKBB_XD5_XDFFM_MFB r0 *1 0,0
Ccc_XD4_XDFFM_CKBB_XD5_XDFFM_MFB XD4_XDFFM_CKBB XD5_XDFFM_MFB 1.21e-17
* device instance cc_XD4_XDFFM_CKBB_XD5_XDFFM_S r0 *1 0,0
Ccc_XD4_XDFFM_CKBB_XD5_XDFFM_S XD4_XDFFM_CKBB XD5_XDFFM_S 1.8151e-17
* device instance cc_XD4_XDFFM_CKBB_XD5_XDFFM_SB r0 *1 0,0
Ccc_XD4_XDFFM_CKBB_XD5_XDFFM_SB XD4_XDFFM_CKBB XD5_XDFFM_SB 1.8151e-17
* device instance cc_XD4_XDFFM_CKBB_XD5_XDFFM_SFB r0 *1 0,0
Ccc_XD4_XDFFM_CKBB_XD5_XDFFM_SFB XD4_XDFFM_CKBB XD5_XDFFM_SFB 1.21e-17
* device instance cc_XD4_XDFFM_CKBB_XD5_XDFFQ_CKBB r0 *1 0,0
Ccc_XD4_XDFFM_CKBB_XD5_XDFFQ_CKBB XD4_XDFFM_CKBB XD5_XDFFQ_CKBB 1.8151e-17
* device instance cc_XD4_XDFFM_CKBB_XD5_XDFFQ_CLKB r0 *1 0,0
Ccc_XD4_XDFFM_CKBB_XD5_XDFFQ_CLKB XD4_XDFFM_CKBB XD5_XDFFQ_CLKB 2.4201e-17
* device instance cc_XD4_XDFFM_CKBB_XD5_XDFFQ_M r0 *1 0,0
Ccc_XD4_XDFFM_CKBB_XD5_XDFFQ_M XD4_XDFFM_CKBB XD5_XDFFQ_M 2.4201e-17
* device instance cc_XD4_XDFFM_CKBB_XD5_XDFFQ_MB r0 *1 0,0
Ccc_XD4_XDFFM_CKBB_XD5_XDFFQ_MB XD4_XDFFM_CKBB XD5_XDFFQ_MB 1.21e-17
* device instance cc_XD4_XDFFM_CKBB_XD5_XDFFQ_MFB r0 *1 0,0
Ccc_XD4_XDFFM_CKBB_XD5_XDFFQ_MFB XD4_XDFFM_CKBB XD5_XDFFQ_MFB 1.21e-17
* device instance cc_XD4_XDFFM_CKBB_XD5_XDFFQ_S r0 *1 0,0
Ccc_XD4_XDFFM_CKBB_XD5_XDFFQ_S XD4_XDFFM_CKBB XD5_XDFFQ_S 1.8151e-17
* device instance cc_XD4_XDFFM_CKBB_XD5_XDFFQ_SB r0 *1 0,0
Ccc_XD4_XDFFM_CKBB_XD5_XDFFQ_SB XD4_XDFFM_CKBB XD5_XDFFQ_SB 1.8151e-17
* device instance cc_XD4_XDFFM_CKBB_XD5_XDFFQ_SFB r0 *1 0,0
Ccc_XD4_XDFFM_CKBB_XD5_XDFFQ_SFB XD4_XDFFM_CKBB XD5_XDFFQ_SFB 1.21e-17
* device instance cc_XD4_XDFFM_CKBB_XD5_XN2_mid1 r0 *1 0,0
Ccc_XD4_XDFFM_CKBB_XD5_XN2_mid1 XD4_XDFFM_CKBB XD5_XN2_mid1 1.21e-17
* device instance cc_XD4_XDFFM_CKBB_XD5_XN3_mid1 r0 *1 0,0
Ccc_XD4_XDFFM_CKBB_XD5_XN3_mid1 XD4_XDFFM_CKBB XD5_XN3_mid1 1.21e-17
* device instance cc_XD4_XDFFM_CKBB_XD5_XN3_mid2 r0 *1 0,0
Ccc_XD4_XDFFM_CKBB_XD5_XN3_mid2 XD4_XDFFM_CKBB XD5_XN3_mid2 1.21e-17
* device instance cc_XD4_XDFFM_CKBB_XD5_dmodout r0 *1 0,0
Ccc_XD4_XDFFM_CKBB_XD5_dmodout XD4_XDFFM_CKBB XD5_dmodout 1.21e-17
* device instance cc_XD4_XDFFM_CKBB_XD5_dq r0 *1 0,0
Ccc_XD4_XDFFM_CKBB_XD5_dq XD4_XDFFM_CKBB XD5_dq 1.8151e-17
* device instance cc_XD4_XDFFM_CKBB_XD5_nm r0 *1 0,0
Ccc_XD4_XDFFM_CKBB_XD5_nm XD4_XDFFM_CKBB XD5_nm 1.21e-17
* device instance cc_XD4_XDFFM_CKBB_XD5_nt r0 *1 0,0
Ccc_XD4_XDFFM_CKBB_XD5_nt XD4_XDFFM_CKBB XD5_nt 1.21e-17
* device instance cc_XD4_XDFFM_CKBB_XD5_t1 r0 *1 0,0
Ccc_XD4_XDFFM_CKBB_XD5_t1 XD4_XDFFM_CKBB XD5_t1 1.21e-17
* device instance cc_XD4_XDFFM_CKBB_XFRT_CKBB r0 *1 0,0
Ccc_XD4_XDFFM_CKBB_XFRT_CKBB XD4_XDFFM_CKBB XFRT_CKBB 1.8151e-17
* device instance cc_XD4_XDFFM_CKBB_XFRT_CLKB r0 *1 0,0
Ccc_XD4_XDFFM_CKBB_XFRT_CLKB XD4_XDFFM_CKBB XFRT_CLKB 2.4201e-17
* device instance cc_XD4_XDFFM_CKBB_XFRT_M r0 *1 0,0
Ccc_XD4_XDFFM_CKBB_XFRT_M XD4_XDFFM_CKBB XFRT_M 2.4201e-17
* device instance cc_XD4_XDFFM_CKBB_XFRT_MB r0 *1 0,0
Ccc_XD4_XDFFM_CKBB_XFRT_MB XD4_XDFFM_CKBB XFRT_MB 1.21e-17
* device instance cc_XD4_XDFFM_CKBB_XFRT_MFB r0 *1 0,0
Ccc_XD4_XDFFM_CKBB_XFRT_MFB XD4_XDFFM_CKBB XFRT_MFB 1.21e-17
* device instance cc_XD4_XDFFM_CKBB_XFRT_S r0 *1 0,0
Ccc_XD4_XDFFM_CKBB_XFRT_S XD4_XDFFM_CKBB XFRT_S 1.8151e-17
* device instance cc_XD4_XDFFM_CKBB_XFRT_SB r0 *1 0,0
Ccc_XD4_XDFFM_CKBB_XFRT_SB XD4_XDFFM_CKBB XFRT_SB 1.8151e-17
* device instance cc_XD4_XDFFM_CKBB_XFRT_SFB r0 *1 0,0
Ccc_XD4_XDFFM_CKBB_XFRT_SFB XD4_XDFFM_CKBB XFRT_SFB 1.21e-17
* device instance cc_XD4_XDFFM_CKBB_ck1 r0 *1 0,0
Ccc_XD4_XDFFM_CKBB_ck1 XD4_XDFFM_CKBB ck1 3.0251e-17
* device instance cc_XD4_XDFFM_CKBB_ck2 r0 *1 0,0
Ccc_XD4_XDFFM_CKBB_ck2 XD4_XDFFM_CKBB ck2 3.0251e-17
* device instance cc_XD4_XDFFM_CKBB_ck3 r0 *1 0,0
Ccc_XD4_XDFFM_CKBB_ck3 XD4_XDFFM_CKBB ck3 3.0251e-17
* device instance cc_XD4_XDFFM_CKBB_ck4 r0 *1 0,0
Ccc_XD4_XDFFM_CKBB_ck4 XD4_XDFFM_CKBB ck4 3.0251e-17
* device instance cc_XD4_XDFFM_CKBB_ck5 r0 *1 0,0
Ccc_XD4_XDFFM_CKBB_ck5 XD4_XDFFM_CKBB ck5 3.0251e-17
* device instance cc_XD4_XDFFM_CKBB_mod0 r0 *1 0,0
Ccc_XD4_XDFFM_CKBB_mod0 XD4_XDFFM_CKBB mod0 2.4201e-17
* device instance cc_XD4_XDFFM_CKBB_mod1 r0 *1 0,0
Ccc_XD4_XDFFM_CKBB_mod1 XD4_XDFFM_CKBB mod1 2.4201e-17
* device instance cc_XD4_XDFFM_CKBB_mod2 r0 *1 0,0
Ccc_XD4_XDFFM_CKBB_mod2 XD4_XDFFM_CKBB mod2 2.4201e-17
* device instance cc_XD4_XDFFM_CKBB_mod3 r0 *1 0,0
Ccc_XD4_XDFFM_CKBB_mod3 XD4_XDFFM_CKBB mod3 2.4201e-17
* device instance cc_XD4_XDFFM_CKBB_mod4 r0 *1 0,0
Ccc_XD4_XDFFM_CKBB_mod4 XD4_XDFFM_CKBB mod4 2.4201e-17
* device instance cc_XD4_XDFFM_CKBB_net1 r0 *1 0,0
Ccc_XD4_XDFFM_CKBB_net1 XD4_XDFFM_CKBB net1 1.21e-17
* device instance cc_XD4_XDFFM_CLKB_XD4_XDFFM_M r0 *1 0,0
Ccc_XD4_XDFFM_CLKB_XD4_XDFFM_M XD4_XDFFM_CLKB XD4_XDFFM_M 4.2352e-17
* device instance cc_XD4_XDFFM_CLKB_XD4_XDFFM_MB r0 *1 0,0
Ccc_XD4_XDFFM_CLKB_XD4_XDFFM_MB XD4_XDFFM_CLKB XD4_XDFFM_MB 2.4201e-17
* device instance cc_XD4_XDFFM_CLKB_XD4_XDFFM_MFB r0 *1 0,0
Ccc_XD4_XDFFM_CLKB_XD4_XDFFM_MFB XD4_XDFFM_CLKB XD4_XDFFM_MFB 2.4201e-17
* device instance cc_XD4_XDFFM_CLKB_XD4_XDFFM_S r0 *1 0,0
Ccc_XD4_XDFFM_CLKB_XD4_XDFFM_S XD4_XDFFM_CLKB XD4_XDFFM_S 1.8151e-17
* device instance cc_XD4_XDFFM_CLKB_XD4_XDFFM_SB r0 *1 0,0
Ccc_XD4_XDFFM_CLKB_XD4_XDFFM_SB XD4_XDFFM_CLKB XD4_XDFFM_SB 1.8151e-17
* device instance cc_XD4_XDFFM_CLKB_XD4_XDFFM_SFB r0 *1 0,0
Ccc_XD4_XDFFM_CLKB_XD4_XDFFM_SFB XD4_XDFFM_CLKB XD4_XDFFM_SFB 1.21e-17
* device instance cc_XD4_XDFFM_CLKB_XD4_XDFFQ_CKBB r0 *1 0,0
Ccc_XD4_XDFFM_CLKB_XD4_XDFFQ_CKBB XD4_XDFFM_CLKB XD4_XDFFQ_CKBB 1.8151e-17
* device instance cc_XD4_XDFFM_CLKB_XD4_XDFFQ_CLKB r0 *1 0,0
Ccc_XD4_XDFFM_CLKB_XD4_XDFFQ_CLKB XD4_XDFFM_CLKB XD4_XDFFQ_CLKB 2.4201e-17
* device instance cc_XD4_XDFFM_CLKB_XD4_XDFFQ_M r0 *1 0,0
Ccc_XD4_XDFFM_CLKB_XD4_XDFFQ_M XD4_XDFFM_CLKB XD4_XDFFQ_M 2.4201e-17
* device instance cc_XD4_XDFFM_CLKB_XD4_XDFFQ_MB r0 *1 0,0
Ccc_XD4_XDFFM_CLKB_XD4_XDFFQ_MB XD4_XDFFM_CLKB XD4_XDFFQ_MB 1.21e-17
* device instance cc_XD4_XDFFM_CLKB_XD4_XDFFQ_MFB r0 *1 0,0
Ccc_XD4_XDFFM_CLKB_XD4_XDFFQ_MFB XD4_XDFFM_CLKB XD4_XDFFQ_MFB 1.21e-17
* device instance cc_XD4_XDFFM_CLKB_XD4_XDFFQ_S r0 *1 0,0
Ccc_XD4_XDFFM_CLKB_XD4_XDFFQ_S XD4_XDFFM_CLKB XD4_XDFFQ_S 1.8151e-17
* device instance cc_XD4_XDFFM_CLKB_XD4_XDFFQ_SB r0 *1 0,0
Ccc_XD4_XDFFM_CLKB_XD4_XDFFQ_SB XD4_XDFFM_CLKB XD4_XDFFQ_SB 1.8151e-17
* device instance cc_XD4_XDFFM_CLKB_XD4_XDFFQ_SFB r0 *1 0,0
Ccc_XD4_XDFFM_CLKB_XD4_XDFFQ_SFB XD4_XDFFM_CLKB XD4_XDFFQ_SFB 1.21e-17
* device instance cc_XD4_XDFFM_CLKB_XD4_XNOR_midp r0 *1 0,0
Ccc_XD4_XDFFM_CLKB_XD4_XNOR_midp XD4_XDFFM_CLKB XD4_XNOR_midp 1.21e-17
* device instance cc_XD4_XDFFM_CLKB_XD4_dmodout r0 *1 0,0
Ccc_XD4_XDFFM_CLKB_XD4_dmodout XD4_XDFFM_CLKB XD4_dmodout 1.8151e-17
* device instance cc_XD4_XDFFM_CLKB_XD4_dq r0 *1 0,0
Ccc_XD4_XDFFM_CLKB_XD4_dq XD4_XDFFM_CLKB XD4_dq 1.21e-17
* device instance cc_XD4_XDFFM_CLKB_XD4_nm r0 *1 0,0
Ccc_XD4_XDFFM_CLKB_XD4_nm XD4_XDFFM_CLKB XD4_nm 1.8151e-17
* device instance cc_XD4_XDFFM_CLKB_XD4_nt r0 *1 0,0
Ccc_XD4_XDFFM_CLKB_XD4_nt XD4_XDFFM_CLKB XD4_nt 2.4201e-17
* device instance cc_XD4_XDFFM_CLKB_XD4_t1 r0 *1 0,0
Ccc_XD4_XDFFM_CLKB_XD4_t1 XD4_XDFFM_CLKB XD4_t1 1.21e-17
* device instance cc_XD4_XDFFM_CLKB_XD5_XDFFM_CKBB r0 *1 0,0
Ccc_XD4_XDFFM_CLKB_XD5_XDFFM_CKBB XD4_XDFFM_CLKB XD5_XDFFM_CKBB 1.8151e-17
* device instance cc_XD4_XDFFM_CLKB_XD5_XDFFM_CLKB r0 *1 0,0
Ccc_XD4_XDFFM_CLKB_XD5_XDFFM_CLKB XD4_XDFFM_CLKB XD5_XDFFM_CLKB 2.4201e-17
* device instance cc_XD4_XDFFM_CLKB_XD5_XDFFM_M r0 *1 0,0
Ccc_XD4_XDFFM_CLKB_XD5_XDFFM_M XD4_XDFFM_CLKB XD5_XDFFM_M 2.4201e-17
* device instance cc_XD4_XDFFM_CLKB_XD5_XDFFM_MB r0 *1 0,0
Ccc_XD4_XDFFM_CLKB_XD5_XDFFM_MB XD4_XDFFM_CLKB XD5_XDFFM_MB 1.21e-17
* device instance cc_XD4_XDFFM_CLKB_XD5_XDFFM_MFB r0 *1 0,0
Ccc_XD4_XDFFM_CLKB_XD5_XDFFM_MFB XD4_XDFFM_CLKB XD5_XDFFM_MFB 1.21e-17
* device instance cc_XD4_XDFFM_CLKB_XD5_XDFFM_S r0 *1 0,0
Ccc_XD4_XDFFM_CLKB_XD5_XDFFM_S XD4_XDFFM_CLKB XD5_XDFFM_S 1.8151e-17
* device instance cc_XD4_XDFFM_CLKB_XD5_XDFFM_SB r0 *1 0,0
Ccc_XD4_XDFFM_CLKB_XD5_XDFFM_SB XD4_XDFFM_CLKB XD5_XDFFM_SB 1.8151e-17
* device instance cc_XD4_XDFFM_CLKB_XD5_XDFFM_SFB r0 *1 0,0
Ccc_XD4_XDFFM_CLKB_XD5_XDFFM_SFB XD4_XDFFM_CLKB XD5_XDFFM_SFB 1.21e-17
* device instance cc_XD4_XDFFM_CLKB_XD5_XDFFQ_CKBB r0 *1 0,0
Ccc_XD4_XDFFM_CLKB_XD5_XDFFQ_CKBB XD4_XDFFM_CLKB XD5_XDFFQ_CKBB 1.8151e-17
* device instance cc_XD4_XDFFM_CLKB_XD5_XDFFQ_CLKB r0 *1 0,0
Ccc_XD4_XDFFM_CLKB_XD5_XDFFQ_CLKB XD4_XDFFM_CLKB XD5_XDFFQ_CLKB 2.4201e-17
* device instance cc_XD4_XDFFM_CLKB_XD5_XDFFQ_M r0 *1 0,0
Ccc_XD4_XDFFM_CLKB_XD5_XDFFQ_M XD4_XDFFM_CLKB XD5_XDFFQ_M 2.4201e-17
* device instance cc_XD4_XDFFM_CLKB_XD5_XDFFQ_MB r0 *1 0,0
Ccc_XD4_XDFFM_CLKB_XD5_XDFFQ_MB XD4_XDFFM_CLKB XD5_XDFFQ_MB 1.21e-17
* device instance cc_XD4_XDFFM_CLKB_XD5_XDFFQ_MFB r0 *1 0,0
Ccc_XD4_XDFFM_CLKB_XD5_XDFFQ_MFB XD4_XDFFM_CLKB XD5_XDFFQ_MFB 1.21e-17
* device instance cc_XD4_XDFFM_CLKB_XD5_XDFFQ_S r0 *1 0,0
Ccc_XD4_XDFFM_CLKB_XD5_XDFFQ_S XD4_XDFFM_CLKB XD5_XDFFQ_S 1.8151e-17
* device instance cc_XD4_XDFFM_CLKB_XD5_XDFFQ_SB r0 *1 0,0
Ccc_XD4_XDFFM_CLKB_XD5_XDFFQ_SB XD4_XDFFM_CLKB XD5_XDFFQ_SB 1.8151e-17
* device instance cc_XD4_XDFFM_CLKB_XD5_XDFFQ_SFB r0 *1 0,0
Ccc_XD4_XDFFM_CLKB_XD5_XDFFQ_SFB XD4_XDFFM_CLKB XD5_XDFFQ_SFB 1.21e-17
* device instance cc_XD4_XDFFM_CLKB_XD5_XN2_mid1 r0 *1 0,0
Ccc_XD4_XDFFM_CLKB_XD5_XN2_mid1 XD4_XDFFM_CLKB XD5_XN2_mid1 1.21e-17
* device instance cc_XD4_XDFFM_CLKB_XD5_XN3_mid1 r0 *1 0,0
Ccc_XD4_XDFFM_CLKB_XD5_XN3_mid1 XD4_XDFFM_CLKB XD5_XN3_mid1 1.21e-17
* device instance cc_XD4_XDFFM_CLKB_XD5_XN3_mid2 r0 *1 0,0
Ccc_XD4_XDFFM_CLKB_XD5_XN3_mid2 XD4_XDFFM_CLKB XD5_XN3_mid2 1.21e-17
* device instance cc_XD4_XDFFM_CLKB_XD5_dmodout r0 *1 0,0
Ccc_XD4_XDFFM_CLKB_XD5_dmodout XD4_XDFFM_CLKB XD5_dmodout 1.21e-17
* device instance cc_XD4_XDFFM_CLKB_XD5_dq r0 *1 0,0
Ccc_XD4_XDFFM_CLKB_XD5_dq XD4_XDFFM_CLKB XD5_dq 1.8151e-17
* device instance cc_XD4_XDFFM_CLKB_XD5_nm r0 *1 0,0
Ccc_XD4_XDFFM_CLKB_XD5_nm XD4_XDFFM_CLKB XD5_nm 1.21e-17
* device instance cc_XD4_XDFFM_CLKB_XD5_nt r0 *1 0,0
Ccc_XD4_XDFFM_CLKB_XD5_nt XD4_XDFFM_CLKB XD5_nt 1.21e-17
* device instance cc_XD4_XDFFM_CLKB_XD5_t1 r0 *1 0,0
Ccc_XD4_XDFFM_CLKB_XD5_t1 XD4_XDFFM_CLKB XD5_t1 1.21e-17
* device instance cc_XD4_XDFFM_CLKB_XFRT_CKBB r0 *1 0,0
Ccc_XD4_XDFFM_CLKB_XFRT_CKBB XD4_XDFFM_CLKB XFRT_CKBB 1.8151e-17
* device instance cc_XD4_XDFFM_CLKB_XFRT_CLKB r0 *1 0,0
Ccc_XD4_XDFFM_CLKB_XFRT_CLKB XD4_XDFFM_CLKB XFRT_CLKB 2.4201e-17
* device instance cc_XD4_XDFFM_CLKB_XFRT_M r0 *1 0,0
Ccc_XD4_XDFFM_CLKB_XFRT_M XD4_XDFFM_CLKB XFRT_M 2.4201e-17
* device instance cc_XD4_XDFFM_CLKB_XFRT_MB r0 *1 0,0
Ccc_XD4_XDFFM_CLKB_XFRT_MB XD4_XDFFM_CLKB XFRT_MB 1.21e-17
* device instance cc_XD4_XDFFM_CLKB_XFRT_MFB r0 *1 0,0
Ccc_XD4_XDFFM_CLKB_XFRT_MFB XD4_XDFFM_CLKB XFRT_MFB 1.21e-17
* device instance cc_XD4_XDFFM_CLKB_XFRT_S r0 *1 0,0
Ccc_XD4_XDFFM_CLKB_XFRT_S XD4_XDFFM_CLKB XFRT_S 1.8151e-17
* device instance cc_XD4_XDFFM_CLKB_XFRT_SB r0 *1 0,0
Ccc_XD4_XDFFM_CLKB_XFRT_SB XD4_XDFFM_CLKB XFRT_SB 1.8151e-17
* device instance cc_XD4_XDFFM_CLKB_XFRT_SFB r0 *1 0,0
Ccc_XD4_XDFFM_CLKB_XFRT_SFB XD4_XDFFM_CLKB XFRT_SFB 1.21e-17
* device instance cc_XD4_XDFFM_CLKB_ck1 r0 *1 0,0
Ccc_XD4_XDFFM_CLKB_ck1 XD4_XDFFM_CLKB ck1 3.0251e-17
* device instance cc_XD4_XDFFM_CLKB_ck2 r0 *1 0,0
Ccc_XD4_XDFFM_CLKB_ck2 XD4_XDFFM_CLKB ck2 3.0251e-17
* device instance cc_XD4_XDFFM_CLKB_ck3 r0 *1 0,0
Ccc_XD4_XDFFM_CLKB_ck3 XD4_XDFFM_CLKB ck3 3.0251e-17
* device instance cc_XD4_XDFFM_CLKB_ck4 r0 *1 0,0
Ccc_XD4_XDFFM_CLKB_ck4 XD4_XDFFM_CLKB ck4 3.0251e-17
* device instance cc_XD4_XDFFM_CLKB_ck5 r0 *1 0,0
Ccc_XD4_XDFFM_CLKB_ck5 XD4_XDFFM_CLKB ck5 3.0251e-17
* device instance cc_XD4_XDFFM_CLKB_mod0 r0 *1 0,0
Ccc_XD4_XDFFM_CLKB_mod0 XD4_XDFFM_CLKB mod0 2.4201e-17
* device instance cc_XD4_XDFFM_CLKB_mod1 r0 *1 0,0
Ccc_XD4_XDFFM_CLKB_mod1 XD4_XDFFM_CLKB mod1 2.4201e-17
* device instance cc_XD4_XDFFM_CLKB_mod2 r0 *1 0,0
Ccc_XD4_XDFFM_CLKB_mod2 XD4_XDFFM_CLKB mod2 2.4201e-17
* device instance cc_XD4_XDFFM_CLKB_mod3 r0 *1 0,0
Ccc_XD4_XDFFM_CLKB_mod3 XD4_XDFFM_CLKB mod3 2.4201e-17
* device instance cc_XD4_XDFFM_CLKB_mod4 r0 *1 0,0
Ccc_XD4_XDFFM_CLKB_mod4 XD4_XDFFM_CLKB mod4 2.4201e-17
* device instance cc_XD4_XDFFM_CLKB_net1 r0 *1 0,0
Ccc_XD4_XDFFM_CLKB_net1 XD4_XDFFM_CLKB net1 1.21e-17
* device instance cc_XD4_XDFFM_M_XD4_XDFFM_MB r0 *1 0,0
Ccc_XD4_XDFFM_M_XD4_XDFFM_MB XD4_XDFFM_M XD4_XDFFM_MB 2.4201e-17
* device instance cc_XD4_XDFFM_M_XD4_XDFFM_MFB r0 *1 0,0
Ccc_XD4_XDFFM_M_XD4_XDFFM_MFB XD4_XDFFM_M XD4_XDFFM_MFB 3.4688e-17
* device instance cc_XD4_XDFFM_M_XD4_XDFFM_S r0 *1 0,0
Ccc_XD4_XDFFM_M_XD4_XDFFM_S XD4_XDFFM_M XD4_XDFFM_S 2.8638e-17
* device instance cc_XD4_XDFFM_M_XD4_XDFFM_SB r0 *1 0,0
Ccc_XD4_XDFFM_M_XD4_XDFFM_SB XD4_XDFFM_M XD4_XDFFM_SB 1.8151e-17
* device instance cc_XD4_XDFFM_M_XD4_XDFFM_SFB r0 *1 0,0
Ccc_XD4_XDFFM_M_XD4_XDFFM_SFB XD4_XDFFM_M XD4_XDFFM_SFB 1.21e-17
* device instance cc_XD4_XDFFM_M_XD4_XDFFQ_CKBB r0 *1 0,0
Ccc_XD4_XDFFM_M_XD4_XDFFQ_CKBB XD4_XDFFM_M XD4_XDFFQ_CKBB 1.8151e-17
* device instance cc_XD4_XDFFM_M_XD4_XDFFQ_CLKB r0 *1 0,0
Ccc_XD4_XDFFM_M_XD4_XDFFQ_CLKB XD4_XDFFM_M XD4_XDFFQ_CLKB 2.4201e-17
* device instance cc_XD4_XDFFM_M_XD4_XDFFQ_M r0 *1 0,0
Ccc_XD4_XDFFM_M_XD4_XDFFQ_M XD4_XDFFM_M XD4_XDFFQ_M 2.4201e-17
* device instance cc_XD4_XDFFM_M_XD4_XDFFQ_MB r0 *1 0,0
Ccc_XD4_XDFFM_M_XD4_XDFFQ_MB XD4_XDFFM_M XD4_XDFFQ_MB 1.21e-17
* device instance cc_XD4_XDFFM_M_XD4_XDFFQ_MFB r0 *1 0,0
Ccc_XD4_XDFFM_M_XD4_XDFFQ_MFB XD4_XDFFM_M XD4_XDFFQ_MFB 1.21e-17
* device instance cc_XD4_XDFFM_M_XD4_XDFFQ_S r0 *1 0,0
Ccc_XD4_XDFFM_M_XD4_XDFFQ_S XD4_XDFFM_M XD4_XDFFQ_S 1.8151e-17
* device instance cc_XD4_XDFFM_M_XD4_XDFFQ_SB r0 *1 0,0
Ccc_XD4_XDFFM_M_XD4_XDFFQ_SB XD4_XDFFM_M XD4_XDFFQ_SB 1.8151e-17
* device instance cc_XD4_XDFFM_M_XD4_XDFFQ_SFB r0 *1 0,0
Ccc_XD4_XDFFM_M_XD4_XDFFQ_SFB XD4_XDFFM_M XD4_XDFFQ_SFB 1.21e-17
* device instance cc_XD4_XDFFM_M_XD4_XNOR_midp r0 *1 0,0
Ccc_XD4_XDFFM_M_XD4_XNOR_midp XD4_XDFFM_M XD4_XNOR_midp 1.21e-17
* device instance cc_XD4_XDFFM_M_XD4_dmodout r0 *1 0,0
Ccc_XD4_XDFFM_M_XD4_dmodout XD4_XDFFM_M XD4_dmodout 2.8638e-17
* device instance cc_XD4_XDFFM_M_XD4_dq r0 *1 0,0
Ccc_XD4_XDFFM_M_XD4_dq XD4_XDFFM_M XD4_dq 1.21e-17
* device instance cc_XD4_XDFFM_M_XD4_nm r0 *1 0,0
Ccc_XD4_XDFFM_M_XD4_nm XD4_XDFFM_M XD4_nm 1.8151e-17
* device instance cc_XD4_XDFFM_M_XD4_nt r0 *1 0,0
Ccc_XD4_XDFFM_M_XD4_nt XD4_XDFFM_M XD4_nt 2.4201e-17
* device instance cc_XD4_XDFFM_M_XD4_t1 r0 *1 0,0
Ccc_XD4_XDFFM_M_XD4_t1 XD4_XDFFM_M XD4_t1 1.21e-17
* device instance cc_XD4_XDFFM_M_XD5_XDFFM_CKBB r0 *1 0,0
Ccc_XD4_XDFFM_M_XD5_XDFFM_CKBB XD4_XDFFM_M XD5_XDFFM_CKBB 1.8151e-17
* device instance cc_XD4_XDFFM_M_XD5_XDFFM_CLKB r0 *1 0,0
Ccc_XD4_XDFFM_M_XD5_XDFFM_CLKB XD4_XDFFM_M XD5_XDFFM_CLKB 2.4201e-17
* device instance cc_XD4_XDFFM_M_XD5_XDFFM_M r0 *1 0,0
Ccc_XD4_XDFFM_M_XD5_XDFFM_M XD4_XDFFM_M XD5_XDFFM_M 2.4201e-17
* device instance cc_XD4_XDFFM_M_XD5_XDFFM_MB r0 *1 0,0
Ccc_XD4_XDFFM_M_XD5_XDFFM_MB XD4_XDFFM_M XD5_XDFFM_MB 1.21e-17
* device instance cc_XD4_XDFFM_M_XD5_XDFFM_MFB r0 *1 0,0
Ccc_XD4_XDFFM_M_XD5_XDFFM_MFB XD4_XDFFM_M XD5_XDFFM_MFB 1.21e-17
* device instance cc_XD4_XDFFM_M_XD5_XDFFM_S r0 *1 0,0
Ccc_XD4_XDFFM_M_XD5_XDFFM_S XD4_XDFFM_M XD5_XDFFM_S 1.8151e-17
* device instance cc_XD4_XDFFM_M_XD5_XDFFM_SB r0 *1 0,0
Ccc_XD4_XDFFM_M_XD5_XDFFM_SB XD4_XDFFM_M XD5_XDFFM_SB 1.8151e-17
* device instance cc_XD4_XDFFM_M_XD5_XDFFM_SFB r0 *1 0,0
Ccc_XD4_XDFFM_M_XD5_XDFFM_SFB XD4_XDFFM_M XD5_XDFFM_SFB 1.21e-17
* device instance cc_XD4_XDFFM_M_XD5_XDFFQ_CKBB r0 *1 0,0
Ccc_XD4_XDFFM_M_XD5_XDFFQ_CKBB XD4_XDFFM_M XD5_XDFFQ_CKBB 1.8151e-17
* device instance cc_XD4_XDFFM_M_XD5_XDFFQ_CLKB r0 *1 0,0
Ccc_XD4_XDFFM_M_XD5_XDFFQ_CLKB XD4_XDFFM_M XD5_XDFFQ_CLKB 2.4201e-17
* device instance cc_XD4_XDFFM_M_XD5_XDFFQ_M r0 *1 0,0
Ccc_XD4_XDFFM_M_XD5_XDFFQ_M XD4_XDFFM_M XD5_XDFFQ_M 2.4201e-17
* device instance cc_XD4_XDFFM_M_XD5_XDFFQ_MB r0 *1 0,0
Ccc_XD4_XDFFM_M_XD5_XDFFQ_MB XD4_XDFFM_M XD5_XDFFQ_MB 1.21e-17
* device instance cc_XD4_XDFFM_M_XD5_XDFFQ_MFB r0 *1 0,0
Ccc_XD4_XDFFM_M_XD5_XDFFQ_MFB XD4_XDFFM_M XD5_XDFFQ_MFB 1.21e-17
* device instance cc_XD4_XDFFM_M_XD5_XDFFQ_S r0 *1 0,0
Ccc_XD4_XDFFM_M_XD5_XDFFQ_S XD4_XDFFM_M XD5_XDFFQ_S 1.8151e-17
* device instance cc_XD4_XDFFM_M_XD5_XDFFQ_SB r0 *1 0,0
Ccc_XD4_XDFFM_M_XD5_XDFFQ_SB XD4_XDFFM_M XD5_XDFFQ_SB 1.8151e-17
* device instance cc_XD4_XDFFM_M_XD5_XDFFQ_SFB r0 *1 0,0
Ccc_XD4_XDFFM_M_XD5_XDFFQ_SFB XD4_XDFFM_M XD5_XDFFQ_SFB 1.21e-17
* device instance cc_XD4_XDFFM_M_XD5_XN2_mid1 r0 *1 0,0
Ccc_XD4_XDFFM_M_XD5_XN2_mid1 XD4_XDFFM_M XD5_XN2_mid1 1.21e-17
* device instance cc_XD4_XDFFM_M_XD5_XN3_mid1 r0 *1 0,0
Ccc_XD4_XDFFM_M_XD5_XN3_mid1 XD4_XDFFM_M XD5_XN3_mid1 1.21e-17
* device instance cc_XD4_XDFFM_M_XD5_XN3_mid2 r0 *1 0,0
Ccc_XD4_XDFFM_M_XD5_XN3_mid2 XD4_XDFFM_M XD5_XN3_mid2 1.21e-17
* device instance cc_XD4_XDFFM_M_XD5_dmodout r0 *1 0,0
Ccc_XD4_XDFFM_M_XD5_dmodout XD4_XDFFM_M XD5_dmodout 1.21e-17
* device instance cc_XD4_XDFFM_M_XD5_dq r0 *1 0,0
Ccc_XD4_XDFFM_M_XD5_dq XD4_XDFFM_M XD5_dq 1.8151e-17
* device instance cc_XD4_XDFFM_M_XD5_nm r0 *1 0,0
Ccc_XD4_XDFFM_M_XD5_nm XD4_XDFFM_M XD5_nm 1.21e-17
* device instance cc_XD4_XDFFM_M_XD5_nt r0 *1 0,0
Ccc_XD4_XDFFM_M_XD5_nt XD4_XDFFM_M XD5_nt 1.21e-17
* device instance cc_XD4_XDFFM_M_XD5_t1 r0 *1 0,0
Ccc_XD4_XDFFM_M_XD5_t1 XD4_XDFFM_M XD5_t1 1.21e-17
* device instance cc_XD4_XDFFM_M_XFRT_CKBB r0 *1 0,0
Ccc_XD4_XDFFM_M_XFRT_CKBB XD4_XDFFM_M XFRT_CKBB 1.8151e-17
* device instance cc_XD4_XDFFM_M_XFRT_CLKB r0 *1 0,0
Ccc_XD4_XDFFM_M_XFRT_CLKB XD4_XDFFM_M XFRT_CLKB 2.4201e-17
* device instance cc_XD4_XDFFM_M_XFRT_M r0 *1 0,0
Ccc_XD4_XDFFM_M_XFRT_M XD4_XDFFM_M XFRT_M 2.4201e-17
* device instance cc_XD4_XDFFM_M_XFRT_MB r0 *1 0,0
Ccc_XD4_XDFFM_M_XFRT_MB XD4_XDFFM_M XFRT_MB 1.21e-17
* device instance cc_XD4_XDFFM_M_XFRT_MFB r0 *1 0,0
Ccc_XD4_XDFFM_M_XFRT_MFB XD4_XDFFM_M XFRT_MFB 1.21e-17
* device instance cc_XD4_XDFFM_M_XFRT_S r0 *1 0,0
Ccc_XD4_XDFFM_M_XFRT_S XD4_XDFFM_M XFRT_S 1.8151e-17
* device instance cc_XD4_XDFFM_M_XFRT_SB r0 *1 0,0
Ccc_XD4_XDFFM_M_XFRT_SB XD4_XDFFM_M XFRT_SB 1.8151e-17
* device instance cc_XD4_XDFFM_M_XFRT_SFB r0 *1 0,0
Ccc_XD4_XDFFM_M_XFRT_SFB XD4_XDFFM_M XFRT_SFB 1.21e-17
* device instance cc_XD4_XDFFM_M_ck1 r0 *1 0,0
Ccc_XD4_XDFFM_M_ck1 XD4_XDFFM_M ck1 3.0251e-17
* device instance cc_XD4_XDFFM_M_ck2 r0 *1 0,0
Ccc_XD4_XDFFM_M_ck2 XD4_XDFFM_M ck2 3.0251e-17
* device instance cc_XD4_XDFFM_M_ck3 r0 *1 0,0
Ccc_XD4_XDFFM_M_ck3 XD4_XDFFM_M ck3 3.0251e-17
* device instance cc_XD4_XDFFM_M_ck4 r0 *1 0,0
Ccc_XD4_XDFFM_M_ck4 XD4_XDFFM_M ck4 3.0251e-17
* device instance cc_XD4_XDFFM_M_ck5 r0 *1 0,0
Ccc_XD4_XDFFM_M_ck5 XD4_XDFFM_M ck5 3.0251e-17
* device instance cc_XD4_XDFFM_M_mod0 r0 *1 0,0
Ccc_XD4_XDFFM_M_mod0 XD4_XDFFM_M mod0 2.4201e-17
* device instance cc_XD4_XDFFM_M_mod1 r0 *1 0,0
Ccc_XD4_XDFFM_M_mod1 XD4_XDFFM_M mod1 2.4201e-17
* device instance cc_XD4_XDFFM_M_mod2 r0 *1 0,0
Ccc_XD4_XDFFM_M_mod2 XD4_XDFFM_M mod2 2.4201e-17
* device instance cc_XD4_XDFFM_M_mod3 r0 *1 0,0
Ccc_XD4_XDFFM_M_mod3 XD4_XDFFM_M mod3 2.4201e-17
* device instance cc_XD4_XDFFM_M_mod4 r0 *1 0,0
Ccc_XD4_XDFFM_M_mod4 XD4_XDFFM_M mod4 2.4201e-17
* device instance cc_XD4_XDFFM_M_net1 r0 *1 0,0
Ccc_XD4_XDFFM_M_net1 XD4_XDFFM_M net1 1.21e-17
* device instance cc_XD4_XDFFM_MB_XD4_XDFFM_MFB r0 *1 0,0
Ccc_XD4_XDFFM_MB_XD4_XDFFM_MFB XD4_XDFFM_MB XD4_XDFFM_MFB 1.21e-17
* device instance cc_XD4_XDFFM_MB_XD4_XDFFM_S r0 *1 0,0
Ccc_XD4_XDFFM_MB_XD4_XDFFM_S XD4_XDFFM_MB XD4_XDFFM_S 1.8151e-17
* device instance cc_XD4_XDFFM_MB_XD4_XDFFM_SB r0 *1 0,0
Ccc_XD4_XDFFM_MB_XD4_XDFFM_SB XD4_XDFFM_MB XD4_XDFFM_SB 1.8151e-17
* device instance cc_XD4_XDFFM_MB_XD4_XDFFM_SFB r0 *1 0,0
Ccc_XD4_XDFFM_MB_XD4_XDFFM_SFB XD4_XDFFM_MB XD4_XDFFM_SFB 1.21e-17
* device instance cc_XD4_XDFFM_MB_XD4_XDFFQ_CKBB r0 *1 0,0
Ccc_XD4_XDFFM_MB_XD4_XDFFQ_CKBB XD4_XDFFM_MB XD4_XDFFQ_CKBB 1.8151e-17
* device instance cc_XD4_XDFFM_MB_XD4_XDFFQ_CLKB r0 *1 0,0
Ccc_XD4_XDFFM_MB_XD4_XDFFQ_CLKB XD4_XDFFM_MB XD4_XDFFQ_CLKB 2.4201e-17
* device instance cc_XD4_XDFFM_MB_XD4_XDFFQ_M r0 *1 0,0
Ccc_XD4_XDFFM_MB_XD4_XDFFQ_M XD4_XDFFM_MB XD4_XDFFQ_M 2.4201e-17
* device instance cc_XD4_XDFFM_MB_XD4_XDFFQ_MB r0 *1 0,0
Ccc_XD4_XDFFM_MB_XD4_XDFFQ_MB XD4_XDFFM_MB XD4_XDFFQ_MB 1.21e-17
* device instance cc_XD4_XDFFM_MB_XD4_XDFFQ_MFB r0 *1 0,0
Ccc_XD4_XDFFM_MB_XD4_XDFFQ_MFB XD4_XDFFM_MB XD4_XDFFQ_MFB 1.21e-17
* device instance cc_XD4_XDFFM_MB_XD4_XDFFQ_S r0 *1 0,0
Ccc_XD4_XDFFM_MB_XD4_XDFFQ_S XD4_XDFFM_MB XD4_XDFFQ_S 1.8151e-17
* device instance cc_XD4_XDFFM_MB_XD4_XDFFQ_SB r0 *1 0,0
Ccc_XD4_XDFFM_MB_XD4_XDFFQ_SB XD4_XDFFM_MB XD4_XDFFQ_SB 1.8151e-17
* device instance cc_XD4_XDFFM_MB_XD4_XDFFQ_SFB r0 *1 0,0
Ccc_XD4_XDFFM_MB_XD4_XDFFQ_SFB XD4_XDFFM_MB XD4_XDFFQ_SFB 1.21e-17
* device instance cc_XD4_XDFFM_MB_XD4_XNOR_midp r0 *1 0,0
Ccc_XD4_XDFFM_MB_XD4_XNOR_midp XD4_XDFFM_MB XD4_XNOR_midp 1.21e-17
* device instance cc_XD4_XDFFM_MB_XD4_dmodout r0 *1 0,0
Ccc_XD4_XDFFM_MB_XD4_dmodout XD4_XDFFM_MB XD4_dmodout 1.21e-17
* device instance cc_XD4_XDFFM_MB_XD4_dq r0 *1 0,0
Ccc_XD4_XDFFM_MB_XD4_dq XD4_XDFFM_MB XD4_dq 1.21e-17
* device instance cc_XD4_XDFFM_MB_XD4_nm r0 *1 0,0
Ccc_XD4_XDFFM_MB_XD4_nm XD4_XDFFM_MB XD4_nm 1.8151e-17
* device instance cc_XD4_XDFFM_MB_XD4_nt r0 *1 0,0
Ccc_XD4_XDFFM_MB_XD4_nt XD4_XDFFM_MB XD4_nt 2.4201e-17
* device instance cc_XD4_XDFFM_MB_XD4_t1 r0 *1 0,0
Ccc_XD4_XDFFM_MB_XD4_t1 XD4_XDFFM_MB XD4_t1 1.21e-17
* device instance cc_XD4_XDFFM_MB_XD5_XDFFM_CKBB r0 *1 0,0
Ccc_XD4_XDFFM_MB_XD5_XDFFM_CKBB XD4_XDFFM_MB XD5_XDFFM_CKBB 1.8151e-17
* device instance cc_XD4_XDFFM_MB_XD5_XDFFM_CLKB r0 *1 0,0
Ccc_XD4_XDFFM_MB_XD5_XDFFM_CLKB XD4_XDFFM_MB XD5_XDFFM_CLKB 2.4201e-17
* device instance cc_XD4_XDFFM_MB_XD5_XDFFM_M r0 *1 0,0
Ccc_XD4_XDFFM_MB_XD5_XDFFM_M XD4_XDFFM_MB XD5_XDFFM_M 2.4201e-17
* device instance cc_XD4_XDFFM_MB_XD5_XDFFM_MB r0 *1 0,0
Ccc_XD4_XDFFM_MB_XD5_XDFFM_MB XD4_XDFFM_MB XD5_XDFFM_MB 1.21e-17
* device instance cc_XD4_XDFFM_MB_XD5_XDFFM_MFB r0 *1 0,0
Ccc_XD4_XDFFM_MB_XD5_XDFFM_MFB XD4_XDFFM_MB XD5_XDFFM_MFB 1.21e-17
* device instance cc_XD4_XDFFM_MB_XD5_XDFFM_S r0 *1 0,0
Ccc_XD4_XDFFM_MB_XD5_XDFFM_S XD4_XDFFM_MB XD5_XDFFM_S 1.8151e-17
* device instance cc_XD4_XDFFM_MB_XD5_XDFFM_SB r0 *1 0,0
Ccc_XD4_XDFFM_MB_XD5_XDFFM_SB XD4_XDFFM_MB XD5_XDFFM_SB 1.8151e-17
* device instance cc_XD4_XDFFM_MB_XD5_XDFFM_SFB r0 *1 0,0
Ccc_XD4_XDFFM_MB_XD5_XDFFM_SFB XD4_XDFFM_MB XD5_XDFFM_SFB 1.21e-17
* device instance cc_XD4_XDFFM_MB_XD5_XDFFQ_CKBB r0 *1 0,0
Ccc_XD4_XDFFM_MB_XD5_XDFFQ_CKBB XD4_XDFFM_MB XD5_XDFFQ_CKBB 1.8151e-17
* device instance cc_XD4_XDFFM_MB_XD5_XDFFQ_CLKB r0 *1 0,0
Ccc_XD4_XDFFM_MB_XD5_XDFFQ_CLKB XD4_XDFFM_MB XD5_XDFFQ_CLKB 2.4201e-17
* device instance cc_XD4_XDFFM_MB_XD5_XDFFQ_M r0 *1 0,0
Ccc_XD4_XDFFM_MB_XD5_XDFFQ_M XD4_XDFFM_MB XD5_XDFFQ_M 2.4201e-17
* device instance cc_XD4_XDFFM_MB_XD5_XDFFQ_MB r0 *1 0,0
Ccc_XD4_XDFFM_MB_XD5_XDFFQ_MB XD4_XDFFM_MB XD5_XDFFQ_MB 1.21e-17
* device instance cc_XD4_XDFFM_MB_XD5_XDFFQ_MFB r0 *1 0,0
Ccc_XD4_XDFFM_MB_XD5_XDFFQ_MFB XD4_XDFFM_MB XD5_XDFFQ_MFB 1.21e-17
* device instance cc_XD4_XDFFM_MB_XD5_XDFFQ_S r0 *1 0,0
Ccc_XD4_XDFFM_MB_XD5_XDFFQ_S XD4_XDFFM_MB XD5_XDFFQ_S 1.8151e-17
* device instance cc_XD4_XDFFM_MB_XD5_XDFFQ_SB r0 *1 0,0
Ccc_XD4_XDFFM_MB_XD5_XDFFQ_SB XD4_XDFFM_MB XD5_XDFFQ_SB 1.8151e-17
* device instance cc_XD4_XDFFM_MB_XD5_XDFFQ_SFB r0 *1 0,0
Ccc_XD4_XDFFM_MB_XD5_XDFFQ_SFB XD4_XDFFM_MB XD5_XDFFQ_SFB 1.21e-17
* device instance cc_XD4_XDFFM_MB_XD5_XN2_mid1 r0 *1 0,0
Ccc_XD4_XDFFM_MB_XD5_XN2_mid1 XD4_XDFFM_MB XD5_XN2_mid1 1.21e-17
* device instance cc_XD4_XDFFM_MB_XD5_XN3_mid1 r0 *1 0,0
Ccc_XD4_XDFFM_MB_XD5_XN3_mid1 XD4_XDFFM_MB XD5_XN3_mid1 1.21e-17
* device instance cc_XD4_XDFFM_MB_XD5_XN3_mid2 r0 *1 0,0
Ccc_XD4_XDFFM_MB_XD5_XN3_mid2 XD4_XDFFM_MB XD5_XN3_mid2 1.21e-17
* device instance cc_XD4_XDFFM_MB_XD5_dmodout r0 *1 0,0
Ccc_XD4_XDFFM_MB_XD5_dmodout XD4_XDFFM_MB XD5_dmodout 1.21e-17
* device instance cc_XD4_XDFFM_MB_XD5_dq r0 *1 0,0
Ccc_XD4_XDFFM_MB_XD5_dq XD4_XDFFM_MB XD5_dq 1.8151e-17
* device instance cc_XD4_XDFFM_MB_XD5_nm r0 *1 0,0
Ccc_XD4_XDFFM_MB_XD5_nm XD4_XDFFM_MB XD5_nm 1.21e-17
* device instance cc_XD4_XDFFM_MB_XD5_nt r0 *1 0,0
Ccc_XD4_XDFFM_MB_XD5_nt XD4_XDFFM_MB XD5_nt 1.21e-17
* device instance cc_XD4_XDFFM_MB_XD5_t1 r0 *1 0,0
Ccc_XD4_XDFFM_MB_XD5_t1 XD4_XDFFM_MB XD5_t1 1.21e-17
* device instance cc_XD4_XDFFM_MB_XFRT_CKBB r0 *1 0,0
Ccc_XD4_XDFFM_MB_XFRT_CKBB XD4_XDFFM_MB XFRT_CKBB 1.8151e-17
* device instance cc_XD4_XDFFM_MB_XFRT_CLKB r0 *1 0,0
Ccc_XD4_XDFFM_MB_XFRT_CLKB XD4_XDFFM_MB XFRT_CLKB 2.4201e-17
* device instance cc_XD4_XDFFM_MB_XFRT_M r0 *1 0,0
Ccc_XD4_XDFFM_MB_XFRT_M XD4_XDFFM_MB XFRT_M 2.4201e-17
* device instance cc_XD4_XDFFM_MB_XFRT_MB r0 *1 0,0
Ccc_XD4_XDFFM_MB_XFRT_MB XD4_XDFFM_MB XFRT_MB 1.21e-17
* device instance cc_XD4_XDFFM_MB_XFRT_MFB r0 *1 0,0
Ccc_XD4_XDFFM_MB_XFRT_MFB XD4_XDFFM_MB XFRT_MFB 1.21e-17
* device instance cc_XD4_XDFFM_MB_XFRT_S r0 *1 0,0
Ccc_XD4_XDFFM_MB_XFRT_S XD4_XDFFM_MB XFRT_S 1.8151e-17
* device instance cc_XD4_XDFFM_MB_XFRT_SB r0 *1 0,0
Ccc_XD4_XDFFM_MB_XFRT_SB XD4_XDFFM_MB XFRT_SB 1.8151e-17
* device instance cc_XD4_XDFFM_MB_XFRT_SFB r0 *1 0,0
Ccc_XD4_XDFFM_MB_XFRT_SFB XD4_XDFFM_MB XFRT_SFB 1.21e-17
* device instance cc_XD4_XDFFM_MB_ck1 r0 *1 0,0
Ccc_XD4_XDFFM_MB_ck1 XD4_XDFFM_MB ck1 3.0251e-17
* device instance cc_XD4_XDFFM_MB_ck2 r0 *1 0,0
Ccc_XD4_XDFFM_MB_ck2 XD4_XDFFM_MB ck2 3.0251e-17
* device instance cc_XD4_XDFFM_MB_ck3 r0 *1 0,0
Ccc_XD4_XDFFM_MB_ck3 XD4_XDFFM_MB ck3 3.0251e-17
* device instance cc_XD4_XDFFM_MB_ck4 r0 *1 0,0
Ccc_XD4_XDFFM_MB_ck4 XD4_XDFFM_MB ck4 3.0251e-17
* device instance cc_XD4_XDFFM_MB_ck5 r0 *1 0,0
Ccc_XD4_XDFFM_MB_ck5 XD4_XDFFM_MB ck5 3.0251e-17
* device instance cc_XD4_XDFFM_MB_mod0 r0 *1 0,0
Ccc_XD4_XDFFM_MB_mod0 XD4_XDFFM_MB mod0 2.4201e-17
* device instance cc_XD4_XDFFM_MB_mod1 r0 *1 0,0
Ccc_XD4_XDFFM_MB_mod1 XD4_XDFFM_MB mod1 2.4201e-17
* device instance cc_XD4_XDFFM_MB_mod2 r0 *1 0,0
Ccc_XD4_XDFFM_MB_mod2 XD4_XDFFM_MB mod2 2.4201e-17
* device instance cc_XD4_XDFFM_MB_mod3 r0 *1 0,0
Ccc_XD4_XDFFM_MB_mod3 XD4_XDFFM_MB mod3 2.4201e-17
* device instance cc_XD4_XDFFM_MB_mod4 r0 *1 0,0
Ccc_XD4_XDFFM_MB_mod4 XD4_XDFFM_MB mod4 2.4201e-17
* device instance cc_XD4_XDFFM_MB_net1 r0 *1 0,0
Ccc_XD4_XDFFM_MB_net1 XD4_XDFFM_MB net1 1.21e-17
* device instance cc_XD4_XDFFM_MFB_XD4_XDFFM_S r0 *1 0,0
Ccc_XD4_XDFFM_MFB_XD4_XDFFM_S XD4_XDFFM_MFB XD4_XDFFM_S 1.8151e-17
* device instance cc_XD4_XDFFM_MFB_XD4_XDFFM_SB r0 *1 0,0
Ccc_XD4_XDFFM_MFB_XD4_XDFFM_SB XD4_XDFFM_MFB XD4_XDFFM_SB 1.8151e-17
* device instance cc_XD4_XDFFM_MFB_XD4_XDFFM_SFB r0 *1 0,0
Ccc_XD4_XDFFM_MFB_XD4_XDFFM_SFB XD4_XDFFM_MFB XD4_XDFFM_SFB 1.21e-17
* device instance cc_XD4_XDFFM_MFB_XD4_XDFFQ_CKBB r0 *1 0,0
Ccc_XD4_XDFFM_MFB_XD4_XDFFQ_CKBB XD4_XDFFM_MFB XD4_XDFFQ_CKBB 1.8151e-17
* device instance cc_XD4_XDFFM_MFB_XD4_XDFFQ_CLKB r0 *1 0,0
Ccc_XD4_XDFFM_MFB_XD4_XDFFQ_CLKB XD4_XDFFM_MFB XD4_XDFFQ_CLKB 2.4201e-17
* device instance cc_XD4_XDFFM_MFB_XD4_XDFFQ_M r0 *1 0,0
Ccc_XD4_XDFFM_MFB_XD4_XDFFQ_M XD4_XDFFM_MFB XD4_XDFFQ_M 2.4201e-17
* device instance cc_XD4_XDFFM_MFB_XD4_XDFFQ_MB r0 *1 0,0
Ccc_XD4_XDFFM_MFB_XD4_XDFFQ_MB XD4_XDFFM_MFB XD4_XDFFQ_MB 1.21e-17
* device instance cc_XD4_XDFFM_MFB_XD4_XDFFQ_MFB r0 *1 0,0
Ccc_XD4_XDFFM_MFB_XD4_XDFFQ_MFB XD4_XDFFM_MFB XD4_XDFFQ_MFB 1.21e-17
* device instance cc_XD4_XDFFM_MFB_XD4_XDFFQ_S r0 *1 0,0
Ccc_XD4_XDFFM_MFB_XD4_XDFFQ_S XD4_XDFFM_MFB XD4_XDFFQ_S 1.8151e-17
* device instance cc_XD4_XDFFM_MFB_XD4_XDFFQ_SB r0 *1 0,0
Ccc_XD4_XDFFM_MFB_XD4_XDFFQ_SB XD4_XDFFM_MFB XD4_XDFFQ_SB 1.8151e-17
* device instance cc_XD4_XDFFM_MFB_XD4_XDFFQ_SFB r0 *1 0,0
Ccc_XD4_XDFFM_MFB_XD4_XDFFQ_SFB XD4_XDFFM_MFB XD4_XDFFQ_SFB 1.21e-17
* device instance cc_XD4_XDFFM_MFB_XD4_XNOR_midp r0 *1 0,0
Ccc_XD4_XDFFM_MFB_XD4_XNOR_midp XD4_XDFFM_MFB XD4_XNOR_midp 1.21e-17
* device instance cc_XD4_XDFFM_MFB_XD4_dmodout r0 *1 0,0
Ccc_XD4_XDFFM_MFB_XD4_dmodout XD4_XDFFM_MFB XD4_dmodout 1.21e-17
* device instance cc_XD4_XDFFM_MFB_XD4_dq r0 *1 0,0
Ccc_XD4_XDFFM_MFB_XD4_dq XD4_XDFFM_MFB XD4_dq 1.21e-17
* device instance cc_XD4_XDFFM_MFB_XD4_nm r0 *1 0,0
Ccc_XD4_XDFFM_MFB_XD4_nm XD4_XDFFM_MFB XD4_nm 1.8151e-17
* device instance cc_XD4_XDFFM_MFB_XD4_nt r0 *1 0,0
Ccc_XD4_XDFFM_MFB_XD4_nt XD4_XDFFM_MFB XD4_nt 2.4201e-17
* device instance cc_XD4_XDFFM_MFB_XD4_t1 r0 *1 0,0
Ccc_XD4_XDFFM_MFB_XD4_t1 XD4_XDFFM_MFB XD4_t1 1.21e-17
* device instance cc_XD4_XDFFM_MFB_XD5_XDFFM_CKBB r0 *1 0,0
Ccc_XD4_XDFFM_MFB_XD5_XDFFM_CKBB XD4_XDFFM_MFB XD5_XDFFM_CKBB 1.8151e-17
* device instance cc_XD4_XDFFM_MFB_XD5_XDFFM_CLKB r0 *1 0,0
Ccc_XD4_XDFFM_MFB_XD5_XDFFM_CLKB XD4_XDFFM_MFB XD5_XDFFM_CLKB 2.4201e-17
* device instance cc_XD4_XDFFM_MFB_XD5_XDFFM_M r0 *1 0,0
Ccc_XD4_XDFFM_MFB_XD5_XDFFM_M XD4_XDFFM_MFB XD5_XDFFM_M 2.4201e-17
* device instance cc_XD4_XDFFM_MFB_XD5_XDFFM_MB r0 *1 0,0
Ccc_XD4_XDFFM_MFB_XD5_XDFFM_MB XD4_XDFFM_MFB XD5_XDFFM_MB 1.21e-17
* device instance cc_XD4_XDFFM_MFB_XD5_XDFFM_MFB r0 *1 0,0
Ccc_XD4_XDFFM_MFB_XD5_XDFFM_MFB XD4_XDFFM_MFB XD5_XDFFM_MFB 1.21e-17
* device instance cc_XD4_XDFFM_MFB_XD5_XDFFM_S r0 *1 0,0
Ccc_XD4_XDFFM_MFB_XD5_XDFFM_S XD4_XDFFM_MFB XD5_XDFFM_S 1.8151e-17
* device instance cc_XD4_XDFFM_MFB_XD5_XDFFM_SB r0 *1 0,0
Ccc_XD4_XDFFM_MFB_XD5_XDFFM_SB XD4_XDFFM_MFB XD5_XDFFM_SB 1.8151e-17
* device instance cc_XD4_XDFFM_MFB_XD5_XDFFM_SFB r0 *1 0,0
Ccc_XD4_XDFFM_MFB_XD5_XDFFM_SFB XD4_XDFFM_MFB XD5_XDFFM_SFB 1.21e-17
* device instance cc_XD4_XDFFM_MFB_XD5_XDFFQ_CKBB r0 *1 0,0
Ccc_XD4_XDFFM_MFB_XD5_XDFFQ_CKBB XD4_XDFFM_MFB XD5_XDFFQ_CKBB 1.8151e-17
* device instance cc_XD4_XDFFM_MFB_XD5_XDFFQ_CLKB r0 *1 0,0
Ccc_XD4_XDFFM_MFB_XD5_XDFFQ_CLKB XD4_XDFFM_MFB XD5_XDFFQ_CLKB 2.4201e-17
* device instance cc_XD4_XDFFM_MFB_XD5_XDFFQ_M r0 *1 0,0
Ccc_XD4_XDFFM_MFB_XD5_XDFFQ_M XD4_XDFFM_MFB XD5_XDFFQ_M 2.4201e-17
* device instance cc_XD4_XDFFM_MFB_XD5_XDFFQ_MB r0 *1 0,0
Ccc_XD4_XDFFM_MFB_XD5_XDFFQ_MB XD4_XDFFM_MFB XD5_XDFFQ_MB 1.21e-17
* device instance cc_XD4_XDFFM_MFB_XD5_XDFFQ_MFB r0 *1 0,0
Ccc_XD4_XDFFM_MFB_XD5_XDFFQ_MFB XD4_XDFFM_MFB XD5_XDFFQ_MFB 1.21e-17
* device instance cc_XD4_XDFFM_MFB_XD5_XDFFQ_S r0 *1 0,0
Ccc_XD4_XDFFM_MFB_XD5_XDFFQ_S XD4_XDFFM_MFB XD5_XDFFQ_S 1.8151e-17
* device instance cc_XD4_XDFFM_MFB_XD5_XDFFQ_SB r0 *1 0,0
Ccc_XD4_XDFFM_MFB_XD5_XDFFQ_SB XD4_XDFFM_MFB XD5_XDFFQ_SB 1.8151e-17
* device instance cc_XD4_XDFFM_MFB_XD5_XDFFQ_SFB r0 *1 0,0
Ccc_XD4_XDFFM_MFB_XD5_XDFFQ_SFB XD4_XDFFM_MFB XD5_XDFFQ_SFB 1.21e-17
* device instance cc_XD4_XDFFM_MFB_XD5_XN2_mid1 r0 *1 0,0
Ccc_XD4_XDFFM_MFB_XD5_XN2_mid1 XD4_XDFFM_MFB XD5_XN2_mid1 1.21e-17
* device instance cc_XD4_XDFFM_MFB_XD5_XN3_mid1 r0 *1 0,0
Ccc_XD4_XDFFM_MFB_XD5_XN3_mid1 XD4_XDFFM_MFB XD5_XN3_mid1 1.21e-17
* device instance cc_XD4_XDFFM_MFB_XD5_XN3_mid2 r0 *1 0,0
Ccc_XD4_XDFFM_MFB_XD5_XN3_mid2 XD4_XDFFM_MFB XD5_XN3_mid2 1.21e-17
* device instance cc_XD4_XDFFM_MFB_XD5_dmodout r0 *1 0,0
Ccc_XD4_XDFFM_MFB_XD5_dmodout XD4_XDFFM_MFB XD5_dmodout 1.21e-17
* device instance cc_XD4_XDFFM_MFB_XD5_dq r0 *1 0,0
Ccc_XD4_XDFFM_MFB_XD5_dq XD4_XDFFM_MFB XD5_dq 1.8151e-17
* device instance cc_XD4_XDFFM_MFB_XD5_nm r0 *1 0,0
Ccc_XD4_XDFFM_MFB_XD5_nm XD4_XDFFM_MFB XD5_nm 1.21e-17
* device instance cc_XD4_XDFFM_MFB_XD5_nt r0 *1 0,0
Ccc_XD4_XDFFM_MFB_XD5_nt XD4_XDFFM_MFB XD5_nt 1.21e-17
* device instance cc_XD4_XDFFM_MFB_XD5_t1 r0 *1 0,0
Ccc_XD4_XDFFM_MFB_XD5_t1 XD4_XDFFM_MFB XD5_t1 1.21e-17
* device instance cc_XD4_XDFFM_MFB_XFRT_CKBB r0 *1 0,0
Ccc_XD4_XDFFM_MFB_XFRT_CKBB XD4_XDFFM_MFB XFRT_CKBB 1.8151e-17
* device instance cc_XD4_XDFFM_MFB_XFRT_CLKB r0 *1 0,0
Ccc_XD4_XDFFM_MFB_XFRT_CLKB XD4_XDFFM_MFB XFRT_CLKB 2.4201e-17
* device instance cc_XD4_XDFFM_MFB_XFRT_M r0 *1 0,0
Ccc_XD4_XDFFM_MFB_XFRT_M XD4_XDFFM_MFB XFRT_M 2.4201e-17
* device instance cc_XD4_XDFFM_MFB_XFRT_MB r0 *1 0,0
Ccc_XD4_XDFFM_MFB_XFRT_MB XD4_XDFFM_MFB XFRT_MB 1.21e-17
* device instance cc_XD4_XDFFM_MFB_XFRT_MFB r0 *1 0,0
Ccc_XD4_XDFFM_MFB_XFRT_MFB XD4_XDFFM_MFB XFRT_MFB 1.21e-17
* device instance cc_XD4_XDFFM_MFB_XFRT_S r0 *1 0,0
Ccc_XD4_XDFFM_MFB_XFRT_S XD4_XDFFM_MFB XFRT_S 1.8151e-17
* device instance cc_XD4_XDFFM_MFB_XFRT_SB r0 *1 0,0
Ccc_XD4_XDFFM_MFB_XFRT_SB XD4_XDFFM_MFB XFRT_SB 1.8151e-17
* device instance cc_XD4_XDFFM_MFB_XFRT_SFB r0 *1 0,0
Ccc_XD4_XDFFM_MFB_XFRT_SFB XD4_XDFFM_MFB XFRT_SFB 1.21e-17
* device instance cc_XD4_XDFFM_MFB_ck1 r0 *1 0,0
Ccc_XD4_XDFFM_MFB_ck1 XD4_XDFFM_MFB ck1 3.0251e-17
* device instance cc_XD4_XDFFM_MFB_ck2 r0 *1 0,0
Ccc_XD4_XDFFM_MFB_ck2 XD4_XDFFM_MFB ck2 3.0251e-17
* device instance cc_XD4_XDFFM_MFB_ck3 r0 *1 0,0
Ccc_XD4_XDFFM_MFB_ck3 XD4_XDFFM_MFB ck3 3.0251e-17
* device instance cc_XD4_XDFFM_MFB_ck4 r0 *1 0,0
Ccc_XD4_XDFFM_MFB_ck4 XD4_XDFFM_MFB ck4 3.0251e-17
* device instance cc_XD4_XDFFM_MFB_ck5 r0 *1 0,0
Ccc_XD4_XDFFM_MFB_ck5 XD4_XDFFM_MFB ck5 3.0251e-17
* device instance cc_XD4_XDFFM_MFB_mod0 r0 *1 0,0
Ccc_XD4_XDFFM_MFB_mod0 XD4_XDFFM_MFB mod0 2.4201e-17
* device instance cc_XD4_XDFFM_MFB_mod1 r0 *1 0,0
Ccc_XD4_XDFFM_MFB_mod1 XD4_XDFFM_MFB mod1 2.4201e-17
* device instance cc_XD4_XDFFM_MFB_mod2 r0 *1 0,0
Ccc_XD4_XDFFM_MFB_mod2 XD4_XDFFM_MFB mod2 2.4201e-17
* device instance cc_XD4_XDFFM_MFB_mod3 r0 *1 0,0
Ccc_XD4_XDFFM_MFB_mod3 XD4_XDFFM_MFB mod3 2.4201e-17
* device instance cc_XD4_XDFFM_MFB_mod4 r0 *1 0,0
Ccc_XD4_XDFFM_MFB_mod4 XD4_XDFFM_MFB mod4 2.4201e-17
* device instance cc_XD4_XDFFM_MFB_net1 r0 *1 0,0
Ccc_XD4_XDFFM_MFB_net1 XD4_XDFFM_MFB net1 1.21e-17
* device instance cc_XD4_XDFFM_S_XD4_XDFFM_SB r0 *1 0,0
Ccc_XD4_XDFFM_S_XD4_XDFFM_SB XD4_XDFFM_S XD4_XDFFM_SB 3.0251e-17
* device instance cc_XD4_XDFFM_S_XD4_XDFFM_SFB r0 *1 0,0
Ccc_XD4_XDFFM_S_XD4_XDFFM_SFB XD4_XDFFM_S XD4_XDFFM_SFB 3.4688e-17
* device instance cc_XD4_XDFFM_S_XD4_XDFFQ_CKBB r0 *1 0,0
Ccc_XD4_XDFFM_S_XD4_XDFFQ_CKBB XD4_XDFFM_S XD4_XDFFQ_CKBB 1.8151e-17
* device instance cc_XD4_XDFFM_S_XD4_XDFFQ_CLKB r0 *1 0,0
Ccc_XD4_XDFFM_S_XD4_XDFFQ_CLKB XD4_XDFFM_S XD4_XDFFQ_CLKB 2.4201e-17
* device instance cc_XD4_XDFFM_S_XD4_XDFFQ_M r0 *1 0,0
Ccc_XD4_XDFFM_S_XD4_XDFFQ_M XD4_XDFFM_S XD4_XDFFQ_M 2.4201e-17
* device instance cc_XD4_XDFFM_S_XD4_XDFFQ_MB r0 *1 0,0
Ccc_XD4_XDFFM_S_XD4_XDFFQ_MB XD4_XDFFM_S XD4_XDFFQ_MB 1.21e-17
* device instance cc_XD4_XDFFM_S_XD4_XDFFQ_MFB r0 *1 0,0
Ccc_XD4_XDFFM_S_XD4_XDFFQ_MFB XD4_XDFFM_S XD4_XDFFQ_MFB 1.21e-17
* device instance cc_XD4_XDFFM_S_XD4_XDFFQ_S r0 *1 0,0
Ccc_XD4_XDFFM_S_XD4_XDFFQ_S XD4_XDFFM_S XD4_XDFFQ_S 1.8151e-17
* device instance cc_XD4_XDFFM_S_XD4_XDFFQ_SB r0 *1 0,0
Ccc_XD4_XDFFM_S_XD4_XDFFQ_SB XD4_XDFFM_S XD4_XDFFQ_SB 1.8151e-17
* device instance cc_XD4_XDFFM_S_XD4_XDFFQ_SFB r0 *1 0,0
Ccc_XD4_XDFFM_S_XD4_XDFFQ_SFB XD4_XDFFM_S XD4_XDFFQ_SFB 1.21e-17
* device instance cc_XD4_XDFFM_S_XD4_XNOR_midp r0 *1 0,0
Ccc_XD4_XDFFM_S_XD4_XNOR_midp XD4_XDFFM_S XD4_XNOR_midp 1.21e-17
* device instance cc_XD4_XDFFM_S_XD4_dmodout r0 *1 0,0
Ccc_XD4_XDFFM_S_XD4_dmodout XD4_XDFFM_S XD4_dmodout 1.21e-17
* device instance cc_XD4_XDFFM_S_XD4_dq r0 *1 0,0
Ccc_XD4_XDFFM_S_XD4_dq XD4_XDFFM_S XD4_dq 1.21e-17
* device instance cc_XD4_XDFFM_S_XD4_nm r0 *1 0,0
Ccc_XD4_XDFFM_S_XD4_nm XD4_XDFFM_S XD4_nm 1.8151e-17
* device instance cc_XD4_XDFFM_S_XD4_nt r0 *1 0,0
Ccc_XD4_XDFFM_S_XD4_nt XD4_XDFFM_S XD4_nt 2.4201e-17
* device instance cc_XD4_XDFFM_S_XD4_t1 r0 *1 0,0
Ccc_XD4_XDFFM_S_XD4_t1 XD4_XDFFM_S XD4_t1 1.21e-17
* device instance cc_XD4_XDFFM_S_XD5_XDFFM_CKBB r0 *1 0,0
Ccc_XD4_XDFFM_S_XD5_XDFFM_CKBB XD4_XDFFM_S XD5_XDFFM_CKBB 1.8151e-17
* device instance cc_XD4_XDFFM_S_XD5_XDFFM_CLKB r0 *1 0,0
Ccc_XD4_XDFFM_S_XD5_XDFFM_CLKB XD4_XDFFM_S XD5_XDFFM_CLKB 2.4201e-17
* device instance cc_XD4_XDFFM_S_XD5_XDFFM_M r0 *1 0,0
Ccc_XD4_XDFFM_S_XD5_XDFFM_M XD4_XDFFM_S XD5_XDFFM_M 2.4201e-17
* device instance cc_XD4_XDFFM_S_XD5_XDFFM_MB r0 *1 0,0
Ccc_XD4_XDFFM_S_XD5_XDFFM_MB XD4_XDFFM_S XD5_XDFFM_MB 1.21e-17
* device instance cc_XD4_XDFFM_S_XD5_XDFFM_MFB r0 *1 0,0
Ccc_XD4_XDFFM_S_XD5_XDFFM_MFB XD4_XDFFM_S XD5_XDFFM_MFB 1.21e-17
* device instance cc_XD4_XDFFM_S_XD5_XDFFM_S r0 *1 0,0
Ccc_XD4_XDFFM_S_XD5_XDFFM_S XD4_XDFFM_S XD5_XDFFM_S 1.8151e-17
* device instance cc_XD4_XDFFM_S_XD5_XDFFM_SB r0 *1 0,0
Ccc_XD4_XDFFM_S_XD5_XDFFM_SB XD4_XDFFM_S XD5_XDFFM_SB 1.8151e-17
* device instance cc_XD4_XDFFM_S_XD5_XDFFM_SFB r0 *1 0,0
Ccc_XD4_XDFFM_S_XD5_XDFFM_SFB XD4_XDFFM_S XD5_XDFFM_SFB 1.21e-17
* device instance cc_XD4_XDFFM_S_XD5_XDFFQ_CKBB r0 *1 0,0
Ccc_XD4_XDFFM_S_XD5_XDFFQ_CKBB XD4_XDFFM_S XD5_XDFFQ_CKBB 1.8151e-17
* device instance cc_XD4_XDFFM_S_XD5_XDFFQ_CLKB r0 *1 0,0
Ccc_XD4_XDFFM_S_XD5_XDFFQ_CLKB XD4_XDFFM_S XD5_XDFFQ_CLKB 2.4201e-17
* device instance cc_XD4_XDFFM_S_XD5_XDFFQ_M r0 *1 0,0
Ccc_XD4_XDFFM_S_XD5_XDFFQ_M XD4_XDFFM_S XD5_XDFFQ_M 2.4201e-17
* device instance cc_XD4_XDFFM_S_XD5_XDFFQ_MB r0 *1 0,0
Ccc_XD4_XDFFM_S_XD5_XDFFQ_MB XD4_XDFFM_S XD5_XDFFQ_MB 1.21e-17
* device instance cc_XD4_XDFFM_S_XD5_XDFFQ_MFB r0 *1 0,0
Ccc_XD4_XDFFM_S_XD5_XDFFQ_MFB XD4_XDFFM_S XD5_XDFFQ_MFB 1.21e-17
* device instance cc_XD4_XDFFM_S_XD5_XDFFQ_S r0 *1 0,0
Ccc_XD4_XDFFM_S_XD5_XDFFQ_S XD4_XDFFM_S XD5_XDFFQ_S 1.8151e-17
* device instance cc_XD4_XDFFM_S_XD5_XDFFQ_SB r0 *1 0,0
Ccc_XD4_XDFFM_S_XD5_XDFFQ_SB XD4_XDFFM_S XD5_XDFFQ_SB 1.8151e-17
* device instance cc_XD4_XDFFM_S_XD5_XDFFQ_SFB r0 *1 0,0
Ccc_XD4_XDFFM_S_XD5_XDFFQ_SFB XD4_XDFFM_S XD5_XDFFQ_SFB 1.21e-17
* device instance cc_XD4_XDFFM_S_XD5_XN2_mid1 r0 *1 0,0
Ccc_XD4_XDFFM_S_XD5_XN2_mid1 XD4_XDFFM_S XD5_XN2_mid1 1.21e-17
* device instance cc_XD4_XDFFM_S_XD5_XN3_mid1 r0 *1 0,0
Ccc_XD4_XDFFM_S_XD5_XN3_mid1 XD4_XDFFM_S XD5_XN3_mid1 1.21e-17
* device instance cc_XD4_XDFFM_S_XD5_XN3_mid2 r0 *1 0,0
Ccc_XD4_XDFFM_S_XD5_XN3_mid2 XD4_XDFFM_S XD5_XN3_mid2 1.21e-17
* device instance cc_XD4_XDFFM_S_XD5_dmodout r0 *1 0,0
Ccc_XD4_XDFFM_S_XD5_dmodout XD4_XDFFM_S XD5_dmodout 1.21e-17
* device instance cc_XD4_XDFFM_S_XD5_dq r0 *1 0,0
Ccc_XD4_XDFFM_S_XD5_dq XD4_XDFFM_S XD5_dq 1.8151e-17
* device instance cc_XD4_XDFFM_S_XD5_nm r0 *1 0,0
Ccc_XD4_XDFFM_S_XD5_nm XD4_XDFFM_S XD5_nm 1.21e-17
* device instance cc_XD4_XDFFM_S_XD5_nt r0 *1 0,0
Ccc_XD4_XDFFM_S_XD5_nt XD4_XDFFM_S XD5_nt 1.21e-17
* device instance cc_XD4_XDFFM_S_XD5_t1 r0 *1 0,0
Ccc_XD4_XDFFM_S_XD5_t1 XD4_XDFFM_S XD5_t1 1.21e-17
* device instance cc_XD4_XDFFM_S_XFRT_CKBB r0 *1 0,0
Ccc_XD4_XDFFM_S_XFRT_CKBB XD4_XDFFM_S XFRT_CKBB 1.8151e-17
* device instance cc_XD4_XDFFM_S_XFRT_CLKB r0 *1 0,0
Ccc_XD4_XDFFM_S_XFRT_CLKB XD4_XDFFM_S XFRT_CLKB 2.4201e-17
* device instance cc_XD4_XDFFM_S_XFRT_M r0 *1 0,0
Ccc_XD4_XDFFM_S_XFRT_M XD4_XDFFM_S XFRT_M 2.4201e-17
* device instance cc_XD4_XDFFM_S_XFRT_MB r0 *1 0,0
Ccc_XD4_XDFFM_S_XFRT_MB XD4_XDFFM_S XFRT_MB 1.21e-17
* device instance cc_XD4_XDFFM_S_XFRT_MFB r0 *1 0,0
Ccc_XD4_XDFFM_S_XFRT_MFB XD4_XDFFM_S XFRT_MFB 1.21e-17
* device instance cc_XD4_XDFFM_S_XFRT_S r0 *1 0,0
Ccc_XD4_XDFFM_S_XFRT_S XD4_XDFFM_S XFRT_S 1.8151e-17
* device instance cc_XD4_XDFFM_S_XFRT_SB r0 *1 0,0
Ccc_XD4_XDFFM_S_XFRT_SB XD4_XDFFM_S XFRT_SB 1.8151e-17
* device instance cc_XD4_XDFFM_S_XFRT_SFB r0 *1 0,0
Ccc_XD4_XDFFM_S_XFRT_SFB XD4_XDFFM_S XFRT_SFB 1.21e-17
* device instance cc_XD4_XDFFM_S_ck1 r0 *1 0,0
Ccc_XD4_XDFFM_S_ck1 XD4_XDFFM_S ck1 3.0251e-17
* device instance cc_XD4_XDFFM_S_ck2 r0 *1 0,0
Ccc_XD4_XDFFM_S_ck2 XD4_XDFFM_S ck2 3.0251e-17
* device instance cc_XD4_XDFFM_S_ck3 r0 *1 0,0
Ccc_XD4_XDFFM_S_ck3 XD4_XDFFM_S ck3 3.0251e-17
* device instance cc_XD4_XDFFM_S_ck4 r0 *1 0,0
Ccc_XD4_XDFFM_S_ck4 XD4_XDFFM_S ck4 3.0251e-17
* device instance cc_XD4_XDFFM_S_ck5 r0 *1 0,0
Ccc_XD4_XDFFM_S_ck5 XD4_XDFFM_S ck5 3.0251e-17
* device instance cc_XD4_XDFFM_S_mod0 r0 *1 0,0
Ccc_XD4_XDFFM_S_mod0 XD4_XDFFM_S mod0 2.4201e-17
* device instance cc_XD4_XDFFM_S_mod1 r0 *1 0,0
Ccc_XD4_XDFFM_S_mod1 XD4_XDFFM_S mod1 2.4201e-17
* device instance cc_XD4_XDFFM_S_mod2 r0 *1 0,0
Ccc_XD4_XDFFM_S_mod2 XD4_XDFFM_S mod2 2.4201e-17
* device instance cc_XD4_XDFFM_S_mod3 r0 *1 0,0
Ccc_XD4_XDFFM_S_mod3 XD4_XDFFM_S mod3 2.4201e-17
* device instance cc_XD4_XDFFM_S_mod4 r0 *1 0,0
Ccc_XD4_XDFFM_S_mod4 XD4_XDFFM_S mod4 2.4201e-17
* device instance cc_XD4_XDFFM_S_net1 r0 *1 0,0
Ccc_XD4_XDFFM_S_net1 XD4_XDFFM_S net1 1.21e-17
* device instance cc_XD4_XDFFM_SB_XD4_XDFFM_SFB r0 *1 0,0
Ccc_XD4_XDFFM_SB_XD4_XDFFM_SFB XD4_XDFFM_SB XD4_XDFFM_SFB 2.4201e-17
* device instance cc_XD4_XDFFM_SB_XD4_XDFFQ_CKBB r0 *1 0,0
Ccc_XD4_XDFFM_SB_XD4_XDFFQ_CKBB XD4_XDFFM_SB XD4_XDFFQ_CKBB 1.8151e-17
* device instance cc_XD4_XDFFM_SB_XD4_XDFFQ_CLKB r0 *1 0,0
Ccc_XD4_XDFFM_SB_XD4_XDFFQ_CLKB XD4_XDFFM_SB XD4_XDFFQ_CLKB 2.4201e-17
* device instance cc_XD4_XDFFM_SB_XD4_XDFFQ_M r0 *1 0,0
Ccc_XD4_XDFFM_SB_XD4_XDFFQ_M XD4_XDFFM_SB XD4_XDFFQ_M 2.4201e-17
* device instance cc_XD4_XDFFM_SB_XD4_XDFFQ_MB r0 *1 0,0
Ccc_XD4_XDFFM_SB_XD4_XDFFQ_MB XD4_XDFFM_SB XD4_XDFFQ_MB 1.21e-17
* device instance cc_XD4_XDFFM_SB_XD4_XDFFQ_MFB r0 *1 0,0
Ccc_XD4_XDFFM_SB_XD4_XDFFQ_MFB XD4_XDFFM_SB XD4_XDFFQ_MFB 1.21e-17
* device instance cc_XD4_XDFFM_SB_XD4_XDFFQ_S r0 *1 0,0
Ccc_XD4_XDFFM_SB_XD4_XDFFQ_S XD4_XDFFM_SB XD4_XDFFQ_S 1.8151e-17
* device instance cc_XD4_XDFFM_SB_XD4_XDFFQ_SB r0 *1 0,0
Ccc_XD4_XDFFM_SB_XD4_XDFFQ_SB XD4_XDFFM_SB XD4_XDFFQ_SB 1.8151e-17
* device instance cc_XD4_XDFFM_SB_XD4_XDFFQ_SFB r0 *1 0,0
Ccc_XD4_XDFFM_SB_XD4_XDFFQ_SFB XD4_XDFFM_SB XD4_XDFFQ_SFB 1.21e-17
* device instance cc_XD4_XDFFM_SB_XD4_XNOR_midp r0 *1 0,0
Ccc_XD4_XDFFM_SB_XD4_XNOR_midp XD4_XDFFM_SB XD4_XNOR_midp 1.21e-17
* device instance cc_XD4_XDFFM_SB_XD4_dmodout r0 *1 0,0
Ccc_XD4_XDFFM_SB_XD4_dmodout XD4_XDFFM_SB XD4_dmodout 1.21e-17
* device instance cc_XD4_XDFFM_SB_XD4_dq r0 *1 0,0
Ccc_XD4_XDFFM_SB_XD4_dq XD4_XDFFM_SB XD4_dq 1.21e-17
* device instance cc_XD4_XDFFM_SB_XD4_nm r0 *1 0,0
Ccc_XD4_XDFFM_SB_XD4_nm XD4_XDFFM_SB XD4_nm 1.8151e-17
* device instance cc_XD4_XDFFM_SB_XD4_nt r0 *1 0,0
Ccc_XD4_XDFFM_SB_XD4_nt XD4_XDFFM_SB XD4_nt 2.4201e-17
* device instance cc_XD4_XDFFM_SB_XD4_t1 r0 *1 0,0
Ccc_XD4_XDFFM_SB_XD4_t1 XD4_XDFFM_SB XD4_t1 1.21e-17
* device instance cc_XD4_XDFFM_SB_XD5_XDFFM_CKBB r0 *1 0,0
Ccc_XD4_XDFFM_SB_XD5_XDFFM_CKBB XD4_XDFFM_SB XD5_XDFFM_CKBB 1.8151e-17
* device instance cc_XD4_XDFFM_SB_XD5_XDFFM_CLKB r0 *1 0,0
Ccc_XD4_XDFFM_SB_XD5_XDFFM_CLKB XD4_XDFFM_SB XD5_XDFFM_CLKB 2.4201e-17
* device instance cc_XD4_XDFFM_SB_XD5_XDFFM_M r0 *1 0,0
Ccc_XD4_XDFFM_SB_XD5_XDFFM_M XD4_XDFFM_SB XD5_XDFFM_M 2.4201e-17
* device instance cc_XD4_XDFFM_SB_XD5_XDFFM_MB r0 *1 0,0
Ccc_XD4_XDFFM_SB_XD5_XDFFM_MB XD4_XDFFM_SB XD5_XDFFM_MB 1.21e-17
* device instance cc_XD4_XDFFM_SB_XD5_XDFFM_MFB r0 *1 0,0
Ccc_XD4_XDFFM_SB_XD5_XDFFM_MFB XD4_XDFFM_SB XD5_XDFFM_MFB 1.21e-17
* device instance cc_XD4_XDFFM_SB_XD5_XDFFM_S r0 *1 0,0
Ccc_XD4_XDFFM_SB_XD5_XDFFM_S XD4_XDFFM_SB XD5_XDFFM_S 1.8151e-17
* device instance cc_XD4_XDFFM_SB_XD5_XDFFM_SB r0 *1 0,0
Ccc_XD4_XDFFM_SB_XD5_XDFFM_SB XD4_XDFFM_SB XD5_XDFFM_SB 1.8151e-17
* device instance cc_XD4_XDFFM_SB_XD5_XDFFM_SFB r0 *1 0,0
Ccc_XD4_XDFFM_SB_XD5_XDFFM_SFB XD4_XDFFM_SB XD5_XDFFM_SFB 1.21e-17
* device instance cc_XD4_XDFFM_SB_XD5_XDFFQ_CKBB r0 *1 0,0
Ccc_XD4_XDFFM_SB_XD5_XDFFQ_CKBB XD4_XDFFM_SB XD5_XDFFQ_CKBB 1.8151e-17
* device instance cc_XD4_XDFFM_SB_XD5_XDFFQ_CLKB r0 *1 0,0
Ccc_XD4_XDFFM_SB_XD5_XDFFQ_CLKB XD4_XDFFM_SB XD5_XDFFQ_CLKB 2.4201e-17
* device instance cc_XD4_XDFFM_SB_XD5_XDFFQ_M r0 *1 0,0
Ccc_XD4_XDFFM_SB_XD5_XDFFQ_M XD4_XDFFM_SB XD5_XDFFQ_M 2.4201e-17
* device instance cc_XD4_XDFFM_SB_XD5_XDFFQ_MB r0 *1 0,0
Ccc_XD4_XDFFM_SB_XD5_XDFFQ_MB XD4_XDFFM_SB XD5_XDFFQ_MB 1.21e-17
* device instance cc_XD4_XDFFM_SB_XD5_XDFFQ_MFB r0 *1 0,0
Ccc_XD4_XDFFM_SB_XD5_XDFFQ_MFB XD4_XDFFM_SB XD5_XDFFQ_MFB 1.21e-17
* device instance cc_XD4_XDFFM_SB_XD5_XDFFQ_S r0 *1 0,0
Ccc_XD4_XDFFM_SB_XD5_XDFFQ_S XD4_XDFFM_SB XD5_XDFFQ_S 1.8151e-17
* device instance cc_XD4_XDFFM_SB_XD5_XDFFQ_SB r0 *1 0,0
Ccc_XD4_XDFFM_SB_XD5_XDFFQ_SB XD4_XDFFM_SB XD5_XDFFQ_SB 1.8151e-17
* device instance cc_XD4_XDFFM_SB_XD5_XDFFQ_SFB r0 *1 0,0
Ccc_XD4_XDFFM_SB_XD5_XDFFQ_SFB XD4_XDFFM_SB XD5_XDFFQ_SFB 1.21e-17
* device instance cc_XD4_XDFFM_SB_XD5_XN2_mid1 r0 *1 0,0
Ccc_XD4_XDFFM_SB_XD5_XN2_mid1 XD4_XDFFM_SB XD5_XN2_mid1 1.21e-17
* device instance cc_XD4_XDFFM_SB_XD5_XN3_mid1 r0 *1 0,0
Ccc_XD4_XDFFM_SB_XD5_XN3_mid1 XD4_XDFFM_SB XD5_XN3_mid1 1.21e-17
* device instance cc_XD4_XDFFM_SB_XD5_XN3_mid2 r0 *1 0,0
Ccc_XD4_XDFFM_SB_XD5_XN3_mid2 XD4_XDFFM_SB XD5_XN3_mid2 1.21e-17
* device instance cc_XD4_XDFFM_SB_XD5_dmodout r0 *1 0,0
Ccc_XD4_XDFFM_SB_XD5_dmodout XD4_XDFFM_SB XD5_dmodout 1.21e-17
* device instance cc_XD4_XDFFM_SB_XD5_dq r0 *1 0,0
Ccc_XD4_XDFFM_SB_XD5_dq XD4_XDFFM_SB XD5_dq 1.8151e-17
* device instance cc_XD4_XDFFM_SB_XD5_nm r0 *1 0,0
Ccc_XD4_XDFFM_SB_XD5_nm XD4_XDFFM_SB XD5_nm 1.21e-17
* device instance cc_XD4_XDFFM_SB_XD5_nt r0 *1 0,0
Ccc_XD4_XDFFM_SB_XD5_nt XD4_XDFFM_SB XD5_nt 1.21e-17
* device instance cc_XD4_XDFFM_SB_XD5_t1 r0 *1 0,0
Ccc_XD4_XDFFM_SB_XD5_t1 XD4_XDFFM_SB XD5_t1 1.21e-17
* device instance cc_XD4_XDFFM_SB_XFRT_CKBB r0 *1 0,0
Ccc_XD4_XDFFM_SB_XFRT_CKBB XD4_XDFFM_SB XFRT_CKBB 1.8151e-17
* device instance cc_XD4_XDFFM_SB_XFRT_CLKB r0 *1 0,0
Ccc_XD4_XDFFM_SB_XFRT_CLKB XD4_XDFFM_SB XFRT_CLKB 2.4201e-17
* device instance cc_XD4_XDFFM_SB_XFRT_M r0 *1 0,0
Ccc_XD4_XDFFM_SB_XFRT_M XD4_XDFFM_SB XFRT_M 2.4201e-17
* device instance cc_XD4_XDFFM_SB_XFRT_MB r0 *1 0,0
Ccc_XD4_XDFFM_SB_XFRT_MB XD4_XDFFM_SB XFRT_MB 1.21e-17
* device instance cc_XD4_XDFFM_SB_XFRT_MFB r0 *1 0,0
Ccc_XD4_XDFFM_SB_XFRT_MFB XD4_XDFFM_SB XFRT_MFB 1.21e-17
* device instance cc_XD4_XDFFM_SB_XFRT_S r0 *1 0,0
Ccc_XD4_XDFFM_SB_XFRT_S XD4_XDFFM_SB XFRT_S 1.8151e-17
* device instance cc_XD4_XDFFM_SB_XFRT_SB r0 *1 0,0
Ccc_XD4_XDFFM_SB_XFRT_SB XD4_XDFFM_SB XFRT_SB 1.8151e-17
* device instance cc_XD4_XDFFM_SB_XFRT_SFB r0 *1 0,0
Ccc_XD4_XDFFM_SB_XFRT_SFB XD4_XDFFM_SB XFRT_SFB 1.21e-17
* device instance cc_XD4_XDFFM_SB_ck1 r0 *1 0,0
Ccc_XD4_XDFFM_SB_ck1 XD4_XDFFM_SB ck1 3.0251e-17
* device instance cc_XD4_XDFFM_SB_ck2 r0 *1 0,0
Ccc_XD4_XDFFM_SB_ck2 XD4_XDFFM_SB ck2 3.0251e-17
* device instance cc_XD4_XDFFM_SB_ck3 r0 *1 0,0
Ccc_XD4_XDFFM_SB_ck3 XD4_XDFFM_SB ck3 3.0251e-17
* device instance cc_XD4_XDFFM_SB_ck4 r0 *1 0,0
Ccc_XD4_XDFFM_SB_ck4 XD4_XDFFM_SB ck4 3.0251e-17
* device instance cc_XD4_XDFFM_SB_ck5 r0 *1 0,0
Ccc_XD4_XDFFM_SB_ck5 XD4_XDFFM_SB ck5 3.0251e-17
* device instance cc_XD4_XDFFM_SB_mod0 r0 *1 0,0
Ccc_XD4_XDFFM_SB_mod0 XD4_XDFFM_SB mod0 2.4201e-17
* device instance cc_XD4_XDFFM_SB_mod1 r0 *1 0,0
Ccc_XD4_XDFFM_SB_mod1 XD4_XDFFM_SB mod1 2.4201e-17
* device instance cc_XD4_XDFFM_SB_mod2 r0 *1 0,0
Ccc_XD4_XDFFM_SB_mod2 XD4_XDFFM_SB mod2 2.4201e-17
* device instance cc_XD4_XDFFM_SB_mod3 r0 *1 0,0
Ccc_XD4_XDFFM_SB_mod3 XD4_XDFFM_SB mod3 2.4201e-17
* device instance cc_XD4_XDFFM_SB_mod4 r0 *1 0,0
Ccc_XD4_XDFFM_SB_mod4 XD4_XDFFM_SB mod4 2.4201e-17
* device instance cc_XD4_XDFFM_SB_net1 r0 *1 0,0
Ccc_XD4_XDFFM_SB_net1 XD4_XDFFM_SB net1 1.21e-17
* device instance cc_XD4_XDFFM_SFB_XD4_XDFFQ_CKBB r0 *1 0,0
Ccc_XD4_XDFFM_SFB_XD4_XDFFQ_CKBB XD4_XDFFM_SFB XD4_XDFFQ_CKBB 1.8151e-17
* device instance cc_XD4_XDFFM_SFB_XD4_XDFFQ_CLKB r0 *1 0,0
Ccc_XD4_XDFFM_SFB_XD4_XDFFQ_CLKB XD4_XDFFM_SFB XD4_XDFFQ_CLKB 2.4201e-17
* device instance cc_XD4_XDFFM_SFB_XD4_XDFFQ_M r0 *1 0,0
Ccc_XD4_XDFFM_SFB_XD4_XDFFQ_M XD4_XDFFM_SFB XD4_XDFFQ_M 2.4201e-17
* device instance cc_XD4_XDFFM_SFB_XD4_XDFFQ_MB r0 *1 0,0
Ccc_XD4_XDFFM_SFB_XD4_XDFFQ_MB XD4_XDFFM_SFB XD4_XDFFQ_MB 1.21e-17
* device instance cc_XD4_XDFFM_SFB_XD4_XDFFQ_MFB r0 *1 0,0
Ccc_XD4_XDFFM_SFB_XD4_XDFFQ_MFB XD4_XDFFM_SFB XD4_XDFFQ_MFB 1.21e-17
* device instance cc_XD4_XDFFM_SFB_XD4_XDFFQ_S r0 *1 0,0
Ccc_XD4_XDFFM_SFB_XD4_XDFFQ_S XD4_XDFFM_SFB XD4_XDFFQ_S 1.8151e-17
* device instance cc_XD4_XDFFM_SFB_XD4_XDFFQ_SB r0 *1 0,0
Ccc_XD4_XDFFM_SFB_XD4_XDFFQ_SB XD4_XDFFM_SFB XD4_XDFFQ_SB 1.8151e-17
* device instance cc_XD4_XDFFM_SFB_XD4_XDFFQ_SFB r0 *1 0,0
Ccc_XD4_XDFFM_SFB_XD4_XDFFQ_SFB XD4_XDFFM_SFB XD4_XDFFQ_SFB 1.21e-17
* device instance cc_XD4_XDFFM_SFB_XD4_XNOR_midp r0 *1 0,0
Ccc_XD4_XDFFM_SFB_XD4_XNOR_midp XD4_XDFFM_SFB XD4_XNOR_midp 1.21e-17
* device instance cc_XD4_XDFFM_SFB_XD4_dmodout r0 *1 0,0
Ccc_XD4_XDFFM_SFB_XD4_dmodout XD4_XDFFM_SFB XD4_dmodout 1.21e-17
* device instance cc_XD4_XDFFM_SFB_XD4_dq r0 *1 0,0
Ccc_XD4_XDFFM_SFB_XD4_dq XD4_XDFFM_SFB XD4_dq 1.21e-17
* device instance cc_XD4_XDFFM_SFB_XD4_nm r0 *1 0,0
Ccc_XD4_XDFFM_SFB_XD4_nm XD4_XDFFM_SFB XD4_nm 1.8151e-17
* device instance cc_XD4_XDFFM_SFB_XD4_nt r0 *1 0,0
Ccc_XD4_XDFFM_SFB_XD4_nt XD4_XDFFM_SFB XD4_nt 2.4201e-17
* device instance cc_XD4_XDFFM_SFB_XD4_t1 r0 *1 0,0
Ccc_XD4_XDFFM_SFB_XD4_t1 XD4_XDFFM_SFB XD4_t1 1.21e-17
* device instance cc_XD4_XDFFM_SFB_XD5_XDFFM_CKBB r0 *1 0,0
Ccc_XD4_XDFFM_SFB_XD5_XDFFM_CKBB XD4_XDFFM_SFB XD5_XDFFM_CKBB 1.8151e-17
* device instance cc_XD4_XDFFM_SFB_XD5_XDFFM_CLKB r0 *1 0,0
Ccc_XD4_XDFFM_SFB_XD5_XDFFM_CLKB XD4_XDFFM_SFB XD5_XDFFM_CLKB 2.4201e-17
* device instance cc_XD4_XDFFM_SFB_XD5_XDFFM_M r0 *1 0,0
Ccc_XD4_XDFFM_SFB_XD5_XDFFM_M XD4_XDFFM_SFB XD5_XDFFM_M 2.4201e-17
* device instance cc_XD4_XDFFM_SFB_XD5_XDFFM_MB r0 *1 0,0
Ccc_XD4_XDFFM_SFB_XD5_XDFFM_MB XD4_XDFFM_SFB XD5_XDFFM_MB 1.21e-17
* device instance cc_XD4_XDFFM_SFB_XD5_XDFFM_MFB r0 *1 0,0
Ccc_XD4_XDFFM_SFB_XD5_XDFFM_MFB XD4_XDFFM_SFB XD5_XDFFM_MFB 1.21e-17
* device instance cc_XD4_XDFFM_SFB_XD5_XDFFM_S r0 *1 0,0
Ccc_XD4_XDFFM_SFB_XD5_XDFFM_S XD4_XDFFM_SFB XD5_XDFFM_S 1.8151e-17
* device instance cc_XD4_XDFFM_SFB_XD5_XDFFM_SB r0 *1 0,0
Ccc_XD4_XDFFM_SFB_XD5_XDFFM_SB XD4_XDFFM_SFB XD5_XDFFM_SB 1.8151e-17
* device instance cc_XD4_XDFFM_SFB_XD5_XDFFM_SFB r0 *1 0,0
Ccc_XD4_XDFFM_SFB_XD5_XDFFM_SFB XD4_XDFFM_SFB XD5_XDFFM_SFB 1.21e-17
* device instance cc_XD4_XDFFM_SFB_XD5_XDFFQ_CKBB r0 *1 0,0
Ccc_XD4_XDFFM_SFB_XD5_XDFFQ_CKBB XD4_XDFFM_SFB XD5_XDFFQ_CKBB 1.8151e-17
* device instance cc_XD4_XDFFM_SFB_XD5_XDFFQ_CLKB r0 *1 0,0
Ccc_XD4_XDFFM_SFB_XD5_XDFFQ_CLKB XD4_XDFFM_SFB XD5_XDFFQ_CLKB 2.4201e-17
* device instance cc_XD4_XDFFM_SFB_XD5_XDFFQ_M r0 *1 0,0
Ccc_XD4_XDFFM_SFB_XD5_XDFFQ_M XD4_XDFFM_SFB XD5_XDFFQ_M 2.4201e-17
* device instance cc_XD4_XDFFM_SFB_XD5_XDFFQ_MB r0 *1 0,0
Ccc_XD4_XDFFM_SFB_XD5_XDFFQ_MB XD4_XDFFM_SFB XD5_XDFFQ_MB 1.21e-17
* device instance cc_XD4_XDFFM_SFB_XD5_XDFFQ_MFB r0 *1 0,0
Ccc_XD4_XDFFM_SFB_XD5_XDFFQ_MFB XD4_XDFFM_SFB XD5_XDFFQ_MFB 1.21e-17
* device instance cc_XD4_XDFFM_SFB_XD5_XDFFQ_S r0 *1 0,0
Ccc_XD4_XDFFM_SFB_XD5_XDFFQ_S XD4_XDFFM_SFB XD5_XDFFQ_S 1.8151e-17
* device instance cc_XD4_XDFFM_SFB_XD5_XDFFQ_SB r0 *1 0,0
Ccc_XD4_XDFFM_SFB_XD5_XDFFQ_SB XD4_XDFFM_SFB XD5_XDFFQ_SB 1.8151e-17
* device instance cc_XD4_XDFFM_SFB_XD5_XDFFQ_SFB r0 *1 0,0
Ccc_XD4_XDFFM_SFB_XD5_XDFFQ_SFB XD4_XDFFM_SFB XD5_XDFFQ_SFB 1.21e-17
* device instance cc_XD4_XDFFM_SFB_XD5_XN2_mid1 r0 *1 0,0
Ccc_XD4_XDFFM_SFB_XD5_XN2_mid1 XD4_XDFFM_SFB XD5_XN2_mid1 1.21e-17
* device instance cc_XD4_XDFFM_SFB_XD5_XN3_mid1 r0 *1 0,0
Ccc_XD4_XDFFM_SFB_XD5_XN3_mid1 XD4_XDFFM_SFB XD5_XN3_mid1 1.21e-17
* device instance cc_XD4_XDFFM_SFB_XD5_XN3_mid2 r0 *1 0,0
Ccc_XD4_XDFFM_SFB_XD5_XN3_mid2 XD4_XDFFM_SFB XD5_XN3_mid2 1.21e-17
* device instance cc_XD4_XDFFM_SFB_XD5_dmodout r0 *1 0,0
Ccc_XD4_XDFFM_SFB_XD5_dmodout XD4_XDFFM_SFB XD5_dmodout 1.21e-17
* device instance cc_XD4_XDFFM_SFB_XD5_dq r0 *1 0,0
Ccc_XD4_XDFFM_SFB_XD5_dq XD4_XDFFM_SFB XD5_dq 1.8151e-17
* device instance cc_XD4_XDFFM_SFB_XD5_nm r0 *1 0,0
Ccc_XD4_XDFFM_SFB_XD5_nm XD4_XDFFM_SFB XD5_nm 1.21e-17
* device instance cc_XD4_XDFFM_SFB_XD5_nt r0 *1 0,0
Ccc_XD4_XDFFM_SFB_XD5_nt XD4_XDFFM_SFB XD5_nt 1.21e-17
* device instance cc_XD4_XDFFM_SFB_XD5_t1 r0 *1 0,0
Ccc_XD4_XDFFM_SFB_XD5_t1 XD4_XDFFM_SFB XD5_t1 1.21e-17
* device instance cc_XD4_XDFFM_SFB_XFRT_CKBB r0 *1 0,0
Ccc_XD4_XDFFM_SFB_XFRT_CKBB XD4_XDFFM_SFB XFRT_CKBB 1.8151e-17
* device instance cc_XD4_XDFFM_SFB_XFRT_CLKB r0 *1 0,0
Ccc_XD4_XDFFM_SFB_XFRT_CLKB XD4_XDFFM_SFB XFRT_CLKB 2.4201e-17
* device instance cc_XD4_XDFFM_SFB_XFRT_M r0 *1 0,0
Ccc_XD4_XDFFM_SFB_XFRT_M XD4_XDFFM_SFB XFRT_M 2.4201e-17
* device instance cc_XD4_XDFFM_SFB_XFRT_MB r0 *1 0,0
Ccc_XD4_XDFFM_SFB_XFRT_MB XD4_XDFFM_SFB XFRT_MB 1.21e-17
* device instance cc_XD4_XDFFM_SFB_XFRT_MFB r0 *1 0,0
Ccc_XD4_XDFFM_SFB_XFRT_MFB XD4_XDFFM_SFB XFRT_MFB 1.21e-17
* device instance cc_XD4_XDFFM_SFB_XFRT_S r0 *1 0,0
Ccc_XD4_XDFFM_SFB_XFRT_S XD4_XDFFM_SFB XFRT_S 1.8151e-17
* device instance cc_XD4_XDFFM_SFB_XFRT_SB r0 *1 0,0
Ccc_XD4_XDFFM_SFB_XFRT_SB XD4_XDFFM_SFB XFRT_SB 1.8151e-17
* device instance cc_XD4_XDFFM_SFB_XFRT_SFB r0 *1 0,0
Ccc_XD4_XDFFM_SFB_XFRT_SFB XD4_XDFFM_SFB XFRT_SFB 1.21e-17
* device instance cc_XD4_XDFFM_SFB_ck1 r0 *1 0,0
Ccc_XD4_XDFFM_SFB_ck1 XD4_XDFFM_SFB ck1 3.0251e-17
* device instance cc_XD4_XDFFM_SFB_ck2 r0 *1 0,0
Ccc_XD4_XDFFM_SFB_ck2 XD4_XDFFM_SFB ck2 3.0251e-17
* device instance cc_XD4_XDFFM_SFB_ck3 r0 *1 0,0
Ccc_XD4_XDFFM_SFB_ck3 XD4_XDFFM_SFB ck3 3.0251e-17
* device instance cc_XD4_XDFFM_SFB_ck4 r0 *1 0,0
Ccc_XD4_XDFFM_SFB_ck4 XD4_XDFFM_SFB ck4 3.0251e-17
* device instance cc_XD4_XDFFM_SFB_ck5 r0 *1 0,0
Ccc_XD4_XDFFM_SFB_ck5 XD4_XDFFM_SFB ck5 3.0251e-17
* device instance cc_XD4_XDFFM_SFB_mod0 r0 *1 0,0
Ccc_XD4_XDFFM_SFB_mod0 XD4_XDFFM_SFB mod0 2.4201e-17
* device instance cc_XD4_XDFFM_SFB_mod1 r0 *1 0,0
Ccc_XD4_XDFFM_SFB_mod1 XD4_XDFFM_SFB mod1 2.4201e-17
* device instance cc_XD4_XDFFM_SFB_mod2 r0 *1 0,0
Ccc_XD4_XDFFM_SFB_mod2 XD4_XDFFM_SFB mod2 2.4201e-17
* device instance cc_XD4_XDFFM_SFB_mod3 r0 *1 0,0
Ccc_XD4_XDFFM_SFB_mod3 XD4_XDFFM_SFB mod3 2.4201e-17
* device instance cc_XD4_XDFFM_SFB_mod4 r0 *1 0,0
Ccc_XD4_XDFFM_SFB_mod4 XD4_XDFFM_SFB mod4 2.4201e-17
* device instance cc_XD4_XDFFM_SFB_net1 r0 *1 0,0
Ccc_XD4_XDFFM_SFB_net1 XD4_XDFFM_SFB net1 1.21e-17
* device instance cc_XD4_XDFFQ_CKBB_XD4_XDFFQ_CLKB r0 *1 0,0
Ccc_XD4_XDFFQ_CKBB_XD4_XDFFQ_CLKB XD4_XDFFQ_CKBB XD4_XDFFQ_CLKB 3.6302e-17
* device instance cc_XD4_XDFFQ_CKBB_XD4_XDFFQ_M r0 *1 0,0
Ccc_XD4_XDFFQ_CKBB_XD4_XDFFQ_M XD4_XDFFQ_CKBB XD4_XDFFQ_M 4.8402e-17
* device instance cc_XD4_XDFFQ_CKBB_XD4_XDFFQ_MB r0 *1 0,0
Ccc_XD4_XDFFQ_CKBB_XD4_XDFFQ_MB XD4_XDFFQ_CKBB XD4_XDFFQ_MB 2.4201e-17
* device instance cc_XD4_XDFFQ_CKBB_XD4_XDFFQ_MFB r0 *1 0,0
Ccc_XD4_XDFFQ_CKBB_XD4_XDFFQ_MFB XD4_XDFFQ_CKBB XD4_XDFFQ_MFB 2.4201e-17
* device instance cc_XD4_XDFFQ_CKBB_XD4_XDFFQ_S r0 *1 0,0
Ccc_XD4_XDFFQ_CKBB_XD4_XDFFQ_S XD4_XDFFQ_CKBB XD4_XDFFQ_S 3.0251e-17
* device instance cc_XD4_XDFFQ_CKBB_XD4_XDFFQ_SB r0 *1 0,0
Ccc_XD4_XDFFQ_CKBB_XD4_XDFFQ_SB XD4_XDFFQ_CKBB XD4_XDFFQ_SB 3.0251e-17
* device instance cc_XD4_XDFFQ_CKBB_XD4_XDFFQ_SFB r0 *1 0,0
Ccc_XD4_XDFFQ_CKBB_XD4_XDFFQ_SFB XD4_XDFFQ_CKBB XD4_XDFFQ_SFB 1.8151e-17
* device instance cc_XD4_XDFFQ_CKBB_XD4_XN2_mid1 r0 *1 0,0
Ccc_XD4_XDFFQ_CKBB_XD4_XN2_mid1 XD4_XDFFQ_CKBB XD4_XN2_mid1 1.21e-17
* device instance cc_XD4_XDFFQ_CKBB_XD4_XNOR_midp r0 *1 0,0
Ccc_XD4_XDFFQ_CKBB_XD4_XNOR_midp XD4_XDFFQ_CKBB XD4_XNOR_midp 1.21e-17
* device instance cc_XD4_XDFFQ_CKBB_XD4_dmodout r0 *1 0,0
Ccc_XD4_XDFFQ_CKBB_XD4_dmodout XD4_XDFFQ_CKBB XD4_dmodout 1.21e-17
* device instance cc_XD4_XDFFQ_CKBB_XD4_dq r0 *1 0,0
Ccc_XD4_XDFFQ_CKBB_XD4_dq XD4_XDFFQ_CKBB XD4_dq 1.8151e-17
* device instance cc_XD4_XDFFQ_CKBB_XD4_nm r0 *1 0,0
Ccc_XD4_XDFFQ_CKBB_XD4_nm XD4_XDFFQ_CKBB XD4_nm 1.21e-17
* device instance cc_XD4_XDFFQ_CKBB_XD4_nt r0 *1 0,0
Ccc_XD4_XDFFQ_CKBB_XD4_nt XD4_XDFFQ_CKBB XD4_nt 2.4201e-17
* device instance cc_XD4_XDFFQ_CKBB_XD4_t1 r0 *1 0,0
Ccc_XD4_XDFFQ_CKBB_XD4_t1 XD4_XDFFQ_CKBB XD4_t1 1.21e-17
* device instance cc_XD4_XDFFQ_CKBB_XD5_XDFFM_CKBB r0 *1 0,0
Ccc_XD4_XDFFQ_CKBB_XD5_XDFFM_CKBB XD4_XDFFQ_CKBB XD5_XDFFM_CKBB 1.8151e-17
* device instance cc_XD4_XDFFQ_CKBB_XD5_XDFFM_CLKB r0 *1 0,0
Ccc_XD4_XDFFQ_CKBB_XD5_XDFFM_CLKB XD4_XDFFQ_CKBB XD5_XDFFM_CLKB 2.4201e-17
* device instance cc_XD4_XDFFQ_CKBB_XD5_XDFFM_M r0 *1 0,0
Ccc_XD4_XDFFQ_CKBB_XD5_XDFFM_M XD4_XDFFQ_CKBB XD5_XDFFM_M 2.4201e-17
* device instance cc_XD4_XDFFQ_CKBB_XD5_XDFFM_MB r0 *1 0,0
Ccc_XD4_XDFFQ_CKBB_XD5_XDFFM_MB XD4_XDFFQ_CKBB XD5_XDFFM_MB 1.21e-17
* device instance cc_XD4_XDFFQ_CKBB_XD5_XDFFM_MFB r0 *1 0,0
Ccc_XD4_XDFFQ_CKBB_XD5_XDFFM_MFB XD4_XDFFQ_CKBB XD5_XDFFM_MFB 1.21e-17
* device instance cc_XD4_XDFFQ_CKBB_XD5_XDFFM_S r0 *1 0,0
Ccc_XD4_XDFFQ_CKBB_XD5_XDFFM_S XD4_XDFFQ_CKBB XD5_XDFFM_S 1.8151e-17
* device instance cc_XD4_XDFFQ_CKBB_XD5_XDFFM_SB r0 *1 0,0
Ccc_XD4_XDFFQ_CKBB_XD5_XDFFM_SB XD4_XDFFQ_CKBB XD5_XDFFM_SB 1.8151e-17
* device instance cc_XD4_XDFFQ_CKBB_XD5_XDFFM_SFB r0 *1 0,0
Ccc_XD4_XDFFQ_CKBB_XD5_XDFFM_SFB XD4_XDFFQ_CKBB XD5_XDFFM_SFB 1.21e-17
* device instance cc_XD4_XDFFQ_CKBB_XD5_XDFFQ_CKBB r0 *1 0,0
Ccc_XD4_XDFFQ_CKBB_XD5_XDFFQ_CKBB XD4_XDFFQ_CKBB XD5_XDFFQ_CKBB 1.8151e-17
* device instance cc_XD4_XDFFQ_CKBB_XD5_XDFFQ_CLKB r0 *1 0,0
Ccc_XD4_XDFFQ_CKBB_XD5_XDFFQ_CLKB XD4_XDFFQ_CKBB XD5_XDFFQ_CLKB 2.4201e-17
* device instance cc_XD4_XDFFQ_CKBB_XD5_XDFFQ_M r0 *1 0,0
Ccc_XD4_XDFFQ_CKBB_XD5_XDFFQ_M XD4_XDFFQ_CKBB XD5_XDFFQ_M 2.4201e-17
* device instance cc_XD4_XDFFQ_CKBB_XD5_XDFFQ_MB r0 *1 0,0
Ccc_XD4_XDFFQ_CKBB_XD5_XDFFQ_MB XD4_XDFFQ_CKBB XD5_XDFFQ_MB 1.21e-17
* device instance cc_XD4_XDFFQ_CKBB_XD5_XDFFQ_MFB r0 *1 0,0
Ccc_XD4_XDFFQ_CKBB_XD5_XDFFQ_MFB XD4_XDFFQ_CKBB XD5_XDFFQ_MFB 1.21e-17
* device instance cc_XD4_XDFFQ_CKBB_XD5_XDFFQ_S r0 *1 0,0
Ccc_XD4_XDFFQ_CKBB_XD5_XDFFQ_S XD4_XDFFQ_CKBB XD5_XDFFQ_S 1.8151e-17
* device instance cc_XD4_XDFFQ_CKBB_XD5_XDFFQ_SB r0 *1 0,0
Ccc_XD4_XDFFQ_CKBB_XD5_XDFFQ_SB XD4_XDFFQ_CKBB XD5_XDFFQ_SB 1.8151e-17
* device instance cc_XD4_XDFFQ_CKBB_XD5_XDFFQ_SFB r0 *1 0,0
Ccc_XD4_XDFFQ_CKBB_XD5_XDFFQ_SFB XD4_XDFFQ_CKBB XD5_XDFFQ_SFB 1.21e-17
* device instance cc_XD4_XDFFQ_CKBB_XD5_XN2_mid1 r0 *1 0,0
Ccc_XD4_XDFFQ_CKBB_XD5_XN2_mid1 XD4_XDFFQ_CKBB XD5_XN2_mid1 1.21e-17
* device instance cc_XD4_XDFFQ_CKBB_XD5_XN3_mid1 r0 *1 0,0
Ccc_XD4_XDFFQ_CKBB_XD5_XN3_mid1 XD4_XDFFQ_CKBB XD5_XN3_mid1 1.21e-17
* device instance cc_XD4_XDFFQ_CKBB_XD5_XN3_mid2 r0 *1 0,0
Ccc_XD4_XDFFQ_CKBB_XD5_XN3_mid2 XD4_XDFFQ_CKBB XD5_XN3_mid2 1.21e-17
* device instance cc_XD4_XDFFQ_CKBB_XD5_dmodout r0 *1 0,0
Ccc_XD4_XDFFQ_CKBB_XD5_dmodout XD4_XDFFQ_CKBB XD5_dmodout 1.21e-17
* device instance cc_XD4_XDFFQ_CKBB_XD5_dq r0 *1 0,0
Ccc_XD4_XDFFQ_CKBB_XD5_dq XD4_XDFFQ_CKBB XD5_dq 1.8151e-17
* device instance cc_XD4_XDFFQ_CKBB_XD5_nm r0 *1 0,0
Ccc_XD4_XDFFQ_CKBB_XD5_nm XD4_XDFFQ_CKBB XD5_nm 1.21e-17
* device instance cc_XD4_XDFFQ_CKBB_XD5_nt r0 *1 0,0
Ccc_XD4_XDFFQ_CKBB_XD5_nt XD4_XDFFQ_CKBB XD5_nt 1.21e-17
* device instance cc_XD4_XDFFQ_CKBB_XD5_t1 r0 *1 0,0
Ccc_XD4_XDFFQ_CKBB_XD5_t1 XD4_XDFFQ_CKBB XD5_t1 1.21e-17
* device instance cc_XD4_XDFFQ_CKBB_XFRT_CKBB r0 *1 0,0
Ccc_XD4_XDFFQ_CKBB_XFRT_CKBB XD4_XDFFQ_CKBB XFRT_CKBB 1.8151e-17
* device instance cc_XD4_XDFFQ_CKBB_XFRT_CLKB r0 *1 0,0
Ccc_XD4_XDFFQ_CKBB_XFRT_CLKB XD4_XDFFQ_CKBB XFRT_CLKB 2.4201e-17
* device instance cc_XD4_XDFFQ_CKBB_XFRT_M r0 *1 0,0
Ccc_XD4_XDFFQ_CKBB_XFRT_M XD4_XDFFQ_CKBB XFRT_M 2.4201e-17
* device instance cc_XD4_XDFFQ_CKBB_XFRT_MB r0 *1 0,0
Ccc_XD4_XDFFQ_CKBB_XFRT_MB XD4_XDFFQ_CKBB XFRT_MB 1.21e-17
* device instance cc_XD4_XDFFQ_CKBB_XFRT_MFB r0 *1 0,0
Ccc_XD4_XDFFQ_CKBB_XFRT_MFB XD4_XDFFQ_CKBB XFRT_MFB 1.21e-17
* device instance cc_XD4_XDFFQ_CKBB_XFRT_S r0 *1 0,0
Ccc_XD4_XDFFQ_CKBB_XFRT_S XD4_XDFFQ_CKBB XFRT_S 1.8151e-17
* device instance cc_XD4_XDFFQ_CKBB_XFRT_SB r0 *1 0,0
Ccc_XD4_XDFFQ_CKBB_XFRT_SB XD4_XDFFQ_CKBB XFRT_SB 1.8151e-17
* device instance cc_XD4_XDFFQ_CKBB_XFRT_SFB r0 *1 0,0
Ccc_XD4_XDFFQ_CKBB_XFRT_SFB XD4_XDFFQ_CKBB XFRT_SFB 1.21e-17
* device instance cc_XD4_XDFFQ_CKBB_ck1 r0 *1 0,0
Ccc_XD4_XDFFQ_CKBB_ck1 XD4_XDFFQ_CKBB ck1 3.0251e-17
* device instance cc_XD4_XDFFQ_CKBB_ck2 r0 *1 0,0
Ccc_XD4_XDFFQ_CKBB_ck2 XD4_XDFFQ_CKBB ck2 3.0251e-17
* device instance cc_XD4_XDFFQ_CKBB_ck3 r0 *1 0,0
Ccc_XD4_XDFFQ_CKBB_ck3 XD4_XDFFQ_CKBB ck3 3.0251e-17
* device instance cc_XD4_XDFFQ_CKBB_ck4 r0 *1 0,0
Ccc_XD4_XDFFQ_CKBB_ck4 XD4_XDFFQ_CKBB ck4 3.0251e-17
* device instance cc_XD4_XDFFQ_CKBB_ck5 r0 *1 0,0
Ccc_XD4_XDFFQ_CKBB_ck5 XD4_XDFFQ_CKBB ck5 3.0251e-17
* device instance cc_XD4_XDFFQ_CKBB_mod0 r0 *1 0,0
Ccc_XD4_XDFFQ_CKBB_mod0 XD4_XDFFQ_CKBB mod0 2.4201e-17
* device instance cc_XD4_XDFFQ_CKBB_mod1 r0 *1 0,0
Ccc_XD4_XDFFQ_CKBB_mod1 XD4_XDFFQ_CKBB mod1 2.4201e-17
* device instance cc_XD4_XDFFQ_CKBB_mod2 r0 *1 0,0
Ccc_XD4_XDFFQ_CKBB_mod2 XD4_XDFFQ_CKBB mod2 2.4201e-17
* device instance cc_XD4_XDFFQ_CKBB_mod3 r0 *1 0,0
Ccc_XD4_XDFFQ_CKBB_mod3 XD4_XDFFQ_CKBB mod3 2.4201e-17
* device instance cc_XD4_XDFFQ_CKBB_mod4 r0 *1 0,0
Ccc_XD4_XDFFQ_CKBB_mod4 XD4_XDFFQ_CKBB mod4 2.4201e-17
* device instance cc_XD4_XDFFQ_CKBB_net1 r0 *1 0,0
Ccc_XD4_XDFFQ_CKBB_net1 XD4_XDFFQ_CKBB net1 1.21e-17
* device instance cc_XD4_XDFFQ_CLKB_XD4_XDFFQ_M r0 *1 0,0
Ccc_XD4_XDFFQ_CLKB_XD4_XDFFQ_M XD4_XDFFQ_CLKB XD4_XDFFQ_M 4.2352e-17
* device instance cc_XD4_XDFFQ_CLKB_XD4_XDFFQ_MB r0 *1 0,0
Ccc_XD4_XDFFQ_CLKB_XD4_XDFFQ_MB XD4_XDFFQ_CLKB XD4_XDFFQ_MB 2.4201e-17
* device instance cc_XD4_XDFFQ_CLKB_XD4_XDFFQ_MFB r0 *1 0,0
Ccc_XD4_XDFFQ_CLKB_XD4_XDFFQ_MFB XD4_XDFFQ_CLKB XD4_XDFFQ_MFB 2.4201e-17
* device instance cc_XD4_XDFFQ_CLKB_XD4_XDFFQ_S r0 *1 0,0
Ccc_XD4_XDFFQ_CLKB_XD4_XDFFQ_S XD4_XDFFQ_CLKB XD4_XDFFQ_S 1.8151e-17
* device instance cc_XD4_XDFFQ_CLKB_XD4_XDFFQ_SB r0 *1 0,0
Ccc_XD4_XDFFQ_CLKB_XD4_XDFFQ_SB XD4_XDFFQ_CLKB XD4_XDFFQ_SB 1.8151e-17
* device instance cc_XD4_XDFFQ_CLKB_XD4_XDFFQ_SFB r0 *1 0,0
Ccc_XD4_XDFFQ_CLKB_XD4_XDFFQ_SFB XD4_XDFFQ_CLKB XD4_XDFFQ_SFB 1.21e-17
* device instance cc_XD4_XDFFQ_CLKB_XD4_XN2_mid1 r0 *1 0,0
Ccc_XD4_XDFFQ_CLKB_XD4_XN2_mid1 XD4_XDFFQ_CLKB XD4_XN2_mid1 1.21e-17
* device instance cc_XD4_XDFFQ_CLKB_XD4_XNOR_midp r0 *1 0,0
Ccc_XD4_XDFFQ_CLKB_XD4_XNOR_midp XD4_XDFFQ_CLKB XD4_XNOR_midp 1.21e-17
* device instance cc_XD4_XDFFQ_CLKB_XD4_dmodout r0 *1 0,0
Ccc_XD4_XDFFQ_CLKB_XD4_dmodout XD4_XDFFQ_CLKB XD4_dmodout 1.21e-17
* device instance cc_XD4_XDFFQ_CLKB_XD4_dq r0 *1 0,0
Ccc_XD4_XDFFQ_CLKB_XD4_dq XD4_XDFFQ_CLKB XD4_dq 1.8151e-17
* device instance cc_XD4_XDFFQ_CLKB_XD4_nm r0 *1 0,0
Ccc_XD4_XDFFQ_CLKB_XD4_nm XD4_XDFFQ_CLKB XD4_nm 1.21e-17
* device instance cc_XD4_XDFFQ_CLKB_XD4_nt r0 *1 0,0
Ccc_XD4_XDFFQ_CLKB_XD4_nt XD4_XDFFQ_CLKB XD4_nt 2.4201e-17
* device instance cc_XD4_XDFFQ_CLKB_XD4_t1 r0 *1 0,0
Ccc_XD4_XDFFQ_CLKB_XD4_t1 XD4_XDFFQ_CLKB XD4_t1 1.21e-17
* device instance cc_XD4_XDFFQ_CLKB_XD5_XDFFM_CKBB r0 *1 0,0
Ccc_XD4_XDFFQ_CLKB_XD5_XDFFM_CKBB XD4_XDFFQ_CLKB XD5_XDFFM_CKBB 1.8151e-17
* device instance cc_XD4_XDFFQ_CLKB_XD5_XDFFM_CLKB r0 *1 0,0
Ccc_XD4_XDFFQ_CLKB_XD5_XDFFM_CLKB XD4_XDFFQ_CLKB XD5_XDFFM_CLKB 2.4201e-17
* device instance cc_XD4_XDFFQ_CLKB_XD5_XDFFM_M r0 *1 0,0
Ccc_XD4_XDFFQ_CLKB_XD5_XDFFM_M XD4_XDFFQ_CLKB XD5_XDFFM_M 2.4201e-17
* device instance cc_XD4_XDFFQ_CLKB_XD5_XDFFM_MB r0 *1 0,0
Ccc_XD4_XDFFQ_CLKB_XD5_XDFFM_MB XD4_XDFFQ_CLKB XD5_XDFFM_MB 1.21e-17
* device instance cc_XD4_XDFFQ_CLKB_XD5_XDFFM_MFB r0 *1 0,0
Ccc_XD4_XDFFQ_CLKB_XD5_XDFFM_MFB XD4_XDFFQ_CLKB XD5_XDFFM_MFB 1.21e-17
* device instance cc_XD4_XDFFQ_CLKB_XD5_XDFFM_S r0 *1 0,0
Ccc_XD4_XDFFQ_CLKB_XD5_XDFFM_S XD4_XDFFQ_CLKB XD5_XDFFM_S 1.8151e-17
* device instance cc_XD4_XDFFQ_CLKB_XD5_XDFFM_SB r0 *1 0,0
Ccc_XD4_XDFFQ_CLKB_XD5_XDFFM_SB XD4_XDFFQ_CLKB XD5_XDFFM_SB 1.8151e-17
* device instance cc_XD4_XDFFQ_CLKB_XD5_XDFFM_SFB r0 *1 0,0
Ccc_XD4_XDFFQ_CLKB_XD5_XDFFM_SFB XD4_XDFFQ_CLKB XD5_XDFFM_SFB 1.21e-17
* device instance cc_XD4_XDFFQ_CLKB_XD5_XDFFQ_CKBB r0 *1 0,0
Ccc_XD4_XDFFQ_CLKB_XD5_XDFFQ_CKBB XD4_XDFFQ_CLKB XD5_XDFFQ_CKBB 1.8151e-17
* device instance cc_XD4_XDFFQ_CLKB_XD5_XDFFQ_CLKB r0 *1 0,0
Ccc_XD4_XDFFQ_CLKB_XD5_XDFFQ_CLKB XD4_XDFFQ_CLKB XD5_XDFFQ_CLKB 2.4201e-17
* device instance cc_XD4_XDFFQ_CLKB_XD5_XDFFQ_M r0 *1 0,0
Ccc_XD4_XDFFQ_CLKB_XD5_XDFFQ_M XD4_XDFFQ_CLKB XD5_XDFFQ_M 2.4201e-17
* device instance cc_XD4_XDFFQ_CLKB_XD5_XDFFQ_MB r0 *1 0,0
Ccc_XD4_XDFFQ_CLKB_XD5_XDFFQ_MB XD4_XDFFQ_CLKB XD5_XDFFQ_MB 1.21e-17
* device instance cc_XD4_XDFFQ_CLKB_XD5_XDFFQ_MFB r0 *1 0,0
Ccc_XD4_XDFFQ_CLKB_XD5_XDFFQ_MFB XD4_XDFFQ_CLKB XD5_XDFFQ_MFB 1.21e-17
* device instance cc_XD4_XDFFQ_CLKB_XD5_XDFFQ_S r0 *1 0,0
Ccc_XD4_XDFFQ_CLKB_XD5_XDFFQ_S XD4_XDFFQ_CLKB XD5_XDFFQ_S 1.8151e-17
* device instance cc_XD4_XDFFQ_CLKB_XD5_XDFFQ_SB r0 *1 0,0
Ccc_XD4_XDFFQ_CLKB_XD5_XDFFQ_SB XD4_XDFFQ_CLKB XD5_XDFFQ_SB 1.8151e-17
* device instance cc_XD4_XDFFQ_CLKB_XD5_XDFFQ_SFB r0 *1 0,0
Ccc_XD4_XDFFQ_CLKB_XD5_XDFFQ_SFB XD4_XDFFQ_CLKB XD5_XDFFQ_SFB 1.21e-17
* device instance cc_XD4_XDFFQ_CLKB_XD5_XN2_mid1 r0 *1 0,0
Ccc_XD4_XDFFQ_CLKB_XD5_XN2_mid1 XD4_XDFFQ_CLKB XD5_XN2_mid1 1.21e-17
* device instance cc_XD4_XDFFQ_CLKB_XD5_XN3_mid1 r0 *1 0,0
Ccc_XD4_XDFFQ_CLKB_XD5_XN3_mid1 XD4_XDFFQ_CLKB XD5_XN3_mid1 1.21e-17
* device instance cc_XD4_XDFFQ_CLKB_XD5_XN3_mid2 r0 *1 0,0
Ccc_XD4_XDFFQ_CLKB_XD5_XN3_mid2 XD4_XDFFQ_CLKB XD5_XN3_mid2 1.21e-17
* device instance cc_XD4_XDFFQ_CLKB_XD5_dmodout r0 *1 0,0
Ccc_XD4_XDFFQ_CLKB_XD5_dmodout XD4_XDFFQ_CLKB XD5_dmodout 1.21e-17
* device instance cc_XD4_XDFFQ_CLKB_XD5_dq r0 *1 0,0
Ccc_XD4_XDFFQ_CLKB_XD5_dq XD4_XDFFQ_CLKB XD5_dq 1.8151e-17
* device instance cc_XD4_XDFFQ_CLKB_XD5_nm r0 *1 0,0
Ccc_XD4_XDFFQ_CLKB_XD5_nm XD4_XDFFQ_CLKB XD5_nm 1.21e-17
* device instance cc_XD4_XDFFQ_CLKB_XD5_nt r0 *1 0,0
Ccc_XD4_XDFFQ_CLKB_XD5_nt XD4_XDFFQ_CLKB XD5_nt 1.21e-17
* device instance cc_XD4_XDFFQ_CLKB_XD5_t1 r0 *1 0,0
Ccc_XD4_XDFFQ_CLKB_XD5_t1 XD4_XDFFQ_CLKB XD5_t1 1.21e-17
* device instance cc_XD4_XDFFQ_CLKB_XFRT_CKBB r0 *1 0,0
Ccc_XD4_XDFFQ_CLKB_XFRT_CKBB XD4_XDFFQ_CLKB XFRT_CKBB 1.8151e-17
* device instance cc_XD4_XDFFQ_CLKB_XFRT_CLKB r0 *1 0,0
Ccc_XD4_XDFFQ_CLKB_XFRT_CLKB XD4_XDFFQ_CLKB XFRT_CLKB 2.4201e-17
* device instance cc_XD4_XDFFQ_CLKB_XFRT_M r0 *1 0,0
Ccc_XD4_XDFFQ_CLKB_XFRT_M XD4_XDFFQ_CLKB XFRT_M 2.4201e-17
* device instance cc_XD4_XDFFQ_CLKB_XFRT_MB r0 *1 0,0
Ccc_XD4_XDFFQ_CLKB_XFRT_MB XD4_XDFFQ_CLKB XFRT_MB 1.21e-17
* device instance cc_XD4_XDFFQ_CLKB_XFRT_MFB r0 *1 0,0
Ccc_XD4_XDFFQ_CLKB_XFRT_MFB XD4_XDFFQ_CLKB XFRT_MFB 1.21e-17
* device instance cc_XD4_XDFFQ_CLKB_XFRT_S r0 *1 0,0
Ccc_XD4_XDFFQ_CLKB_XFRT_S XD4_XDFFQ_CLKB XFRT_S 1.8151e-17
* device instance cc_XD4_XDFFQ_CLKB_XFRT_SB r0 *1 0,0
Ccc_XD4_XDFFQ_CLKB_XFRT_SB XD4_XDFFQ_CLKB XFRT_SB 1.8151e-17
* device instance cc_XD4_XDFFQ_CLKB_XFRT_SFB r0 *1 0,0
Ccc_XD4_XDFFQ_CLKB_XFRT_SFB XD4_XDFFQ_CLKB XFRT_SFB 1.21e-17
* device instance cc_XD4_XDFFQ_CLKB_ck1 r0 *1 0,0
Ccc_XD4_XDFFQ_CLKB_ck1 XD4_XDFFQ_CLKB ck1 3.0251e-17
* device instance cc_XD4_XDFFQ_CLKB_ck2 r0 *1 0,0
Ccc_XD4_XDFFQ_CLKB_ck2 XD4_XDFFQ_CLKB ck2 3.0251e-17
* device instance cc_XD4_XDFFQ_CLKB_ck3 r0 *1 0,0
Ccc_XD4_XDFFQ_CLKB_ck3 XD4_XDFFQ_CLKB ck3 3.0251e-17
* device instance cc_XD4_XDFFQ_CLKB_ck4 r0 *1 0,0
Ccc_XD4_XDFFQ_CLKB_ck4 XD4_XDFFQ_CLKB ck4 3.0251e-17
* device instance cc_XD4_XDFFQ_CLKB_ck5 r0 *1 0,0
Ccc_XD4_XDFFQ_CLKB_ck5 XD4_XDFFQ_CLKB ck5 3.0251e-17
* device instance cc_XD4_XDFFQ_CLKB_mod0 r0 *1 0,0
Ccc_XD4_XDFFQ_CLKB_mod0 XD4_XDFFQ_CLKB mod0 2.4201e-17
* device instance cc_XD4_XDFFQ_CLKB_mod1 r0 *1 0,0
Ccc_XD4_XDFFQ_CLKB_mod1 XD4_XDFFQ_CLKB mod1 2.4201e-17
* device instance cc_XD4_XDFFQ_CLKB_mod2 r0 *1 0,0
Ccc_XD4_XDFFQ_CLKB_mod2 XD4_XDFFQ_CLKB mod2 2.4201e-17
* device instance cc_XD4_XDFFQ_CLKB_mod3 r0 *1 0,0
Ccc_XD4_XDFFQ_CLKB_mod3 XD4_XDFFQ_CLKB mod3 2.4201e-17
* device instance cc_XD4_XDFFQ_CLKB_mod4 r0 *1 0,0
Ccc_XD4_XDFFQ_CLKB_mod4 XD4_XDFFQ_CLKB mod4 2.4201e-17
* device instance cc_XD4_XDFFQ_CLKB_net1 r0 *1 0,0
Ccc_XD4_XDFFQ_CLKB_net1 XD4_XDFFQ_CLKB net1 1.21e-17
* device instance cc_XD4_XDFFQ_M_XD4_XDFFQ_MB r0 *1 0,0
Ccc_XD4_XDFFQ_M_XD4_XDFFQ_MB XD4_XDFFQ_M XD4_XDFFQ_MB 2.4201e-17
* device instance cc_XD4_XDFFQ_M_XD4_XDFFQ_MFB r0 *1 0,0
Ccc_XD4_XDFFQ_M_XD4_XDFFQ_MFB XD4_XDFFQ_M XD4_XDFFQ_MFB 3.4688e-17
* device instance cc_XD4_XDFFQ_M_XD4_XDFFQ_S r0 *1 0,0
Ccc_XD4_XDFFQ_M_XD4_XDFFQ_S XD4_XDFFQ_M XD4_XDFFQ_S 2.8638e-17
* device instance cc_XD4_XDFFQ_M_XD4_XDFFQ_SB r0 *1 0,0
Ccc_XD4_XDFFQ_M_XD4_XDFFQ_SB XD4_XDFFQ_M XD4_XDFFQ_SB 1.8151e-17
* device instance cc_XD4_XDFFQ_M_XD4_XDFFQ_SFB r0 *1 0,0
Ccc_XD4_XDFFQ_M_XD4_XDFFQ_SFB XD4_XDFFQ_M XD4_XDFFQ_SFB 1.21e-17
* device instance cc_XD4_XDFFQ_M_XD4_XN2_mid1 r0 *1 0,0
Ccc_XD4_XDFFQ_M_XD4_XN2_mid1 XD4_XDFFQ_M XD4_XN2_mid1 1.21e-17
* device instance cc_XD4_XDFFQ_M_XD4_XNOR_midp r0 *1 0,0
Ccc_XD4_XDFFQ_M_XD4_XNOR_midp XD4_XDFFQ_M XD4_XNOR_midp 1.21e-17
* device instance cc_XD4_XDFFQ_M_XD4_dmodout r0 *1 0,0
Ccc_XD4_XDFFQ_M_XD4_dmodout XD4_XDFFQ_M XD4_dmodout 1.21e-17
* device instance cc_XD4_XDFFQ_M_XD4_dq r0 *1 0,0
Ccc_XD4_XDFFQ_M_XD4_dq XD4_XDFFQ_M XD4_dq 2.8638e-17
* device instance cc_XD4_XDFFQ_M_XD4_nm r0 *1 0,0
Ccc_XD4_XDFFQ_M_XD4_nm XD4_XDFFQ_M XD4_nm 1.21e-17
* device instance cc_XD4_XDFFQ_M_XD4_nt r0 *1 0,0
Ccc_XD4_XDFFQ_M_XD4_nt XD4_XDFFQ_M XD4_nt 2.4201e-17
* device instance cc_XD4_XDFFQ_M_XD4_t1 r0 *1 0,0
Ccc_XD4_XDFFQ_M_XD4_t1 XD4_XDFFQ_M XD4_t1 1.21e-17
* device instance cc_XD4_XDFFQ_M_XD5_XDFFM_CKBB r0 *1 0,0
Ccc_XD4_XDFFQ_M_XD5_XDFFM_CKBB XD4_XDFFQ_M XD5_XDFFM_CKBB 1.8151e-17
* device instance cc_XD4_XDFFQ_M_XD5_XDFFM_CLKB r0 *1 0,0
Ccc_XD4_XDFFQ_M_XD5_XDFFM_CLKB XD4_XDFFQ_M XD5_XDFFM_CLKB 2.4201e-17
* device instance cc_XD4_XDFFQ_M_XD5_XDFFM_M r0 *1 0,0
Ccc_XD4_XDFFQ_M_XD5_XDFFM_M XD4_XDFFQ_M XD5_XDFFM_M 2.4201e-17
* device instance cc_XD4_XDFFQ_M_XD5_XDFFM_MB r0 *1 0,0
Ccc_XD4_XDFFQ_M_XD5_XDFFM_MB XD4_XDFFQ_M XD5_XDFFM_MB 1.21e-17
* device instance cc_XD4_XDFFQ_M_XD5_XDFFM_MFB r0 *1 0,0
Ccc_XD4_XDFFQ_M_XD5_XDFFM_MFB XD4_XDFFQ_M XD5_XDFFM_MFB 1.21e-17
* device instance cc_XD4_XDFFQ_M_XD5_XDFFM_S r0 *1 0,0
Ccc_XD4_XDFFQ_M_XD5_XDFFM_S XD4_XDFFQ_M XD5_XDFFM_S 1.8151e-17
* device instance cc_XD4_XDFFQ_M_XD5_XDFFM_SB r0 *1 0,0
Ccc_XD4_XDFFQ_M_XD5_XDFFM_SB XD4_XDFFQ_M XD5_XDFFM_SB 1.8151e-17
* device instance cc_XD4_XDFFQ_M_XD5_XDFFM_SFB r0 *1 0,0
Ccc_XD4_XDFFQ_M_XD5_XDFFM_SFB XD4_XDFFQ_M XD5_XDFFM_SFB 1.21e-17
* device instance cc_XD4_XDFFQ_M_XD5_XDFFQ_CKBB r0 *1 0,0
Ccc_XD4_XDFFQ_M_XD5_XDFFQ_CKBB XD4_XDFFQ_M XD5_XDFFQ_CKBB 1.8151e-17
* device instance cc_XD4_XDFFQ_M_XD5_XDFFQ_CLKB r0 *1 0,0
Ccc_XD4_XDFFQ_M_XD5_XDFFQ_CLKB XD4_XDFFQ_M XD5_XDFFQ_CLKB 2.4201e-17
* device instance cc_XD4_XDFFQ_M_XD5_XDFFQ_M r0 *1 0,0
Ccc_XD4_XDFFQ_M_XD5_XDFFQ_M XD4_XDFFQ_M XD5_XDFFQ_M 2.4201e-17
* device instance cc_XD4_XDFFQ_M_XD5_XDFFQ_MB r0 *1 0,0
Ccc_XD4_XDFFQ_M_XD5_XDFFQ_MB XD4_XDFFQ_M XD5_XDFFQ_MB 1.21e-17
* device instance cc_XD4_XDFFQ_M_XD5_XDFFQ_MFB r0 *1 0,0
Ccc_XD4_XDFFQ_M_XD5_XDFFQ_MFB XD4_XDFFQ_M XD5_XDFFQ_MFB 1.21e-17
* device instance cc_XD4_XDFFQ_M_XD5_XDFFQ_S r0 *1 0,0
Ccc_XD4_XDFFQ_M_XD5_XDFFQ_S XD4_XDFFQ_M XD5_XDFFQ_S 1.8151e-17
* device instance cc_XD4_XDFFQ_M_XD5_XDFFQ_SB r0 *1 0,0
Ccc_XD4_XDFFQ_M_XD5_XDFFQ_SB XD4_XDFFQ_M XD5_XDFFQ_SB 1.8151e-17
* device instance cc_XD4_XDFFQ_M_XD5_XDFFQ_SFB r0 *1 0,0
Ccc_XD4_XDFFQ_M_XD5_XDFFQ_SFB XD4_XDFFQ_M XD5_XDFFQ_SFB 1.21e-17
* device instance cc_XD4_XDFFQ_M_XD5_XN2_mid1 r0 *1 0,0
Ccc_XD4_XDFFQ_M_XD5_XN2_mid1 XD4_XDFFQ_M XD5_XN2_mid1 1.21e-17
* device instance cc_XD4_XDFFQ_M_XD5_XN3_mid1 r0 *1 0,0
Ccc_XD4_XDFFQ_M_XD5_XN3_mid1 XD4_XDFFQ_M XD5_XN3_mid1 1.21e-17
* device instance cc_XD4_XDFFQ_M_XD5_XN3_mid2 r0 *1 0,0
Ccc_XD4_XDFFQ_M_XD5_XN3_mid2 XD4_XDFFQ_M XD5_XN3_mid2 1.21e-17
* device instance cc_XD4_XDFFQ_M_XD5_dmodout r0 *1 0,0
Ccc_XD4_XDFFQ_M_XD5_dmodout XD4_XDFFQ_M XD5_dmodout 1.21e-17
* device instance cc_XD4_XDFFQ_M_XD5_dq r0 *1 0,0
Ccc_XD4_XDFFQ_M_XD5_dq XD4_XDFFQ_M XD5_dq 1.8151e-17
* device instance cc_XD4_XDFFQ_M_XD5_nm r0 *1 0,0
Ccc_XD4_XDFFQ_M_XD5_nm XD4_XDFFQ_M XD5_nm 1.21e-17
* device instance cc_XD4_XDFFQ_M_XD5_nt r0 *1 0,0
Ccc_XD4_XDFFQ_M_XD5_nt XD4_XDFFQ_M XD5_nt 1.21e-17
* device instance cc_XD4_XDFFQ_M_XD5_t1 r0 *1 0,0
Ccc_XD4_XDFFQ_M_XD5_t1 XD4_XDFFQ_M XD5_t1 1.21e-17
* device instance cc_XD4_XDFFQ_M_XFRT_CKBB r0 *1 0,0
Ccc_XD4_XDFFQ_M_XFRT_CKBB XD4_XDFFQ_M XFRT_CKBB 1.8151e-17
* device instance cc_XD4_XDFFQ_M_XFRT_CLKB r0 *1 0,0
Ccc_XD4_XDFFQ_M_XFRT_CLKB XD4_XDFFQ_M XFRT_CLKB 2.4201e-17
* device instance cc_XD4_XDFFQ_M_XFRT_M r0 *1 0,0
Ccc_XD4_XDFFQ_M_XFRT_M XD4_XDFFQ_M XFRT_M 2.4201e-17
* device instance cc_XD4_XDFFQ_M_XFRT_MB r0 *1 0,0
Ccc_XD4_XDFFQ_M_XFRT_MB XD4_XDFFQ_M XFRT_MB 1.21e-17
* device instance cc_XD4_XDFFQ_M_XFRT_MFB r0 *1 0,0
Ccc_XD4_XDFFQ_M_XFRT_MFB XD4_XDFFQ_M XFRT_MFB 1.21e-17
* device instance cc_XD4_XDFFQ_M_XFRT_S r0 *1 0,0
Ccc_XD4_XDFFQ_M_XFRT_S XD4_XDFFQ_M XFRT_S 1.8151e-17
* device instance cc_XD4_XDFFQ_M_XFRT_SB r0 *1 0,0
Ccc_XD4_XDFFQ_M_XFRT_SB XD4_XDFFQ_M XFRT_SB 1.8151e-17
* device instance cc_XD4_XDFFQ_M_XFRT_SFB r0 *1 0,0
Ccc_XD4_XDFFQ_M_XFRT_SFB XD4_XDFFQ_M XFRT_SFB 1.21e-17
* device instance cc_XD4_XDFFQ_M_ck1 r0 *1 0,0
Ccc_XD4_XDFFQ_M_ck1 XD4_XDFFQ_M ck1 3.0251e-17
* device instance cc_XD4_XDFFQ_M_ck2 r0 *1 0,0
Ccc_XD4_XDFFQ_M_ck2 XD4_XDFFQ_M ck2 3.0251e-17
* device instance cc_XD4_XDFFQ_M_ck3 r0 *1 0,0
Ccc_XD4_XDFFQ_M_ck3 XD4_XDFFQ_M ck3 3.0251e-17
* device instance cc_XD4_XDFFQ_M_ck4 r0 *1 0,0
Ccc_XD4_XDFFQ_M_ck4 XD4_XDFFQ_M ck4 3.0251e-17
* device instance cc_XD4_XDFFQ_M_ck5 r0 *1 0,0
Ccc_XD4_XDFFQ_M_ck5 XD4_XDFFQ_M ck5 3.0251e-17
* device instance cc_XD4_XDFFQ_M_mod0 r0 *1 0,0
Ccc_XD4_XDFFQ_M_mod0 XD4_XDFFQ_M mod0 2.4201e-17
* device instance cc_XD4_XDFFQ_M_mod1 r0 *1 0,0
Ccc_XD4_XDFFQ_M_mod1 XD4_XDFFQ_M mod1 2.4201e-17
* device instance cc_XD4_XDFFQ_M_mod2 r0 *1 0,0
Ccc_XD4_XDFFQ_M_mod2 XD4_XDFFQ_M mod2 2.4201e-17
* device instance cc_XD4_XDFFQ_M_mod3 r0 *1 0,0
Ccc_XD4_XDFFQ_M_mod3 XD4_XDFFQ_M mod3 2.4201e-17
* device instance cc_XD4_XDFFQ_M_mod4 r0 *1 0,0
Ccc_XD4_XDFFQ_M_mod4 XD4_XDFFQ_M mod4 2.4201e-17
* device instance cc_XD4_XDFFQ_M_net1 r0 *1 0,0
Ccc_XD4_XDFFQ_M_net1 XD4_XDFFQ_M net1 1.21e-17
* device instance cc_XD4_XDFFQ_MB_XD4_XDFFQ_MFB r0 *1 0,0
Ccc_XD4_XDFFQ_MB_XD4_XDFFQ_MFB XD4_XDFFQ_MB XD4_XDFFQ_MFB 1.21e-17
* device instance cc_XD4_XDFFQ_MB_XD4_XDFFQ_S r0 *1 0,0
Ccc_XD4_XDFFQ_MB_XD4_XDFFQ_S XD4_XDFFQ_MB XD4_XDFFQ_S 1.8151e-17
* device instance cc_XD4_XDFFQ_MB_XD4_XDFFQ_SB r0 *1 0,0
Ccc_XD4_XDFFQ_MB_XD4_XDFFQ_SB XD4_XDFFQ_MB XD4_XDFFQ_SB 1.8151e-17
* device instance cc_XD4_XDFFQ_MB_XD4_XDFFQ_SFB r0 *1 0,0
Ccc_XD4_XDFFQ_MB_XD4_XDFFQ_SFB XD4_XDFFQ_MB XD4_XDFFQ_SFB 1.21e-17
* device instance cc_XD4_XDFFQ_MB_XD4_XN2_mid1 r0 *1 0,0
Ccc_XD4_XDFFQ_MB_XD4_XN2_mid1 XD4_XDFFQ_MB XD4_XN2_mid1 1.21e-17
* device instance cc_XD4_XDFFQ_MB_XD4_XNOR_midp r0 *1 0,0
Ccc_XD4_XDFFQ_MB_XD4_XNOR_midp XD4_XDFFQ_MB XD4_XNOR_midp 1.21e-17
* device instance cc_XD4_XDFFQ_MB_XD4_dmodout r0 *1 0,0
Ccc_XD4_XDFFQ_MB_XD4_dmodout XD4_XDFFQ_MB XD4_dmodout 1.21e-17
* device instance cc_XD4_XDFFQ_MB_XD4_dq r0 *1 0,0
Ccc_XD4_XDFFQ_MB_XD4_dq XD4_XDFFQ_MB XD4_dq 1.21e-17
* device instance cc_XD4_XDFFQ_MB_XD4_nm r0 *1 0,0
Ccc_XD4_XDFFQ_MB_XD4_nm XD4_XDFFQ_MB XD4_nm 1.21e-17
* device instance cc_XD4_XDFFQ_MB_XD4_nt r0 *1 0,0
Ccc_XD4_XDFFQ_MB_XD4_nt XD4_XDFFQ_MB XD4_nt 2.4201e-17
* device instance cc_XD4_XDFFQ_MB_XD4_t1 r0 *1 0,0
Ccc_XD4_XDFFQ_MB_XD4_t1 XD4_XDFFQ_MB XD4_t1 1.21e-17
* device instance cc_XD4_XDFFQ_MB_XD5_XDFFM_CKBB r0 *1 0,0
Ccc_XD4_XDFFQ_MB_XD5_XDFFM_CKBB XD4_XDFFQ_MB XD5_XDFFM_CKBB 1.8151e-17
* device instance cc_XD4_XDFFQ_MB_XD5_XDFFM_CLKB r0 *1 0,0
Ccc_XD4_XDFFQ_MB_XD5_XDFFM_CLKB XD4_XDFFQ_MB XD5_XDFFM_CLKB 2.4201e-17
* device instance cc_XD4_XDFFQ_MB_XD5_XDFFM_M r0 *1 0,0
Ccc_XD4_XDFFQ_MB_XD5_XDFFM_M XD4_XDFFQ_MB XD5_XDFFM_M 2.4201e-17
* device instance cc_XD4_XDFFQ_MB_XD5_XDFFM_MB r0 *1 0,0
Ccc_XD4_XDFFQ_MB_XD5_XDFFM_MB XD4_XDFFQ_MB XD5_XDFFM_MB 1.21e-17
* device instance cc_XD4_XDFFQ_MB_XD5_XDFFM_MFB r0 *1 0,0
Ccc_XD4_XDFFQ_MB_XD5_XDFFM_MFB XD4_XDFFQ_MB XD5_XDFFM_MFB 1.21e-17
* device instance cc_XD4_XDFFQ_MB_XD5_XDFFM_S r0 *1 0,0
Ccc_XD4_XDFFQ_MB_XD5_XDFFM_S XD4_XDFFQ_MB XD5_XDFFM_S 1.8151e-17
* device instance cc_XD4_XDFFQ_MB_XD5_XDFFM_SB r0 *1 0,0
Ccc_XD4_XDFFQ_MB_XD5_XDFFM_SB XD4_XDFFQ_MB XD5_XDFFM_SB 1.8151e-17
* device instance cc_XD4_XDFFQ_MB_XD5_XDFFM_SFB r0 *1 0,0
Ccc_XD4_XDFFQ_MB_XD5_XDFFM_SFB XD4_XDFFQ_MB XD5_XDFFM_SFB 1.21e-17
* device instance cc_XD4_XDFFQ_MB_XD5_XDFFQ_CKBB r0 *1 0,0
Ccc_XD4_XDFFQ_MB_XD5_XDFFQ_CKBB XD4_XDFFQ_MB XD5_XDFFQ_CKBB 1.8151e-17
* device instance cc_XD4_XDFFQ_MB_XD5_XDFFQ_CLKB r0 *1 0,0
Ccc_XD4_XDFFQ_MB_XD5_XDFFQ_CLKB XD4_XDFFQ_MB XD5_XDFFQ_CLKB 2.4201e-17
* device instance cc_XD4_XDFFQ_MB_XD5_XDFFQ_M r0 *1 0,0
Ccc_XD4_XDFFQ_MB_XD5_XDFFQ_M XD4_XDFFQ_MB XD5_XDFFQ_M 2.4201e-17
* device instance cc_XD4_XDFFQ_MB_XD5_XDFFQ_MB r0 *1 0,0
Ccc_XD4_XDFFQ_MB_XD5_XDFFQ_MB XD4_XDFFQ_MB XD5_XDFFQ_MB 1.21e-17
* device instance cc_XD4_XDFFQ_MB_XD5_XDFFQ_MFB r0 *1 0,0
Ccc_XD4_XDFFQ_MB_XD5_XDFFQ_MFB XD4_XDFFQ_MB XD5_XDFFQ_MFB 1.21e-17
* device instance cc_XD4_XDFFQ_MB_XD5_XDFFQ_S r0 *1 0,0
Ccc_XD4_XDFFQ_MB_XD5_XDFFQ_S XD4_XDFFQ_MB XD5_XDFFQ_S 1.8151e-17
* device instance cc_XD4_XDFFQ_MB_XD5_XDFFQ_SB r0 *1 0,0
Ccc_XD4_XDFFQ_MB_XD5_XDFFQ_SB XD4_XDFFQ_MB XD5_XDFFQ_SB 1.8151e-17
* device instance cc_XD4_XDFFQ_MB_XD5_XDFFQ_SFB r0 *1 0,0
Ccc_XD4_XDFFQ_MB_XD5_XDFFQ_SFB XD4_XDFFQ_MB XD5_XDFFQ_SFB 1.21e-17
* device instance cc_XD4_XDFFQ_MB_XD5_XN2_mid1 r0 *1 0,0
Ccc_XD4_XDFFQ_MB_XD5_XN2_mid1 XD4_XDFFQ_MB XD5_XN2_mid1 1.21e-17
* device instance cc_XD4_XDFFQ_MB_XD5_XN3_mid1 r0 *1 0,0
Ccc_XD4_XDFFQ_MB_XD5_XN3_mid1 XD4_XDFFQ_MB XD5_XN3_mid1 1.21e-17
* device instance cc_XD4_XDFFQ_MB_XD5_XN3_mid2 r0 *1 0,0
Ccc_XD4_XDFFQ_MB_XD5_XN3_mid2 XD4_XDFFQ_MB XD5_XN3_mid2 1.21e-17
* device instance cc_XD4_XDFFQ_MB_XD5_dmodout r0 *1 0,0
Ccc_XD4_XDFFQ_MB_XD5_dmodout XD4_XDFFQ_MB XD5_dmodout 1.21e-17
* device instance cc_XD4_XDFFQ_MB_XD5_dq r0 *1 0,0
Ccc_XD4_XDFFQ_MB_XD5_dq XD4_XDFFQ_MB XD5_dq 1.8151e-17
* device instance cc_XD4_XDFFQ_MB_XD5_nm r0 *1 0,0
Ccc_XD4_XDFFQ_MB_XD5_nm XD4_XDFFQ_MB XD5_nm 1.21e-17
* device instance cc_XD4_XDFFQ_MB_XD5_nt r0 *1 0,0
Ccc_XD4_XDFFQ_MB_XD5_nt XD4_XDFFQ_MB XD5_nt 1.21e-17
* device instance cc_XD4_XDFFQ_MB_XD5_t1 r0 *1 0,0
Ccc_XD4_XDFFQ_MB_XD5_t1 XD4_XDFFQ_MB XD5_t1 1.21e-17
* device instance cc_XD4_XDFFQ_MB_XFRT_CKBB r0 *1 0,0
Ccc_XD4_XDFFQ_MB_XFRT_CKBB XD4_XDFFQ_MB XFRT_CKBB 1.8151e-17
* device instance cc_XD4_XDFFQ_MB_XFRT_CLKB r0 *1 0,0
Ccc_XD4_XDFFQ_MB_XFRT_CLKB XD4_XDFFQ_MB XFRT_CLKB 2.4201e-17
* device instance cc_XD4_XDFFQ_MB_XFRT_M r0 *1 0,0
Ccc_XD4_XDFFQ_MB_XFRT_M XD4_XDFFQ_MB XFRT_M 2.4201e-17
* device instance cc_XD4_XDFFQ_MB_XFRT_MB r0 *1 0,0
Ccc_XD4_XDFFQ_MB_XFRT_MB XD4_XDFFQ_MB XFRT_MB 1.21e-17
* device instance cc_XD4_XDFFQ_MB_XFRT_MFB r0 *1 0,0
Ccc_XD4_XDFFQ_MB_XFRT_MFB XD4_XDFFQ_MB XFRT_MFB 1.21e-17
* device instance cc_XD4_XDFFQ_MB_XFRT_S r0 *1 0,0
Ccc_XD4_XDFFQ_MB_XFRT_S XD4_XDFFQ_MB XFRT_S 1.8151e-17
* device instance cc_XD4_XDFFQ_MB_XFRT_SB r0 *1 0,0
Ccc_XD4_XDFFQ_MB_XFRT_SB XD4_XDFFQ_MB XFRT_SB 1.8151e-17
* device instance cc_XD4_XDFFQ_MB_XFRT_SFB r0 *1 0,0
Ccc_XD4_XDFFQ_MB_XFRT_SFB XD4_XDFFQ_MB XFRT_SFB 1.21e-17
* device instance cc_XD4_XDFFQ_MB_ck1 r0 *1 0,0
Ccc_XD4_XDFFQ_MB_ck1 XD4_XDFFQ_MB ck1 3.0251e-17
* device instance cc_XD4_XDFFQ_MB_ck2 r0 *1 0,0
Ccc_XD4_XDFFQ_MB_ck2 XD4_XDFFQ_MB ck2 3.0251e-17
* device instance cc_XD4_XDFFQ_MB_ck3 r0 *1 0,0
Ccc_XD4_XDFFQ_MB_ck3 XD4_XDFFQ_MB ck3 3.0251e-17
* device instance cc_XD4_XDFFQ_MB_ck4 r0 *1 0,0
Ccc_XD4_XDFFQ_MB_ck4 XD4_XDFFQ_MB ck4 3.0251e-17
* device instance cc_XD4_XDFFQ_MB_ck5 r0 *1 0,0
Ccc_XD4_XDFFQ_MB_ck5 XD4_XDFFQ_MB ck5 3.0251e-17
* device instance cc_XD4_XDFFQ_MB_mod0 r0 *1 0,0
Ccc_XD4_XDFFQ_MB_mod0 XD4_XDFFQ_MB mod0 2.4201e-17
* device instance cc_XD4_XDFFQ_MB_mod1 r0 *1 0,0
Ccc_XD4_XDFFQ_MB_mod1 XD4_XDFFQ_MB mod1 2.4201e-17
* device instance cc_XD4_XDFFQ_MB_mod2 r0 *1 0,0
Ccc_XD4_XDFFQ_MB_mod2 XD4_XDFFQ_MB mod2 2.4201e-17
* device instance cc_XD4_XDFFQ_MB_mod3 r0 *1 0,0
Ccc_XD4_XDFFQ_MB_mod3 XD4_XDFFQ_MB mod3 2.4201e-17
* device instance cc_XD4_XDFFQ_MB_mod4 r0 *1 0,0
Ccc_XD4_XDFFQ_MB_mod4 XD4_XDFFQ_MB mod4 2.4201e-17
* device instance cc_XD4_XDFFQ_MB_net1 r0 *1 0,0
Ccc_XD4_XDFFQ_MB_net1 XD4_XDFFQ_MB net1 1.21e-17
* device instance cc_XD4_XDFFQ_MFB_XD4_XDFFQ_S r0 *1 0,0
Ccc_XD4_XDFFQ_MFB_XD4_XDFFQ_S XD4_XDFFQ_MFB XD4_XDFFQ_S 1.8151e-17
* device instance cc_XD4_XDFFQ_MFB_XD4_XDFFQ_SB r0 *1 0,0
Ccc_XD4_XDFFQ_MFB_XD4_XDFFQ_SB XD4_XDFFQ_MFB XD4_XDFFQ_SB 1.8151e-17
* device instance cc_XD4_XDFFQ_MFB_XD4_XDFFQ_SFB r0 *1 0,0
Ccc_XD4_XDFFQ_MFB_XD4_XDFFQ_SFB XD4_XDFFQ_MFB XD4_XDFFQ_SFB 1.21e-17
* device instance cc_XD4_XDFFQ_MFB_XD4_XN2_mid1 r0 *1 0,0
Ccc_XD4_XDFFQ_MFB_XD4_XN2_mid1 XD4_XDFFQ_MFB XD4_XN2_mid1 1.21e-17
* device instance cc_XD4_XDFFQ_MFB_XD4_XNOR_midp r0 *1 0,0
Ccc_XD4_XDFFQ_MFB_XD4_XNOR_midp XD4_XDFFQ_MFB XD4_XNOR_midp 1.21e-17
* device instance cc_XD4_XDFFQ_MFB_XD4_dmodout r0 *1 0,0
Ccc_XD4_XDFFQ_MFB_XD4_dmodout XD4_XDFFQ_MFB XD4_dmodout 1.21e-17
* device instance cc_XD4_XDFFQ_MFB_XD4_dq r0 *1 0,0
Ccc_XD4_XDFFQ_MFB_XD4_dq XD4_XDFFQ_MFB XD4_dq 1.21e-17
* device instance cc_XD4_XDFFQ_MFB_XD4_nm r0 *1 0,0
Ccc_XD4_XDFFQ_MFB_XD4_nm XD4_XDFFQ_MFB XD4_nm 1.21e-17
* device instance cc_XD4_XDFFQ_MFB_XD4_nt r0 *1 0,0
Ccc_XD4_XDFFQ_MFB_XD4_nt XD4_XDFFQ_MFB XD4_nt 2.4201e-17
* device instance cc_XD4_XDFFQ_MFB_XD4_t1 r0 *1 0,0
Ccc_XD4_XDFFQ_MFB_XD4_t1 XD4_XDFFQ_MFB XD4_t1 1.21e-17
* device instance cc_XD4_XDFFQ_MFB_XD5_XDFFM_CKBB r0 *1 0,0
Ccc_XD4_XDFFQ_MFB_XD5_XDFFM_CKBB XD4_XDFFQ_MFB XD5_XDFFM_CKBB 1.8151e-17
* device instance cc_XD4_XDFFQ_MFB_XD5_XDFFM_CLKB r0 *1 0,0
Ccc_XD4_XDFFQ_MFB_XD5_XDFFM_CLKB XD4_XDFFQ_MFB XD5_XDFFM_CLKB 2.4201e-17
* device instance cc_XD4_XDFFQ_MFB_XD5_XDFFM_M r0 *1 0,0
Ccc_XD4_XDFFQ_MFB_XD5_XDFFM_M XD4_XDFFQ_MFB XD5_XDFFM_M 2.4201e-17
* device instance cc_XD4_XDFFQ_MFB_XD5_XDFFM_MB r0 *1 0,0
Ccc_XD4_XDFFQ_MFB_XD5_XDFFM_MB XD4_XDFFQ_MFB XD5_XDFFM_MB 1.21e-17
* device instance cc_XD4_XDFFQ_MFB_XD5_XDFFM_MFB r0 *1 0,0
Ccc_XD4_XDFFQ_MFB_XD5_XDFFM_MFB XD4_XDFFQ_MFB XD5_XDFFM_MFB 1.21e-17
* device instance cc_XD4_XDFFQ_MFB_XD5_XDFFM_S r0 *1 0,0
Ccc_XD4_XDFFQ_MFB_XD5_XDFFM_S XD4_XDFFQ_MFB XD5_XDFFM_S 1.8151e-17
* device instance cc_XD4_XDFFQ_MFB_XD5_XDFFM_SB r0 *1 0,0
Ccc_XD4_XDFFQ_MFB_XD5_XDFFM_SB XD4_XDFFQ_MFB XD5_XDFFM_SB 1.8151e-17
* device instance cc_XD4_XDFFQ_MFB_XD5_XDFFM_SFB r0 *1 0,0
Ccc_XD4_XDFFQ_MFB_XD5_XDFFM_SFB XD4_XDFFQ_MFB XD5_XDFFM_SFB 1.21e-17
* device instance cc_XD4_XDFFQ_MFB_XD5_XDFFQ_CKBB r0 *1 0,0
Ccc_XD4_XDFFQ_MFB_XD5_XDFFQ_CKBB XD4_XDFFQ_MFB XD5_XDFFQ_CKBB 1.8151e-17
* device instance cc_XD4_XDFFQ_MFB_XD5_XDFFQ_CLKB r0 *1 0,0
Ccc_XD4_XDFFQ_MFB_XD5_XDFFQ_CLKB XD4_XDFFQ_MFB XD5_XDFFQ_CLKB 2.4201e-17
* device instance cc_XD4_XDFFQ_MFB_XD5_XDFFQ_M r0 *1 0,0
Ccc_XD4_XDFFQ_MFB_XD5_XDFFQ_M XD4_XDFFQ_MFB XD5_XDFFQ_M 2.4201e-17
* device instance cc_XD4_XDFFQ_MFB_XD5_XDFFQ_MB r0 *1 0,0
Ccc_XD4_XDFFQ_MFB_XD5_XDFFQ_MB XD4_XDFFQ_MFB XD5_XDFFQ_MB 1.21e-17
* device instance cc_XD4_XDFFQ_MFB_XD5_XDFFQ_MFB r0 *1 0,0
Ccc_XD4_XDFFQ_MFB_XD5_XDFFQ_MFB XD4_XDFFQ_MFB XD5_XDFFQ_MFB 1.21e-17
* device instance cc_XD4_XDFFQ_MFB_XD5_XDFFQ_S r0 *1 0,0
Ccc_XD4_XDFFQ_MFB_XD5_XDFFQ_S XD4_XDFFQ_MFB XD5_XDFFQ_S 1.8151e-17
* device instance cc_XD4_XDFFQ_MFB_XD5_XDFFQ_SB r0 *1 0,0
Ccc_XD4_XDFFQ_MFB_XD5_XDFFQ_SB XD4_XDFFQ_MFB XD5_XDFFQ_SB 1.8151e-17
* device instance cc_XD4_XDFFQ_MFB_XD5_XDFFQ_SFB r0 *1 0,0
Ccc_XD4_XDFFQ_MFB_XD5_XDFFQ_SFB XD4_XDFFQ_MFB XD5_XDFFQ_SFB 1.21e-17
* device instance cc_XD4_XDFFQ_MFB_XD5_XN2_mid1 r0 *1 0,0
Ccc_XD4_XDFFQ_MFB_XD5_XN2_mid1 XD4_XDFFQ_MFB XD5_XN2_mid1 1.21e-17
* device instance cc_XD4_XDFFQ_MFB_XD5_XN3_mid1 r0 *1 0,0
Ccc_XD4_XDFFQ_MFB_XD5_XN3_mid1 XD4_XDFFQ_MFB XD5_XN3_mid1 1.21e-17
* device instance cc_XD4_XDFFQ_MFB_XD5_XN3_mid2 r0 *1 0,0
Ccc_XD4_XDFFQ_MFB_XD5_XN3_mid2 XD4_XDFFQ_MFB XD5_XN3_mid2 1.21e-17
* device instance cc_XD4_XDFFQ_MFB_XD5_dmodout r0 *1 0,0
Ccc_XD4_XDFFQ_MFB_XD5_dmodout XD4_XDFFQ_MFB XD5_dmodout 1.21e-17
* device instance cc_XD4_XDFFQ_MFB_XD5_dq r0 *1 0,0
Ccc_XD4_XDFFQ_MFB_XD5_dq XD4_XDFFQ_MFB XD5_dq 1.8151e-17
* device instance cc_XD4_XDFFQ_MFB_XD5_nm r0 *1 0,0
Ccc_XD4_XDFFQ_MFB_XD5_nm XD4_XDFFQ_MFB XD5_nm 1.21e-17
* device instance cc_XD4_XDFFQ_MFB_XD5_nt r0 *1 0,0
Ccc_XD4_XDFFQ_MFB_XD5_nt XD4_XDFFQ_MFB XD5_nt 1.21e-17
* device instance cc_XD4_XDFFQ_MFB_XD5_t1 r0 *1 0,0
Ccc_XD4_XDFFQ_MFB_XD5_t1 XD4_XDFFQ_MFB XD5_t1 1.21e-17
* device instance cc_XD4_XDFFQ_MFB_XFRT_CKBB r0 *1 0,0
Ccc_XD4_XDFFQ_MFB_XFRT_CKBB XD4_XDFFQ_MFB XFRT_CKBB 1.8151e-17
* device instance cc_XD4_XDFFQ_MFB_XFRT_CLKB r0 *1 0,0
Ccc_XD4_XDFFQ_MFB_XFRT_CLKB XD4_XDFFQ_MFB XFRT_CLKB 2.4201e-17
* device instance cc_XD4_XDFFQ_MFB_XFRT_M r0 *1 0,0
Ccc_XD4_XDFFQ_MFB_XFRT_M XD4_XDFFQ_MFB XFRT_M 2.4201e-17
* device instance cc_XD4_XDFFQ_MFB_XFRT_MB r0 *1 0,0
Ccc_XD4_XDFFQ_MFB_XFRT_MB XD4_XDFFQ_MFB XFRT_MB 1.21e-17
* device instance cc_XD4_XDFFQ_MFB_XFRT_MFB r0 *1 0,0
Ccc_XD4_XDFFQ_MFB_XFRT_MFB XD4_XDFFQ_MFB XFRT_MFB 1.21e-17
* device instance cc_XD4_XDFFQ_MFB_XFRT_S r0 *1 0,0
Ccc_XD4_XDFFQ_MFB_XFRT_S XD4_XDFFQ_MFB XFRT_S 1.8151e-17
* device instance cc_XD4_XDFFQ_MFB_XFRT_SB r0 *1 0,0
Ccc_XD4_XDFFQ_MFB_XFRT_SB XD4_XDFFQ_MFB XFRT_SB 1.8151e-17
* device instance cc_XD4_XDFFQ_MFB_XFRT_SFB r0 *1 0,0
Ccc_XD4_XDFFQ_MFB_XFRT_SFB XD4_XDFFQ_MFB XFRT_SFB 1.21e-17
* device instance cc_XD4_XDFFQ_MFB_ck1 r0 *1 0,0
Ccc_XD4_XDFFQ_MFB_ck1 XD4_XDFFQ_MFB ck1 3.0251e-17
* device instance cc_XD4_XDFFQ_MFB_ck2 r0 *1 0,0
Ccc_XD4_XDFFQ_MFB_ck2 XD4_XDFFQ_MFB ck2 3.0251e-17
* device instance cc_XD4_XDFFQ_MFB_ck3 r0 *1 0,0
Ccc_XD4_XDFFQ_MFB_ck3 XD4_XDFFQ_MFB ck3 3.0251e-17
* device instance cc_XD4_XDFFQ_MFB_ck4 r0 *1 0,0
Ccc_XD4_XDFFQ_MFB_ck4 XD4_XDFFQ_MFB ck4 3.0251e-17
* device instance cc_XD4_XDFFQ_MFB_ck5 r0 *1 0,0
Ccc_XD4_XDFFQ_MFB_ck5 XD4_XDFFQ_MFB ck5 3.0251e-17
* device instance cc_XD4_XDFFQ_MFB_mod0 r0 *1 0,0
Ccc_XD4_XDFFQ_MFB_mod0 XD4_XDFFQ_MFB mod0 2.4201e-17
* device instance cc_XD4_XDFFQ_MFB_mod1 r0 *1 0,0
Ccc_XD4_XDFFQ_MFB_mod1 XD4_XDFFQ_MFB mod1 2.4201e-17
* device instance cc_XD4_XDFFQ_MFB_mod2 r0 *1 0,0
Ccc_XD4_XDFFQ_MFB_mod2 XD4_XDFFQ_MFB mod2 2.4201e-17
* device instance cc_XD4_XDFFQ_MFB_mod3 r0 *1 0,0
Ccc_XD4_XDFFQ_MFB_mod3 XD4_XDFFQ_MFB mod3 2.4201e-17
* device instance cc_XD4_XDFFQ_MFB_mod4 r0 *1 0,0
Ccc_XD4_XDFFQ_MFB_mod4 XD4_XDFFQ_MFB mod4 2.4201e-17
* device instance cc_XD4_XDFFQ_MFB_net1 r0 *1 0,0
Ccc_XD4_XDFFQ_MFB_net1 XD4_XDFFQ_MFB net1 1.21e-17
* device instance cc_XD4_XDFFQ_S_XD4_XDFFQ_SB r0 *1 0,0
Ccc_XD4_XDFFQ_S_XD4_XDFFQ_SB XD4_XDFFQ_S XD4_XDFFQ_SB 3.0251e-17
* device instance cc_XD4_XDFFQ_S_XD4_XDFFQ_SFB r0 *1 0,0
Ccc_XD4_XDFFQ_S_XD4_XDFFQ_SFB XD4_XDFFQ_S XD4_XDFFQ_SFB 3.4688e-17
* device instance cc_XD4_XDFFQ_S_XD4_XN2_mid1 r0 *1 0,0
Ccc_XD4_XDFFQ_S_XD4_XN2_mid1 XD4_XDFFQ_S XD4_XN2_mid1 1.21e-17
* device instance cc_XD4_XDFFQ_S_XD4_XNOR_midp r0 *1 0,0
Ccc_XD4_XDFFQ_S_XD4_XNOR_midp XD4_XDFFQ_S XD4_XNOR_midp 1.21e-17
* device instance cc_XD4_XDFFQ_S_XD4_dmodout r0 *1 0,0
Ccc_XD4_XDFFQ_S_XD4_dmodout XD4_XDFFQ_S XD4_dmodout 1.21e-17
* device instance cc_XD4_XDFFQ_S_XD4_dq r0 *1 0,0
Ccc_XD4_XDFFQ_S_XD4_dq XD4_XDFFQ_S XD4_dq 1.21e-17
* device instance cc_XD4_XDFFQ_S_XD4_nm r0 *1 0,0
Ccc_XD4_XDFFQ_S_XD4_nm XD4_XDFFQ_S XD4_nm 1.21e-17
* device instance cc_XD4_XDFFQ_S_XD4_nt r0 *1 0,0
Ccc_XD4_XDFFQ_S_XD4_nt XD4_XDFFQ_S XD4_nt 2.4201e-17
* device instance cc_XD4_XDFFQ_S_XD4_t1 r0 *1 0,0
Ccc_XD4_XDFFQ_S_XD4_t1 XD4_XDFFQ_S XD4_t1 1.21e-17
* device instance cc_XD4_XDFFQ_S_XD5_XDFFM_CKBB r0 *1 0,0
Ccc_XD4_XDFFQ_S_XD5_XDFFM_CKBB XD4_XDFFQ_S XD5_XDFFM_CKBB 1.8151e-17
* device instance cc_XD4_XDFFQ_S_XD5_XDFFM_CLKB r0 *1 0,0
Ccc_XD4_XDFFQ_S_XD5_XDFFM_CLKB XD4_XDFFQ_S XD5_XDFFM_CLKB 2.4201e-17
* device instance cc_XD4_XDFFQ_S_XD5_XDFFM_M r0 *1 0,0
Ccc_XD4_XDFFQ_S_XD5_XDFFM_M XD4_XDFFQ_S XD5_XDFFM_M 2.4201e-17
* device instance cc_XD4_XDFFQ_S_XD5_XDFFM_MB r0 *1 0,0
Ccc_XD4_XDFFQ_S_XD5_XDFFM_MB XD4_XDFFQ_S XD5_XDFFM_MB 1.21e-17
* device instance cc_XD4_XDFFQ_S_XD5_XDFFM_MFB r0 *1 0,0
Ccc_XD4_XDFFQ_S_XD5_XDFFM_MFB XD4_XDFFQ_S XD5_XDFFM_MFB 1.21e-17
* device instance cc_XD4_XDFFQ_S_XD5_XDFFM_S r0 *1 0,0
Ccc_XD4_XDFFQ_S_XD5_XDFFM_S XD4_XDFFQ_S XD5_XDFFM_S 1.8151e-17
* device instance cc_XD4_XDFFQ_S_XD5_XDFFM_SB r0 *1 0,0
Ccc_XD4_XDFFQ_S_XD5_XDFFM_SB XD4_XDFFQ_S XD5_XDFFM_SB 1.8151e-17
* device instance cc_XD4_XDFFQ_S_XD5_XDFFM_SFB r0 *1 0,0
Ccc_XD4_XDFFQ_S_XD5_XDFFM_SFB XD4_XDFFQ_S XD5_XDFFM_SFB 1.21e-17
* device instance cc_XD4_XDFFQ_S_XD5_XDFFQ_CKBB r0 *1 0,0
Ccc_XD4_XDFFQ_S_XD5_XDFFQ_CKBB XD4_XDFFQ_S XD5_XDFFQ_CKBB 1.8151e-17
* device instance cc_XD4_XDFFQ_S_XD5_XDFFQ_CLKB r0 *1 0,0
Ccc_XD4_XDFFQ_S_XD5_XDFFQ_CLKB XD4_XDFFQ_S XD5_XDFFQ_CLKB 2.4201e-17
* device instance cc_XD4_XDFFQ_S_XD5_XDFFQ_M r0 *1 0,0
Ccc_XD4_XDFFQ_S_XD5_XDFFQ_M XD4_XDFFQ_S XD5_XDFFQ_M 2.4201e-17
* device instance cc_XD4_XDFFQ_S_XD5_XDFFQ_MB r0 *1 0,0
Ccc_XD4_XDFFQ_S_XD5_XDFFQ_MB XD4_XDFFQ_S XD5_XDFFQ_MB 1.21e-17
* device instance cc_XD4_XDFFQ_S_XD5_XDFFQ_MFB r0 *1 0,0
Ccc_XD4_XDFFQ_S_XD5_XDFFQ_MFB XD4_XDFFQ_S XD5_XDFFQ_MFB 1.21e-17
* device instance cc_XD4_XDFFQ_S_XD5_XDFFQ_S r0 *1 0,0
Ccc_XD4_XDFFQ_S_XD5_XDFFQ_S XD4_XDFFQ_S XD5_XDFFQ_S 1.8151e-17
* device instance cc_XD4_XDFFQ_S_XD5_XDFFQ_SB r0 *1 0,0
Ccc_XD4_XDFFQ_S_XD5_XDFFQ_SB XD4_XDFFQ_S XD5_XDFFQ_SB 1.8151e-17
* device instance cc_XD4_XDFFQ_S_XD5_XDFFQ_SFB r0 *1 0,0
Ccc_XD4_XDFFQ_S_XD5_XDFFQ_SFB XD4_XDFFQ_S XD5_XDFFQ_SFB 1.21e-17
* device instance cc_XD4_XDFFQ_S_XD5_XN2_mid1 r0 *1 0,0
Ccc_XD4_XDFFQ_S_XD5_XN2_mid1 XD4_XDFFQ_S XD5_XN2_mid1 1.21e-17
* device instance cc_XD4_XDFFQ_S_XD5_XN3_mid1 r0 *1 0,0
Ccc_XD4_XDFFQ_S_XD5_XN3_mid1 XD4_XDFFQ_S XD5_XN3_mid1 1.21e-17
* device instance cc_XD4_XDFFQ_S_XD5_XN3_mid2 r0 *1 0,0
Ccc_XD4_XDFFQ_S_XD5_XN3_mid2 XD4_XDFFQ_S XD5_XN3_mid2 1.21e-17
* device instance cc_XD4_XDFFQ_S_XD5_dmodout r0 *1 0,0
Ccc_XD4_XDFFQ_S_XD5_dmodout XD4_XDFFQ_S XD5_dmodout 1.21e-17
* device instance cc_XD4_XDFFQ_S_XD5_dq r0 *1 0,0
Ccc_XD4_XDFFQ_S_XD5_dq XD4_XDFFQ_S XD5_dq 1.8151e-17
* device instance cc_XD4_XDFFQ_S_XD5_nm r0 *1 0,0
Ccc_XD4_XDFFQ_S_XD5_nm XD4_XDFFQ_S XD5_nm 1.21e-17
* device instance cc_XD4_XDFFQ_S_XD5_nt r0 *1 0,0
Ccc_XD4_XDFFQ_S_XD5_nt XD4_XDFFQ_S XD5_nt 1.21e-17
* device instance cc_XD4_XDFFQ_S_XD5_t1 r0 *1 0,0
Ccc_XD4_XDFFQ_S_XD5_t1 XD4_XDFFQ_S XD5_t1 1.21e-17
* device instance cc_XD4_XDFFQ_S_XFRT_CKBB r0 *1 0,0
Ccc_XD4_XDFFQ_S_XFRT_CKBB XD4_XDFFQ_S XFRT_CKBB 1.8151e-17
* device instance cc_XD4_XDFFQ_S_XFRT_CLKB r0 *1 0,0
Ccc_XD4_XDFFQ_S_XFRT_CLKB XD4_XDFFQ_S XFRT_CLKB 2.4201e-17
* device instance cc_XD4_XDFFQ_S_XFRT_M r0 *1 0,0
Ccc_XD4_XDFFQ_S_XFRT_M XD4_XDFFQ_S XFRT_M 2.4201e-17
* device instance cc_XD4_XDFFQ_S_XFRT_MB r0 *1 0,0
Ccc_XD4_XDFFQ_S_XFRT_MB XD4_XDFFQ_S XFRT_MB 1.21e-17
* device instance cc_XD4_XDFFQ_S_XFRT_MFB r0 *1 0,0
Ccc_XD4_XDFFQ_S_XFRT_MFB XD4_XDFFQ_S XFRT_MFB 1.21e-17
* device instance cc_XD4_XDFFQ_S_XFRT_S r0 *1 0,0
Ccc_XD4_XDFFQ_S_XFRT_S XD4_XDFFQ_S XFRT_S 1.8151e-17
* device instance cc_XD4_XDFFQ_S_XFRT_SB r0 *1 0,0
Ccc_XD4_XDFFQ_S_XFRT_SB XD4_XDFFQ_S XFRT_SB 1.8151e-17
* device instance cc_XD4_XDFFQ_S_XFRT_SFB r0 *1 0,0
Ccc_XD4_XDFFQ_S_XFRT_SFB XD4_XDFFQ_S XFRT_SFB 1.21e-17
* device instance cc_XD4_XDFFQ_S_ck1 r0 *1 0,0
Ccc_XD4_XDFFQ_S_ck1 XD4_XDFFQ_S ck1 3.0251e-17
* device instance cc_XD4_XDFFQ_S_ck2 r0 *1 0,0
Ccc_XD4_XDFFQ_S_ck2 XD4_XDFFQ_S ck2 3.0251e-17
* device instance cc_XD4_XDFFQ_S_ck3 r0 *1 0,0
Ccc_XD4_XDFFQ_S_ck3 XD4_XDFFQ_S ck3 3.0251e-17
* device instance cc_XD4_XDFFQ_S_ck4 r0 *1 0,0
Ccc_XD4_XDFFQ_S_ck4 XD4_XDFFQ_S ck4 3.0251e-17
* device instance cc_XD4_XDFFQ_S_ck5 r0 *1 0,0
Ccc_XD4_XDFFQ_S_ck5 XD4_XDFFQ_S ck5 3.0251e-17
* device instance cc_XD4_XDFFQ_S_mod0 r0 *1 0,0
Ccc_XD4_XDFFQ_S_mod0 XD4_XDFFQ_S mod0 2.4201e-17
* device instance cc_XD4_XDFFQ_S_mod1 r0 *1 0,0
Ccc_XD4_XDFFQ_S_mod1 XD4_XDFFQ_S mod1 2.4201e-17
* device instance cc_XD4_XDFFQ_S_mod2 r0 *1 0,0
Ccc_XD4_XDFFQ_S_mod2 XD4_XDFFQ_S mod2 2.4201e-17
* device instance cc_XD4_XDFFQ_S_mod3 r0 *1 0,0
Ccc_XD4_XDFFQ_S_mod3 XD4_XDFFQ_S mod3 2.4201e-17
* device instance cc_XD4_XDFFQ_S_mod4 r0 *1 0,0
Ccc_XD4_XDFFQ_S_mod4 XD4_XDFFQ_S mod4 2.4201e-17
* device instance cc_XD4_XDFFQ_S_net1 r0 *1 0,0
Ccc_XD4_XDFFQ_S_net1 XD4_XDFFQ_S net1 1.21e-17
* device instance cc_XD4_XDFFQ_SB_XD4_XDFFQ_SFB r0 *1 0,0
Ccc_XD4_XDFFQ_SB_XD4_XDFFQ_SFB XD4_XDFFQ_SB XD4_XDFFQ_SFB 2.4201e-17
* device instance cc_XD4_XDFFQ_SB_XD4_XN2_mid1 r0 *1 0,0
Ccc_XD4_XDFFQ_SB_XD4_XN2_mid1 XD4_XDFFQ_SB XD4_XN2_mid1 1.21e-17
* device instance cc_XD4_XDFFQ_SB_XD4_XNOR_midp r0 *1 0,0
Ccc_XD4_XDFFQ_SB_XD4_XNOR_midp XD4_XDFFQ_SB XD4_XNOR_midp 1.21e-17
* device instance cc_XD4_XDFFQ_SB_XD4_dmodout r0 *1 0,0
Ccc_XD4_XDFFQ_SB_XD4_dmodout XD4_XDFFQ_SB XD4_dmodout 1.21e-17
* device instance cc_XD4_XDFFQ_SB_XD4_dq r0 *1 0,0
Ccc_XD4_XDFFQ_SB_XD4_dq XD4_XDFFQ_SB XD4_dq 1.21e-17
* device instance cc_XD4_XDFFQ_SB_XD4_nm r0 *1 0,0
Ccc_XD4_XDFFQ_SB_XD4_nm XD4_XDFFQ_SB XD4_nm 1.21e-17
* device instance cc_XD4_XDFFQ_SB_XD4_nt r0 *1 0,0
Ccc_XD4_XDFFQ_SB_XD4_nt XD4_XDFFQ_SB XD4_nt 2.4201e-17
* device instance cc_XD4_XDFFQ_SB_XD4_t1 r0 *1 0,0
Ccc_XD4_XDFFQ_SB_XD4_t1 XD4_XDFFQ_SB XD4_t1 1.21e-17
* device instance cc_XD4_XDFFQ_SB_XD5_XDFFM_CKBB r0 *1 0,0
Ccc_XD4_XDFFQ_SB_XD5_XDFFM_CKBB XD4_XDFFQ_SB XD5_XDFFM_CKBB 1.8151e-17
* device instance cc_XD4_XDFFQ_SB_XD5_XDFFM_CLKB r0 *1 0,0
Ccc_XD4_XDFFQ_SB_XD5_XDFFM_CLKB XD4_XDFFQ_SB XD5_XDFFM_CLKB 2.4201e-17
* device instance cc_XD4_XDFFQ_SB_XD5_XDFFM_M r0 *1 0,0
Ccc_XD4_XDFFQ_SB_XD5_XDFFM_M XD4_XDFFQ_SB XD5_XDFFM_M 2.4201e-17
* device instance cc_XD4_XDFFQ_SB_XD5_XDFFM_MB r0 *1 0,0
Ccc_XD4_XDFFQ_SB_XD5_XDFFM_MB XD4_XDFFQ_SB XD5_XDFFM_MB 1.21e-17
* device instance cc_XD4_XDFFQ_SB_XD5_XDFFM_MFB r0 *1 0,0
Ccc_XD4_XDFFQ_SB_XD5_XDFFM_MFB XD4_XDFFQ_SB XD5_XDFFM_MFB 1.21e-17
* device instance cc_XD4_XDFFQ_SB_XD5_XDFFM_S r0 *1 0,0
Ccc_XD4_XDFFQ_SB_XD5_XDFFM_S XD4_XDFFQ_SB XD5_XDFFM_S 1.8151e-17
* device instance cc_XD4_XDFFQ_SB_XD5_XDFFM_SB r0 *1 0,0
Ccc_XD4_XDFFQ_SB_XD5_XDFFM_SB XD4_XDFFQ_SB XD5_XDFFM_SB 1.8151e-17
* device instance cc_XD4_XDFFQ_SB_XD5_XDFFM_SFB r0 *1 0,0
Ccc_XD4_XDFFQ_SB_XD5_XDFFM_SFB XD4_XDFFQ_SB XD5_XDFFM_SFB 1.21e-17
* device instance cc_XD4_XDFFQ_SB_XD5_XDFFQ_CKBB r0 *1 0,0
Ccc_XD4_XDFFQ_SB_XD5_XDFFQ_CKBB XD4_XDFFQ_SB XD5_XDFFQ_CKBB 1.8151e-17
* device instance cc_XD4_XDFFQ_SB_XD5_XDFFQ_CLKB r0 *1 0,0
Ccc_XD4_XDFFQ_SB_XD5_XDFFQ_CLKB XD4_XDFFQ_SB XD5_XDFFQ_CLKB 2.4201e-17
* device instance cc_XD4_XDFFQ_SB_XD5_XDFFQ_M r0 *1 0,0
Ccc_XD4_XDFFQ_SB_XD5_XDFFQ_M XD4_XDFFQ_SB XD5_XDFFQ_M 2.4201e-17
* device instance cc_XD4_XDFFQ_SB_XD5_XDFFQ_MB r0 *1 0,0
Ccc_XD4_XDFFQ_SB_XD5_XDFFQ_MB XD4_XDFFQ_SB XD5_XDFFQ_MB 1.21e-17
* device instance cc_XD4_XDFFQ_SB_XD5_XDFFQ_MFB r0 *1 0,0
Ccc_XD4_XDFFQ_SB_XD5_XDFFQ_MFB XD4_XDFFQ_SB XD5_XDFFQ_MFB 1.21e-17
* device instance cc_XD4_XDFFQ_SB_XD5_XDFFQ_S r0 *1 0,0
Ccc_XD4_XDFFQ_SB_XD5_XDFFQ_S XD4_XDFFQ_SB XD5_XDFFQ_S 1.8151e-17
* device instance cc_XD4_XDFFQ_SB_XD5_XDFFQ_SB r0 *1 0,0
Ccc_XD4_XDFFQ_SB_XD5_XDFFQ_SB XD4_XDFFQ_SB XD5_XDFFQ_SB 1.8151e-17
* device instance cc_XD4_XDFFQ_SB_XD5_XDFFQ_SFB r0 *1 0,0
Ccc_XD4_XDFFQ_SB_XD5_XDFFQ_SFB XD4_XDFFQ_SB XD5_XDFFQ_SFB 1.21e-17
* device instance cc_XD4_XDFFQ_SB_XD5_XN2_mid1 r0 *1 0,0
Ccc_XD4_XDFFQ_SB_XD5_XN2_mid1 XD4_XDFFQ_SB XD5_XN2_mid1 1.21e-17
* device instance cc_XD4_XDFFQ_SB_XD5_XN3_mid1 r0 *1 0,0
Ccc_XD4_XDFFQ_SB_XD5_XN3_mid1 XD4_XDFFQ_SB XD5_XN3_mid1 1.21e-17
* device instance cc_XD4_XDFFQ_SB_XD5_XN3_mid2 r0 *1 0,0
Ccc_XD4_XDFFQ_SB_XD5_XN3_mid2 XD4_XDFFQ_SB XD5_XN3_mid2 1.21e-17
* device instance cc_XD4_XDFFQ_SB_XD5_dmodout r0 *1 0,0
Ccc_XD4_XDFFQ_SB_XD5_dmodout XD4_XDFFQ_SB XD5_dmodout 1.21e-17
* device instance cc_XD4_XDFFQ_SB_XD5_dq r0 *1 0,0
Ccc_XD4_XDFFQ_SB_XD5_dq XD4_XDFFQ_SB XD5_dq 1.8151e-17
* device instance cc_XD4_XDFFQ_SB_XD5_nm r0 *1 0,0
Ccc_XD4_XDFFQ_SB_XD5_nm XD4_XDFFQ_SB XD5_nm 1.21e-17
* device instance cc_XD4_XDFFQ_SB_XD5_nt r0 *1 0,0
Ccc_XD4_XDFFQ_SB_XD5_nt XD4_XDFFQ_SB XD5_nt 1.21e-17
* device instance cc_XD4_XDFFQ_SB_XD5_t1 r0 *1 0,0
Ccc_XD4_XDFFQ_SB_XD5_t1 XD4_XDFFQ_SB XD5_t1 1.21e-17
* device instance cc_XD4_XDFFQ_SB_XFRT_CKBB r0 *1 0,0
Ccc_XD4_XDFFQ_SB_XFRT_CKBB XD4_XDFFQ_SB XFRT_CKBB 1.8151e-17
* device instance cc_XD4_XDFFQ_SB_XFRT_CLKB r0 *1 0,0
Ccc_XD4_XDFFQ_SB_XFRT_CLKB XD4_XDFFQ_SB XFRT_CLKB 2.4201e-17
* device instance cc_XD4_XDFFQ_SB_XFRT_M r0 *1 0,0
Ccc_XD4_XDFFQ_SB_XFRT_M XD4_XDFFQ_SB XFRT_M 2.4201e-17
* device instance cc_XD4_XDFFQ_SB_XFRT_MB r0 *1 0,0
Ccc_XD4_XDFFQ_SB_XFRT_MB XD4_XDFFQ_SB XFRT_MB 1.21e-17
* device instance cc_XD4_XDFFQ_SB_XFRT_MFB r0 *1 0,0
Ccc_XD4_XDFFQ_SB_XFRT_MFB XD4_XDFFQ_SB XFRT_MFB 1.21e-17
* device instance cc_XD4_XDFFQ_SB_XFRT_S r0 *1 0,0
Ccc_XD4_XDFFQ_SB_XFRT_S XD4_XDFFQ_SB XFRT_S 1.8151e-17
* device instance cc_XD4_XDFFQ_SB_XFRT_SB r0 *1 0,0
Ccc_XD4_XDFFQ_SB_XFRT_SB XD4_XDFFQ_SB XFRT_SB 1.8151e-17
* device instance cc_XD4_XDFFQ_SB_XFRT_SFB r0 *1 0,0
Ccc_XD4_XDFFQ_SB_XFRT_SFB XD4_XDFFQ_SB XFRT_SFB 1.21e-17
* device instance cc_XD4_XDFFQ_SB_ck1 r0 *1 0,0
Ccc_XD4_XDFFQ_SB_ck1 XD4_XDFFQ_SB ck1 3.0251e-17
* device instance cc_XD4_XDFFQ_SB_ck2 r0 *1 0,0
Ccc_XD4_XDFFQ_SB_ck2 XD4_XDFFQ_SB ck2 3.0251e-17
* device instance cc_XD4_XDFFQ_SB_ck3 r0 *1 0,0
Ccc_XD4_XDFFQ_SB_ck3 XD4_XDFFQ_SB ck3 3.0251e-17
* device instance cc_XD4_XDFFQ_SB_ck4 r0 *1 0,0
Ccc_XD4_XDFFQ_SB_ck4 XD4_XDFFQ_SB ck4 3.0251e-17
* device instance cc_XD4_XDFFQ_SB_ck5 r0 *1 0,0
Ccc_XD4_XDFFQ_SB_ck5 XD4_XDFFQ_SB ck5 3.0251e-17
* device instance cc_XD4_XDFFQ_SB_mod0 r0 *1 0,0
Ccc_XD4_XDFFQ_SB_mod0 XD4_XDFFQ_SB mod0 2.4201e-17
* device instance cc_XD4_XDFFQ_SB_mod1 r0 *1 0,0
Ccc_XD4_XDFFQ_SB_mod1 XD4_XDFFQ_SB mod1 2.4201e-17
* device instance cc_XD4_XDFFQ_SB_mod2 r0 *1 0,0
Ccc_XD4_XDFFQ_SB_mod2 XD4_XDFFQ_SB mod2 2.4201e-17
* device instance cc_XD4_XDFFQ_SB_mod3 r0 *1 0,0
Ccc_XD4_XDFFQ_SB_mod3 XD4_XDFFQ_SB mod3 2.4201e-17
* device instance cc_XD4_XDFFQ_SB_mod4 r0 *1 0,0
Ccc_XD4_XDFFQ_SB_mod4 XD4_XDFFQ_SB mod4 2.4201e-17
* device instance cc_XD4_XDFFQ_SB_net1 r0 *1 0,0
Ccc_XD4_XDFFQ_SB_net1 XD4_XDFFQ_SB net1 1.21e-17
* device instance cc_XD4_XDFFQ_SFB_XD4_XN2_mid1 r0 *1 0,0
Ccc_XD4_XDFFQ_SFB_XD4_XN2_mid1 XD4_XDFFQ_SFB XD4_XN2_mid1 1.21e-17
* device instance cc_XD4_XDFFQ_SFB_XD4_XNOR_midp r0 *1 0,0
Ccc_XD4_XDFFQ_SFB_XD4_XNOR_midp XD4_XDFFQ_SFB XD4_XNOR_midp 1.21e-17
* device instance cc_XD4_XDFFQ_SFB_XD4_dmodout r0 *1 0,0
Ccc_XD4_XDFFQ_SFB_XD4_dmodout XD4_XDFFQ_SFB XD4_dmodout 1.21e-17
* device instance cc_XD4_XDFFQ_SFB_XD4_dq r0 *1 0,0
Ccc_XD4_XDFFQ_SFB_XD4_dq XD4_XDFFQ_SFB XD4_dq 1.21e-17
* device instance cc_XD4_XDFFQ_SFB_XD4_nm r0 *1 0,0
Ccc_XD4_XDFFQ_SFB_XD4_nm XD4_XDFFQ_SFB XD4_nm 1.21e-17
* device instance cc_XD4_XDFFQ_SFB_XD4_nt r0 *1 0,0
Ccc_XD4_XDFFQ_SFB_XD4_nt XD4_XDFFQ_SFB XD4_nt 2.4201e-17
* device instance cc_XD4_XDFFQ_SFB_XD4_t1 r0 *1 0,0
Ccc_XD4_XDFFQ_SFB_XD4_t1 XD4_XDFFQ_SFB XD4_t1 1.21e-17
* device instance cc_XD4_XDFFQ_SFB_XD5_XDFFM_CKBB r0 *1 0,0
Ccc_XD4_XDFFQ_SFB_XD5_XDFFM_CKBB XD4_XDFFQ_SFB XD5_XDFFM_CKBB 1.8151e-17
* device instance cc_XD4_XDFFQ_SFB_XD5_XDFFM_CLKB r0 *1 0,0
Ccc_XD4_XDFFQ_SFB_XD5_XDFFM_CLKB XD4_XDFFQ_SFB XD5_XDFFM_CLKB 2.4201e-17
* device instance cc_XD4_XDFFQ_SFB_XD5_XDFFM_M r0 *1 0,0
Ccc_XD4_XDFFQ_SFB_XD5_XDFFM_M XD4_XDFFQ_SFB XD5_XDFFM_M 2.4201e-17
* device instance cc_XD4_XDFFQ_SFB_XD5_XDFFM_MB r0 *1 0,0
Ccc_XD4_XDFFQ_SFB_XD5_XDFFM_MB XD4_XDFFQ_SFB XD5_XDFFM_MB 1.21e-17
* device instance cc_XD4_XDFFQ_SFB_XD5_XDFFM_MFB r0 *1 0,0
Ccc_XD4_XDFFQ_SFB_XD5_XDFFM_MFB XD4_XDFFQ_SFB XD5_XDFFM_MFB 1.21e-17
* device instance cc_XD4_XDFFQ_SFB_XD5_XDFFM_S r0 *1 0,0
Ccc_XD4_XDFFQ_SFB_XD5_XDFFM_S XD4_XDFFQ_SFB XD5_XDFFM_S 1.8151e-17
* device instance cc_XD4_XDFFQ_SFB_XD5_XDFFM_SB r0 *1 0,0
Ccc_XD4_XDFFQ_SFB_XD5_XDFFM_SB XD4_XDFFQ_SFB XD5_XDFFM_SB 1.8151e-17
* device instance cc_XD4_XDFFQ_SFB_XD5_XDFFM_SFB r0 *1 0,0
Ccc_XD4_XDFFQ_SFB_XD5_XDFFM_SFB XD4_XDFFQ_SFB XD5_XDFFM_SFB 1.21e-17
* device instance cc_XD4_XDFFQ_SFB_XD5_XDFFQ_CKBB r0 *1 0,0
Ccc_XD4_XDFFQ_SFB_XD5_XDFFQ_CKBB XD4_XDFFQ_SFB XD5_XDFFQ_CKBB 1.8151e-17
* device instance cc_XD4_XDFFQ_SFB_XD5_XDFFQ_CLKB r0 *1 0,0
Ccc_XD4_XDFFQ_SFB_XD5_XDFFQ_CLKB XD4_XDFFQ_SFB XD5_XDFFQ_CLKB 2.4201e-17
* device instance cc_XD4_XDFFQ_SFB_XD5_XDFFQ_M r0 *1 0,0
Ccc_XD4_XDFFQ_SFB_XD5_XDFFQ_M XD4_XDFFQ_SFB XD5_XDFFQ_M 2.4201e-17
* device instance cc_XD4_XDFFQ_SFB_XD5_XDFFQ_MB r0 *1 0,0
Ccc_XD4_XDFFQ_SFB_XD5_XDFFQ_MB XD4_XDFFQ_SFB XD5_XDFFQ_MB 1.21e-17
* device instance cc_XD4_XDFFQ_SFB_XD5_XDFFQ_MFB r0 *1 0,0
Ccc_XD4_XDFFQ_SFB_XD5_XDFFQ_MFB XD4_XDFFQ_SFB XD5_XDFFQ_MFB 1.21e-17
* device instance cc_XD4_XDFFQ_SFB_XD5_XDFFQ_S r0 *1 0,0
Ccc_XD4_XDFFQ_SFB_XD5_XDFFQ_S XD4_XDFFQ_SFB XD5_XDFFQ_S 1.8151e-17
* device instance cc_XD4_XDFFQ_SFB_XD5_XDFFQ_SB r0 *1 0,0
Ccc_XD4_XDFFQ_SFB_XD5_XDFFQ_SB XD4_XDFFQ_SFB XD5_XDFFQ_SB 1.8151e-17
* device instance cc_XD4_XDFFQ_SFB_XD5_XDFFQ_SFB r0 *1 0,0
Ccc_XD4_XDFFQ_SFB_XD5_XDFFQ_SFB XD4_XDFFQ_SFB XD5_XDFFQ_SFB 1.21e-17
* device instance cc_XD4_XDFFQ_SFB_XD5_XN2_mid1 r0 *1 0,0
Ccc_XD4_XDFFQ_SFB_XD5_XN2_mid1 XD4_XDFFQ_SFB XD5_XN2_mid1 1.21e-17
* device instance cc_XD4_XDFFQ_SFB_XD5_XN3_mid1 r0 *1 0,0
Ccc_XD4_XDFFQ_SFB_XD5_XN3_mid1 XD4_XDFFQ_SFB XD5_XN3_mid1 1.21e-17
* device instance cc_XD4_XDFFQ_SFB_XD5_XN3_mid2 r0 *1 0,0
Ccc_XD4_XDFFQ_SFB_XD5_XN3_mid2 XD4_XDFFQ_SFB XD5_XN3_mid2 1.21e-17
* device instance cc_XD4_XDFFQ_SFB_XD5_dmodout r0 *1 0,0
Ccc_XD4_XDFFQ_SFB_XD5_dmodout XD4_XDFFQ_SFB XD5_dmodout 1.21e-17
* device instance cc_XD4_XDFFQ_SFB_XD5_dq r0 *1 0,0
Ccc_XD4_XDFFQ_SFB_XD5_dq XD4_XDFFQ_SFB XD5_dq 1.8151e-17
* device instance cc_XD4_XDFFQ_SFB_XD5_nm r0 *1 0,0
Ccc_XD4_XDFFQ_SFB_XD5_nm XD4_XDFFQ_SFB XD5_nm 1.21e-17
* device instance cc_XD4_XDFFQ_SFB_XD5_nt r0 *1 0,0
Ccc_XD4_XDFFQ_SFB_XD5_nt XD4_XDFFQ_SFB XD5_nt 1.21e-17
* device instance cc_XD4_XDFFQ_SFB_XD5_t1 r0 *1 0,0
Ccc_XD4_XDFFQ_SFB_XD5_t1 XD4_XDFFQ_SFB XD5_t1 1.21e-17
* device instance cc_XD4_XDFFQ_SFB_XFRT_CKBB r0 *1 0,0
Ccc_XD4_XDFFQ_SFB_XFRT_CKBB XD4_XDFFQ_SFB XFRT_CKBB 1.8151e-17
* device instance cc_XD4_XDFFQ_SFB_XFRT_CLKB r0 *1 0,0
Ccc_XD4_XDFFQ_SFB_XFRT_CLKB XD4_XDFFQ_SFB XFRT_CLKB 2.4201e-17
* device instance cc_XD4_XDFFQ_SFB_XFRT_M r0 *1 0,0
Ccc_XD4_XDFFQ_SFB_XFRT_M XD4_XDFFQ_SFB XFRT_M 2.4201e-17
* device instance cc_XD4_XDFFQ_SFB_XFRT_MB r0 *1 0,0
Ccc_XD4_XDFFQ_SFB_XFRT_MB XD4_XDFFQ_SFB XFRT_MB 1.21e-17
* device instance cc_XD4_XDFFQ_SFB_XFRT_MFB r0 *1 0,0
Ccc_XD4_XDFFQ_SFB_XFRT_MFB XD4_XDFFQ_SFB XFRT_MFB 1.21e-17
* device instance cc_XD4_XDFFQ_SFB_XFRT_S r0 *1 0,0
Ccc_XD4_XDFFQ_SFB_XFRT_S XD4_XDFFQ_SFB XFRT_S 1.8151e-17
* device instance cc_XD4_XDFFQ_SFB_XFRT_SB r0 *1 0,0
Ccc_XD4_XDFFQ_SFB_XFRT_SB XD4_XDFFQ_SFB XFRT_SB 1.8151e-17
* device instance cc_XD4_XDFFQ_SFB_XFRT_SFB r0 *1 0,0
Ccc_XD4_XDFFQ_SFB_XFRT_SFB XD4_XDFFQ_SFB XFRT_SFB 1.21e-17
* device instance cc_XD4_XDFFQ_SFB_ck1 r0 *1 0,0
Ccc_XD4_XDFFQ_SFB_ck1 XD4_XDFFQ_SFB ck1 3.0251e-17
* device instance cc_XD4_XDFFQ_SFB_ck2 r0 *1 0,0
Ccc_XD4_XDFFQ_SFB_ck2 XD4_XDFFQ_SFB ck2 3.0251e-17
* device instance cc_XD4_XDFFQ_SFB_ck3 r0 *1 0,0
Ccc_XD4_XDFFQ_SFB_ck3 XD4_XDFFQ_SFB ck3 3.0251e-17
* device instance cc_XD4_XDFFQ_SFB_ck4 r0 *1 0,0
Ccc_XD4_XDFFQ_SFB_ck4 XD4_XDFFQ_SFB ck4 3.0251e-17
* device instance cc_XD4_XDFFQ_SFB_ck5 r0 *1 0,0
Ccc_XD4_XDFFQ_SFB_ck5 XD4_XDFFQ_SFB ck5 3.0251e-17
* device instance cc_XD4_XDFFQ_SFB_mod0 r0 *1 0,0
Ccc_XD4_XDFFQ_SFB_mod0 XD4_XDFFQ_SFB mod0 2.4201e-17
* device instance cc_XD4_XDFFQ_SFB_mod1 r0 *1 0,0
Ccc_XD4_XDFFQ_SFB_mod1 XD4_XDFFQ_SFB mod1 2.4201e-17
* device instance cc_XD4_XDFFQ_SFB_mod2 r0 *1 0,0
Ccc_XD4_XDFFQ_SFB_mod2 XD4_XDFFQ_SFB mod2 2.4201e-17
* device instance cc_XD4_XDFFQ_SFB_mod3 r0 *1 0,0
Ccc_XD4_XDFFQ_SFB_mod3 XD4_XDFFQ_SFB mod3 2.4201e-17
* device instance cc_XD4_XDFFQ_SFB_mod4 r0 *1 0,0
Ccc_XD4_XDFFQ_SFB_mod4 XD4_XDFFQ_SFB mod4 2.4201e-17
* device instance cc_XD4_XDFFQ_SFB_net1 r0 *1 0,0
Ccc_XD4_XDFFQ_SFB_net1 XD4_XDFFQ_SFB net1 1.21e-17
* device instance cc_XD4_XN2_mid1_XD4_nm r0 *1 0,0
Ccc_XD4_XN2_mid1_XD4_nm XD4_XN2_mid1 XD4_nm 1.1294e-17
* device instance cc_XD4_XN2_mid1_ck5 r0 *1 0,0
Ccc_XD4_XN2_mid1_ck5 XD4_XN2_mid1 ck5 6.05e-18
* device instance cc_XD4_XN3_mid1_XD4_XN3_mid2 r0 *1 0,0
Ccc_XD4_XN3_mid1_XD4_XN3_mid2 XD4_XN3_mid1 XD4_XN3_mid2 1.1294e-17
* device instance cc_XD4_XN3_mid1_XD4_nt r0 *1 0,0
Ccc_XD4_XN3_mid1_XD4_nt XD4_XN3_mid1 XD4_nt 1.1294e-17
* device instance cc_XD4_XN3_mid2_mod3 r0 *1 0,0
Ccc_XD4_XN3_mid2_mod3 XD4_XN3_mid2 mod3 6.05e-18
* device instance cc_XD4_XNOR_midp_XD4_dq r0 *1 0,0
Ccc_XD4_XNOR_midp_XD4_dq XD4_XNOR_midp XD4_dq 5.244e-18
* device instance cc_XD4_XNOR_midp_XD4_t1 r0 *1 0,0
Ccc_XD4_XNOR_midp_XD4_t1 XD4_XNOR_midp XD4_t1 6.05e-18
* device instance cc_XD4_dmodout_XD4_dq r0 *1 0,0
Ccc_XD4_dmodout_XD4_dq XD4_dmodout XD4_dq 1.21e-17
* device instance cc_XD4_dmodout_XD4_nm r0 *1 0,0
Ccc_XD4_dmodout_XD4_nm XD4_dmodout XD4_nm 1.8151e-17
* device instance cc_XD4_dmodout_XD4_nt r0 *1 0,0
Ccc_XD4_dmodout_XD4_nt XD4_dmodout XD4_nt 2.4201e-17
* device instance cc_XD4_dmodout_XD4_t1 r0 *1 0,0
Ccc_XD4_dmodout_XD4_t1 XD4_dmodout XD4_t1 1.21e-17
* device instance cc_XD4_dmodout_XD5_XDFFM_CKBB r0 *1 0,0
Ccc_XD4_dmodout_XD5_XDFFM_CKBB XD4_dmodout XD5_XDFFM_CKBB 1.8151e-17
* device instance cc_XD4_dmodout_XD5_XDFFM_CLKB r0 *1 0,0
Ccc_XD4_dmodout_XD5_XDFFM_CLKB XD4_dmodout XD5_XDFFM_CLKB 2.4201e-17
* device instance cc_XD4_dmodout_XD5_XDFFM_M r0 *1 0,0
Ccc_XD4_dmodout_XD5_XDFFM_M XD4_dmodout XD5_XDFFM_M 2.4201e-17
* device instance cc_XD4_dmodout_XD5_XDFFM_MB r0 *1 0,0
Ccc_XD4_dmodout_XD5_XDFFM_MB XD4_dmodout XD5_XDFFM_MB 1.21e-17
* device instance cc_XD4_dmodout_XD5_XDFFM_MFB r0 *1 0,0
Ccc_XD4_dmodout_XD5_XDFFM_MFB XD4_dmodout XD5_XDFFM_MFB 1.21e-17
* device instance cc_XD4_dmodout_XD5_XDFFM_S r0 *1 0,0
Ccc_XD4_dmodout_XD5_XDFFM_S XD4_dmodout XD5_XDFFM_S 1.8151e-17
* device instance cc_XD4_dmodout_XD5_XDFFM_SB r0 *1 0,0
Ccc_XD4_dmodout_XD5_XDFFM_SB XD4_dmodout XD5_XDFFM_SB 1.8151e-17
* device instance cc_XD4_dmodout_XD5_XDFFM_SFB r0 *1 0,0
Ccc_XD4_dmodout_XD5_XDFFM_SFB XD4_dmodout XD5_XDFFM_SFB 1.21e-17
* device instance cc_XD4_dmodout_XD5_XDFFQ_CKBB r0 *1 0,0
Ccc_XD4_dmodout_XD5_XDFFQ_CKBB XD4_dmodout XD5_XDFFQ_CKBB 1.8151e-17
* device instance cc_XD4_dmodout_XD5_XDFFQ_CLKB r0 *1 0,0
Ccc_XD4_dmodout_XD5_XDFFQ_CLKB XD4_dmodout XD5_XDFFQ_CLKB 2.4201e-17
* device instance cc_XD4_dmodout_XD5_XDFFQ_M r0 *1 0,0
Ccc_XD4_dmodout_XD5_XDFFQ_M XD4_dmodout XD5_XDFFQ_M 2.4201e-17
* device instance cc_XD4_dmodout_XD5_XDFFQ_MB r0 *1 0,0
Ccc_XD4_dmodout_XD5_XDFFQ_MB XD4_dmodout XD5_XDFFQ_MB 1.21e-17
* device instance cc_XD4_dmodout_XD5_XDFFQ_MFB r0 *1 0,0
Ccc_XD4_dmodout_XD5_XDFFQ_MFB XD4_dmodout XD5_XDFFQ_MFB 1.21e-17
* device instance cc_XD4_dmodout_XD5_XDFFQ_S r0 *1 0,0
Ccc_XD4_dmodout_XD5_XDFFQ_S XD4_dmodout XD5_XDFFQ_S 1.8151e-17
* device instance cc_XD4_dmodout_XD5_XDFFQ_SB r0 *1 0,0
Ccc_XD4_dmodout_XD5_XDFFQ_SB XD4_dmodout XD5_XDFFQ_SB 1.8151e-17
* device instance cc_XD4_dmodout_XD5_XDFFQ_SFB r0 *1 0,0
Ccc_XD4_dmodout_XD5_XDFFQ_SFB XD4_dmodout XD5_XDFFQ_SFB 1.21e-17
* device instance cc_XD4_dmodout_XD5_XN2_mid1 r0 *1 0,0
Ccc_XD4_dmodout_XD5_XN2_mid1 XD4_dmodout XD5_XN2_mid1 1.21e-17
* device instance cc_XD4_dmodout_XD5_XN3_mid1 r0 *1 0,0
Ccc_XD4_dmodout_XD5_XN3_mid1 XD4_dmodout XD5_XN3_mid1 1.21e-17
* device instance cc_XD4_dmodout_XD5_XN3_mid2 r0 *1 0,0
Ccc_XD4_dmodout_XD5_XN3_mid2 XD4_dmodout XD5_XN3_mid2 1.21e-17
* device instance cc_XD4_dmodout_XD5_dmodout r0 *1 0,0
Ccc_XD4_dmodout_XD5_dmodout XD4_dmodout XD5_dmodout 1.21e-17
* device instance cc_XD4_dmodout_XD5_dq r0 *1 0,0
Ccc_XD4_dmodout_XD5_dq XD4_dmodout XD5_dq 1.8151e-17
* device instance cc_XD4_dmodout_XD5_nm r0 *1 0,0
Ccc_XD4_dmodout_XD5_nm XD4_dmodout XD5_nm 1.21e-17
* device instance cc_XD4_dmodout_XD5_nt r0 *1 0,0
Ccc_XD4_dmodout_XD5_nt XD4_dmodout XD5_nt 1.21e-17
* device instance cc_XD4_dmodout_XD5_t1 r0 *1 0,0
Ccc_XD4_dmodout_XD5_t1 XD4_dmodout XD5_t1 1.21e-17
* device instance cc_XD4_dmodout_XFRT_CKBB r0 *1 0,0
Ccc_XD4_dmodout_XFRT_CKBB XD4_dmodout XFRT_CKBB 1.8151e-17
* device instance cc_XD4_dmodout_XFRT_CLKB r0 *1 0,0
Ccc_XD4_dmodout_XFRT_CLKB XD4_dmodout XFRT_CLKB 2.4201e-17
* device instance cc_XD4_dmodout_XFRT_M r0 *1 0,0
Ccc_XD4_dmodout_XFRT_M XD4_dmodout XFRT_M 2.4201e-17
* device instance cc_XD4_dmodout_XFRT_MB r0 *1 0,0
Ccc_XD4_dmodout_XFRT_MB XD4_dmodout XFRT_MB 1.21e-17
* device instance cc_XD4_dmodout_XFRT_MFB r0 *1 0,0
Ccc_XD4_dmodout_XFRT_MFB XD4_dmodout XFRT_MFB 1.21e-17
* device instance cc_XD4_dmodout_XFRT_S r0 *1 0,0
Ccc_XD4_dmodout_XFRT_S XD4_dmodout XFRT_S 1.8151e-17
* device instance cc_XD4_dmodout_XFRT_SB r0 *1 0,0
Ccc_XD4_dmodout_XFRT_SB XD4_dmodout XFRT_SB 1.8151e-17
* device instance cc_XD4_dmodout_XFRT_SFB r0 *1 0,0
Ccc_XD4_dmodout_XFRT_SFB XD4_dmodout XFRT_SFB 1.21e-17
* device instance cc_XD4_dmodout_ck1 r0 *1 0,0
Ccc_XD4_dmodout_ck1 XD4_dmodout ck1 3.0251e-17
* device instance cc_XD4_dmodout_ck2 r0 *1 0,0
Ccc_XD4_dmodout_ck2 XD4_dmodout ck2 3.0251e-17
* device instance cc_XD4_dmodout_ck3 r0 *1 0,0
Ccc_XD4_dmodout_ck3 XD4_dmodout ck3 3.0251e-17
* device instance cc_XD4_dmodout_ck4 r0 *1 0,0
Ccc_XD4_dmodout_ck4 XD4_dmodout ck4 3.6302e-17
* device instance cc_XD4_dmodout_ck5 r0 *1 0,0
Ccc_XD4_dmodout_ck5 XD4_dmodout ck5 3.0251e-17
* device instance cc_XD4_dmodout_mod0 r0 *1 0,0
Ccc_XD4_dmodout_mod0 XD4_dmodout mod0 2.4201e-17
* device instance cc_XD4_dmodout_mod1 r0 *1 0,0
Ccc_XD4_dmodout_mod1 XD4_dmodout mod1 2.4201e-17
* device instance cc_XD4_dmodout_mod2 r0 *1 0,0
Ccc_XD4_dmodout_mod2 XD4_dmodout mod2 2.4201e-17
* device instance cc_XD4_dmodout_mod3 r0 *1 0,0
Ccc_XD4_dmodout_mod3 XD4_dmodout mod3 2.4201e-17
* device instance cc_XD4_dmodout_mod4 r0 *1 0,0
Ccc_XD4_dmodout_mod4 XD4_dmodout mod4 2.4201e-17
* device instance cc_XD4_dmodout_net1 r0 *1 0,0
Ccc_XD4_dmodout_net1 XD4_dmodout net1 1.21e-17
* device instance cc_XD4_dq_XD4_nm r0 *1 0,0
Ccc_XD4_dq_XD4_nm XD4_dq XD4_nm 1.21e-17
* device instance cc_XD4_dq_XD4_nt r0 *1 0,0
Ccc_XD4_dq_XD4_nt XD4_dq XD4_nt 2.4201e-17
* device instance cc_XD4_dq_XD4_t1 r0 *1 0,0
Ccc_XD4_dq_XD4_t1 XD4_dq XD4_t1 1.8151e-17
* device instance cc_XD4_dq_XD5_XDFFM_CKBB r0 *1 0,0
Ccc_XD4_dq_XD5_XDFFM_CKBB XD4_dq XD5_XDFFM_CKBB 1.8151e-17
* device instance cc_XD4_dq_XD5_XDFFM_CLKB r0 *1 0,0
Ccc_XD4_dq_XD5_XDFFM_CLKB XD4_dq XD5_XDFFM_CLKB 2.4201e-17
* device instance cc_XD4_dq_XD5_XDFFM_M r0 *1 0,0
Ccc_XD4_dq_XD5_XDFFM_M XD4_dq XD5_XDFFM_M 2.4201e-17
* device instance cc_XD4_dq_XD5_XDFFM_MB r0 *1 0,0
Ccc_XD4_dq_XD5_XDFFM_MB XD4_dq XD5_XDFFM_MB 1.21e-17
* device instance cc_XD4_dq_XD5_XDFFM_MFB r0 *1 0,0
Ccc_XD4_dq_XD5_XDFFM_MFB XD4_dq XD5_XDFFM_MFB 1.21e-17
* device instance cc_XD4_dq_XD5_XDFFM_S r0 *1 0,0
Ccc_XD4_dq_XD5_XDFFM_S XD4_dq XD5_XDFFM_S 1.8151e-17
* device instance cc_XD4_dq_XD5_XDFFM_SB r0 *1 0,0
Ccc_XD4_dq_XD5_XDFFM_SB XD4_dq XD5_XDFFM_SB 1.8151e-17
* device instance cc_XD4_dq_XD5_XDFFM_SFB r0 *1 0,0
Ccc_XD4_dq_XD5_XDFFM_SFB XD4_dq XD5_XDFFM_SFB 1.21e-17
* device instance cc_XD4_dq_XD5_XDFFQ_CKBB r0 *1 0,0
Ccc_XD4_dq_XD5_XDFFQ_CKBB XD4_dq XD5_XDFFQ_CKBB 1.8151e-17
* device instance cc_XD4_dq_XD5_XDFFQ_CLKB r0 *1 0,0
Ccc_XD4_dq_XD5_XDFFQ_CLKB XD4_dq XD5_XDFFQ_CLKB 2.4201e-17
* device instance cc_XD4_dq_XD5_XDFFQ_M r0 *1 0,0
Ccc_XD4_dq_XD5_XDFFQ_M XD4_dq XD5_XDFFQ_M 2.4201e-17
* device instance cc_XD4_dq_XD5_XDFFQ_MB r0 *1 0,0
Ccc_XD4_dq_XD5_XDFFQ_MB XD4_dq XD5_XDFFQ_MB 1.21e-17
* device instance cc_XD4_dq_XD5_XDFFQ_MFB r0 *1 0,0
Ccc_XD4_dq_XD5_XDFFQ_MFB XD4_dq XD5_XDFFQ_MFB 1.21e-17
* device instance cc_XD4_dq_XD5_XDFFQ_S r0 *1 0,0
Ccc_XD4_dq_XD5_XDFFQ_S XD4_dq XD5_XDFFQ_S 1.8151e-17
* device instance cc_XD4_dq_XD5_XDFFQ_SB r0 *1 0,0
Ccc_XD4_dq_XD5_XDFFQ_SB XD4_dq XD5_XDFFQ_SB 1.8151e-17
* device instance cc_XD4_dq_XD5_XDFFQ_SFB r0 *1 0,0
Ccc_XD4_dq_XD5_XDFFQ_SFB XD4_dq XD5_XDFFQ_SFB 1.21e-17
* device instance cc_XD4_dq_XD5_XN2_mid1 r0 *1 0,0
Ccc_XD4_dq_XD5_XN2_mid1 XD4_dq XD5_XN2_mid1 1.21e-17
* device instance cc_XD4_dq_XD5_XN3_mid1 r0 *1 0,0
Ccc_XD4_dq_XD5_XN3_mid1 XD4_dq XD5_XN3_mid1 1.21e-17
* device instance cc_XD4_dq_XD5_XN3_mid2 r0 *1 0,0
Ccc_XD4_dq_XD5_XN3_mid2 XD4_dq XD5_XN3_mid2 1.21e-17
* device instance cc_XD4_dq_XD5_dmodout r0 *1 0,0
Ccc_XD4_dq_XD5_dmodout XD4_dq XD5_dmodout 1.21e-17
* device instance cc_XD4_dq_XD5_dq r0 *1 0,0
Ccc_XD4_dq_XD5_dq XD4_dq XD5_dq 1.8151e-17
* device instance cc_XD4_dq_XD5_nm r0 *1 0,0
Ccc_XD4_dq_XD5_nm XD4_dq XD5_nm 1.21e-17
* device instance cc_XD4_dq_XD5_nt r0 *1 0,0
Ccc_XD4_dq_XD5_nt XD4_dq XD5_nt 1.21e-17
* device instance cc_XD4_dq_XD5_t1 r0 *1 0,0
Ccc_XD4_dq_XD5_t1 XD4_dq XD5_t1 1.21e-17
* device instance cc_XD4_dq_XFRT_CKBB r0 *1 0,0
Ccc_XD4_dq_XFRT_CKBB XD4_dq XFRT_CKBB 1.8151e-17
* device instance cc_XD4_dq_XFRT_CLKB r0 *1 0,0
Ccc_XD4_dq_XFRT_CLKB XD4_dq XFRT_CLKB 2.4201e-17
* device instance cc_XD4_dq_XFRT_M r0 *1 0,0
Ccc_XD4_dq_XFRT_M XD4_dq XFRT_M 2.4201e-17
* device instance cc_XD4_dq_XFRT_MB r0 *1 0,0
Ccc_XD4_dq_XFRT_MB XD4_dq XFRT_MB 1.21e-17
* device instance cc_XD4_dq_XFRT_MFB r0 *1 0,0
Ccc_XD4_dq_XFRT_MFB XD4_dq XFRT_MFB 1.21e-17
* device instance cc_XD4_dq_XFRT_S r0 *1 0,0
Ccc_XD4_dq_XFRT_S XD4_dq XFRT_S 1.8151e-17
* device instance cc_XD4_dq_XFRT_SB r0 *1 0,0
Ccc_XD4_dq_XFRT_SB XD4_dq XFRT_SB 1.8151e-17
* device instance cc_XD4_dq_XFRT_SFB r0 *1 0,0
Ccc_XD4_dq_XFRT_SFB XD4_dq XFRT_SFB 1.21e-17
* device instance cc_XD4_dq_ck1 r0 *1 0,0
Ccc_XD4_dq_ck1 XD4_dq ck1 3.0251e-17
* device instance cc_XD4_dq_ck2 r0 *1 0,0
Ccc_XD4_dq_ck2 XD4_dq ck2 3.0251e-17
* device instance cc_XD4_dq_ck3 r0 *1 0,0
Ccc_XD4_dq_ck3 XD4_dq ck3 3.0251e-17
* device instance cc_XD4_dq_ck4 r0 *1 0,0
Ccc_XD4_dq_ck4 XD4_dq ck4 3.6302e-17
* device instance cc_XD4_dq_ck5 r0 *1 0,0
Ccc_XD4_dq_ck5 XD4_dq ck5 3.0251e-17
* device instance cc_XD4_dq_mod0 r0 *1 0,0
Ccc_XD4_dq_mod0 XD4_dq mod0 2.4201e-17
* device instance cc_XD4_dq_mod1 r0 *1 0,0
Ccc_XD4_dq_mod1 XD4_dq mod1 2.4201e-17
* device instance cc_XD4_dq_mod2 r0 *1 0,0
Ccc_XD4_dq_mod2 XD4_dq mod2 2.4201e-17
* device instance cc_XD4_dq_mod3 r0 *1 0,0
Ccc_XD4_dq_mod3 XD4_dq mod3 2.4201e-17
* device instance cc_XD4_dq_mod4 r0 *1 0,0
Ccc_XD4_dq_mod4 XD4_dq mod4 2.4201e-17
* device instance cc_XD4_dq_net1 r0 *1 0,0
Ccc_XD4_dq_net1 XD4_dq net1 1.21e-17
* device instance cc_XD4_nm_XD4_nt r0 *1 0,0
Ccc_XD4_nm_XD4_nt XD4_nm XD4_nt 2.4201e-17
* device instance cc_XD4_nm_XD4_t1 r0 *1 0,0
Ccc_XD4_nm_XD4_t1 XD4_nm XD4_t1 1.21e-17
* device instance cc_XD4_nm_XD5_XDFFM_CKBB r0 *1 0,0
Ccc_XD4_nm_XD5_XDFFM_CKBB XD4_nm XD5_XDFFM_CKBB 1.8151e-17
* device instance cc_XD4_nm_XD5_XDFFM_CLKB r0 *1 0,0
Ccc_XD4_nm_XD5_XDFFM_CLKB XD4_nm XD5_XDFFM_CLKB 2.4201e-17
* device instance cc_XD4_nm_XD5_XDFFM_M r0 *1 0,0
Ccc_XD4_nm_XD5_XDFFM_M XD4_nm XD5_XDFFM_M 2.4201e-17
* device instance cc_XD4_nm_XD5_XDFFM_MB r0 *1 0,0
Ccc_XD4_nm_XD5_XDFFM_MB XD4_nm XD5_XDFFM_MB 1.21e-17
* device instance cc_XD4_nm_XD5_XDFFM_MFB r0 *1 0,0
Ccc_XD4_nm_XD5_XDFFM_MFB XD4_nm XD5_XDFFM_MFB 1.21e-17
* device instance cc_XD4_nm_XD5_XDFFM_S r0 *1 0,0
Ccc_XD4_nm_XD5_XDFFM_S XD4_nm XD5_XDFFM_S 1.8151e-17
* device instance cc_XD4_nm_XD5_XDFFM_SB r0 *1 0,0
Ccc_XD4_nm_XD5_XDFFM_SB XD4_nm XD5_XDFFM_SB 1.8151e-17
* device instance cc_XD4_nm_XD5_XDFFM_SFB r0 *1 0,0
Ccc_XD4_nm_XD5_XDFFM_SFB XD4_nm XD5_XDFFM_SFB 1.21e-17
* device instance cc_XD4_nm_XD5_XDFFQ_CKBB r0 *1 0,0
Ccc_XD4_nm_XD5_XDFFQ_CKBB XD4_nm XD5_XDFFQ_CKBB 1.8151e-17
* device instance cc_XD4_nm_XD5_XDFFQ_CLKB r0 *1 0,0
Ccc_XD4_nm_XD5_XDFFQ_CLKB XD4_nm XD5_XDFFQ_CLKB 2.4201e-17
* device instance cc_XD4_nm_XD5_XDFFQ_M r0 *1 0,0
Ccc_XD4_nm_XD5_XDFFQ_M XD4_nm XD5_XDFFQ_M 2.4201e-17
* device instance cc_XD4_nm_XD5_XDFFQ_MB r0 *1 0,0
Ccc_XD4_nm_XD5_XDFFQ_MB XD4_nm XD5_XDFFQ_MB 1.21e-17
* device instance cc_XD4_nm_XD5_XDFFQ_MFB r0 *1 0,0
Ccc_XD4_nm_XD5_XDFFQ_MFB XD4_nm XD5_XDFFQ_MFB 1.21e-17
* device instance cc_XD4_nm_XD5_XDFFQ_S r0 *1 0,0
Ccc_XD4_nm_XD5_XDFFQ_S XD4_nm XD5_XDFFQ_S 1.8151e-17
* device instance cc_XD4_nm_XD5_XDFFQ_SB r0 *1 0,0
Ccc_XD4_nm_XD5_XDFFQ_SB XD4_nm XD5_XDFFQ_SB 1.8151e-17
* device instance cc_XD4_nm_XD5_XDFFQ_SFB r0 *1 0,0
Ccc_XD4_nm_XD5_XDFFQ_SFB XD4_nm XD5_XDFFQ_SFB 1.21e-17
* device instance cc_XD4_nm_XD5_XN2_mid1 r0 *1 0,0
Ccc_XD4_nm_XD5_XN2_mid1 XD4_nm XD5_XN2_mid1 1.21e-17
* device instance cc_XD4_nm_XD5_XN3_mid1 r0 *1 0,0
Ccc_XD4_nm_XD5_XN3_mid1 XD4_nm XD5_XN3_mid1 1.21e-17
* device instance cc_XD4_nm_XD5_XN3_mid2 r0 *1 0,0
Ccc_XD4_nm_XD5_XN3_mid2 XD4_nm XD5_XN3_mid2 1.21e-17
* device instance cc_XD4_nm_XD5_dmodout r0 *1 0,0
Ccc_XD4_nm_XD5_dmodout XD4_nm XD5_dmodout 1.21e-17
* device instance cc_XD4_nm_XD5_dq r0 *1 0,0
Ccc_XD4_nm_XD5_dq XD4_nm XD5_dq 1.8151e-17
* device instance cc_XD4_nm_XD5_nm r0 *1 0,0
Ccc_XD4_nm_XD5_nm XD4_nm XD5_nm 1.21e-17
* device instance cc_XD4_nm_XD5_nt r0 *1 0,0
Ccc_XD4_nm_XD5_nt XD4_nm XD5_nt 1.21e-17
* device instance cc_XD4_nm_XD5_t1 r0 *1 0,0
Ccc_XD4_nm_XD5_t1 XD4_nm XD5_t1 1.21e-17
* device instance cc_XD4_nm_XFRT_CKBB r0 *1 0,0
Ccc_XD4_nm_XFRT_CKBB XD4_nm XFRT_CKBB 1.8151e-17
* device instance cc_XD4_nm_XFRT_CLKB r0 *1 0,0
Ccc_XD4_nm_XFRT_CLKB XD4_nm XFRT_CLKB 2.4201e-17
* device instance cc_XD4_nm_XFRT_M r0 *1 0,0
Ccc_XD4_nm_XFRT_M XD4_nm XFRT_M 2.4201e-17
* device instance cc_XD4_nm_XFRT_MB r0 *1 0,0
Ccc_XD4_nm_XFRT_MB XD4_nm XFRT_MB 1.21e-17
* device instance cc_XD4_nm_XFRT_MFB r0 *1 0,0
Ccc_XD4_nm_XFRT_MFB XD4_nm XFRT_MFB 1.21e-17
* device instance cc_XD4_nm_XFRT_S r0 *1 0,0
Ccc_XD4_nm_XFRT_S XD4_nm XFRT_S 1.8151e-17
* device instance cc_XD4_nm_XFRT_SB r0 *1 0,0
Ccc_XD4_nm_XFRT_SB XD4_nm XFRT_SB 1.8151e-17
* device instance cc_XD4_nm_XFRT_SFB r0 *1 0,0
Ccc_XD4_nm_XFRT_SFB XD4_nm XFRT_SFB 1.21e-17
* device instance cc_XD4_nm_ck1 r0 *1 0,0
Ccc_XD4_nm_ck1 XD4_nm ck1 3.0251e-17
* device instance cc_XD4_nm_ck2 r0 *1 0,0
Ccc_XD4_nm_ck2 XD4_nm ck2 3.0251e-17
* device instance cc_XD4_nm_ck3 r0 *1 0,0
Ccc_XD4_nm_ck3 XD4_nm ck3 3.0251e-17
* device instance cc_XD4_nm_ck4 r0 *1 0,0
Ccc_XD4_nm_ck4 XD4_nm ck4 3.0251e-17
* device instance cc_XD4_nm_ck5 r0 *1 0,0
Ccc_XD4_nm_ck5 XD4_nm ck5 3.6302e-17
* device instance cc_XD4_nm_mod0 r0 *1 0,0
Ccc_XD4_nm_mod0 XD4_nm mod0 2.4201e-17
* device instance cc_XD4_nm_mod1 r0 *1 0,0
Ccc_XD4_nm_mod1 XD4_nm mod1 2.4201e-17
* device instance cc_XD4_nm_mod2 r0 *1 0,0
Ccc_XD4_nm_mod2 XD4_nm mod2 2.4201e-17
* device instance cc_XD4_nm_mod3 r0 *1 0,0
Ccc_XD4_nm_mod3 XD4_nm mod3 2.4201e-17
* device instance cc_XD4_nm_mod4 r0 *1 0,0
Ccc_XD4_nm_mod4 XD4_nm mod4 2.4201e-17
* device instance cc_XD4_nm_net1 r0 *1 0,0
Ccc_XD4_nm_net1 XD4_nm net1 1.21e-17
* device instance cc_XD4_nt_XD4_t1 r0 *1 0,0
Ccc_XD4_nt_XD4_t1 XD4_nt XD4_t1 1.21e-17
* device instance cc_XD4_nt_XD5_XDFFM_CKBB r0 *1 0,0
Ccc_XD4_nt_XD5_XDFFM_CKBB XD4_nt XD5_XDFFM_CKBB 1.8151e-17
* device instance cc_XD4_nt_XD5_XDFFM_CLKB r0 *1 0,0
Ccc_XD4_nt_XD5_XDFFM_CLKB XD4_nt XD5_XDFFM_CLKB 2.4201e-17
* device instance cc_XD4_nt_XD5_XDFFM_M r0 *1 0,0
Ccc_XD4_nt_XD5_XDFFM_M XD4_nt XD5_XDFFM_M 2.4201e-17
* device instance cc_XD4_nt_XD5_XDFFM_MB r0 *1 0,0
Ccc_XD4_nt_XD5_XDFFM_MB XD4_nt XD5_XDFFM_MB 1.21e-17
* device instance cc_XD4_nt_XD5_XDFFM_MFB r0 *1 0,0
Ccc_XD4_nt_XD5_XDFFM_MFB XD4_nt XD5_XDFFM_MFB 1.21e-17
* device instance cc_XD4_nt_XD5_XDFFM_S r0 *1 0,0
Ccc_XD4_nt_XD5_XDFFM_S XD4_nt XD5_XDFFM_S 1.8151e-17
* device instance cc_XD4_nt_XD5_XDFFM_SB r0 *1 0,0
Ccc_XD4_nt_XD5_XDFFM_SB XD4_nt XD5_XDFFM_SB 1.8151e-17
* device instance cc_XD4_nt_XD5_XDFFM_SFB r0 *1 0,0
Ccc_XD4_nt_XD5_XDFFM_SFB XD4_nt XD5_XDFFM_SFB 1.21e-17
* device instance cc_XD4_nt_XD5_XDFFQ_CKBB r0 *1 0,0
Ccc_XD4_nt_XD5_XDFFQ_CKBB XD4_nt XD5_XDFFQ_CKBB 1.8151e-17
* device instance cc_XD4_nt_XD5_XDFFQ_CLKB r0 *1 0,0
Ccc_XD4_nt_XD5_XDFFQ_CLKB XD4_nt XD5_XDFFQ_CLKB 2.4201e-17
* device instance cc_XD4_nt_XD5_XDFFQ_M r0 *1 0,0
Ccc_XD4_nt_XD5_XDFFQ_M XD4_nt XD5_XDFFQ_M 2.4201e-17
* device instance cc_XD4_nt_XD5_XDFFQ_MB r0 *1 0,0
Ccc_XD4_nt_XD5_XDFFQ_MB XD4_nt XD5_XDFFQ_MB 1.21e-17
* device instance cc_XD4_nt_XD5_XDFFQ_MFB r0 *1 0,0
Ccc_XD4_nt_XD5_XDFFQ_MFB XD4_nt XD5_XDFFQ_MFB 1.21e-17
* device instance cc_XD4_nt_XD5_XDFFQ_S r0 *1 0,0
Ccc_XD4_nt_XD5_XDFFQ_S XD4_nt XD5_XDFFQ_S 1.8151e-17
* device instance cc_XD4_nt_XD5_XDFFQ_SB r0 *1 0,0
Ccc_XD4_nt_XD5_XDFFQ_SB XD4_nt XD5_XDFFQ_SB 1.8151e-17
* device instance cc_XD4_nt_XD5_XDFFQ_SFB r0 *1 0,0
Ccc_XD4_nt_XD5_XDFFQ_SFB XD4_nt XD5_XDFFQ_SFB 1.21e-17
* device instance cc_XD4_nt_XD5_XN2_mid1 r0 *1 0,0
Ccc_XD4_nt_XD5_XN2_mid1 XD4_nt XD5_XN2_mid1 1.21e-17
* device instance cc_XD4_nt_XD5_XN3_mid1 r0 *1 0,0
Ccc_XD4_nt_XD5_XN3_mid1 XD4_nt XD5_XN3_mid1 1.21e-17
* device instance cc_XD4_nt_XD5_XN3_mid2 r0 *1 0,0
Ccc_XD4_nt_XD5_XN3_mid2 XD4_nt XD5_XN3_mid2 1.21e-17
* device instance cc_XD4_nt_XD5_dmodout r0 *1 0,0
Ccc_XD4_nt_XD5_dmodout XD4_nt XD5_dmodout 1.21e-17
* device instance cc_XD4_nt_XD5_dq r0 *1 0,0
Ccc_XD4_nt_XD5_dq XD4_nt XD5_dq 1.8151e-17
* device instance cc_XD4_nt_XD5_nm r0 *1 0,0
Ccc_XD4_nt_XD5_nm XD4_nt XD5_nm 1.21e-17
* device instance cc_XD4_nt_XD5_nt r0 *1 0,0
Ccc_XD4_nt_XD5_nt XD4_nt XD5_nt 1.21e-17
* device instance cc_XD4_nt_XD5_t1 r0 *1 0,0
Ccc_XD4_nt_XD5_t1 XD4_nt XD5_t1 1.21e-17
* device instance cc_XD4_nt_XFRT_CKBB r0 *1 0,0
Ccc_XD4_nt_XFRT_CKBB XD4_nt XFRT_CKBB 1.8151e-17
* device instance cc_XD4_nt_XFRT_CLKB r0 *1 0,0
Ccc_XD4_nt_XFRT_CLKB XD4_nt XFRT_CLKB 2.4201e-17
* device instance cc_XD4_nt_XFRT_M r0 *1 0,0
Ccc_XD4_nt_XFRT_M XD4_nt XFRT_M 2.4201e-17
* device instance cc_XD4_nt_XFRT_MB r0 *1 0,0
Ccc_XD4_nt_XFRT_MB XD4_nt XFRT_MB 1.21e-17
* device instance cc_XD4_nt_XFRT_MFB r0 *1 0,0
Ccc_XD4_nt_XFRT_MFB XD4_nt XFRT_MFB 1.21e-17
* device instance cc_XD4_nt_XFRT_S r0 *1 0,0
Ccc_XD4_nt_XFRT_S XD4_nt XFRT_S 1.8151e-17
* device instance cc_XD4_nt_XFRT_SB r0 *1 0,0
Ccc_XD4_nt_XFRT_SB XD4_nt XFRT_SB 1.8151e-17
* device instance cc_XD4_nt_XFRT_SFB r0 *1 0,0
Ccc_XD4_nt_XFRT_SFB XD4_nt XFRT_SFB 1.21e-17
* device instance cc_XD4_nt_ck1 r0 *1 0,0
Ccc_XD4_nt_ck1 XD4_nt ck1 3.0251e-17
* device instance cc_XD4_nt_ck2 r0 *1 0,0
Ccc_XD4_nt_ck2 XD4_nt ck2 3.0251e-17
* device instance cc_XD4_nt_ck3 r0 *1 0,0
Ccc_XD4_nt_ck3 XD4_nt ck3 3.0251e-17
* device instance cc_XD4_nt_ck4 r0 *1 0,0
Ccc_XD4_nt_ck4 XD4_nt ck4 3.0251e-17
* device instance cc_XD4_nt_ck5 r0 *1 0,0
Ccc_XD4_nt_ck5 XD4_nt ck5 3.0251e-17
* device instance cc_XD4_nt_mod0 r0 *1 0,0
Ccc_XD4_nt_mod0 XD4_nt mod0 2.4201e-17
* device instance cc_XD4_nt_mod1 r0 *1 0,0
Ccc_XD4_nt_mod1 XD4_nt mod1 2.4201e-17
* device instance cc_XD4_nt_mod2 r0 *1 0,0
Ccc_XD4_nt_mod2 XD4_nt mod2 2.4201e-17
* device instance cc_XD4_nt_mod3 r0 *1 0,0
Ccc_XD4_nt_mod3 XD4_nt mod3 3.0251e-17
* device instance cc_XD4_nt_mod4 r0 *1 0,0
Ccc_XD4_nt_mod4 XD4_nt mod4 2.4201e-17
* device instance cc_XD4_nt_net1 r0 *1 0,0
Ccc_XD4_nt_net1 XD4_nt net1 1.21e-17
* device instance cc_XD4_t1_XD5_XDFFM_CKBB r0 *1 0,0
Ccc_XD4_t1_XD5_XDFFM_CKBB XD4_t1 XD5_XDFFM_CKBB 1.8151e-17
* device instance cc_XD4_t1_XD5_XDFFM_CLKB r0 *1 0,0
Ccc_XD4_t1_XD5_XDFFM_CLKB XD4_t1 XD5_XDFFM_CLKB 2.4201e-17
* device instance cc_XD4_t1_XD5_XDFFM_M r0 *1 0,0
Ccc_XD4_t1_XD5_XDFFM_M XD4_t1 XD5_XDFFM_M 2.4201e-17
* device instance cc_XD4_t1_XD5_XDFFM_MB r0 *1 0,0
Ccc_XD4_t1_XD5_XDFFM_MB XD4_t1 XD5_XDFFM_MB 1.21e-17
* device instance cc_XD4_t1_XD5_XDFFM_MFB r0 *1 0,0
Ccc_XD4_t1_XD5_XDFFM_MFB XD4_t1 XD5_XDFFM_MFB 1.21e-17
* device instance cc_XD4_t1_XD5_XDFFM_S r0 *1 0,0
Ccc_XD4_t1_XD5_XDFFM_S XD4_t1 XD5_XDFFM_S 1.8151e-17
* device instance cc_XD4_t1_XD5_XDFFM_SB r0 *1 0,0
Ccc_XD4_t1_XD5_XDFFM_SB XD4_t1 XD5_XDFFM_SB 1.8151e-17
* device instance cc_XD4_t1_XD5_XDFFM_SFB r0 *1 0,0
Ccc_XD4_t1_XD5_XDFFM_SFB XD4_t1 XD5_XDFFM_SFB 1.21e-17
* device instance cc_XD4_t1_XD5_XDFFQ_CKBB r0 *1 0,0
Ccc_XD4_t1_XD5_XDFFQ_CKBB XD4_t1 XD5_XDFFQ_CKBB 1.8151e-17
* device instance cc_XD4_t1_XD5_XDFFQ_CLKB r0 *1 0,0
Ccc_XD4_t1_XD5_XDFFQ_CLKB XD4_t1 XD5_XDFFQ_CLKB 2.4201e-17
* device instance cc_XD4_t1_XD5_XDFFQ_M r0 *1 0,0
Ccc_XD4_t1_XD5_XDFFQ_M XD4_t1 XD5_XDFFQ_M 2.4201e-17
* device instance cc_XD4_t1_XD5_XDFFQ_MB r0 *1 0,0
Ccc_XD4_t1_XD5_XDFFQ_MB XD4_t1 XD5_XDFFQ_MB 1.21e-17
* device instance cc_XD4_t1_XD5_XDFFQ_MFB r0 *1 0,0
Ccc_XD4_t1_XD5_XDFFQ_MFB XD4_t1 XD5_XDFFQ_MFB 1.21e-17
* device instance cc_XD4_t1_XD5_XDFFQ_S r0 *1 0,0
Ccc_XD4_t1_XD5_XDFFQ_S XD4_t1 XD5_XDFFQ_S 1.8151e-17
* device instance cc_XD4_t1_XD5_XDFFQ_SB r0 *1 0,0
Ccc_XD4_t1_XD5_XDFFQ_SB XD4_t1 XD5_XDFFQ_SB 1.8151e-17
* device instance cc_XD4_t1_XD5_XDFFQ_SFB r0 *1 0,0
Ccc_XD4_t1_XD5_XDFFQ_SFB XD4_t1 XD5_XDFFQ_SFB 1.21e-17
* device instance cc_XD4_t1_XD5_XN2_mid1 r0 *1 0,0
Ccc_XD4_t1_XD5_XN2_mid1 XD4_t1 XD5_XN2_mid1 1.21e-17
* device instance cc_XD4_t1_XD5_XN3_mid1 r0 *1 0,0
Ccc_XD4_t1_XD5_XN3_mid1 XD4_t1 XD5_XN3_mid1 1.21e-17
* device instance cc_XD4_t1_XD5_XN3_mid2 r0 *1 0,0
Ccc_XD4_t1_XD5_XN3_mid2 XD4_t1 XD5_XN3_mid2 1.21e-17
* device instance cc_XD4_t1_XD5_dmodout r0 *1 0,0
Ccc_XD4_t1_XD5_dmodout XD4_t1 XD5_dmodout 1.21e-17
* device instance cc_XD4_t1_XD5_dq r0 *1 0,0
Ccc_XD4_t1_XD5_dq XD4_t1 XD5_dq 1.8151e-17
* device instance cc_XD4_t1_XD5_nm r0 *1 0,0
Ccc_XD4_t1_XD5_nm XD4_t1 XD5_nm 1.21e-17
* device instance cc_XD4_t1_XD5_nt r0 *1 0,0
Ccc_XD4_t1_XD5_nt XD4_t1 XD5_nt 1.21e-17
* device instance cc_XD4_t1_XD5_t1 r0 *1 0,0
Ccc_XD4_t1_XD5_t1 XD4_t1 XD5_t1 1.21e-17
* device instance cc_XD4_t1_XFRT_CKBB r0 *1 0,0
Ccc_XD4_t1_XFRT_CKBB XD4_t1 XFRT_CKBB 1.8151e-17
* device instance cc_XD4_t1_XFRT_CLKB r0 *1 0,0
Ccc_XD4_t1_XFRT_CLKB XD4_t1 XFRT_CLKB 2.4201e-17
* device instance cc_XD4_t1_XFRT_M r0 *1 0,0
Ccc_XD4_t1_XFRT_M XD4_t1 XFRT_M 2.4201e-17
* device instance cc_XD4_t1_XFRT_MB r0 *1 0,0
Ccc_XD4_t1_XFRT_MB XD4_t1 XFRT_MB 1.21e-17
* device instance cc_XD4_t1_XFRT_MFB r0 *1 0,0
Ccc_XD4_t1_XFRT_MFB XD4_t1 XFRT_MFB 1.21e-17
* device instance cc_XD4_t1_XFRT_S r0 *1 0,0
Ccc_XD4_t1_XFRT_S XD4_t1 XFRT_S 1.8151e-17
* device instance cc_XD4_t1_XFRT_SB r0 *1 0,0
Ccc_XD4_t1_XFRT_SB XD4_t1 XFRT_SB 1.8151e-17
* device instance cc_XD4_t1_XFRT_SFB r0 *1 0,0
Ccc_XD4_t1_XFRT_SFB XD4_t1 XFRT_SFB 1.21e-17
* device instance cc_XD4_t1_ck1 r0 *1 0,0
Ccc_XD4_t1_ck1 XD4_t1 ck1 3.0251e-17
* device instance cc_XD4_t1_ck2 r0 *1 0,0
Ccc_XD4_t1_ck2 XD4_t1 ck2 3.0251e-17
* device instance cc_XD4_t1_ck3 r0 *1 0,0
Ccc_XD4_t1_ck3 XD4_t1 ck3 3.0251e-17
* device instance cc_XD4_t1_ck4 r0 *1 0,0
Ccc_XD4_t1_ck4 XD4_t1 ck4 3.0251e-17
* device instance cc_XD4_t1_ck5 r0 *1 0,0
Ccc_XD4_t1_ck5 XD4_t1 ck5 3.6302e-17
* device instance cc_XD4_t1_mod0 r0 *1 0,0
Ccc_XD4_t1_mod0 XD4_t1 mod0 2.4201e-17
* device instance cc_XD4_t1_mod1 r0 *1 0,0
Ccc_XD4_t1_mod1 XD4_t1 mod1 2.4201e-17
* device instance cc_XD4_t1_mod2 r0 *1 0,0
Ccc_XD4_t1_mod2 XD4_t1 mod2 2.4201e-17
* device instance cc_XD4_t1_mod3 r0 *1 0,0
Ccc_XD4_t1_mod3 XD4_t1 mod3 2.4201e-17
* device instance cc_XD4_t1_mod4 r0 *1 0,0
Ccc_XD4_t1_mod4 XD4_t1 mod4 2.4201e-17
* device instance cc_XD4_t1_net1 r0 *1 0,0
Ccc_XD4_t1_net1 XD4_t1 net1 1.21e-17
* device instance cc_XD5_XDFFM_CKBB_XD5_XDFFM_CLKB r0 *1 0,0
Ccc_XD5_XDFFM_CKBB_XD5_XDFFM_CLKB XD5_XDFFM_CKBB XD5_XDFFM_CLKB 3.6302e-17
* device instance cc_XD5_XDFFM_CKBB_XD5_XDFFM_M r0 *1 0,0
Ccc_XD5_XDFFM_CKBB_XD5_XDFFM_M XD5_XDFFM_CKBB XD5_XDFFM_M 4.8402e-17
* device instance cc_XD5_XDFFM_CKBB_XD5_XDFFM_MB r0 *1 0,0
Ccc_XD5_XDFFM_CKBB_XD5_XDFFM_MB XD5_XDFFM_CKBB XD5_XDFFM_MB 2.4201e-17
* device instance cc_XD5_XDFFM_CKBB_XD5_XDFFM_MFB r0 *1 0,0
Ccc_XD5_XDFFM_CKBB_XD5_XDFFM_MFB XD5_XDFFM_CKBB XD5_XDFFM_MFB 2.4201e-17
* device instance cc_XD5_XDFFM_CKBB_XD5_XDFFM_S r0 *1 0,0
Ccc_XD5_XDFFM_CKBB_XD5_XDFFM_S XD5_XDFFM_CKBB XD5_XDFFM_S 3.0251e-17
* device instance cc_XD5_XDFFM_CKBB_XD5_XDFFM_SB r0 *1 0,0
Ccc_XD5_XDFFM_CKBB_XD5_XDFFM_SB XD5_XDFFM_CKBB XD5_XDFFM_SB 3.0251e-17
* device instance cc_XD5_XDFFM_CKBB_XD5_XDFFM_SFB r0 *1 0,0
Ccc_XD5_XDFFM_CKBB_XD5_XDFFM_SFB XD5_XDFFM_CKBB XD5_XDFFM_SFB 1.8151e-17
* device instance cc_XD5_XDFFM_CKBB_XD5_XDFFQ_CKBB r0 *1 0,0
Ccc_XD5_XDFFM_CKBB_XD5_XDFFQ_CKBB XD5_XDFFM_CKBB XD5_XDFFQ_CKBB 1.8151e-17
* device instance cc_XD5_XDFFM_CKBB_XD5_XDFFQ_CLKB r0 *1 0,0
Ccc_XD5_XDFFM_CKBB_XD5_XDFFQ_CLKB XD5_XDFFM_CKBB XD5_XDFFQ_CLKB 2.4201e-17
* device instance cc_XD5_XDFFM_CKBB_XD5_XDFFQ_M r0 *1 0,0
Ccc_XD5_XDFFM_CKBB_XD5_XDFFQ_M XD5_XDFFM_CKBB XD5_XDFFQ_M 2.4201e-17
* device instance cc_XD5_XDFFM_CKBB_XD5_XDFFQ_MB r0 *1 0,0
Ccc_XD5_XDFFM_CKBB_XD5_XDFFQ_MB XD5_XDFFM_CKBB XD5_XDFFQ_MB 1.21e-17
* device instance cc_XD5_XDFFM_CKBB_XD5_XDFFQ_MFB r0 *1 0,0
Ccc_XD5_XDFFM_CKBB_XD5_XDFFQ_MFB XD5_XDFFM_CKBB XD5_XDFFQ_MFB 1.21e-17
* device instance cc_XD5_XDFFM_CKBB_XD5_XDFFQ_S r0 *1 0,0
Ccc_XD5_XDFFM_CKBB_XD5_XDFFQ_S XD5_XDFFM_CKBB XD5_XDFFQ_S 1.8151e-17
* device instance cc_XD5_XDFFM_CKBB_XD5_XDFFQ_SB r0 *1 0,0
Ccc_XD5_XDFFM_CKBB_XD5_XDFFQ_SB XD5_XDFFM_CKBB XD5_XDFFQ_SB 1.8151e-17
* device instance cc_XD5_XDFFM_CKBB_XD5_XDFFQ_SFB r0 *1 0,0
Ccc_XD5_XDFFM_CKBB_XD5_XDFFQ_SFB XD5_XDFFM_CKBB XD5_XDFFQ_SFB 1.21e-17
* device instance cc_XD5_XDFFM_CKBB_XD5_XNOR_midp r0 *1 0,0
Ccc_XD5_XDFFM_CKBB_XD5_XNOR_midp XD5_XDFFM_CKBB XD5_XNOR_midp 1.21e-17
* device instance cc_XD5_XDFFM_CKBB_XD5_dmodout r0 *1 0,0
Ccc_XD5_XDFFM_CKBB_XD5_dmodout XD5_XDFFM_CKBB XD5_dmodout 1.8151e-17
* device instance cc_XD5_XDFFM_CKBB_XD5_dq r0 *1 0,0
Ccc_XD5_XDFFM_CKBB_XD5_dq XD5_XDFFM_CKBB XD5_dq 1.21e-17
* device instance cc_XD5_XDFFM_CKBB_XD5_nm r0 *1 0,0
Ccc_XD5_XDFFM_CKBB_XD5_nm XD5_XDFFM_CKBB XD5_nm 1.8151e-17
* device instance cc_XD5_XDFFM_CKBB_XD5_nt r0 *1 0,0
Ccc_XD5_XDFFM_CKBB_XD5_nt XD5_XDFFM_CKBB XD5_nt 2.4201e-17
* device instance cc_XD5_XDFFM_CKBB_XD5_t1 r0 *1 0,0
Ccc_XD5_XDFFM_CKBB_XD5_t1 XD5_XDFFM_CKBB XD5_t1 1.21e-17
* device instance cc_XD5_XDFFM_CKBB_XFRT_CKBB r0 *1 0,0
Ccc_XD5_XDFFM_CKBB_XFRT_CKBB XD5_XDFFM_CKBB XFRT_CKBB 1.8151e-17
* device instance cc_XD5_XDFFM_CKBB_XFRT_CLKB r0 *1 0,0
Ccc_XD5_XDFFM_CKBB_XFRT_CLKB XD5_XDFFM_CKBB XFRT_CLKB 2.4201e-17
* device instance cc_XD5_XDFFM_CKBB_XFRT_M r0 *1 0,0
Ccc_XD5_XDFFM_CKBB_XFRT_M XD5_XDFFM_CKBB XFRT_M 2.4201e-17
* device instance cc_XD5_XDFFM_CKBB_XFRT_MB r0 *1 0,0
Ccc_XD5_XDFFM_CKBB_XFRT_MB XD5_XDFFM_CKBB XFRT_MB 1.21e-17
* device instance cc_XD5_XDFFM_CKBB_XFRT_MFB r0 *1 0,0
Ccc_XD5_XDFFM_CKBB_XFRT_MFB XD5_XDFFM_CKBB XFRT_MFB 1.21e-17
* device instance cc_XD5_XDFFM_CKBB_XFRT_S r0 *1 0,0
Ccc_XD5_XDFFM_CKBB_XFRT_S XD5_XDFFM_CKBB XFRT_S 1.8151e-17
* device instance cc_XD5_XDFFM_CKBB_XFRT_SB r0 *1 0,0
Ccc_XD5_XDFFM_CKBB_XFRT_SB XD5_XDFFM_CKBB XFRT_SB 1.8151e-17
* device instance cc_XD5_XDFFM_CKBB_XFRT_SFB r0 *1 0,0
Ccc_XD5_XDFFM_CKBB_XFRT_SFB XD5_XDFFM_CKBB XFRT_SFB 1.21e-17
* device instance cc_XD5_XDFFM_CKBB_ck1 r0 *1 0,0
Ccc_XD5_XDFFM_CKBB_ck1 XD5_XDFFM_CKBB ck1 3.0251e-17
* device instance cc_XD5_XDFFM_CKBB_ck2 r0 *1 0,0
Ccc_XD5_XDFFM_CKBB_ck2 XD5_XDFFM_CKBB ck2 3.0251e-17
* device instance cc_XD5_XDFFM_CKBB_ck3 r0 *1 0,0
Ccc_XD5_XDFFM_CKBB_ck3 XD5_XDFFM_CKBB ck3 3.0251e-17
* device instance cc_XD5_XDFFM_CKBB_ck4 r0 *1 0,0
Ccc_XD5_XDFFM_CKBB_ck4 XD5_XDFFM_CKBB ck4 3.0251e-17
* device instance cc_XD5_XDFFM_CKBB_ck5 r0 *1 0,0
Ccc_XD5_XDFFM_CKBB_ck5 XD5_XDFFM_CKBB ck5 3.0251e-17
* device instance cc_XD5_XDFFM_CKBB_mod0 r0 *1 0,0
Ccc_XD5_XDFFM_CKBB_mod0 XD5_XDFFM_CKBB mod0 2.4201e-17
* device instance cc_XD5_XDFFM_CKBB_mod1 r0 *1 0,0
Ccc_XD5_XDFFM_CKBB_mod1 XD5_XDFFM_CKBB mod1 2.4201e-17
* device instance cc_XD5_XDFFM_CKBB_mod2 r0 *1 0,0
Ccc_XD5_XDFFM_CKBB_mod2 XD5_XDFFM_CKBB mod2 2.4201e-17
* device instance cc_XD5_XDFFM_CKBB_mod3 r0 *1 0,0
Ccc_XD5_XDFFM_CKBB_mod3 XD5_XDFFM_CKBB mod3 2.4201e-17
* device instance cc_XD5_XDFFM_CKBB_mod4 r0 *1 0,0
Ccc_XD5_XDFFM_CKBB_mod4 XD5_XDFFM_CKBB mod4 2.4201e-17
* device instance cc_XD5_XDFFM_CKBB_net1 r0 *1 0,0
Ccc_XD5_XDFFM_CKBB_net1 XD5_XDFFM_CKBB net1 1.21e-17
* device instance cc_XD5_XDFFM_CLKB_XD5_XDFFM_M r0 *1 0,0
Ccc_XD5_XDFFM_CLKB_XD5_XDFFM_M XD5_XDFFM_CLKB XD5_XDFFM_M 4.2352e-17
* device instance cc_XD5_XDFFM_CLKB_XD5_XDFFM_MB r0 *1 0,0
Ccc_XD5_XDFFM_CLKB_XD5_XDFFM_MB XD5_XDFFM_CLKB XD5_XDFFM_MB 2.4201e-17
* device instance cc_XD5_XDFFM_CLKB_XD5_XDFFM_MFB r0 *1 0,0
Ccc_XD5_XDFFM_CLKB_XD5_XDFFM_MFB XD5_XDFFM_CLKB XD5_XDFFM_MFB 2.4201e-17
* device instance cc_XD5_XDFFM_CLKB_XD5_XDFFM_S r0 *1 0,0
Ccc_XD5_XDFFM_CLKB_XD5_XDFFM_S XD5_XDFFM_CLKB XD5_XDFFM_S 1.8151e-17
* device instance cc_XD5_XDFFM_CLKB_XD5_XDFFM_SB r0 *1 0,0
Ccc_XD5_XDFFM_CLKB_XD5_XDFFM_SB XD5_XDFFM_CLKB XD5_XDFFM_SB 1.8151e-17
* device instance cc_XD5_XDFFM_CLKB_XD5_XDFFM_SFB r0 *1 0,0
Ccc_XD5_XDFFM_CLKB_XD5_XDFFM_SFB XD5_XDFFM_CLKB XD5_XDFFM_SFB 1.21e-17
* device instance cc_XD5_XDFFM_CLKB_XD5_XDFFQ_CKBB r0 *1 0,0
Ccc_XD5_XDFFM_CLKB_XD5_XDFFQ_CKBB XD5_XDFFM_CLKB XD5_XDFFQ_CKBB 1.8151e-17
* device instance cc_XD5_XDFFM_CLKB_XD5_XDFFQ_CLKB r0 *1 0,0
Ccc_XD5_XDFFM_CLKB_XD5_XDFFQ_CLKB XD5_XDFFM_CLKB XD5_XDFFQ_CLKB 2.4201e-17
* device instance cc_XD5_XDFFM_CLKB_XD5_XDFFQ_M r0 *1 0,0
Ccc_XD5_XDFFM_CLKB_XD5_XDFFQ_M XD5_XDFFM_CLKB XD5_XDFFQ_M 2.4201e-17
* device instance cc_XD5_XDFFM_CLKB_XD5_XDFFQ_MB r0 *1 0,0
Ccc_XD5_XDFFM_CLKB_XD5_XDFFQ_MB XD5_XDFFM_CLKB XD5_XDFFQ_MB 1.21e-17
* device instance cc_XD5_XDFFM_CLKB_XD5_XDFFQ_MFB r0 *1 0,0
Ccc_XD5_XDFFM_CLKB_XD5_XDFFQ_MFB XD5_XDFFM_CLKB XD5_XDFFQ_MFB 1.21e-17
* device instance cc_XD5_XDFFM_CLKB_XD5_XDFFQ_S r0 *1 0,0
Ccc_XD5_XDFFM_CLKB_XD5_XDFFQ_S XD5_XDFFM_CLKB XD5_XDFFQ_S 1.8151e-17
* device instance cc_XD5_XDFFM_CLKB_XD5_XDFFQ_SB r0 *1 0,0
Ccc_XD5_XDFFM_CLKB_XD5_XDFFQ_SB XD5_XDFFM_CLKB XD5_XDFFQ_SB 1.8151e-17
* device instance cc_XD5_XDFFM_CLKB_XD5_XDFFQ_SFB r0 *1 0,0
Ccc_XD5_XDFFM_CLKB_XD5_XDFFQ_SFB XD5_XDFFM_CLKB XD5_XDFFQ_SFB 1.21e-17
* device instance cc_XD5_XDFFM_CLKB_XD5_XNOR_midp r0 *1 0,0
Ccc_XD5_XDFFM_CLKB_XD5_XNOR_midp XD5_XDFFM_CLKB XD5_XNOR_midp 1.21e-17
* device instance cc_XD5_XDFFM_CLKB_XD5_dmodout r0 *1 0,0
Ccc_XD5_XDFFM_CLKB_XD5_dmodout XD5_XDFFM_CLKB XD5_dmodout 1.8151e-17
* device instance cc_XD5_XDFFM_CLKB_XD5_dq r0 *1 0,0
Ccc_XD5_XDFFM_CLKB_XD5_dq XD5_XDFFM_CLKB XD5_dq 1.21e-17
* device instance cc_XD5_XDFFM_CLKB_XD5_nm r0 *1 0,0
Ccc_XD5_XDFFM_CLKB_XD5_nm XD5_XDFFM_CLKB XD5_nm 1.8151e-17
* device instance cc_XD5_XDFFM_CLKB_XD5_nt r0 *1 0,0
Ccc_XD5_XDFFM_CLKB_XD5_nt XD5_XDFFM_CLKB XD5_nt 2.4201e-17
* device instance cc_XD5_XDFFM_CLKB_XD5_t1 r0 *1 0,0
Ccc_XD5_XDFFM_CLKB_XD5_t1 XD5_XDFFM_CLKB XD5_t1 1.21e-17
* device instance cc_XD5_XDFFM_CLKB_XFRT_CKBB r0 *1 0,0
Ccc_XD5_XDFFM_CLKB_XFRT_CKBB XD5_XDFFM_CLKB XFRT_CKBB 1.8151e-17
* device instance cc_XD5_XDFFM_CLKB_XFRT_CLKB r0 *1 0,0
Ccc_XD5_XDFFM_CLKB_XFRT_CLKB XD5_XDFFM_CLKB XFRT_CLKB 2.4201e-17
* device instance cc_XD5_XDFFM_CLKB_XFRT_M r0 *1 0,0
Ccc_XD5_XDFFM_CLKB_XFRT_M XD5_XDFFM_CLKB XFRT_M 2.4201e-17
* device instance cc_XD5_XDFFM_CLKB_XFRT_MB r0 *1 0,0
Ccc_XD5_XDFFM_CLKB_XFRT_MB XD5_XDFFM_CLKB XFRT_MB 1.21e-17
* device instance cc_XD5_XDFFM_CLKB_XFRT_MFB r0 *1 0,0
Ccc_XD5_XDFFM_CLKB_XFRT_MFB XD5_XDFFM_CLKB XFRT_MFB 1.21e-17
* device instance cc_XD5_XDFFM_CLKB_XFRT_S r0 *1 0,0
Ccc_XD5_XDFFM_CLKB_XFRT_S XD5_XDFFM_CLKB XFRT_S 1.8151e-17
* device instance cc_XD5_XDFFM_CLKB_XFRT_SB r0 *1 0,0
Ccc_XD5_XDFFM_CLKB_XFRT_SB XD5_XDFFM_CLKB XFRT_SB 1.8151e-17
* device instance cc_XD5_XDFFM_CLKB_XFRT_SFB r0 *1 0,0
Ccc_XD5_XDFFM_CLKB_XFRT_SFB XD5_XDFFM_CLKB XFRT_SFB 1.21e-17
* device instance cc_XD5_XDFFM_CLKB_ck1 r0 *1 0,0
Ccc_XD5_XDFFM_CLKB_ck1 XD5_XDFFM_CLKB ck1 3.0251e-17
* device instance cc_XD5_XDFFM_CLKB_ck2 r0 *1 0,0
Ccc_XD5_XDFFM_CLKB_ck2 XD5_XDFFM_CLKB ck2 3.0251e-17
* device instance cc_XD5_XDFFM_CLKB_ck3 r0 *1 0,0
Ccc_XD5_XDFFM_CLKB_ck3 XD5_XDFFM_CLKB ck3 3.0251e-17
* device instance cc_XD5_XDFFM_CLKB_ck4 r0 *1 0,0
Ccc_XD5_XDFFM_CLKB_ck4 XD5_XDFFM_CLKB ck4 3.0251e-17
* device instance cc_XD5_XDFFM_CLKB_ck5 r0 *1 0,0
Ccc_XD5_XDFFM_CLKB_ck5 XD5_XDFFM_CLKB ck5 3.0251e-17
* device instance cc_XD5_XDFFM_CLKB_mod0 r0 *1 0,0
Ccc_XD5_XDFFM_CLKB_mod0 XD5_XDFFM_CLKB mod0 2.4201e-17
* device instance cc_XD5_XDFFM_CLKB_mod1 r0 *1 0,0
Ccc_XD5_XDFFM_CLKB_mod1 XD5_XDFFM_CLKB mod1 2.4201e-17
* device instance cc_XD5_XDFFM_CLKB_mod2 r0 *1 0,0
Ccc_XD5_XDFFM_CLKB_mod2 XD5_XDFFM_CLKB mod2 2.4201e-17
* device instance cc_XD5_XDFFM_CLKB_mod3 r0 *1 0,0
Ccc_XD5_XDFFM_CLKB_mod3 XD5_XDFFM_CLKB mod3 2.4201e-17
* device instance cc_XD5_XDFFM_CLKB_mod4 r0 *1 0,0
Ccc_XD5_XDFFM_CLKB_mod4 XD5_XDFFM_CLKB mod4 2.4201e-17
* device instance cc_XD5_XDFFM_CLKB_net1 r0 *1 0,0
Ccc_XD5_XDFFM_CLKB_net1 XD5_XDFFM_CLKB net1 1.21e-17
* device instance cc_XD5_XDFFM_M_XD5_XDFFM_MB r0 *1 0,0
Ccc_XD5_XDFFM_M_XD5_XDFFM_MB XD5_XDFFM_M XD5_XDFFM_MB 2.4201e-17
* device instance cc_XD5_XDFFM_M_XD5_XDFFM_MFB r0 *1 0,0
Ccc_XD5_XDFFM_M_XD5_XDFFM_MFB XD5_XDFFM_M XD5_XDFFM_MFB 3.4688e-17
* device instance cc_XD5_XDFFM_M_XD5_XDFFM_S r0 *1 0,0
Ccc_XD5_XDFFM_M_XD5_XDFFM_S XD5_XDFFM_M XD5_XDFFM_S 2.8638e-17
* device instance cc_XD5_XDFFM_M_XD5_XDFFM_SB r0 *1 0,0
Ccc_XD5_XDFFM_M_XD5_XDFFM_SB XD5_XDFFM_M XD5_XDFFM_SB 1.8151e-17
* device instance cc_XD5_XDFFM_M_XD5_XDFFM_SFB r0 *1 0,0
Ccc_XD5_XDFFM_M_XD5_XDFFM_SFB XD5_XDFFM_M XD5_XDFFM_SFB 1.21e-17
* device instance cc_XD5_XDFFM_M_XD5_XDFFQ_CKBB r0 *1 0,0
Ccc_XD5_XDFFM_M_XD5_XDFFQ_CKBB XD5_XDFFM_M XD5_XDFFQ_CKBB 1.8151e-17
* device instance cc_XD5_XDFFM_M_XD5_XDFFQ_CLKB r0 *1 0,0
Ccc_XD5_XDFFM_M_XD5_XDFFQ_CLKB XD5_XDFFM_M XD5_XDFFQ_CLKB 2.4201e-17
* device instance cc_XD5_XDFFM_M_XD5_XDFFQ_M r0 *1 0,0
Ccc_XD5_XDFFM_M_XD5_XDFFQ_M XD5_XDFFM_M XD5_XDFFQ_M 2.4201e-17
* device instance cc_XD5_XDFFM_M_XD5_XDFFQ_MB r0 *1 0,0
Ccc_XD5_XDFFM_M_XD5_XDFFQ_MB XD5_XDFFM_M XD5_XDFFQ_MB 1.21e-17
* device instance cc_XD5_XDFFM_M_XD5_XDFFQ_MFB r0 *1 0,0
Ccc_XD5_XDFFM_M_XD5_XDFFQ_MFB XD5_XDFFM_M XD5_XDFFQ_MFB 1.21e-17
* device instance cc_XD5_XDFFM_M_XD5_XDFFQ_S r0 *1 0,0
Ccc_XD5_XDFFM_M_XD5_XDFFQ_S XD5_XDFFM_M XD5_XDFFQ_S 1.8151e-17
* device instance cc_XD5_XDFFM_M_XD5_XDFFQ_SB r0 *1 0,0
Ccc_XD5_XDFFM_M_XD5_XDFFQ_SB XD5_XDFFM_M XD5_XDFFQ_SB 1.8151e-17
* device instance cc_XD5_XDFFM_M_XD5_XDFFQ_SFB r0 *1 0,0
Ccc_XD5_XDFFM_M_XD5_XDFFQ_SFB XD5_XDFFM_M XD5_XDFFQ_SFB 1.21e-17
* device instance cc_XD5_XDFFM_M_XD5_XNOR_midp r0 *1 0,0
Ccc_XD5_XDFFM_M_XD5_XNOR_midp XD5_XDFFM_M XD5_XNOR_midp 1.21e-17
* device instance cc_XD5_XDFFM_M_XD5_dmodout r0 *1 0,0
Ccc_XD5_XDFFM_M_XD5_dmodout XD5_XDFFM_M XD5_dmodout 2.8638e-17
* device instance cc_XD5_XDFFM_M_XD5_dq r0 *1 0,0
Ccc_XD5_XDFFM_M_XD5_dq XD5_XDFFM_M XD5_dq 1.21e-17
* device instance cc_XD5_XDFFM_M_XD5_nm r0 *1 0,0
Ccc_XD5_XDFFM_M_XD5_nm XD5_XDFFM_M XD5_nm 1.8151e-17
* device instance cc_XD5_XDFFM_M_XD5_nt r0 *1 0,0
Ccc_XD5_XDFFM_M_XD5_nt XD5_XDFFM_M XD5_nt 2.4201e-17
* device instance cc_XD5_XDFFM_M_XD5_t1 r0 *1 0,0
Ccc_XD5_XDFFM_M_XD5_t1 XD5_XDFFM_M XD5_t1 1.21e-17
* device instance cc_XD5_XDFFM_M_XFRT_CKBB r0 *1 0,0
Ccc_XD5_XDFFM_M_XFRT_CKBB XD5_XDFFM_M XFRT_CKBB 1.8151e-17
* device instance cc_XD5_XDFFM_M_XFRT_CLKB r0 *1 0,0
Ccc_XD5_XDFFM_M_XFRT_CLKB XD5_XDFFM_M XFRT_CLKB 2.4201e-17
* device instance cc_XD5_XDFFM_M_XFRT_M r0 *1 0,0
Ccc_XD5_XDFFM_M_XFRT_M XD5_XDFFM_M XFRT_M 2.4201e-17
* device instance cc_XD5_XDFFM_M_XFRT_MB r0 *1 0,0
Ccc_XD5_XDFFM_M_XFRT_MB XD5_XDFFM_M XFRT_MB 1.21e-17
* device instance cc_XD5_XDFFM_M_XFRT_MFB r0 *1 0,0
Ccc_XD5_XDFFM_M_XFRT_MFB XD5_XDFFM_M XFRT_MFB 1.21e-17
* device instance cc_XD5_XDFFM_M_XFRT_S r0 *1 0,0
Ccc_XD5_XDFFM_M_XFRT_S XD5_XDFFM_M XFRT_S 1.8151e-17
* device instance cc_XD5_XDFFM_M_XFRT_SB r0 *1 0,0
Ccc_XD5_XDFFM_M_XFRT_SB XD5_XDFFM_M XFRT_SB 1.8151e-17
* device instance cc_XD5_XDFFM_M_XFRT_SFB r0 *1 0,0
Ccc_XD5_XDFFM_M_XFRT_SFB XD5_XDFFM_M XFRT_SFB 1.21e-17
* device instance cc_XD5_XDFFM_M_ck1 r0 *1 0,0
Ccc_XD5_XDFFM_M_ck1 XD5_XDFFM_M ck1 3.0251e-17
* device instance cc_XD5_XDFFM_M_ck2 r0 *1 0,0
Ccc_XD5_XDFFM_M_ck2 XD5_XDFFM_M ck2 3.0251e-17
* device instance cc_XD5_XDFFM_M_ck3 r0 *1 0,0
Ccc_XD5_XDFFM_M_ck3 XD5_XDFFM_M ck3 3.0251e-17
* device instance cc_XD5_XDFFM_M_ck4 r0 *1 0,0
Ccc_XD5_XDFFM_M_ck4 XD5_XDFFM_M ck4 3.0251e-17
* device instance cc_XD5_XDFFM_M_ck5 r0 *1 0,0
Ccc_XD5_XDFFM_M_ck5 XD5_XDFFM_M ck5 3.0251e-17
* device instance cc_XD5_XDFFM_M_mod0 r0 *1 0,0
Ccc_XD5_XDFFM_M_mod0 XD5_XDFFM_M mod0 2.4201e-17
* device instance cc_XD5_XDFFM_M_mod1 r0 *1 0,0
Ccc_XD5_XDFFM_M_mod1 XD5_XDFFM_M mod1 2.4201e-17
* device instance cc_XD5_XDFFM_M_mod2 r0 *1 0,0
Ccc_XD5_XDFFM_M_mod2 XD5_XDFFM_M mod2 2.4201e-17
* device instance cc_XD5_XDFFM_M_mod3 r0 *1 0,0
Ccc_XD5_XDFFM_M_mod3 XD5_XDFFM_M mod3 2.4201e-17
* device instance cc_XD5_XDFFM_M_mod4 r0 *1 0,0
Ccc_XD5_XDFFM_M_mod4 XD5_XDFFM_M mod4 2.4201e-17
* device instance cc_XD5_XDFFM_M_net1 r0 *1 0,0
Ccc_XD5_XDFFM_M_net1 XD5_XDFFM_M net1 1.21e-17
* device instance cc_XD5_XDFFM_MB_XD5_XDFFM_MFB r0 *1 0,0
Ccc_XD5_XDFFM_MB_XD5_XDFFM_MFB XD5_XDFFM_MB XD5_XDFFM_MFB 1.21e-17
* device instance cc_XD5_XDFFM_MB_XD5_XDFFM_S r0 *1 0,0
Ccc_XD5_XDFFM_MB_XD5_XDFFM_S XD5_XDFFM_MB XD5_XDFFM_S 1.8151e-17
* device instance cc_XD5_XDFFM_MB_XD5_XDFFM_SB r0 *1 0,0
Ccc_XD5_XDFFM_MB_XD5_XDFFM_SB XD5_XDFFM_MB XD5_XDFFM_SB 1.8151e-17
* device instance cc_XD5_XDFFM_MB_XD5_XDFFM_SFB r0 *1 0,0
Ccc_XD5_XDFFM_MB_XD5_XDFFM_SFB XD5_XDFFM_MB XD5_XDFFM_SFB 1.21e-17
* device instance cc_XD5_XDFFM_MB_XD5_XDFFQ_CKBB r0 *1 0,0
Ccc_XD5_XDFFM_MB_XD5_XDFFQ_CKBB XD5_XDFFM_MB XD5_XDFFQ_CKBB 1.8151e-17
* device instance cc_XD5_XDFFM_MB_XD5_XDFFQ_CLKB r0 *1 0,0
Ccc_XD5_XDFFM_MB_XD5_XDFFQ_CLKB XD5_XDFFM_MB XD5_XDFFQ_CLKB 2.4201e-17
* device instance cc_XD5_XDFFM_MB_XD5_XDFFQ_M r0 *1 0,0
Ccc_XD5_XDFFM_MB_XD5_XDFFQ_M XD5_XDFFM_MB XD5_XDFFQ_M 2.4201e-17
* device instance cc_XD5_XDFFM_MB_XD5_XDFFQ_MB r0 *1 0,0
Ccc_XD5_XDFFM_MB_XD5_XDFFQ_MB XD5_XDFFM_MB XD5_XDFFQ_MB 1.21e-17
* device instance cc_XD5_XDFFM_MB_XD5_XDFFQ_MFB r0 *1 0,0
Ccc_XD5_XDFFM_MB_XD5_XDFFQ_MFB XD5_XDFFM_MB XD5_XDFFQ_MFB 1.21e-17
* device instance cc_XD5_XDFFM_MB_XD5_XDFFQ_S r0 *1 0,0
Ccc_XD5_XDFFM_MB_XD5_XDFFQ_S XD5_XDFFM_MB XD5_XDFFQ_S 1.8151e-17
* device instance cc_XD5_XDFFM_MB_XD5_XDFFQ_SB r0 *1 0,0
Ccc_XD5_XDFFM_MB_XD5_XDFFQ_SB XD5_XDFFM_MB XD5_XDFFQ_SB 1.8151e-17
* device instance cc_XD5_XDFFM_MB_XD5_XDFFQ_SFB r0 *1 0,0
Ccc_XD5_XDFFM_MB_XD5_XDFFQ_SFB XD5_XDFFM_MB XD5_XDFFQ_SFB 1.21e-17
* device instance cc_XD5_XDFFM_MB_XD5_XNOR_midp r0 *1 0,0
Ccc_XD5_XDFFM_MB_XD5_XNOR_midp XD5_XDFFM_MB XD5_XNOR_midp 1.21e-17
* device instance cc_XD5_XDFFM_MB_XD5_dmodout r0 *1 0,0
Ccc_XD5_XDFFM_MB_XD5_dmodout XD5_XDFFM_MB XD5_dmodout 1.21e-17
* device instance cc_XD5_XDFFM_MB_XD5_dq r0 *1 0,0
Ccc_XD5_XDFFM_MB_XD5_dq XD5_XDFFM_MB XD5_dq 1.21e-17
* device instance cc_XD5_XDFFM_MB_XD5_nm r0 *1 0,0
Ccc_XD5_XDFFM_MB_XD5_nm XD5_XDFFM_MB XD5_nm 1.8151e-17
* device instance cc_XD5_XDFFM_MB_XD5_nt r0 *1 0,0
Ccc_XD5_XDFFM_MB_XD5_nt XD5_XDFFM_MB XD5_nt 2.4201e-17
* device instance cc_XD5_XDFFM_MB_XD5_t1 r0 *1 0,0
Ccc_XD5_XDFFM_MB_XD5_t1 XD5_XDFFM_MB XD5_t1 1.21e-17
* device instance cc_XD5_XDFFM_MB_XFRT_CKBB r0 *1 0,0
Ccc_XD5_XDFFM_MB_XFRT_CKBB XD5_XDFFM_MB XFRT_CKBB 1.8151e-17
* device instance cc_XD5_XDFFM_MB_XFRT_CLKB r0 *1 0,0
Ccc_XD5_XDFFM_MB_XFRT_CLKB XD5_XDFFM_MB XFRT_CLKB 2.4201e-17
* device instance cc_XD5_XDFFM_MB_XFRT_M r0 *1 0,0
Ccc_XD5_XDFFM_MB_XFRT_M XD5_XDFFM_MB XFRT_M 2.4201e-17
* device instance cc_XD5_XDFFM_MB_XFRT_MB r0 *1 0,0
Ccc_XD5_XDFFM_MB_XFRT_MB XD5_XDFFM_MB XFRT_MB 1.21e-17
* device instance cc_XD5_XDFFM_MB_XFRT_MFB r0 *1 0,0
Ccc_XD5_XDFFM_MB_XFRT_MFB XD5_XDFFM_MB XFRT_MFB 1.21e-17
* device instance cc_XD5_XDFFM_MB_XFRT_S r0 *1 0,0
Ccc_XD5_XDFFM_MB_XFRT_S XD5_XDFFM_MB XFRT_S 1.8151e-17
* device instance cc_XD5_XDFFM_MB_XFRT_SB r0 *1 0,0
Ccc_XD5_XDFFM_MB_XFRT_SB XD5_XDFFM_MB XFRT_SB 1.8151e-17
* device instance cc_XD5_XDFFM_MB_XFRT_SFB r0 *1 0,0
Ccc_XD5_XDFFM_MB_XFRT_SFB XD5_XDFFM_MB XFRT_SFB 1.21e-17
* device instance cc_XD5_XDFFM_MB_ck1 r0 *1 0,0
Ccc_XD5_XDFFM_MB_ck1 XD5_XDFFM_MB ck1 3.0251e-17
* device instance cc_XD5_XDFFM_MB_ck2 r0 *1 0,0
Ccc_XD5_XDFFM_MB_ck2 XD5_XDFFM_MB ck2 3.0251e-17
* device instance cc_XD5_XDFFM_MB_ck3 r0 *1 0,0
Ccc_XD5_XDFFM_MB_ck3 XD5_XDFFM_MB ck3 3.0251e-17
* device instance cc_XD5_XDFFM_MB_ck4 r0 *1 0,0
Ccc_XD5_XDFFM_MB_ck4 XD5_XDFFM_MB ck4 3.0251e-17
* device instance cc_XD5_XDFFM_MB_ck5 r0 *1 0,0
Ccc_XD5_XDFFM_MB_ck5 XD5_XDFFM_MB ck5 3.0251e-17
* device instance cc_XD5_XDFFM_MB_mod0 r0 *1 0,0
Ccc_XD5_XDFFM_MB_mod0 XD5_XDFFM_MB mod0 2.4201e-17
* device instance cc_XD5_XDFFM_MB_mod1 r0 *1 0,0
Ccc_XD5_XDFFM_MB_mod1 XD5_XDFFM_MB mod1 2.4201e-17
* device instance cc_XD5_XDFFM_MB_mod2 r0 *1 0,0
Ccc_XD5_XDFFM_MB_mod2 XD5_XDFFM_MB mod2 2.4201e-17
* device instance cc_XD5_XDFFM_MB_mod3 r0 *1 0,0
Ccc_XD5_XDFFM_MB_mod3 XD5_XDFFM_MB mod3 2.4201e-17
* device instance cc_XD5_XDFFM_MB_mod4 r0 *1 0,0
Ccc_XD5_XDFFM_MB_mod4 XD5_XDFFM_MB mod4 2.4201e-17
* device instance cc_XD5_XDFFM_MB_net1 r0 *1 0,0
Ccc_XD5_XDFFM_MB_net1 XD5_XDFFM_MB net1 1.21e-17
* device instance cc_XD5_XDFFM_MFB_XD5_XDFFM_S r0 *1 0,0
Ccc_XD5_XDFFM_MFB_XD5_XDFFM_S XD5_XDFFM_MFB XD5_XDFFM_S 1.8151e-17
* device instance cc_XD5_XDFFM_MFB_XD5_XDFFM_SB r0 *1 0,0
Ccc_XD5_XDFFM_MFB_XD5_XDFFM_SB XD5_XDFFM_MFB XD5_XDFFM_SB 1.8151e-17
* device instance cc_XD5_XDFFM_MFB_XD5_XDFFM_SFB r0 *1 0,0
Ccc_XD5_XDFFM_MFB_XD5_XDFFM_SFB XD5_XDFFM_MFB XD5_XDFFM_SFB 1.21e-17
* device instance cc_XD5_XDFFM_MFB_XD5_XDFFQ_CKBB r0 *1 0,0
Ccc_XD5_XDFFM_MFB_XD5_XDFFQ_CKBB XD5_XDFFM_MFB XD5_XDFFQ_CKBB 1.8151e-17
* device instance cc_XD5_XDFFM_MFB_XD5_XDFFQ_CLKB r0 *1 0,0
Ccc_XD5_XDFFM_MFB_XD5_XDFFQ_CLKB XD5_XDFFM_MFB XD5_XDFFQ_CLKB 2.4201e-17
* device instance cc_XD5_XDFFM_MFB_XD5_XDFFQ_M r0 *1 0,0
Ccc_XD5_XDFFM_MFB_XD5_XDFFQ_M XD5_XDFFM_MFB XD5_XDFFQ_M 2.4201e-17
* device instance cc_XD5_XDFFM_MFB_XD5_XDFFQ_MB r0 *1 0,0
Ccc_XD5_XDFFM_MFB_XD5_XDFFQ_MB XD5_XDFFM_MFB XD5_XDFFQ_MB 1.21e-17
* device instance cc_XD5_XDFFM_MFB_XD5_XDFFQ_MFB r0 *1 0,0
Ccc_XD5_XDFFM_MFB_XD5_XDFFQ_MFB XD5_XDFFM_MFB XD5_XDFFQ_MFB 1.21e-17
* device instance cc_XD5_XDFFM_MFB_XD5_XDFFQ_S r0 *1 0,0
Ccc_XD5_XDFFM_MFB_XD5_XDFFQ_S XD5_XDFFM_MFB XD5_XDFFQ_S 1.8151e-17
* device instance cc_XD5_XDFFM_MFB_XD5_XDFFQ_SB r0 *1 0,0
Ccc_XD5_XDFFM_MFB_XD5_XDFFQ_SB XD5_XDFFM_MFB XD5_XDFFQ_SB 1.8151e-17
* device instance cc_XD5_XDFFM_MFB_XD5_XDFFQ_SFB r0 *1 0,0
Ccc_XD5_XDFFM_MFB_XD5_XDFFQ_SFB XD5_XDFFM_MFB XD5_XDFFQ_SFB 1.21e-17
* device instance cc_XD5_XDFFM_MFB_XD5_XNOR_midp r0 *1 0,0
Ccc_XD5_XDFFM_MFB_XD5_XNOR_midp XD5_XDFFM_MFB XD5_XNOR_midp 1.21e-17
* device instance cc_XD5_XDFFM_MFB_XD5_dmodout r0 *1 0,0
Ccc_XD5_XDFFM_MFB_XD5_dmodout XD5_XDFFM_MFB XD5_dmodout 1.21e-17
* device instance cc_XD5_XDFFM_MFB_XD5_dq r0 *1 0,0
Ccc_XD5_XDFFM_MFB_XD5_dq XD5_XDFFM_MFB XD5_dq 1.21e-17
* device instance cc_XD5_XDFFM_MFB_XD5_nm r0 *1 0,0
Ccc_XD5_XDFFM_MFB_XD5_nm XD5_XDFFM_MFB XD5_nm 1.8151e-17
* device instance cc_XD5_XDFFM_MFB_XD5_nt r0 *1 0,0
Ccc_XD5_XDFFM_MFB_XD5_nt XD5_XDFFM_MFB XD5_nt 2.4201e-17
* device instance cc_XD5_XDFFM_MFB_XD5_t1 r0 *1 0,0
Ccc_XD5_XDFFM_MFB_XD5_t1 XD5_XDFFM_MFB XD5_t1 1.21e-17
* device instance cc_XD5_XDFFM_MFB_XFRT_CKBB r0 *1 0,0
Ccc_XD5_XDFFM_MFB_XFRT_CKBB XD5_XDFFM_MFB XFRT_CKBB 1.8151e-17
* device instance cc_XD5_XDFFM_MFB_XFRT_CLKB r0 *1 0,0
Ccc_XD5_XDFFM_MFB_XFRT_CLKB XD5_XDFFM_MFB XFRT_CLKB 2.4201e-17
* device instance cc_XD5_XDFFM_MFB_XFRT_M r0 *1 0,0
Ccc_XD5_XDFFM_MFB_XFRT_M XD5_XDFFM_MFB XFRT_M 2.4201e-17
* device instance cc_XD5_XDFFM_MFB_XFRT_MB r0 *1 0,0
Ccc_XD5_XDFFM_MFB_XFRT_MB XD5_XDFFM_MFB XFRT_MB 1.21e-17
* device instance cc_XD5_XDFFM_MFB_XFRT_MFB r0 *1 0,0
Ccc_XD5_XDFFM_MFB_XFRT_MFB XD5_XDFFM_MFB XFRT_MFB 1.21e-17
* device instance cc_XD5_XDFFM_MFB_XFRT_S r0 *1 0,0
Ccc_XD5_XDFFM_MFB_XFRT_S XD5_XDFFM_MFB XFRT_S 1.8151e-17
* device instance cc_XD5_XDFFM_MFB_XFRT_SB r0 *1 0,0
Ccc_XD5_XDFFM_MFB_XFRT_SB XD5_XDFFM_MFB XFRT_SB 1.8151e-17
* device instance cc_XD5_XDFFM_MFB_XFRT_SFB r0 *1 0,0
Ccc_XD5_XDFFM_MFB_XFRT_SFB XD5_XDFFM_MFB XFRT_SFB 1.21e-17
* device instance cc_XD5_XDFFM_MFB_ck1 r0 *1 0,0
Ccc_XD5_XDFFM_MFB_ck1 XD5_XDFFM_MFB ck1 3.0251e-17
* device instance cc_XD5_XDFFM_MFB_ck2 r0 *1 0,0
Ccc_XD5_XDFFM_MFB_ck2 XD5_XDFFM_MFB ck2 3.0251e-17
* device instance cc_XD5_XDFFM_MFB_ck3 r0 *1 0,0
Ccc_XD5_XDFFM_MFB_ck3 XD5_XDFFM_MFB ck3 3.0251e-17
* device instance cc_XD5_XDFFM_MFB_ck4 r0 *1 0,0
Ccc_XD5_XDFFM_MFB_ck4 XD5_XDFFM_MFB ck4 3.0251e-17
* device instance cc_XD5_XDFFM_MFB_ck5 r0 *1 0,0
Ccc_XD5_XDFFM_MFB_ck5 XD5_XDFFM_MFB ck5 3.0251e-17
* device instance cc_XD5_XDFFM_MFB_mod0 r0 *1 0,0
Ccc_XD5_XDFFM_MFB_mod0 XD5_XDFFM_MFB mod0 2.4201e-17
* device instance cc_XD5_XDFFM_MFB_mod1 r0 *1 0,0
Ccc_XD5_XDFFM_MFB_mod1 XD5_XDFFM_MFB mod1 2.4201e-17
* device instance cc_XD5_XDFFM_MFB_mod2 r0 *1 0,0
Ccc_XD5_XDFFM_MFB_mod2 XD5_XDFFM_MFB mod2 2.4201e-17
* device instance cc_XD5_XDFFM_MFB_mod3 r0 *1 0,0
Ccc_XD5_XDFFM_MFB_mod3 XD5_XDFFM_MFB mod3 2.4201e-17
* device instance cc_XD5_XDFFM_MFB_mod4 r0 *1 0,0
Ccc_XD5_XDFFM_MFB_mod4 XD5_XDFFM_MFB mod4 2.4201e-17
* device instance cc_XD5_XDFFM_MFB_net1 r0 *1 0,0
Ccc_XD5_XDFFM_MFB_net1 XD5_XDFFM_MFB net1 1.21e-17
* device instance cc_XD5_XDFFM_S_XD5_XDFFM_SB r0 *1 0,0
Ccc_XD5_XDFFM_S_XD5_XDFFM_SB XD5_XDFFM_S XD5_XDFFM_SB 3.0251e-17
* device instance cc_XD5_XDFFM_S_XD5_XDFFM_SFB r0 *1 0,0
Ccc_XD5_XDFFM_S_XD5_XDFFM_SFB XD5_XDFFM_S XD5_XDFFM_SFB 3.4688e-17
* device instance cc_XD5_XDFFM_S_XD5_XDFFQ_CKBB r0 *1 0,0
Ccc_XD5_XDFFM_S_XD5_XDFFQ_CKBB XD5_XDFFM_S XD5_XDFFQ_CKBB 1.8151e-17
* device instance cc_XD5_XDFFM_S_XD5_XDFFQ_CLKB r0 *1 0,0
Ccc_XD5_XDFFM_S_XD5_XDFFQ_CLKB XD5_XDFFM_S XD5_XDFFQ_CLKB 2.4201e-17
* device instance cc_XD5_XDFFM_S_XD5_XDFFQ_M r0 *1 0,0
Ccc_XD5_XDFFM_S_XD5_XDFFQ_M XD5_XDFFM_S XD5_XDFFQ_M 2.4201e-17
* device instance cc_XD5_XDFFM_S_XD5_XDFFQ_MB r0 *1 0,0
Ccc_XD5_XDFFM_S_XD5_XDFFQ_MB XD5_XDFFM_S XD5_XDFFQ_MB 1.21e-17
* device instance cc_XD5_XDFFM_S_XD5_XDFFQ_MFB r0 *1 0,0
Ccc_XD5_XDFFM_S_XD5_XDFFQ_MFB XD5_XDFFM_S XD5_XDFFQ_MFB 1.21e-17
* device instance cc_XD5_XDFFM_S_XD5_XDFFQ_S r0 *1 0,0
Ccc_XD5_XDFFM_S_XD5_XDFFQ_S XD5_XDFFM_S XD5_XDFFQ_S 1.8151e-17
* device instance cc_XD5_XDFFM_S_XD5_XDFFQ_SB r0 *1 0,0
Ccc_XD5_XDFFM_S_XD5_XDFFQ_SB XD5_XDFFM_S XD5_XDFFQ_SB 1.8151e-17
* device instance cc_XD5_XDFFM_S_XD5_XDFFQ_SFB r0 *1 0,0
Ccc_XD5_XDFFM_S_XD5_XDFFQ_SFB XD5_XDFFM_S XD5_XDFFQ_SFB 1.21e-17
* device instance cc_XD5_XDFFM_S_XD5_XNOR_midp r0 *1 0,0
Ccc_XD5_XDFFM_S_XD5_XNOR_midp XD5_XDFFM_S XD5_XNOR_midp 1.21e-17
* device instance cc_XD5_XDFFM_S_XD5_dmodout r0 *1 0,0
Ccc_XD5_XDFFM_S_XD5_dmodout XD5_XDFFM_S XD5_dmodout 1.21e-17
* device instance cc_XD5_XDFFM_S_XD5_dq r0 *1 0,0
Ccc_XD5_XDFFM_S_XD5_dq XD5_XDFFM_S XD5_dq 1.21e-17
* device instance cc_XD5_XDFFM_S_XD5_nm r0 *1 0,0
Ccc_XD5_XDFFM_S_XD5_nm XD5_XDFFM_S XD5_nm 1.8151e-17
* device instance cc_XD5_XDFFM_S_XD5_nt r0 *1 0,0
Ccc_XD5_XDFFM_S_XD5_nt XD5_XDFFM_S XD5_nt 2.4201e-17
* device instance cc_XD5_XDFFM_S_XD5_t1 r0 *1 0,0
Ccc_XD5_XDFFM_S_XD5_t1 XD5_XDFFM_S XD5_t1 1.21e-17
* device instance cc_XD5_XDFFM_S_XFRT_CKBB r0 *1 0,0
Ccc_XD5_XDFFM_S_XFRT_CKBB XD5_XDFFM_S XFRT_CKBB 1.8151e-17
* device instance cc_XD5_XDFFM_S_XFRT_CLKB r0 *1 0,0
Ccc_XD5_XDFFM_S_XFRT_CLKB XD5_XDFFM_S XFRT_CLKB 2.4201e-17
* device instance cc_XD5_XDFFM_S_XFRT_M r0 *1 0,0
Ccc_XD5_XDFFM_S_XFRT_M XD5_XDFFM_S XFRT_M 2.4201e-17
* device instance cc_XD5_XDFFM_S_XFRT_MB r0 *1 0,0
Ccc_XD5_XDFFM_S_XFRT_MB XD5_XDFFM_S XFRT_MB 1.21e-17
* device instance cc_XD5_XDFFM_S_XFRT_MFB r0 *1 0,0
Ccc_XD5_XDFFM_S_XFRT_MFB XD5_XDFFM_S XFRT_MFB 1.21e-17
* device instance cc_XD5_XDFFM_S_XFRT_S r0 *1 0,0
Ccc_XD5_XDFFM_S_XFRT_S XD5_XDFFM_S XFRT_S 1.8151e-17
* device instance cc_XD5_XDFFM_S_XFRT_SB r0 *1 0,0
Ccc_XD5_XDFFM_S_XFRT_SB XD5_XDFFM_S XFRT_SB 1.8151e-17
* device instance cc_XD5_XDFFM_S_XFRT_SFB r0 *1 0,0
Ccc_XD5_XDFFM_S_XFRT_SFB XD5_XDFFM_S XFRT_SFB 1.21e-17
* device instance cc_XD5_XDFFM_S_ck1 r0 *1 0,0
Ccc_XD5_XDFFM_S_ck1 XD5_XDFFM_S ck1 3.0251e-17
* device instance cc_XD5_XDFFM_S_ck2 r0 *1 0,0
Ccc_XD5_XDFFM_S_ck2 XD5_XDFFM_S ck2 3.0251e-17
* device instance cc_XD5_XDFFM_S_ck3 r0 *1 0,0
Ccc_XD5_XDFFM_S_ck3 XD5_XDFFM_S ck3 3.0251e-17
* device instance cc_XD5_XDFFM_S_ck4 r0 *1 0,0
Ccc_XD5_XDFFM_S_ck4 XD5_XDFFM_S ck4 3.0251e-17
* device instance cc_XD5_XDFFM_S_ck5 r0 *1 0,0
Ccc_XD5_XDFFM_S_ck5 XD5_XDFFM_S ck5 3.0251e-17
* device instance cc_XD5_XDFFM_S_mod0 r0 *1 0,0
Ccc_XD5_XDFFM_S_mod0 XD5_XDFFM_S mod0 2.4201e-17
* device instance cc_XD5_XDFFM_S_mod1 r0 *1 0,0
Ccc_XD5_XDFFM_S_mod1 XD5_XDFFM_S mod1 2.4201e-17
* device instance cc_XD5_XDFFM_S_mod2 r0 *1 0,0
Ccc_XD5_XDFFM_S_mod2 XD5_XDFFM_S mod2 2.4201e-17
* device instance cc_XD5_XDFFM_S_mod3 r0 *1 0,0
Ccc_XD5_XDFFM_S_mod3 XD5_XDFFM_S mod3 2.4201e-17
* device instance cc_XD5_XDFFM_S_mod4 r0 *1 0,0
Ccc_XD5_XDFFM_S_mod4 XD5_XDFFM_S mod4 2.4201e-17
* device instance cc_XD5_XDFFM_S_net1 r0 *1 0,0
Ccc_XD5_XDFFM_S_net1 XD5_XDFFM_S net1 1.21e-17
* device instance cc_XD5_XDFFM_SB_XD5_XDFFM_SFB r0 *1 0,0
Ccc_XD5_XDFFM_SB_XD5_XDFFM_SFB XD5_XDFFM_SB XD5_XDFFM_SFB 2.4201e-17
* device instance cc_XD5_XDFFM_SB_XD5_XDFFQ_CKBB r0 *1 0,0
Ccc_XD5_XDFFM_SB_XD5_XDFFQ_CKBB XD5_XDFFM_SB XD5_XDFFQ_CKBB 1.8151e-17
* device instance cc_XD5_XDFFM_SB_XD5_XDFFQ_CLKB r0 *1 0,0
Ccc_XD5_XDFFM_SB_XD5_XDFFQ_CLKB XD5_XDFFM_SB XD5_XDFFQ_CLKB 2.4201e-17
* device instance cc_XD5_XDFFM_SB_XD5_XDFFQ_M r0 *1 0,0
Ccc_XD5_XDFFM_SB_XD5_XDFFQ_M XD5_XDFFM_SB XD5_XDFFQ_M 2.4201e-17
* device instance cc_XD5_XDFFM_SB_XD5_XDFFQ_MB r0 *1 0,0
Ccc_XD5_XDFFM_SB_XD5_XDFFQ_MB XD5_XDFFM_SB XD5_XDFFQ_MB 1.21e-17
* device instance cc_XD5_XDFFM_SB_XD5_XDFFQ_MFB r0 *1 0,0
Ccc_XD5_XDFFM_SB_XD5_XDFFQ_MFB XD5_XDFFM_SB XD5_XDFFQ_MFB 1.21e-17
* device instance cc_XD5_XDFFM_SB_XD5_XDFFQ_S r0 *1 0,0
Ccc_XD5_XDFFM_SB_XD5_XDFFQ_S XD5_XDFFM_SB XD5_XDFFQ_S 1.8151e-17
* device instance cc_XD5_XDFFM_SB_XD5_XDFFQ_SB r0 *1 0,0
Ccc_XD5_XDFFM_SB_XD5_XDFFQ_SB XD5_XDFFM_SB XD5_XDFFQ_SB 1.8151e-17
* device instance cc_XD5_XDFFM_SB_XD5_XDFFQ_SFB r0 *1 0,0
Ccc_XD5_XDFFM_SB_XD5_XDFFQ_SFB XD5_XDFFM_SB XD5_XDFFQ_SFB 1.21e-17
* device instance cc_XD5_XDFFM_SB_XD5_XNOR_midp r0 *1 0,0
Ccc_XD5_XDFFM_SB_XD5_XNOR_midp XD5_XDFFM_SB XD5_XNOR_midp 1.21e-17
* device instance cc_XD5_XDFFM_SB_XD5_dmodout r0 *1 0,0
Ccc_XD5_XDFFM_SB_XD5_dmodout XD5_XDFFM_SB XD5_dmodout 1.21e-17
* device instance cc_XD5_XDFFM_SB_XD5_dq r0 *1 0,0
Ccc_XD5_XDFFM_SB_XD5_dq XD5_XDFFM_SB XD5_dq 1.21e-17
* device instance cc_XD5_XDFFM_SB_XD5_nm r0 *1 0,0
Ccc_XD5_XDFFM_SB_XD5_nm XD5_XDFFM_SB XD5_nm 1.8151e-17
* device instance cc_XD5_XDFFM_SB_XD5_nt r0 *1 0,0
Ccc_XD5_XDFFM_SB_XD5_nt XD5_XDFFM_SB XD5_nt 2.4201e-17
* device instance cc_XD5_XDFFM_SB_XD5_t1 r0 *1 0,0
Ccc_XD5_XDFFM_SB_XD5_t1 XD5_XDFFM_SB XD5_t1 1.21e-17
* device instance cc_XD5_XDFFM_SB_XFRT_CKBB r0 *1 0,0
Ccc_XD5_XDFFM_SB_XFRT_CKBB XD5_XDFFM_SB XFRT_CKBB 1.8151e-17
* device instance cc_XD5_XDFFM_SB_XFRT_CLKB r0 *1 0,0
Ccc_XD5_XDFFM_SB_XFRT_CLKB XD5_XDFFM_SB XFRT_CLKB 2.4201e-17
* device instance cc_XD5_XDFFM_SB_XFRT_M r0 *1 0,0
Ccc_XD5_XDFFM_SB_XFRT_M XD5_XDFFM_SB XFRT_M 2.4201e-17
* device instance cc_XD5_XDFFM_SB_XFRT_MB r0 *1 0,0
Ccc_XD5_XDFFM_SB_XFRT_MB XD5_XDFFM_SB XFRT_MB 1.21e-17
* device instance cc_XD5_XDFFM_SB_XFRT_MFB r0 *1 0,0
Ccc_XD5_XDFFM_SB_XFRT_MFB XD5_XDFFM_SB XFRT_MFB 1.21e-17
* device instance cc_XD5_XDFFM_SB_XFRT_S r0 *1 0,0
Ccc_XD5_XDFFM_SB_XFRT_S XD5_XDFFM_SB XFRT_S 1.8151e-17
* device instance cc_XD5_XDFFM_SB_XFRT_SB r0 *1 0,0
Ccc_XD5_XDFFM_SB_XFRT_SB XD5_XDFFM_SB XFRT_SB 1.8151e-17
* device instance cc_XD5_XDFFM_SB_XFRT_SFB r0 *1 0,0
Ccc_XD5_XDFFM_SB_XFRT_SFB XD5_XDFFM_SB XFRT_SFB 1.21e-17
* device instance cc_XD5_XDFFM_SB_ck1 r0 *1 0,0
Ccc_XD5_XDFFM_SB_ck1 XD5_XDFFM_SB ck1 3.0251e-17
* device instance cc_XD5_XDFFM_SB_ck2 r0 *1 0,0
Ccc_XD5_XDFFM_SB_ck2 XD5_XDFFM_SB ck2 3.0251e-17
* device instance cc_XD5_XDFFM_SB_ck3 r0 *1 0,0
Ccc_XD5_XDFFM_SB_ck3 XD5_XDFFM_SB ck3 3.0251e-17
* device instance cc_XD5_XDFFM_SB_ck4 r0 *1 0,0
Ccc_XD5_XDFFM_SB_ck4 XD5_XDFFM_SB ck4 3.0251e-17
* device instance cc_XD5_XDFFM_SB_ck5 r0 *1 0,0
Ccc_XD5_XDFFM_SB_ck5 XD5_XDFFM_SB ck5 3.0251e-17
* device instance cc_XD5_XDFFM_SB_mod0 r0 *1 0,0
Ccc_XD5_XDFFM_SB_mod0 XD5_XDFFM_SB mod0 2.4201e-17
* device instance cc_XD5_XDFFM_SB_mod1 r0 *1 0,0
Ccc_XD5_XDFFM_SB_mod1 XD5_XDFFM_SB mod1 2.4201e-17
* device instance cc_XD5_XDFFM_SB_mod2 r0 *1 0,0
Ccc_XD5_XDFFM_SB_mod2 XD5_XDFFM_SB mod2 2.4201e-17
* device instance cc_XD5_XDFFM_SB_mod3 r0 *1 0,0
Ccc_XD5_XDFFM_SB_mod3 XD5_XDFFM_SB mod3 2.4201e-17
* device instance cc_XD5_XDFFM_SB_mod4 r0 *1 0,0
Ccc_XD5_XDFFM_SB_mod4 XD5_XDFFM_SB mod4 2.4201e-17
* device instance cc_XD5_XDFFM_SB_net1 r0 *1 0,0
Ccc_XD5_XDFFM_SB_net1 XD5_XDFFM_SB net1 1.21e-17
* device instance cc_XD5_XDFFM_SFB_XD5_XDFFQ_CKBB r0 *1 0,0
Ccc_XD5_XDFFM_SFB_XD5_XDFFQ_CKBB XD5_XDFFM_SFB XD5_XDFFQ_CKBB 1.8151e-17
* device instance cc_XD5_XDFFM_SFB_XD5_XDFFQ_CLKB r0 *1 0,0
Ccc_XD5_XDFFM_SFB_XD5_XDFFQ_CLKB XD5_XDFFM_SFB XD5_XDFFQ_CLKB 2.4201e-17
* device instance cc_XD5_XDFFM_SFB_XD5_XDFFQ_M r0 *1 0,0
Ccc_XD5_XDFFM_SFB_XD5_XDFFQ_M XD5_XDFFM_SFB XD5_XDFFQ_M 2.4201e-17
* device instance cc_XD5_XDFFM_SFB_XD5_XDFFQ_MB r0 *1 0,0
Ccc_XD5_XDFFM_SFB_XD5_XDFFQ_MB XD5_XDFFM_SFB XD5_XDFFQ_MB 1.21e-17
* device instance cc_XD5_XDFFM_SFB_XD5_XDFFQ_MFB r0 *1 0,0
Ccc_XD5_XDFFM_SFB_XD5_XDFFQ_MFB XD5_XDFFM_SFB XD5_XDFFQ_MFB 1.21e-17
* device instance cc_XD5_XDFFM_SFB_XD5_XDFFQ_S r0 *1 0,0
Ccc_XD5_XDFFM_SFB_XD5_XDFFQ_S XD5_XDFFM_SFB XD5_XDFFQ_S 1.8151e-17
* device instance cc_XD5_XDFFM_SFB_XD5_XDFFQ_SB r0 *1 0,0
Ccc_XD5_XDFFM_SFB_XD5_XDFFQ_SB XD5_XDFFM_SFB XD5_XDFFQ_SB 1.8151e-17
* device instance cc_XD5_XDFFM_SFB_XD5_XDFFQ_SFB r0 *1 0,0
Ccc_XD5_XDFFM_SFB_XD5_XDFFQ_SFB XD5_XDFFM_SFB XD5_XDFFQ_SFB 1.21e-17
* device instance cc_XD5_XDFFM_SFB_XD5_XNOR_midp r0 *1 0,0
Ccc_XD5_XDFFM_SFB_XD5_XNOR_midp XD5_XDFFM_SFB XD5_XNOR_midp 1.21e-17
* device instance cc_XD5_XDFFM_SFB_XD5_dmodout r0 *1 0,0
Ccc_XD5_XDFFM_SFB_XD5_dmodout XD5_XDFFM_SFB XD5_dmodout 1.21e-17
* device instance cc_XD5_XDFFM_SFB_XD5_dq r0 *1 0,0
Ccc_XD5_XDFFM_SFB_XD5_dq XD5_XDFFM_SFB XD5_dq 1.21e-17
* device instance cc_XD5_XDFFM_SFB_XD5_nm r0 *1 0,0
Ccc_XD5_XDFFM_SFB_XD5_nm XD5_XDFFM_SFB XD5_nm 1.8151e-17
* device instance cc_XD5_XDFFM_SFB_XD5_nt r0 *1 0,0
Ccc_XD5_XDFFM_SFB_XD5_nt XD5_XDFFM_SFB XD5_nt 2.4201e-17
* device instance cc_XD5_XDFFM_SFB_XD5_t1 r0 *1 0,0
Ccc_XD5_XDFFM_SFB_XD5_t1 XD5_XDFFM_SFB XD5_t1 1.21e-17
* device instance cc_XD5_XDFFM_SFB_XFRT_CKBB r0 *1 0,0
Ccc_XD5_XDFFM_SFB_XFRT_CKBB XD5_XDFFM_SFB XFRT_CKBB 1.8151e-17
* device instance cc_XD5_XDFFM_SFB_XFRT_CLKB r0 *1 0,0
Ccc_XD5_XDFFM_SFB_XFRT_CLKB XD5_XDFFM_SFB XFRT_CLKB 2.4201e-17
* device instance cc_XD5_XDFFM_SFB_XFRT_M r0 *1 0,0
Ccc_XD5_XDFFM_SFB_XFRT_M XD5_XDFFM_SFB XFRT_M 2.4201e-17
* device instance cc_XD5_XDFFM_SFB_XFRT_MB r0 *1 0,0
Ccc_XD5_XDFFM_SFB_XFRT_MB XD5_XDFFM_SFB XFRT_MB 1.21e-17
* device instance cc_XD5_XDFFM_SFB_XFRT_MFB r0 *1 0,0
Ccc_XD5_XDFFM_SFB_XFRT_MFB XD5_XDFFM_SFB XFRT_MFB 1.21e-17
* device instance cc_XD5_XDFFM_SFB_XFRT_S r0 *1 0,0
Ccc_XD5_XDFFM_SFB_XFRT_S XD5_XDFFM_SFB XFRT_S 1.8151e-17
* device instance cc_XD5_XDFFM_SFB_XFRT_SB r0 *1 0,0
Ccc_XD5_XDFFM_SFB_XFRT_SB XD5_XDFFM_SFB XFRT_SB 1.8151e-17
* device instance cc_XD5_XDFFM_SFB_XFRT_SFB r0 *1 0,0
Ccc_XD5_XDFFM_SFB_XFRT_SFB XD5_XDFFM_SFB XFRT_SFB 1.21e-17
* device instance cc_XD5_XDFFM_SFB_ck1 r0 *1 0,0
Ccc_XD5_XDFFM_SFB_ck1 XD5_XDFFM_SFB ck1 3.0251e-17
* device instance cc_XD5_XDFFM_SFB_ck2 r0 *1 0,0
Ccc_XD5_XDFFM_SFB_ck2 XD5_XDFFM_SFB ck2 3.0251e-17
* device instance cc_XD5_XDFFM_SFB_ck3 r0 *1 0,0
Ccc_XD5_XDFFM_SFB_ck3 XD5_XDFFM_SFB ck3 3.0251e-17
* device instance cc_XD5_XDFFM_SFB_ck4 r0 *1 0,0
Ccc_XD5_XDFFM_SFB_ck4 XD5_XDFFM_SFB ck4 3.0251e-17
* device instance cc_XD5_XDFFM_SFB_ck5 r0 *1 0,0
Ccc_XD5_XDFFM_SFB_ck5 XD5_XDFFM_SFB ck5 3.0251e-17
* device instance cc_XD5_XDFFM_SFB_mod0 r0 *1 0,0
Ccc_XD5_XDFFM_SFB_mod0 XD5_XDFFM_SFB mod0 2.4201e-17
* device instance cc_XD5_XDFFM_SFB_mod1 r0 *1 0,0
Ccc_XD5_XDFFM_SFB_mod1 XD5_XDFFM_SFB mod1 2.4201e-17
* device instance cc_XD5_XDFFM_SFB_mod2 r0 *1 0,0
Ccc_XD5_XDFFM_SFB_mod2 XD5_XDFFM_SFB mod2 2.4201e-17
* device instance cc_XD5_XDFFM_SFB_mod3 r0 *1 0,0
Ccc_XD5_XDFFM_SFB_mod3 XD5_XDFFM_SFB mod3 2.4201e-17
* device instance cc_XD5_XDFFM_SFB_mod4 r0 *1 0,0
Ccc_XD5_XDFFM_SFB_mod4 XD5_XDFFM_SFB mod4 2.4201e-17
* device instance cc_XD5_XDFFM_SFB_net1 r0 *1 0,0
Ccc_XD5_XDFFM_SFB_net1 XD5_XDFFM_SFB net1 1.21e-17
* device instance cc_XD5_XDFFQ_CKBB_XD5_XDFFQ_CLKB r0 *1 0,0
Ccc_XD5_XDFFQ_CKBB_XD5_XDFFQ_CLKB XD5_XDFFQ_CKBB XD5_XDFFQ_CLKB 3.6302e-17
* device instance cc_XD5_XDFFQ_CKBB_XD5_XDFFQ_M r0 *1 0,0
Ccc_XD5_XDFFQ_CKBB_XD5_XDFFQ_M XD5_XDFFQ_CKBB XD5_XDFFQ_M 4.8402e-17
* device instance cc_XD5_XDFFQ_CKBB_XD5_XDFFQ_MB r0 *1 0,0
Ccc_XD5_XDFFQ_CKBB_XD5_XDFFQ_MB XD5_XDFFQ_CKBB XD5_XDFFQ_MB 2.4201e-17
* device instance cc_XD5_XDFFQ_CKBB_XD5_XDFFQ_MFB r0 *1 0,0
Ccc_XD5_XDFFQ_CKBB_XD5_XDFFQ_MFB XD5_XDFFQ_CKBB XD5_XDFFQ_MFB 2.4201e-17
* device instance cc_XD5_XDFFQ_CKBB_XD5_XDFFQ_S r0 *1 0,0
Ccc_XD5_XDFFQ_CKBB_XD5_XDFFQ_S XD5_XDFFQ_CKBB XD5_XDFFQ_S 3.0251e-17
* device instance cc_XD5_XDFFQ_CKBB_XD5_XDFFQ_SB r0 *1 0,0
Ccc_XD5_XDFFQ_CKBB_XD5_XDFFQ_SB XD5_XDFFQ_CKBB XD5_XDFFQ_SB 3.0251e-17
* device instance cc_XD5_XDFFQ_CKBB_XD5_XDFFQ_SFB r0 *1 0,0
Ccc_XD5_XDFFQ_CKBB_XD5_XDFFQ_SFB XD5_XDFFQ_CKBB XD5_XDFFQ_SFB 1.8151e-17
* device instance cc_XD5_XDFFQ_CKBB_XD5_XN2_mid1 r0 *1 0,0
Ccc_XD5_XDFFQ_CKBB_XD5_XN2_mid1 XD5_XDFFQ_CKBB XD5_XN2_mid1 1.21e-17
* device instance cc_XD5_XDFFQ_CKBB_XD5_XNOR_midp r0 *1 0,0
Ccc_XD5_XDFFQ_CKBB_XD5_XNOR_midp XD5_XDFFQ_CKBB XD5_XNOR_midp 1.21e-17
* device instance cc_XD5_XDFFQ_CKBB_XD5_dmodout r0 *1 0,0
Ccc_XD5_XDFFQ_CKBB_XD5_dmodout XD5_XDFFQ_CKBB XD5_dmodout 1.21e-17
* device instance cc_XD5_XDFFQ_CKBB_XD5_dq r0 *1 0,0
Ccc_XD5_XDFFQ_CKBB_XD5_dq XD5_XDFFQ_CKBB XD5_dq 1.8151e-17
* device instance cc_XD5_XDFFQ_CKBB_XD5_nm r0 *1 0,0
Ccc_XD5_XDFFQ_CKBB_XD5_nm XD5_XDFFQ_CKBB XD5_nm 1.21e-17
* device instance cc_XD5_XDFFQ_CKBB_XD5_nt r0 *1 0,0
Ccc_XD5_XDFFQ_CKBB_XD5_nt XD5_XDFFQ_CKBB XD5_nt 2.4201e-17
* device instance cc_XD5_XDFFQ_CKBB_XD5_t1 r0 *1 0,0
Ccc_XD5_XDFFQ_CKBB_XD5_t1 XD5_XDFFQ_CKBB XD5_t1 1.21e-17
* device instance cc_XD5_XDFFQ_CKBB_XFRT_CKBB r0 *1 0,0
Ccc_XD5_XDFFQ_CKBB_XFRT_CKBB XD5_XDFFQ_CKBB XFRT_CKBB 1.8151e-17
* device instance cc_XD5_XDFFQ_CKBB_XFRT_CLKB r0 *1 0,0
Ccc_XD5_XDFFQ_CKBB_XFRT_CLKB XD5_XDFFQ_CKBB XFRT_CLKB 2.4201e-17
* device instance cc_XD5_XDFFQ_CKBB_XFRT_M r0 *1 0,0
Ccc_XD5_XDFFQ_CKBB_XFRT_M XD5_XDFFQ_CKBB XFRT_M 2.4201e-17
* device instance cc_XD5_XDFFQ_CKBB_XFRT_MB r0 *1 0,0
Ccc_XD5_XDFFQ_CKBB_XFRT_MB XD5_XDFFQ_CKBB XFRT_MB 1.21e-17
* device instance cc_XD5_XDFFQ_CKBB_XFRT_MFB r0 *1 0,0
Ccc_XD5_XDFFQ_CKBB_XFRT_MFB XD5_XDFFQ_CKBB XFRT_MFB 1.21e-17
* device instance cc_XD5_XDFFQ_CKBB_XFRT_S r0 *1 0,0
Ccc_XD5_XDFFQ_CKBB_XFRT_S XD5_XDFFQ_CKBB XFRT_S 1.8151e-17
* device instance cc_XD5_XDFFQ_CKBB_XFRT_SB r0 *1 0,0
Ccc_XD5_XDFFQ_CKBB_XFRT_SB XD5_XDFFQ_CKBB XFRT_SB 1.8151e-17
* device instance cc_XD5_XDFFQ_CKBB_XFRT_SFB r0 *1 0,0
Ccc_XD5_XDFFQ_CKBB_XFRT_SFB XD5_XDFFQ_CKBB XFRT_SFB 1.21e-17
* device instance cc_XD5_XDFFQ_CKBB_ck1 r0 *1 0,0
Ccc_XD5_XDFFQ_CKBB_ck1 XD5_XDFFQ_CKBB ck1 3.0251e-17
* device instance cc_XD5_XDFFQ_CKBB_ck2 r0 *1 0,0
Ccc_XD5_XDFFQ_CKBB_ck2 XD5_XDFFQ_CKBB ck2 3.0251e-17
* device instance cc_XD5_XDFFQ_CKBB_ck3 r0 *1 0,0
Ccc_XD5_XDFFQ_CKBB_ck3 XD5_XDFFQ_CKBB ck3 3.0251e-17
* device instance cc_XD5_XDFFQ_CKBB_ck4 r0 *1 0,0
Ccc_XD5_XDFFQ_CKBB_ck4 XD5_XDFFQ_CKBB ck4 3.0251e-17
* device instance cc_XD5_XDFFQ_CKBB_ck5 r0 *1 0,0
Ccc_XD5_XDFFQ_CKBB_ck5 XD5_XDFFQ_CKBB ck5 3.0251e-17
* device instance cc_XD5_XDFFQ_CKBB_mod0 r0 *1 0,0
Ccc_XD5_XDFFQ_CKBB_mod0 XD5_XDFFQ_CKBB mod0 2.4201e-17
* device instance cc_XD5_XDFFQ_CKBB_mod1 r0 *1 0,0
Ccc_XD5_XDFFQ_CKBB_mod1 XD5_XDFFQ_CKBB mod1 2.4201e-17
* device instance cc_XD5_XDFFQ_CKBB_mod2 r0 *1 0,0
Ccc_XD5_XDFFQ_CKBB_mod2 XD5_XDFFQ_CKBB mod2 2.4201e-17
* device instance cc_XD5_XDFFQ_CKBB_mod3 r0 *1 0,0
Ccc_XD5_XDFFQ_CKBB_mod3 XD5_XDFFQ_CKBB mod3 2.4201e-17
* device instance cc_XD5_XDFFQ_CKBB_mod4 r0 *1 0,0
Ccc_XD5_XDFFQ_CKBB_mod4 XD5_XDFFQ_CKBB mod4 2.4201e-17
* device instance cc_XD5_XDFFQ_CKBB_net1 r0 *1 0,0
Ccc_XD5_XDFFQ_CKBB_net1 XD5_XDFFQ_CKBB net1 1.21e-17
* device instance cc_XD5_XDFFQ_CLKB_XD5_XDFFQ_M r0 *1 0,0
Ccc_XD5_XDFFQ_CLKB_XD5_XDFFQ_M XD5_XDFFQ_CLKB XD5_XDFFQ_M 4.2352e-17
* device instance cc_XD5_XDFFQ_CLKB_XD5_XDFFQ_MB r0 *1 0,0
Ccc_XD5_XDFFQ_CLKB_XD5_XDFFQ_MB XD5_XDFFQ_CLKB XD5_XDFFQ_MB 2.4201e-17
* device instance cc_XD5_XDFFQ_CLKB_XD5_XDFFQ_MFB r0 *1 0,0
Ccc_XD5_XDFFQ_CLKB_XD5_XDFFQ_MFB XD5_XDFFQ_CLKB XD5_XDFFQ_MFB 2.4201e-17
* device instance cc_XD5_XDFFQ_CLKB_XD5_XDFFQ_S r0 *1 0,0
Ccc_XD5_XDFFQ_CLKB_XD5_XDFFQ_S XD5_XDFFQ_CLKB XD5_XDFFQ_S 1.8151e-17
* device instance cc_XD5_XDFFQ_CLKB_XD5_XDFFQ_SB r0 *1 0,0
Ccc_XD5_XDFFQ_CLKB_XD5_XDFFQ_SB XD5_XDFFQ_CLKB XD5_XDFFQ_SB 1.8151e-17
* device instance cc_XD5_XDFFQ_CLKB_XD5_XDFFQ_SFB r0 *1 0,0
Ccc_XD5_XDFFQ_CLKB_XD5_XDFFQ_SFB XD5_XDFFQ_CLKB XD5_XDFFQ_SFB 1.21e-17
* device instance cc_XD5_XDFFQ_CLKB_XD5_XN2_mid1 r0 *1 0,0
Ccc_XD5_XDFFQ_CLKB_XD5_XN2_mid1 XD5_XDFFQ_CLKB XD5_XN2_mid1 1.21e-17
* device instance cc_XD5_XDFFQ_CLKB_XD5_XNOR_midp r0 *1 0,0
Ccc_XD5_XDFFQ_CLKB_XD5_XNOR_midp XD5_XDFFQ_CLKB XD5_XNOR_midp 1.21e-17
* device instance cc_XD5_XDFFQ_CLKB_XD5_dmodout r0 *1 0,0
Ccc_XD5_XDFFQ_CLKB_XD5_dmodout XD5_XDFFQ_CLKB XD5_dmodout 1.21e-17
* device instance cc_XD5_XDFFQ_CLKB_XD5_dq r0 *1 0,0
Ccc_XD5_XDFFQ_CLKB_XD5_dq XD5_XDFFQ_CLKB XD5_dq 1.8151e-17
* device instance cc_XD5_XDFFQ_CLKB_XD5_nm r0 *1 0,0
Ccc_XD5_XDFFQ_CLKB_XD5_nm XD5_XDFFQ_CLKB XD5_nm 1.21e-17
* device instance cc_XD5_XDFFQ_CLKB_XD5_nt r0 *1 0,0
Ccc_XD5_XDFFQ_CLKB_XD5_nt XD5_XDFFQ_CLKB XD5_nt 2.4201e-17
* device instance cc_XD5_XDFFQ_CLKB_XD5_t1 r0 *1 0,0
Ccc_XD5_XDFFQ_CLKB_XD5_t1 XD5_XDFFQ_CLKB XD5_t1 1.21e-17
* device instance cc_XD5_XDFFQ_CLKB_XFRT_CKBB r0 *1 0,0
Ccc_XD5_XDFFQ_CLKB_XFRT_CKBB XD5_XDFFQ_CLKB XFRT_CKBB 1.8151e-17
* device instance cc_XD5_XDFFQ_CLKB_XFRT_CLKB r0 *1 0,0
Ccc_XD5_XDFFQ_CLKB_XFRT_CLKB XD5_XDFFQ_CLKB XFRT_CLKB 2.4201e-17
* device instance cc_XD5_XDFFQ_CLKB_XFRT_M r0 *1 0,0
Ccc_XD5_XDFFQ_CLKB_XFRT_M XD5_XDFFQ_CLKB XFRT_M 2.4201e-17
* device instance cc_XD5_XDFFQ_CLKB_XFRT_MB r0 *1 0,0
Ccc_XD5_XDFFQ_CLKB_XFRT_MB XD5_XDFFQ_CLKB XFRT_MB 1.21e-17
* device instance cc_XD5_XDFFQ_CLKB_XFRT_MFB r0 *1 0,0
Ccc_XD5_XDFFQ_CLKB_XFRT_MFB XD5_XDFFQ_CLKB XFRT_MFB 1.21e-17
* device instance cc_XD5_XDFFQ_CLKB_XFRT_S r0 *1 0,0
Ccc_XD5_XDFFQ_CLKB_XFRT_S XD5_XDFFQ_CLKB XFRT_S 1.8151e-17
* device instance cc_XD5_XDFFQ_CLKB_XFRT_SB r0 *1 0,0
Ccc_XD5_XDFFQ_CLKB_XFRT_SB XD5_XDFFQ_CLKB XFRT_SB 1.8151e-17
* device instance cc_XD5_XDFFQ_CLKB_XFRT_SFB r0 *1 0,0
Ccc_XD5_XDFFQ_CLKB_XFRT_SFB XD5_XDFFQ_CLKB XFRT_SFB 1.21e-17
* device instance cc_XD5_XDFFQ_CLKB_ck1 r0 *1 0,0
Ccc_XD5_XDFFQ_CLKB_ck1 XD5_XDFFQ_CLKB ck1 3.0251e-17
* device instance cc_XD5_XDFFQ_CLKB_ck2 r0 *1 0,0
Ccc_XD5_XDFFQ_CLKB_ck2 XD5_XDFFQ_CLKB ck2 3.0251e-17
* device instance cc_XD5_XDFFQ_CLKB_ck3 r0 *1 0,0
Ccc_XD5_XDFFQ_CLKB_ck3 XD5_XDFFQ_CLKB ck3 3.0251e-17
* device instance cc_XD5_XDFFQ_CLKB_ck4 r0 *1 0,0
Ccc_XD5_XDFFQ_CLKB_ck4 XD5_XDFFQ_CLKB ck4 3.0251e-17
* device instance cc_XD5_XDFFQ_CLKB_ck5 r0 *1 0,0
Ccc_XD5_XDFFQ_CLKB_ck5 XD5_XDFFQ_CLKB ck5 3.0251e-17
* device instance cc_XD5_XDFFQ_CLKB_mod0 r0 *1 0,0
Ccc_XD5_XDFFQ_CLKB_mod0 XD5_XDFFQ_CLKB mod0 2.4201e-17
* device instance cc_XD5_XDFFQ_CLKB_mod1 r0 *1 0,0
Ccc_XD5_XDFFQ_CLKB_mod1 XD5_XDFFQ_CLKB mod1 2.4201e-17
* device instance cc_XD5_XDFFQ_CLKB_mod2 r0 *1 0,0
Ccc_XD5_XDFFQ_CLKB_mod2 XD5_XDFFQ_CLKB mod2 2.4201e-17
* device instance cc_XD5_XDFFQ_CLKB_mod3 r0 *1 0,0
Ccc_XD5_XDFFQ_CLKB_mod3 XD5_XDFFQ_CLKB mod3 2.4201e-17
* device instance cc_XD5_XDFFQ_CLKB_mod4 r0 *1 0,0
Ccc_XD5_XDFFQ_CLKB_mod4 XD5_XDFFQ_CLKB mod4 2.4201e-17
* device instance cc_XD5_XDFFQ_CLKB_net1 r0 *1 0,0
Ccc_XD5_XDFFQ_CLKB_net1 XD5_XDFFQ_CLKB net1 1.21e-17
* device instance cc_XD5_XDFFQ_M_XD5_XDFFQ_MB r0 *1 0,0
Ccc_XD5_XDFFQ_M_XD5_XDFFQ_MB XD5_XDFFQ_M XD5_XDFFQ_MB 2.4201e-17
* device instance cc_XD5_XDFFQ_M_XD5_XDFFQ_MFB r0 *1 0,0
Ccc_XD5_XDFFQ_M_XD5_XDFFQ_MFB XD5_XDFFQ_M XD5_XDFFQ_MFB 3.4688e-17
* device instance cc_XD5_XDFFQ_M_XD5_XDFFQ_S r0 *1 0,0
Ccc_XD5_XDFFQ_M_XD5_XDFFQ_S XD5_XDFFQ_M XD5_XDFFQ_S 2.8638e-17
* device instance cc_XD5_XDFFQ_M_XD5_XDFFQ_SB r0 *1 0,0
Ccc_XD5_XDFFQ_M_XD5_XDFFQ_SB XD5_XDFFQ_M XD5_XDFFQ_SB 1.8151e-17
* device instance cc_XD5_XDFFQ_M_XD5_XDFFQ_SFB r0 *1 0,0
Ccc_XD5_XDFFQ_M_XD5_XDFFQ_SFB XD5_XDFFQ_M XD5_XDFFQ_SFB 1.21e-17
* device instance cc_XD5_XDFFQ_M_XD5_XN2_mid1 r0 *1 0,0
Ccc_XD5_XDFFQ_M_XD5_XN2_mid1 XD5_XDFFQ_M XD5_XN2_mid1 1.21e-17
* device instance cc_XD5_XDFFQ_M_XD5_XNOR_midp r0 *1 0,0
Ccc_XD5_XDFFQ_M_XD5_XNOR_midp XD5_XDFFQ_M XD5_XNOR_midp 1.21e-17
* device instance cc_XD5_XDFFQ_M_XD5_dmodout r0 *1 0,0
Ccc_XD5_XDFFQ_M_XD5_dmodout XD5_XDFFQ_M XD5_dmodout 1.21e-17
* device instance cc_XD5_XDFFQ_M_XD5_dq r0 *1 0,0
Ccc_XD5_XDFFQ_M_XD5_dq XD5_XDFFQ_M XD5_dq 2.8638e-17
* device instance cc_XD5_XDFFQ_M_XD5_nm r0 *1 0,0
Ccc_XD5_XDFFQ_M_XD5_nm XD5_XDFFQ_M XD5_nm 1.21e-17
* device instance cc_XD5_XDFFQ_M_XD5_nt r0 *1 0,0
Ccc_XD5_XDFFQ_M_XD5_nt XD5_XDFFQ_M XD5_nt 2.4201e-17
* device instance cc_XD5_XDFFQ_M_XD5_t1 r0 *1 0,0
Ccc_XD5_XDFFQ_M_XD5_t1 XD5_XDFFQ_M XD5_t1 1.21e-17
* device instance cc_XD5_XDFFQ_M_XFRT_CKBB r0 *1 0,0
Ccc_XD5_XDFFQ_M_XFRT_CKBB XD5_XDFFQ_M XFRT_CKBB 1.8151e-17
* device instance cc_XD5_XDFFQ_M_XFRT_CLKB r0 *1 0,0
Ccc_XD5_XDFFQ_M_XFRT_CLKB XD5_XDFFQ_M XFRT_CLKB 2.4201e-17
* device instance cc_XD5_XDFFQ_M_XFRT_M r0 *1 0,0
Ccc_XD5_XDFFQ_M_XFRT_M XD5_XDFFQ_M XFRT_M 2.4201e-17
* device instance cc_XD5_XDFFQ_M_XFRT_MB r0 *1 0,0
Ccc_XD5_XDFFQ_M_XFRT_MB XD5_XDFFQ_M XFRT_MB 1.21e-17
* device instance cc_XD5_XDFFQ_M_XFRT_MFB r0 *1 0,0
Ccc_XD5_XDFFQ_M_XFRT_MFB XD5_XDFFQ_M XFRT_MFB 1.21e-17
* device instance cc_XD5_XDFFQ_M_XFRT_S r0 *1 0,0
Ccc_XD5_XDFFQ_M_XFRT_S XD5_XDFFQ_M XFRT_S 1.8151e-17
* device instance cc_XD5_XDFFQ_M_XFRT_SB r0 *1 0,0
Ccc_XD5_XDFFQ_M_XFRT_SB XD5_XDFFQ_M XFRT_SB 1.8151e-17
* device instance cc_XD5_XDFFQ_M_XFRT_SFB r0 *1 0,0
Ccc_XD5_XDFFQ_M_XFRT_SFB XD5_XDFFQ_M XFRT_SFB 1.21e-17
* device instance cc_XD5_XDFFQ_M_ck1 r0 *1 0,0
Ccc_XD5_XDFFQ_M_ck1 XD5_XDFFQ_M ck1 3.0251e-17
* device instance cc_XD5_XDFFQ_M_ck2 r0 *1 0,0
Ccc_XD5_XDFFQ_M_ck2 XD5_XDFFQ_M ck2 3.0251e-17
* device instance cc_XD5_XDFFQ_M_ck3 r0 *1 0,0
Ccc_XD5_XDFFQ_M_ck3 XD5_XDFFQ_M ck3 3.0251e-17
* device instance cc_XD5_XDFFQ_M_ck4 r0 *1 0,0
Ccc_XD5_XDFFQ_M_ck4 XD5_XDFFQ_M ck4 3.0251e-17
* device instance cc_XD5_XDFFQ_M_ck5 r0 *1 0,0
Ccc_XD5_XDFFQ_M_ck5 XD5_XDFFQ_M ck5 3.0251e-17
* device instance cc_XD5_XDFFQ_M_mod0 r0 *1 0,0
Ccc_XD5_XDFFQ_M_mod0 XD5_XDFFQ_M mod0 2.4201e-17
* device instance cc_XD5_XDFFQ_M_mod1 r0 *1 0,0
Ccc_XD5_XDFFQ_M_mod1 XD5_XDFFQ_M mod1 2.4201e-17
* device instance cc_XD5_XDFFQ_M_mod2 r0 *1 0,0
Ccc_XD5_XDFFQ_M_mod2 XD5_XDFFQ_M mod2 2.4201e-17
* device instance cc_XD5_XDFFQ_M_mod3 r0 *1 0,0
Ccc_XD5_XDFFQ_M_mod3 XD5_XDFFQ_M mod3 2.4201e-17
* device instance cc_XD5_XDFFQ_M_mod4 r0 *1 0,0
Ccc_XD5_XDFFQ_M_mod4 XD5_XDFFQ_M mod4 2.4201e-17
* device instance cc_XD5_XDFFQ_M_net1 r0 *1 0,0
Ccc_XD5_XDFFQ_M_net1 XD5_XDFFQ_M net1 1.21e-17
* device instance cc_XD5_XDFFQ_MB_XD5_XDFFQ_MFB r0 *1 0,0
Ccc_XD5_XDFFQ_MB_XD5_XDFFQ_MFB XD5_XDFFQ_MB XD5_XDFFQ_MFB 1.21e-17
* device instance cc_XD5_XDFFQ_MB_XD5_XDFFQ_S r0 *1 0,0
Ccc_XD5_XDFFQ_MB_XD5_XDFFQ_S XD5_XDFFQ_MB XD5_XDFFQ_S 1.8151e-17
* device instance cc_XD5_XDFFQ_MB_XD5_XDFFQ_SB r0 *1 0,0
Ccc_XD5_XDFFQ_MB_XD5_XDFFQ_SB XD5_XDFFQ_MB XD5_XDFFQ_SB 1.8151e-17
* device instance cc_XD5_XDFFQ_MB_XD5_XDFFQ_SFB r0 *1 0,0
Ccc_XD5_XDFFQ_MB_XD5_XDFFQ_SFB XD5_XDFFQ_MB XD5_XDFFQ_SFB 1.21e-17
* device instance cc_XD5_XDFFQ_MB_XD5_XN2_mid1 r0 *1 0,0
Ccc_XD5_XDFFQ_MB_XD5_XN2_mid1 XD5_XDFFQ_MB XD5_XN2_mid1 1.21e-17
* device instance cc_XD5_XDFFQ_MB_XD5_XNOR_midp r0 *1 0,0
Ccc_XD5_XDFFQ_MB_XD5_XNOR_midp XD5_XDFFQ_MB XD5_XNOR_midp 1.21e-17
* device instance cc_XD5_XDFFQ_MB_XD5_dmodout r0 *1 0,0
Ccc_XD5_XDFFQ_MB_XD5_dmodout XD5_XDFFQ_MB XD5_dmodout 1.21e-17
* device instance cc_XD5_XDFFQ_MB_XD5_dq r0 *1 0,0
Ccc_XD5_XDFFQ_MB_XD5_dq XD5_XDFFQ_MB XD5_dq 1.21e-17
* device instance cc_XD5_XDFFQ_MB_XD5_nm r0 *1 0,0
Ccc_XD5_XDFFQ_MB_XD5_nm XD5_XDFFQ_MB XD5_nm 1.21e-17
* device instance cc_XD5_XDFFQ_MB_XD5_nt r0 *1 0,0
Ccc_XD5_XDFFQ_MB_XD5_nt XD5_XDFFQ_MB XD5_nt 2.4201e-17
* device instance cc_XD5_XDFFQ_MB_XD5_t1 r0 *1 0,0
Ccc_XD5_XDFFQ_MB_XD5_t1 XD5_XDFFQ_MB XD5_t1 1.21e-17
* device instance cc_XD5_XDFFQ_MB_XFRT_CKBB r0 *1 0,0
Ccc_XD5_XDFFQ_MB_XFRT_CKBB XD5_XDFFQ_MB XFRT_CKBB 1.8151e-17
* device instance cc_XD5_XDFFQ_MB_XFRT_CLKB r0 *1 0,0
Ccc_XD5_XDFFQ_MB_XFRT_CLKB XD5_XDFFQ_MB XFRT_CLKB 2.4201e-17
* device instance cc_XD5_XDFFQ_MB_XFRT_M r0 *1 0,0
Ccc_XD5_XDFFQ_MB_XFRT_M XD5_XDFFQ_MB XFRT_M 2.4201e-17
* device instance cc_XD5_XDFFQ_MB_XFRT_MB r0 *1 0,0
Ccc_XD5_XDFFQ_MB_XFRT_MB XD5_XDFFQ_MB XFRT_MB 1.21e-17
* device instance cc_XD5_XDFFQ_MB_XFRT_MFB r0 *1 0,0
Ccc_XD5_XDFFQ_MB_XFRT_MFB XD5_XDFFQ_MB XFRT_MFB 1.21e-17
* device instance cc_XD5_XDFFQ_MB_XFRT_S r0 *1 0,0
Ccc_XD5_XDFFQ_MB_XFRT_S XD5_XDFFQ_MB XFRT_S 1.8151e-17
* device instance cc_XD5_XDFFQ_MB_XFRT_SB r0 *1 0,0
Ccc_XD5_XDFFQ_MB_XFRT_SB XD5_XDFFQ_MB XFRT_SB 1.8151e-17
* device instance cc_XD5_XDFFQ_MB_XFRT_SFB r0 *1 0,0
Ccc_XD5_XDFFQ_MB_XFRT_SFB XD5_XDFFQ_MB XFRT_SFB 1.21e-17
* device instance cc_XD5_XDFFQ_MB_ck1 r0 *1 0,0
Ccc_XD5_XDFFQ_MB_ck1 XD5_XDFFQ_MB ck1 3.0251e-17
* device instance cc_XD5_XDFFQ_MB_ck2 r0 *1 0,0
Ccc_XD5_XDFFQ_MB_ck2 XD5_XDFFQ_MB ck2 3.0251e-17
* device instance cc_XD5_XDFFQ_MB_ck3 r0 *1 0,0
Ccc_XD5_XDFFQ_MB_ck3 XD5_XDFFQ_MB ck3 3.0251e-17
* device instance cc_XD5_XDFFQ_MB_ck4 r0 *1 0,0
Ccc_XD5_XDFFQ_MB_ck4 XD5_XDFFQ_MB ck4 3.0251e-17
* device instance cc_XD5_XDFFQ_MB_ck5 r0 *1 0,0
Ccc_XD5_XDFFQ_MB_ck5 XD5_XDFFQ_MB ck5 3.0251e-17
* device instance cc_XD5_XDFFQ_MB_mod0 r0 *1 0,0
Ccc_XD5_XDFFQ_MB_mod0 XD5_XDFFQ_MB mod0 2.4201e-17
* device instance cc_XD5_XDFFQ_MB_mod1 r0 *1 0,0
Ccc_XD5_XDFFQ_MB_mod1 XD5_XDFFQ_MB mod1 2.4201e-17
* device instance cc_XD5_XDFFQ_MB_mod2 r0 *1 0,0
Ccc_XD5_XDFFQ_MB_mod2 XD5_XDFFQ_MB mod2 2.4201e-17
* device instance cc_XD5_XDFFQ_MB_mod3 r0 *1 0,0
Ccc_XD5_XDFFQ_MB_mod3 XD5_XDFFQ_MB mod3 2.4201e-17
* device instance cc_XD5_XDFFQ_MB_mod4 r0 *1 0,0
Ccc_XD5_XDFFQ_MB_mod4 XD5_XDFFQ_MB mod4 2.4201e-17
* device instance cc_XD5_XDFFQ_MB_net1 r0 *1 0,0
Ccc_XD5_XDFFQ_MB_net1 XD5_XDFFQ_MB net1 1.21e-17
* device instance cc_XD5_XDFFQ_MFB_XD5_XDFFQ_S r0 *1 0,0
Ccc_XD5_XDFFQ_MFB_XD5_XDFFQ_S XD5_XDFFQ_MFB XD5_XDFFQ_S 1.8151e-17
* device instance cc_XD5_XDFFQ_MFB_XD5_XDFFQ_SB r0 *1 0,0
Ccc_XD5_XDFFQ_MFB_XD5_XDFFQ_SB XD5_XDFFQ_MFB XD5_XDFFQ_SB 1.8151e-17
* device instance cc_XD5_XDFFQ_MFB_XD5_XDFFQ_SFB r0 *1 0,0
Ccc_XD5_XDFFQ_MFB_XD5_XDFFQ_SFB XD5_XDFFQ_MFB XD5_XDFFQ_SFB 1.21e-17
* device instance cc_XD5_XDFFQ_MFB_XD5_XN2_mid1 r0 *1 0,0
Ccc_XD5_XDFFQ_MFB_XD5_XN2_mid1 XD5_XDFFQ_MFB XD5_XN2_mid1 1.21e-17
* device instance cc_XD5_XDFFQ_MFB_XD5_XNOR_midp r0 *1 0,0
Ccc_XD5_XDFFQ_MFB_XD5_XNOR_midp XD5_XDFFQ_MFB XD5_XNOR_midp 1.21e-17
* device instance cc_XD5_XDFFQ_MFB_XD5_dmodout r0 *1 0,0
Ccc_XD5_XDFFQ_MFB_XD5_dmodout XD5_XDFFQ_MFB XD5_dmodout 1.21e-17
* device instance cc_XD5_XDFFQ_MFB_XD5_dq r0 *1 0,0
Ccc_XD5_XDFFQ_MFB_XD5_dq XD5_XDFFQ_MFB XD5_dq 1.21e-17
* device instance cc_XD5_XDFFQ_MFB_XD5_nm r0 *1 0,0
Ccc_XD5_XDFFQ_MFB_XD5_nm XD5_XDFFQ_MFB XD5_nm 1.21e-17
* device instance cc_XD5_XDFFQ_MFB_XD5_nt r0 *1 0,0
Ccc_XD5_XDFFQ_MFB_XD5_nt XD5_XDFFQ_MFB XD5_nt 2.4201e-17
* device instance cc_XD5_XDFFQ_MFB_XD5_t1 r0 *1 0,0
Ccc_XD5_XDFFQ_MFB_XD5_t1 XD5_XDFFQ_MFB XD5_t1 1.21e-17
* device instance cc_XD5_XDFFQ_MFB_XFRT_CKBB r0 *1 0,0
Ccc_XD5_XDFFQ_MFB_XFRT_CKBB XD5_XDFFQ_MFB XFRT_CKBB 1.8151e-17
* device instance cc_XD5_XDFFQ_MFB_XFRT_CLKB r0 *1 0,0
Ccc_XD5_XDFFQ_MFB_XFRT_CLKB XD5_XDFFQ_MFB XFRT_CLKB 2.4201e-17
* device instance cc_XD5_XDFFQ_MFB_XFRT_M r0 *1 0,0
Ccc_XD5_XDFFQ_MFB_XFRT_M XD5_XDFFQ_MFB XFRT_M 2.4201e-17
* device instance cc_XD5_XDFFQ_MFB_XFRT_MB r0 *1 0,0
Ccc_XD5_XDFFQ_MFB_XFRT_MB XD5_XDFFQ_MFB XFRT_MB 1.21e-17
* device instance cc_XD5_XDFFQ_MFB_XFRT_MFB r0 *1 0,0
Ccc_XD5_XDFFQ_MFB_XFRT_MFB XD5_XDFFQ_MFB XFRT_MFB 1.21e-17
* device instance cc_XD5_XDFFQ_MFB_XFRT_S r0 *1 0,0
Ccc_XD5_XDFFQ_MFB_XFRT_S XD5_XDFFQ_MFB XFRT_S 1.8151e-17
* device instance cc_XD5_XDFFQ_MFB_XFRT_SB r0 *1 0,0
Ccc_XD5_XDFFQ_MFB_XFRT_SB XD5_XDFFQ_MFB XFRT_SB 1.8151e-17
* device instance cc_XD5_XDFFQ_MFB_XFRT_SFB r0 *1 0,0
Ccc_XD5_XDFFQ_MFB_XFRT_SFB XD5_XDFFQ_MFB XFRT_SFB 1.21e-17
* device instance cc_XD5_XDFFQ_MFB_ck1 r0 *1 0,0
Ccc_XD5_XDFFQ_MFB_ck1 XD5_XDFFQ_MFB ck1 3.0251e-17
* device instance cc_XD5_XDFFQ_MFB_ck2 r0 *1 0,0
Ccc_XD5_XDFFQ_MFB_ck2 XD5_XDFFQ_MFB ck2 3.0251e-17
* device instance cc_XD5_XDFFQ_MFB_ck3 r0 *1 0,0
Ccc_XD5_XDFFQ_MFB_ck3 XD5_XDFFQ_MFB ck3 3.0251e-17
* device instance cc_XD5_XDFFQ_MFB_ck4 r0 *1 0,0
Ccc_XD5_XDFFQ_MFB_ck4 XD5_XDFFQ_MFB ck4 3.0251e-17
* device instance cc_XD5_XDFFQ_MFB_ck5 r0 *1 0,0
Ccc_XD5_XDFFQ_MFB_ck5 XD5_XDFFQ_MFB ck5 3.0251e-17
* device instance cc_XD5_XDFFQ_MFB_mod0 r0 *1 0,0
Ccc_XD5_XDFFQ_MFB_mod0 XD5_XDFFQ_MFB mod0 2.4201e-17
* device instance cc_XD5_XDFFQ_MFB_mod1 r0 *1 0,0
Ccc_XD5_XDFFQ_MFB_mod1 XD5_XDFFQ_MFB mod1 2.4201e-17
* device instance cc_XD5_XDFFQ_MFB_mod2 r0 *1 0,0
Ccc_XD5_XDFFQ_MFB_mod2 XD5_XDFFQ_MFB mod2 2.4201e-17
* device instance cc_XD5_XDFFQ_MFB_mod3 r0 *1 0,0
Ccc_XD5_XDFFQ_MFB_mod3 XD5_XDFFQ_MFB mod3 2.4201e-17
* device instance cc_XD5_XDFFQ_MFB_mod4 r0 *1 0,0
Ccc_XD5_XDFFQ_MFB_mod4 XD5_XDFFQ_MFB mod4 2.4201e-17
* device instance cc_XD5_XDFFQ_MFB_net1 r0 *1 0,0
Ccc_XD5_XDFFQ_MFB_net1 XD5_XDFFQ_MFB net1 1.21e-17
* device instance cc_XD5_XDFFQ_S_XD5_XDFFQ_SB r0 *1 0,0
Ccc_XD5_XDFFQ_S_XD5_XDFFQ_SB XD5_XDFFQ_S XD5_XDFFQ_SB 3.0251e-17
* device instance cc_XD5_XDFFQ_S_XD5_XDFFQ_SFB r0 *1 0,0
Ccc_XD5_XDFFQ_S_XD5_XDFFQ_SFB XD5_XDFFQ_S XD5_XDFFQ_SFB 3.4688e-17
* device instance cc_XD5_XDFFQ_S_XD5_XN2_mid1 r0 *1 0,0
Ccc_XD5_XDFFQ_S_XD5_XN2_mid1 XD5_XDFFQ_S XD5_XN2_mid1 1.21e-17
* device instance cc_XD5_XDFFQ_S_XD5_XNOR_midp r0 *1 0,0
Ccc_XD5_XDFFQ_S_XD5_XNOR_midp XD5_XDFFQ_S XD5_XNOR_midp 1.21e-17
* device instance cc_XD5_XDFFQ_S_XD5_dmodout r0 *1 0,0
Ccc_XD5_XDFFQ_S_XD5_dmodout XD5_XDFFQ_S XD5_dmodout 1.21e-17
* device instance cc_XD5_XDFFQ_S_XD5_dq r0 *1 0,0
Ccc_XD5_XDFFQ_S_XD5_dq XD5_XDFFQ_S XD5_dq 1.21e-17
* device instance cc_XD5_XDFFQ_S_XD5_nm r0 *1 0,0
Ccc_XD5_XDFFQ_S_XD5_nm XD5_XDFFQ_S XD5_nm 1.21e-17
* device instance cc_XD5_XDFFQ_S_XD5_nt r0 *1 0,0
Ccc_XD5_XDFFQ_S_XD5_nt XD5_XDFFQ_S XD5_nt 2.4201e-17
* device instance cc_XD5_XDFFQ_S_XD5_t1 r0 *1 0,0
Ccc_XD5_XDFFQ_S_XD5_t1 XD5_XDFFQ_S XD5_t1 1.21e-17
* device instance cc_XD5_XDFFQ_S_XFRT_CKBB r0 *1 0,0
Ccc_XD5_XDFFQ_S_XFRT_CKBB XD5_XDFFQ_S XFRT_CKBB 1.8151e-17
* device instance cc_XD5_XDFFQ_S_XFRT_CLKB r0 *1 0,0
Ccc_XD5_XDFFQ_S_XFRT_CLKB XD5_XDFFQ_S XFRT_CLKB 2.4201e-17
* device instance cc_XD5_XDFFQ_S_XFRT_M r0 *1 0,0
Ccc_XD5_XDFFQ_S_XFRT_M XD5_XDFFQ_S XFRT_M 2.4201e-17
* device instance cc_XD5_XDFFQ_S_XFRT_MB r0 *1 0,0
Ccc_XD5_XDFFQ_S_XFRT_MB XD5_XDFFQ_S XFRT_MB 1.21e-17
* device instance cc_XD5_XDFFQ_S_XFRT_MFB r0 *1 0,0
Ccc_XD5_XDFFQ_S_XFRT_MFB XD5_XDFFQ_S XFRT_MFB 1.21e-17
* device instance cc_XD5_XDFFQ_S_XFRT_S r0 *1 0,0
Ccc_XD5_XDFFQ_S_XFRT_S XD5_XDFFQ_S XFRT_S 1.8151e-17
* device instance cc_XD5_XDFFQ_S_XFRT_SB r0 *1 0,0
Ccc_XD5_XDFFQ_S_XFRT_SB XD5_XDFFQ_S XFRT_SB 1.8151e-17
* device instance cc_XD5_XDFFQ_S_XFRT_SFB r0 *1 0,0
Ccc_XD5_XDFFQ_S_XFRT_SFB XD5_XDFFQ_S XFRT_SFB 1.21e-17
* device instance cc_XD5_XDFFQ_S_ck1 r0 *1 0,0
Ccc_XD5_XDFFQ_S_ck1 XD5_XDFFQ_S ck1 3.0251e-17
* device instance cc_XD5_XDFFQ_S_ck2 r0 *1 0,0
Ccc_XD5_XDFFQ_S_ck2 XD5_XDFFQ_S ck2 3.0251e-17
* device instance cc_XD5_XDFFQ_S_ck3 r0 *1 0,0
Ccc_XD5_XDFFQ_S_ck3 XD5_XDFFQ_S ck3 3.0251e-17
* device instance cc_XD5_XDFFQ_S_ck4 r0 *1 0,0
Ccc_XD5_XDFFQ_S_ck4 XD5_XDFFQ_S ck4 3.0251e-17
* device instance cc_XD5_XDFFQ_S_ck5 r0 *1 0,0
Ccc_XD5_XDFFQ_S_ck5 XD5_XDFFQ_S ck5 3.0251e-17
* device instance cc_XD5_XDFFQ_S_mod0 r0 *1 0,0
Ccc_XD5_XDFFQ_S_mod0 XD5_XDFFQ_S mod0 2.4201e-17
* device instance cc_XD5_XDFFQ_S_mod1 r0 *1 0,0
Ccc_XD5_XDFFQ_S_mod1 XD5_XDFFQ_S mod1 2.4201e-17
* device instance cc_XD5_XDFFQ_S_mod2 r0 *1 0,0
Ccc_XD5_XDFFQ_S_mod2 XD5_XDFFQ_S mod2 2.4201e-17
* device instance cc_XD5_XDFFQ_S_mod3 r0 *1 0,0
Ccc_XD5_XDFFQ_S_mod3 XD5_XDFFQ_S mod3 2.4201e-17
* device instance cc_XD5_XDFFQ_S_mod4 r0 *1 0,0
Ccc_XD5_XDFFQ_S_mod4 XD5_XDFFQ_S mod4 2.4201e-17
* device instance cc_XD5_XDFFQ_S_net1 r0 *1 0,0
Ccc_XD5_XDFFQ_S_net1 XD5_XDFFQ_S net1 1.21e-17
* device instance cc_XD5_XDFFQ_SB_XD5_XDFFQ_SFB r0 *1 0,0
Ccc_XD5_XDFFQ_SB_XD5_XDFFQ_SFB XD5_XDFFQ_SB XD5_XDFFQ_SFB 2.4201e-17
* device instance cc_XD5_XDFFQ_SB_XD5_XN2_mid1 r0 *1 0,0
Ccc_XD5_XDFFQ_SB_XD5_XN2_mid1 XD5_XDFFQ_SB XD5_XN2_mid1 1.21e-17
* device instance cc_XD5_XDFFQ_SB_XD5_XNOR_midp r0 *1 0,0
Ccc_XD5_XDFFQ_SB_XD5_XNOR_midp XD5_XDFFQ_SB XD5_XNOR_midp 1.21e-17
* device instance cc_XD5_XDFFQ_SB_XD5_dmodout r0 *1 0,0
Ccc_XD5_XDFFQ_SB_XD5_dmodout XD5_XDFFQ_SB XD5_dmodout 1.21e-17
* device instance cc_XD5_XDFFQ_SB_XD5_dq r0 *1 0,0
Ccc_XD5_XDFFQ_SB_XD5_dq XD5_XDFFQ_SB XD5_dq 1.21e-17
* device instance cc_XD5_XDFFQ_SB_XD5_nm r0 *1 0,0
Ccc_XD5_XDFFQ_SB_XD5_nm XD5_XDFFQ_SB XD5_nm 1.21e-17
* device instance cc_XD5_XDFFQ_SB_XD5_nt r0 *1 0,0
Ccc_XD5_XDFFQ_SB_XD5_nt XD5_XDFFQ_SB XD5_nt 2.4201e-17
* device instance cc_XD5_XDFFQ_SB_XD5_t1 r0 *1 0,0
Ccc_XD5_XDFFQ_SB_XD5_t1 XD5_XDFFQ_SB XD5_t1 1.21e-17
* device instance cc_XD5_XDFFQ_SB_XFRT_CKBB r0 *1 0,0
Ccc_XD5_XDFFQ_SB_XFRT_CKBB XD5_XDFFQ_SB XFRT_CKBB 1.8151e-17
* device instance cc_XD5_XDFFQ_SB_XFRT_CLKB r0 *1 0,0
Ccc_XD5_XDFFQ_SB_XFRT_CLKB XD5_XDFFQ_SB XFRT_CLKB 2.4201e-17
* device instance cc_XD5_XDFFQ_SB_XFRT_M r0 *1 0,0
Ccc_XD5_XDFFQ_SB_XFRT_M XD5_XDFFQ_SB XFRT_M 2.4201e-17
* device instance cc_XD5_XDFFQ_SB_XFRT_MB r0 *1 0,0
Ccc_XD5_XDFFQ_SB_XFRT_MB XD5_XDFFQ_SB XFRT_MB 1.21e-17
* device instance cc_XD5_XDFFQ_SB_XFRT_MFB r0 *1 0,0
Ccc_XD5_XDFFQ_SB_XFRT_MFB XD5_XDFFQ_SB XFRT_MFB 1.21e-17
* device instance cc_XD5_XDFFQ_SB_XFRT_S r0 *1 0,0
Ccc_XD5_XDFFQ_SB_XFRT_S XD5_XDFFQ_SB XFRT_S 1.8151e-17
* device instance cc_XD5_XDFFQ_SB_XFRT_SB r0 *1 0,0
Ccc_XD5_XDFFQ_SB_XFRT_SB XD5_XDFFQ_SB XFRT_SB 1.8151e-17
* device instance cc_XD5_XDFFQ_SB_XFRT_SFB r0 *1 0,0
Ccc_XD5_XDFFQ_SB_XFRT_SFB XD5_XDFFQ_SB XFRT_SFB 1.21e-17
* device instance cc_XD5_XDFFQ_SB_ck1 r0 *1 0,0
Ccc_XD5_XDFFQ_SB_ck1 XD5_XDFFQ_SB ck1 3.0251e-17
* device instance cc_XD5_XDFFQ_SB_ck2 r0 *1 0,0
Ccc_XD5_XDFFQ_SB_ck2 XD5_XDFFQ_SB ck2 3.0251e-17
* device instance cc_XD5_XDFFQ_SB_ck3 r0 *1 0,0
Ccc_XD5_XDFFQ_SB_ck3 XD5_XDFFQ_SB ck3 3.0251e-17
* device instance cc_XD5_XDFFQ_SB_ck4 r0 *1 0,0
Ccc_XD5_XDFFQ_SB_ck4 XD5_XDFFQ_SB ck4 3.0251e-17
* device instance cc_XD5_XDFFQ_SB_ck5 r0 *1 0,0
Ccc_XD5_XDFFQ_SB_ck5 XD5_XDFFQ_SB ck5 3.0251e-17
* device instance cc_XD5_XDFFQ_SB_mod0 r0 *1 0,0
Ccc_XD5_XDFFQ_SB_mod0 XD5_XDFFQ_SB mod0 2.4201e-17
* device instance cc_XD5_XDFFQ_SB_mod1 r0 *1 0,0
Ccc_XD5_XDFFQ_SB_mod1 XD5_XDFFQ_SB mod1 2.4201e-17
* device instance cc_XD5_XDFFQ_SB_mod2 r0 *1 0,0
Ccc_XD5_XDFFQ_SB_mod2 XD5_XDFFQ_SB mod2 2.4201e-17
* device instance cc_XD5_XDFFQ_SB_mod3 r0 *1 0,0
Ccc_XD5_XDFFQ_SB_mod3 XD5_XDFFQ_SB mod3 2.4201e-17
* device instance cc_XD5_XDFFQ_SB_mod4 r0 *1 0,0
Ccc_XD5_XDFFQ_SB_mod4 XD5_XDFFQ_SB mod4 2.4201e-17
* device instance cc_XD5_XDFFQ_SB_net1 r0 *1 0,0
Ccc_XD5_XDFFQ_SB_net1 XD5_XDFFQ_SB net1 1.21e-17
* device instance cc_XD5_XDFFQ_SFB_XD5_XN2_mid1 r0 *1 0,0
Ccc_XD5_XDFFQ_SFB_XD5_XN2_mid1 XD5_XDFFQ_SFB XD5_XN2_mid1 1.21e-17
* device instance cc_XD5_XDFFQ_SFB_XD5_XNOR_midp r0 *1 0,0
Ccc_XD5_XDFFQ_SFB_XD5_XNOR_midp XD5_XDFFQ_SFB XD5_XNOR_midp 1.21e-17
* device instance cc_XD5_XDFFQ_SFB_XD5_dmodout r0 *1 0,0
Ccc_XD5_XDFFQ_SFB_XD5_dmodout XD5_XDFFQ_SFB XD5_dmodout 1.21e-17
* device instance cc_XD5_XDFFQ_SFB_XD5_dq r0 *1 0,0
Ccc_XD5_XDFFQ_SFB_XD5_dq XD5_XDFFQ_SFB XD5_dq 1.21e-17
* device instance cc_XD5_XDFFQ_SFB_XD5_nm r0 *1 0,0
Ccc_XD5_XDFFQ_SFB_XD5_nm XD5_XDFFQ_SFB XD5_nm 1.21e-17
* device instance cc_XD5_XDFFQ_SFB_XD5_nt r0 *1 0,0
Ccc_XD5_XDFFQ_SFB_XD5_nt XD5_XDFFQ_SFB XD5_nt 2.4201e-17
* device instance cc_XD5_XDFFQ_SFB_XD5_t1 r0 *1 0,0
Ccc_XD5_XDFFQ_SFB_XD5_t1 XD5_XDFFQ_SFB XD5_t1 1.21e-17
* device instance cc_XD5_XDFFQ_SFB_XFRT_CKBB r0 *1 0,0
Ccc_XD5_XDFFQ_SFB_XFRT_CKBB XD5_XDFFQ_SFB XFRT_CKBB 1.8151e-17
* device instance cc_XD5_XDFFQ_SFB_XFRT_CLKB r0 *1 0,0
Ccc_XD5_XDFFQ_SFB_XFRT_CLKB XD5_XDFFQ_SFB XFRT_CLKB 2.4201e-17
* device instance cc_XD5_XDFFQ_SFB_XFRT_M r0 *1 0,0
Ccc_XD5_XDFFQ_SFB_XFRT_M XD5_XDFFQ_SFB XFRT_M 2.4201e-17
* device instance cc_XD5_XDFFQ_SFB_XFRT_MB r0 *1 0,0
Ccc_XD5_XDFFQ_SFB_XFRT_MB XD5_XDFFQ_SFB XFRT_MB 1.21e-17
* device instance cc_XD5_XDFFQ_SFB_XFRT_MFB r0 *1 0,0
Ccc_XD5_XDFFQ_SFB_XFRT_MFB XD5_XDFFQ_SFB XFRT_MFB 1.21e-17
* device instance cc_XD5_XDFFQ_SFB_XFRT_S r0 *1 0,0
Ccc_XD5_XDFFQ_SFB_XFRT_S XD5_XDFFQ_SFB XFRT_S 1.8151e-17
* device instance cc_XD5_XDFFQ_SFB_XFRT_SB r0 *1 0,0
Ccc_XD5_XDFFQ_SFB_XFRT_SB XD5_XDFFQ_SFB XFRT_SB 1.8151e-17
* device instance cc_XD5_XDFFQ_SFB_XFRT_SFB r0 *1 0,0
Ccc_XD5_XDFFQ_SFB_XFRT_SFB XD5_XDFFQ_SFB XFRT_SFB 1.21e-17
* device instance cc_XD5_XDFFQ_SFB_ck1 r0 *1 0,0
Ccc_XD5_XDFFQ_SFB_ck1 XD5_XDFFQ_SFB ck1 3.0251e-17
* device instance cc_XD5_XDFFQ_SFB_ck2 r0 *1 0,0
Ccc_XD5_XDFFQ_SFB_ck2 XD5_XDFFQ_SFB ck2 3.0251e-17
* device instance cc_XD5_XDFFQ_SFB_ck3 r0 *1 0,0
Ccc_XD5_XDFFQ_SFB_ck3 XD5_XDFFQ_SFB ck3 3.0251e-17
* device instance cc_XD5_XDFFQ_SFB_ck4 r0 *1 0,0
Ccc_XD5_XDFFQ_SFB_ck4 XD5_XDFFQ_SFB ck4 3.0251e-17
* device instance cc_XD5_XDFFQ_SFB_ck5 r0 *1 0,0
Ccc_XD5_XDFFQ_SFB_ck5 XD5_XDFFQ_SFB ck5 3.0251e-17
* device instance cc_XD5_XDFFQ_SFB_mod0 r0 *1 0,0
Ccc_XD5_XDFFQ_SFB_mod0 XD5_XDFFQ_SFB mod0 2.4201e-17
* device instance cc_XD5_XDFFQ_SFB_mod1 r0 *1 0,0
Ccc_XD5_XDFFQ_SFB_mod1 XD5_XDFFQ_SFB mod1 2.4201e-17
* device instance cc_XD5_XDFFQ_SFB_mod2 r0 *1 0,0
Ccc_XD5_XDFFQ_SFB_mod2 XD5_XDFFQ_SFB mod2 2.4201e-17
* device instance cc_XD5_XDFFQ_SFB_mod3 r0 *1 0,0
Ccc_XD5_XDFFQ_SFB_mod3 XD5_XDFFQ_SFB mod3 2.4201e-17
* device instance cc_XD5_XDFFQ_SFB_mod4 r0 *1 0,0
Ccc_XD5_XDFFQ_SFB_mod4 XD5_XDFFQ_SFB mod4 2.4201e-17
* device instance cc_XD5_XDFFQ_SFB_net1 r0 *1 0,0
Ccc_XD5_XDFFQ_SFB_net1 XD5_XDFFQ_SFB net1 1.21e-17
* device instance cc_XD5_XN2_mid1_XD5_nm r0 *1 0,0
Ccc_XD5_XN2_mid1_XD5_nm XD5_XN2_mid1 XD5_nm 1.1294e-17
* device instance cc_XD5_XN3_mid1_XD5_XN3_mid2 r0 *1 0,0
Ccc_XD5_XN3_mid1_XD5_XN3_mid2 XD5_XN3_mid1 XD5_XN3_mid2 1.1294e-17
* device instance cc_XD5_XN3_mid1_XD5_nt r0 *1 0,0
Ccc_XD5_XN3_mid1_XD5_nt XD5_XN3_mid1 XD5_nt 1.1294e-17
* device instance cc_XD5_XN3_mid2_mod4 r0 *1 0,0
Ccc_XD5_XN3_mid2_mod4 XD5_XN3_mid2 mod4 6.05e-18
* device instance cc_XD5_XNOR_midp_XD5_dq r0 *1 0,0
Ccc_XD5_XNOR_midp_XD5_dq XD5_XNOR_midp XD5_dq 5.244e-18
* device instance cc_XD5_XNOR_midp_XD5_t1 r0 *1 0,0
Ccc_XD5_XNOR_midp_XD5_t1 XD5_XNOR_midp XD5_t1 6.05e-18
* device instance cc_XD5_dmodout_XD5_dq r0 *1 0,0
Ccc_XD5_dmodout_XD5_dq XD5_dmodout XD5_dq 1.21e-17
* device instance cc_XD5_dmodout_XD5_nm r0 *1 0,0
Ccc_XD5_dmodout_XD5_nm XD5_dmodout XD5_nm 1.8151e-17
* device instance cc_XD5_dmodout_XD5_nt r0 *1 0,0
Ccc_XD5_dmodout_XD5_nt XD5_dmodout XD5_nt 2.4201e-17
* device instance cc_XD5_dmodout_XD5_t1 r0 *1 0,0
Ccc_XD5_dmodout_XD5_t1 XD5_dmodout XD5_t1 1.21e-17
* device instance cc_XD5_dmodout_XFRT_CKBB r0 *1 0,0
Ccc_XD5_dmodout_XFRT_CKBB XD5_dmodout XFRT_CKBB 1.8151e-17
* device instance cc_XD5_dmodout_XFRT_CLKB r0 *1 0,0
Ccc_XD5_dmodout_XFRT_CLKB XD5_dmodout XFRT_CLKB 2.4201e-17
* device instance cc_XD5_dmodout_XFRT_M r0 *1 0,0
Ccc_XD5_dmodout_XFRT_M XD5_dmodout XFRT_M 2.4201e-17
* device instance cc_XD5_dmodout_XFRT_MB r0 *1 0,0
Ccc_XD5_dmodout_XFRT_MB XD5_dmodout XFRT_MB 1.21e-17
* device instance cc_XD5_dmodout_XFRT_MFB r0 *1 0,0
Ccc_XD5_dmodout_XFRT_MFB XD5_dmodout XFRT_MFB 1.21e-17
* device instance cc_XD5_dmodout_XFRT_S r0 *1 0,0
Ccc_XD5_dmodout_XFRT_S XD5_dmodout XFRT_S 1.8151e-17
* device instance cc_XD5_dmodout_XFRT_SB r0 *1 0,0
Ccc_XD5_dmodout_XFRT_SB XD5_dmodout XFRT_SB 1.8151e-17
* device instance cc_XD5_dmodout_XFRT_SFB r0 *1 0,0
Ccc_XD5_dmodout_XFRT_SFB XD5_dmodout XFRT_SFB 1.21e-17
* device instance cc_XD5_dmodout_ck1 r0 *1 0,0
Ccc_XD5_dmodout_ck1 XD5_dmodout ck1 3.0251e-17
* device instance cc_XD5_dmodout_ck2 r0 *1 0,0
Ccc_XD5_dmodout_ck2 XD5_dmodout ck2 3.0251e-17
* device instance cc_XD5_dmodout_ck3 r0 *1 0,0
Ccc_XD5_dmodout_ck3 XD5_dmodout ck3 3.0251e-17
* device instance cc_XD5_dmodout_ck4 r0 *1 0,0
Ccc_XD5_dmodout_ck4 XD5_dmodout ck4 3.0251e-17
* device instance cc_XD5_dmodout_ck5 r0 *1 0,0
Ccc_XD5_dmodout_ck5 XD5_dmodout ck5 3.6302e-17
* device instance cc_XD5_dmodout_mod0 r0 *1 0,0
Ccc_XD5_dmodout_mod0 XD5_dmodout mod0 2.4201e-17
* device instance cc_XD5_dmodout_mod1 r0 *1 0,0
Ccc_XD5_dmodout_mod1 XD5_dmodout mod1 2.4201e-17
* device instance cc_XD5_dmodout_mod2 r0 *1 0,0
Ccc_XD5_dmodout_mod2 XD5_dmodout mod2 2.4201e-17
* device instance cc_XD5_dmodout_mod3 r0 *1 0,0
Ccc_XD5_dmodout_mod3 XD5_dmodout mod3 2.4201e-17
* device instance cc_XD5_dmodout_mod4 r0 *1 0,0
Ccc_XD5_dmodout_mod4 XD5_dmodout mod4 2.4201e-17
* device instance cc_XD5_dmodout_net1 r0 *1 0,0
Ccc_XD5_dmodout_net1 XD5_dmodout net1 1.21e-17
* device instance cc_XD5_dq_XD5_nm r0 *1 0,0
Ccc_XD5_dq_XD5_nm XD5_dq XD5_nm 1.21e-17
* device instance cc_XD5_dq_XD5_nt r0 *1 0,0
Ccc_XD5_dq_XD5_nt XD5_dq XD5_nt 2.4201e-17
* device instance cc_XD5_dq_XD5_t1 r0 *1 0,0
Ccc_XD5_dq_XD5_t1 XD5_dq XD5_t1 1.8151e-17
* device instance cc_XD5_dq_XFRT_CKBB r0 *1 0,0
Ccc_XD5_dq_XFRT_CKBB XD5_dq XFRT_CKBB 1.8151e-17
* device instance cc_XD5_dq_XFRT_CLKB r0 *1 0,0
Ccc_XD5_dq_XFRT_CLKB XD5_dq XFRT_CLKB 2.4201e-17
* device instance cc_XD5_dq_XFRT_M r0 *1 0,0
Ccc_XD5_dq_XFRT_M XD5_dq XFRT_M 2.4201e-17
* device instance cc_XD5_dq_XFRT_MB r0 *1 0,0
Ccc_XD5_dq_XFRT_MB XD5_dq XFRT_MB 1.21e-17
* device instance cc_XD5_dq_XFRT_MFB r0 *1 0,0
Ccc_XD5_dq_XFRT_MFB XD5_dq XFRT_MFB 1.21e-17
* device instance cc_XD5_dq_XFRT_S r0 *1 0,0
Ccc_XD5_dq_XFRT_S XD5_dq XFRT_S 1.8151e-17
* device instance cc_XD5_dq_XFRT_SB r0 *1 0,0
Ccc_XD5_dq_XFRT_SB XD5_dq XFRT_SB 1.8151e-17
* device instance cc_XD5_dq_XFRT_SFB r0 *1 0,0
Ccc_XD5_dq_XFRT_SFB XD5_dq XFRT_SFB 1.21e-17
* device instance cc_XD5_dq_ck1 r0 *1 0,0
Ccc_XD5_dq_ck1 XD5_dq ck1 3.0251e-17
* device instance cc_XD5_dq_ck2 r0 *1 0,0
Ccc_XD5_dq_ck2 XD5_dq ck2 3.0251e-17
* device instance cc_XD5_dq_ck3 r0 *1 0,0
Ccc_XD5_dq_ck3 XD5_dq ck3 3.0251e-17
* device instance cc_XD5_dq_ck4 r0 *1 0,0
Ccc_XD5_dq_ck4 XD5_dq ck4 3.0251e-17
* device instance cc_XD5_dq_ck5 r0 *1 0,0
Ccc_XD5_dq_ck5 XD5_dq ck5 3.6302e-17
* device instance cc_XD5_dq_mod0 r0 *1 0,0
Ccc_XD5_dq_mod0 XD5_dq mod0 2.4201e-17
* device instance cc_XD5_dq_mod1 r0 *1 0,0
Ccc_XD5_dq_mod1 XD5_dq mod1 2.4201e-17
* device instance cc_XD5_dq_mod2 r0 *1 0,0
Ccc_XD5_dq_mod2 XD5_dq mod2 2.4201e-17
* device instance cc_XD5_dq_mod3 r0 *1 0,0
Ccc_XD5_dq_mod3 XD5_dq mod3 2.4201e-17
* device instance cc_XD5_dq_mod4 r0 *1 0,0
Ccc_XD5_dq_mod4 XD5_dq mod4 2.4201e-17
* device instance cc_XD5_dq_net1 r0 *1 0,0
Ccc_XD5_dq_net1 XD5_dq net1 1.21e-17
* device instance cc_XD5_nm_XD5_nt r0 *1 0,0
Ccc_XD5_nm_XD5_nt XD5_nm XD5_nt 2.4201e-17
* device instance cc_XD5_nm_XD5_t1 r0 *1 0,0
Ccc_XD5_nm_XD5_t1 XD5_nm XD5_t1 1.21e-17
* device instance cc_XD5_nm_XFRT_CKBB r0 *1 0,0
Ccc_XD5_nm_XFRT_CKBB XD5_nm XFRT_CKBB 1.8151e-17
* device instance cc_XD5_nm_XFRT_CLKB r0 *1 0,0
Ccc_XD5_nm_XFRT_CLKB XD5_nm XFRT_CLKB 2.4201e-17
* device instance cc_XD5_nm_XFRT_M r0 *1 0,0
Ccc_XD5_nm_XFRT_M XD5_nm XFRT_M 2.4201e-17
* device instance cc_XD5_nm_XFRT_MB r0 *1 0,0
Ccc_XD5_nm_XFRT_MB XD5_nm XFRT_MB 1.21e-17
* device instance cc_XD5_nm_XFRT_MFB r0 *1 0,0
Ccc_XD5_nm_XFRT_MFB XD5_nm XFRT_MFB 1.21e-17
* device instance cc_XD5_nm_XFRT_S r0 *1 0,0
Ccc_XD5_nm_XFRT_S XD5_nm XFRT_S 1.8151e-17
* device instance cc_XD5_nm_XFRT_SB r0 *1 0,0
Ccc_XD5_nm_XFRT_SB XD5_nm XFRT_SB 1.8151e-17
* device instance cc_XD5_nm_XFRT_SFB r0 *1 0,0
Ccc_XD5_nm_XFRT_SFB XD5_nm XFRT_SFB 1.21e-17
* device instance cc_XD5_nm_ck1 r0 *1 0,0
Ccc_XD5_nm_ck1 XD5_nm ck1 3.0251e-17
* device instance cc_XD5_nm_ck2 r0 *1 0,0
Ccc_XD5_nm_ck2 XD5_nm ck2 3.0251e-17
* device instance cc_XD5_nm_ck3 r0 *1 0,0
Ccc_XD5_nm_ck3 XD5_nm ck3 3.0251e-17
* device instance cc_XD5_nm_ck4 r0 *1 0,0
Ccc_XD5_nm_ck4 XD5_nm ck4 3.0251e-17
* device instance cc_XD5_nm_ck5 r0 *1 0,0
Ccc_XD5_nm_ck5 XD5_nm ck5 3.0251e-17
* device instance cc_XD5_nm_mod0 r0 *1 0,0
Ccc_XD5_nm_mod0 XD5_nm mod0 2.4201e-17
* device instance cc_XD5_nm_mod1 r0 *1 0,0
Ccc_XD5_nm_mod1 XD5_nm mod1 2.4201e-17
* device instance cc_XD5_nm_mod2 r0 *1 0,0
Ccc_XD5_nm_mod2 XD5_nm mod2 2.4201e-17
* device instance cc_XD5_nm_mod3 r0 *1 0,0
Ccc_XD5_nm_mod3 XD5_nm mod3 2.4201e-17
* device instance cc_XD5_nm_mod4 r0 *1 0,0
Ccc_XD5_nm_mod4 XD5_nm mod4 2.4201e-17
* device instance cc_XD5_nm_net1 r0 *1 0,0
Ccc_XD5_nm_net1 XD5_nm net1 1.21e-17
* device instance cc_XD5_nt_XD5_t1 r0 *1 0,0
Ccc_XD5_nt_XD5_t1 XD5_nt XD5_t1 1.21e-17
* device instance cc_XD5_nt_XFRT_CKBB r0 *1 0,0
Ccc_XD5_nt_XFRT_CKBB XD5_nt XFRT_CKBB 1.8151e-17
* device instance cc_XD5_nt_XFRT_CLKB r0 *1 0,0
Ccc_XD5_nt_XFRT_CLKB XD5_nt XFRT_CLKB 2.4201e-17
* device instance cc_XD5_nt_XFRT_M r0 *1 0,0
Ccc_XD5_nt_XFRT_M XD5_nt XFRT_M 2.4201e-17
* device instance cc_XD5_nt_XFRT_MB r0 *1 0,0
Ccc_XD5_nt_XFRT_MB XD5_nt XFRT_MB 1.21e-17
* device instance cc_XD5_nt_XFRT_MFB r0 *1 0,0
Ccc_XD5_nt_XFRT_MFB XD5_nt XFRT_MFB 1.21e-17
* device instance cc_XD5_nt_XFRT_S r0 *1 0,0
Ccc_XD5_nt_XFRT_S XD5_nt XFRT_S 1.8151e-17
* device instance cc_XD5_nt_XFRT_SB r0 *1 0,0
Ccc_XD5_nt_XFRT_SB XD5_nt XFRT_SB 1.8151e-17
* device instance cc_XD5_nt_XFRT_SFB r0 *1 0,0
Ccc_XD5_nt_XFRT_SFB XD5_nt XFRT_SFB 1.21e-17
* device instance cc_XD5_nt_ck1 r0 *1 0,0
Ccc_XD5_nt_ck1 XD5_nt ck1 3.0251e-17
* device instance cc_XD5_nt_ck2 r0 *1 0,0
Ccc_XD5_nt_ck2 XD5_nt ck2 3.0251e-17
* device instance cc_XD5_nt_ck3 r0 *1 0,0
Ccc_XD5_nt_ck3 XD5_nt ck3 3.0251e-17
* device instance cc_XD5_nt_ck4 r0 *1 0,0
Ccc_XD5_nt_ck4 XD5_nt ck4 3.0251e-17
* device instance cc_XD5_nt_ck5 r0 *1 0,0
Ccc_XD5_nt_ck5 XD5_nt ck5 3.0251e-17
* device instance cc_XD5_nt_mod0 r0 *1 0,0
Ccc_XD5_nt_mod0 XD5_nt mod0 2.4201e-17
* device instance cc_XD5_nt_mod1 r0 *1 0,0
Ccc_XD5_nt_mod1 XD5_nt mod1 2.4201e-17
* device instance cc_XD5_nt_mod2 r0 *1 0,0
Ccc_XD5_nt_mod2 XD5_nt mod2 2.4201e-17
* device instance cc_XD5_nt_mod3 r0 *1 0,0
Ccc_XD5_nt_mod3 XD5_nt mod3 2.4201e-17
* device instance cc_XD5_nt_mod4 r0 *1 0,0
Ccc_XD5_nt_mod4 XD5_nt mod4 3.0251e-17
* device instance cc_XD5_nt_net1 r0 *1 0,0
Ccc_XD5_nt_net1 XD5_nt net1 1.21e-17
* device instance cc_XD5_t1_XFRT_CKBB r0 *1 0,0
Ccc_XD5_t1_XFRT_CKBB XD5_t1 XFRT_CKBB 1.8151e-17
* device instance cc_XD5_t1_XFRT_CLKB r0 *1 0,0
Ccc_XD5_t1_XFRT_CLKB XD5_t1 XFRT_CLKB 2.4201e-17
* device instance cc_XD5_t1_XFRT_M r0 *1 0,0
Ccc_XD5_t1_XFRT_M XD5_t1 XFRT_M 2.4201e-17
* device instance cc_XD5_t1_XFRT_MB r0 *1 0,0
Ccc_XD5_t1_XFRT_MB XD5_t1 XFRT_MB 1.21e-17
* device instance cc_XD5_t1_XFRT_MFB r0 *1 0,0
Ccc_XD5_t1_XFRT_MFB XD5_t1 XFRT_MFB 1.21e-17
* device instance cc_XD5_t1_XFRT_S r0 *1 0,0
Ccc_XD5_t1_XFRT_S XD5_t1 XFRT_S 1.8151e-17
* device instance cc_XD5_t1_XFRT_SB r0 *1 0,0
Ccc_XD5_t1_XFRT_SB XD5_t1 XFRT_SB 1.8151e-17
* device instance cc_XD5_t1_XFRT_SFB r0 *1 0,0
Ccc_XD5_t1_XFRT_SFB XD5_t1 XFRT_SFB 1.21e-17
* device instance cc_XD5_t1_ck1 r0 *1 0,0
Ccc_XD5_t1_ck1 XD5_t1 ck1 3.0251e-17
* device instance cc_XD5_t1_ck2 r0 *1 0,0
Ccc_XD5_t1_ck2 XD5_t1 ck2 3.0251e-17
* device instance cc_XD5_t1_ck3 r0 *1 0,0
Ccc_XD5_t1_ck3 XD5_t1 ck3 3.0251e-17
* device instance cc_XD5_t1_ck4 r0 *1 0,0
Ccc_XD5_t1_ck4 XD5_t1 ck4 3.0251e-17
* device instance cc_XD5_t1_ck5 r0 *1 0,0
Ccc_XD5_t1_ck5 XD5_t1 ck5 3.0251e-17
* device instance cc_XD5_t1_mod0 r0 *1 0,0
Ccc_XD5_t1_mod0 XD5_t1 mod0 2.4201e-17
* device instance cc_XD5_t1_mod1 r0 *1 0,0
Ccc_XD5_t1_mod1 XD5_t1 mod1 2.4201e-17
* device instance cc_XD5_t1_mod2 r0 *1 0,0
Ccc_XD5_t1_mod2 XD5_t1 mod2 2.4201e-17
* device instance cc_XD5_t1_mod3 r0 *1 0,0
Ccc_XD5_t1_mod3 XD5_t1 mod3 2.4201e-17
* device instance cc_XD5_t1_mod4 r0 *1 0,0
Ccc_XD5_t1_mod4 XD5_t1 mod4 2.4201e-17
* device instance cc_XD5_t1_net1 r0 *1 0,0
Ccc_XD5_t1_net1 XD5_t1 net1 1.21e-17
* device instance cc_XFRT_CKBB_XFRT_CLKB r0 *1 0,0
Ccc_XFRT_CKBB_XFRT_CLKB XFRT_CKBB XFRT_CLKB 3.6302e-17
* device instance cc_XFRT_CKBB_XFRT_M r0 *1 0,0
Ccc_XFRT_CKBB_XFRT_M XFRT_CKBB XFRT_M 4.8402e-17
* device instance cc_XFRT_CKBB_XFRT_MB r0 *1 0,0
Ccc_XFRT_CKBB_XFRT_MB XFRT_CKBB XFRT_MB 2.4201e-17
* device instance cc_XFRT_CKBB_XFRT_MFB r0 *1 0,0
Ccc_XFRT_CKBB_XFRT_MFB XFRT_CKBB XFRT_MFB 2.4201e-17
* device instance cc_XFRT_CKBB_XFRT_S r0 *1 0,0
Ccc_XFRT_CKBB_XFRT_S XFRT_CKBB XFRT_S 3.0251e-17
* device instance cc_XFRT_CKBB_XFRT_SB r0 *1 0,0
Ccc_XFRT_CKBB_XFRT_SB XFRT_CKBB XFRT_SB 3.0251e-17
* device instance cc_XFRT_CKBB_XFRT_SFB r0 *1 0,0
Ccc_XFRT_CKBB_XFRT_SFB XFRT_CKBB XFRT_SFB 1.8151e-17
* device instance cc_XFRT_CKBB_ck1 r0 *1 0,0
Ccc_XFRT_CKBB_ck1 XFRT_CKBB ck1 3.0251e-17
* device instance cc_XFRT_CKBB_ck2 r0 *1 0,0
Ccc_XFRT_CKBB_ck2 XFRT_CKBB ck2 3.0251e-17
* device instance cc_XFRT_CKBB_ck3 r0 *1 0,0
Ccc_XFRT_CKBB_ck3 XFRT_CKBB ck3 3.0251e-17
* device instance cc_XFRT_CKBB_ck4 r0 *1 0,0
Ccc_XFRT_CKBB_ck4 XFRT_CKBB ck4 3.0251e-17
* device instance cc_XFRT_CKBB_ck5 r0 *1 0,0
Ccc_XFRT_CKBB_ck5 XFRT_CKBB ck5 3.0251e-17
* device instance cc_XFRT_CKBB_mod0 r0 *1 0,0
Ccc_XFRT_CKBB_mod0 XFRT_CKBB mod0 2.4201e-17
* device instance cc_XFRT_CKBB_mod1 r0 *1 0,0
Ccc_XFRT_CKBB_mod1 XFRT_CKBB mod1 2.4201e-17
* device instance cc_XFRT_CKBB_mod2 r0 *1 0,0
Ccc_XFRT_CKBB_mod2 XFRT_CKBB mod2 2.4201e-17
* device instance cc_XFRT_CKBB_mod3 r0 *1 0,0
Ccc_XFRT_CKBB_mod3 XFRT_CKBB mod3 2.4201e-17
* device instance cc_XFRT_CKBB_mod4 r0 *1 0,0
Ccc_XFRT_CKBB_mod4 XFRT_CKBB mod4 2.4201e-17
* device instance cc_XFRT_CKBB_net1 r0 *1 0,0
Ccc_XFRT_CKBB_net1 XFRT_CKBB net1 1.21e-17
* device instance cc_XFRT_CLKB_XFRT_M r0 *1 0,0
Ccc_XFRT_CLKB_XFRT_M XFRT_CLKB XFRT_M 4.2352e-17
* device instance cc_XFRT_CLKB_XFRT_MB r0 *1 0,0
Ccc_XFRT_CLKB_XFRT_MB XFRT_CLKB XFRT_MB 2.4201e-17
* device instance cc_XFRT_CLKB_XFRT_MFB r0 *1 0,0
Ccc_XFRT_CLKB_XFRT_MFB XFRT_CLKB XFRT_MFB 2.4201e-17
* device instance cc_XFRT_CLKB_XFRT_S r0 *1 0,0
Ccc_XFRT_CLKB_XFRT_S XFRT_CLKB XFRT_S 1.8151e-17
* device instance cc_XFRT_CLKB_XFRT_SB r0 *1 0,0
Ccc_XFRT_CLKB_XFRT_SB XFRT_CLKB XFRT_SB 1.8151e-17
* device instance cc_XFRT_CLKB_XFRT_SFB r0 *1 0,0
Ccc_XFRT_CLKB_XFRT_SFB XFRT_CLKB XFRT_SFB 1.21e-17
* device instance cc_XFRT_CLKB_ck1 r0 *1 0,0
Ccc_XFRT_CLKB_ck1 XFRT_CLKB ck1 3.0251e-17
* device instance cc_XFRT_CLKB_ck2 r0 *1 0,0
Ccc_XFRT_CLKB_ck2 XFRT_CLKB ck2 3.0251e-17
* device instance cc_XFRT_CLKB_ck3 r0 *1 0,0
Ccc_XFRT_CLKB_ck3 XFRT_CLKB ck3 3.0251e-17
* device instance cc_XFRT_CLKB_ck4 r0 *1 0,0
Ccc_XFRT_CLKB_ck4 XFRT_CLKB ck4 3.0251e-17
* device instance cc_XFRT_CLKB_ck5 r0 *1 0,0
Ccc_XFRT_CLKB_ck5 XFRT_CLKB ck5 3.0251e-17
* device instance cc_XFRT_CLKB_mod0 r0 *1 0,0
Ccc_XFRT_CLKB_mod0 XFRT_CLKB mod0 2.4201e-17
* device instance cc_XFRT_CLKB_mod1 r0 *1 0,0
Ccc_XFRT_CLKB_mod1 XFRT_CLKB mod1 2.4201e-17
* device instance cc_XFRT_CLKB_mod2 r0 *1 0,0
Ccc_XFRT_CLKB_mod2 XFRT_CLKB mod2 2.4201e-17
* device instance cc_XFRT_CLKB_mod3 r0 *1 0,0
Ccc_XFRT_CLKB_mod3 XFRT_CLKB mod3 2.4201e-17
* device instance cc_XFRT_CLKB_mod4 r0 *1 0,0
Ccc_XFRT_CLKB_mod4 XFRT_CLKB mod4 2.4201e-17
* device instance cc_XFRT_CLKB_net1 r0 *1 0,0
Ccc_XFRT_CLKB_net1 XFRT_CLKB net1 1.21e-17
* device instance cc_XFRT_M_XFRT_MB r0 *1 0,0
Ccc_XFRT_M_XFRT_MB XFRT_M XFRT_MB 2.4201e-17
* device instance cc_XFRT_M_XFRT_MFB r0 *1 0,0
Ccc_XFRT_M_XFRT_MFB XFRT_M XFRT_MFB 3.4688e-17
* device instance cc_XFRT_M_XFRT_S r0 *1 0,0
Ccc_XFRT_M_XFRT_S XFRT_M XFRT_S 2.8638e-17
* device instance cc_XFRT_M_XFRT_SB r0 *1 0,0
Ccc_XFRT_M_XFRT_SB XFRT_M XFRT_SB 1.8151e-17
* device instance cc_XFRT_M_XFRT_SFB r0 *1 0,0
Ccc_XFRT_M_XFRT_SFB XFRT_M XFRT_SFB 1.21e-17
* device instance cc_XFRT_M_ck1 r0 *1 0,0
Ccc_XFRT_M_ck1 XFRT_M ck1 3.0251e-17
* device instance cc_XFRT_M_ck2 r0 *1 0,0
Ccc_XFRT_M_ck2 XFRT_M ck2 3.0251e-17
* device instance cc_XFRT_M_ck3 r0 *1 0,0
Ccc_XFRT_M_ck3 XFRT_M ck3 3.0251e-17
* device instance cc_XFRT_M_ck4 r0 *1 0,0
Ccc_XFRT_M_ck4 XFRT_M ck4 3.0251e-17
* device instance cc_XFRT_M_ck5 r0 *1 0,0
Ccc_XFRT_M_ck5 XFRT_M ck5 3.0251e-17
* device instance cc_XFRT_M_mod0 r0 *1 0,0
Ccc_XFRT_M_mod0 XFRT_M mod0 2.4201e-17
* device instance cc_XFRT_M_mod1 r0 *1 0,0
Ccc_XFRT_M_mod1 XFRT_M mod1 2.4201e-17
* device instance cc_XFRT_M_mod2 r0 *1 0,0
Ccc_XFRT_M_mod2 XFRT_M mod2 2.4201e-17
* device instance cc_XFRT_M_mod3 r0 *1 0,0
Ccc_XFRT_M_mod3 XFRT_M mod3 2.4201e-17
* device instance cc_XFRT_M_mod4 r0 *1 0,0
Ccc_XFRT_M_mod4 XFRT_M mod4 2.4201e-17
* device instance cc_XFRT_M_net1 r0 *1 0,0
Ccc_XFRT_M_net1 XFRT_M net1 1.21e-17
* device instance cc_XFRT_MB_XFRT_MFB r0 *1 0,0
Ccc_XFRT_MB_XFRT_MFB XFRT_MB XFRT_MFB 1.21e-17
* device instance cc_XFRT_MB_XFRT_S r0 *1 0,0
Ccc_XFRT_MB_XFRT_S XFRT_MB XFRT_S 1.8151e-17
* device instance cc_XFRT_MB_XFRT_SB r0 *1 0,0
Ccc_XFRT_MB_XFRT_SB XFRT_MB XFRT_SB 1.8151e-17
* device instance cc_XFRT_MB_XFRT_SFB r0 *1 0,0
Ccc_XFRT_MB_XFRT_SFB XFRT_MB XFRT_SFB 1.21e-17
* device instance cc_XFRT_MB_ck1 r0 *1 0,0
Ccc_XFRT_MB_ck1 XFRT_MB ck1 3.0251e-17
* device instance cc_XFRT_MB_ck2 r0 *1 0,0
Ccc_XFRT_MB_ck2 XFRT_MB ck2 3.0251e-17
* device instance cc_XFRT_MB_ck3 r0 *1 0,0
Ccc_XFRT_MB_ck3 XFRT_MB ck3 3.0251e-17
* device instance cc_XFRT_MB_ck4 r0 *1 0,0
Ccc_XFRT_MB_ck4 XFRT_MB ck4 3.0251e-17
* device instance cc_XFRT_MB_ck5 r0 *1 0,0
Ccc_XFRT_MB_ck5 XFRT_MB ck5 3.0251e-17
* device instance cc_XFRT_MB_mod0 r0 *1 0,0
Ccc_XFRT_MB_mod0 XFRT_MB mod0 2.4201e-17
* device instance cc_XFRT_MB_mod1 r0 *1 0,0
Ccc_XFRT_MB_mod1 XFRT_MB mod1 2.4201e-17
* device instance cc_XFRT_MB_mod2 r0 *1 0,0
Ccc_XFRT_MB_mod2 XFRT_MB mod2 2.4201e-17
* device instance cc_XFRT_MB_mod3 r0 *1 0,0
Ccc_XFRT_MB_mod3 XFRT_MB mod3 2.4201e-17
* device instance cc_XFRT_MB_mod4 r0 *1 0,0
Ccc_XFRT_MB_mod4 XFRT_MB mod4 2.4201e-17
* device instance cc_XFRT_MB_net1 r0 *1 0,0
Ccc_XFRT_MB_net1 XFRT_MB net1 1.21e-17
* device instance cc_XFRT_MFB_XFRT_S r0 *1 0,0
Ccc_XFRT_MFB_XFRT_S XFRT_MFB XFRT_S 1.8151e-17
* device instance cc_XFRT_MFB_XFRT_SB r0 *1 0,0
Ccc_XFRT_MFB_XFRT_SB XFRT_MFB XFRT_SB 1.8151e-17
* device instance cc_XFRT_MFB_XFRT_SFB r0 *1 0,0
Ccc_XFRT_MFB_XFRT_SFB XFRT_MFB XFRT_SFB 1.21e-17
* device instance cc_XFRT_MFB_ck1 r0 *1 0,0
Ccc_XFRT_MFB_ck1 XFRT_MFB ck1 3.0251e-17
* device instance cc_XFRT_MFB_ck2 r0 *1 0,0
Ccc_XFRT_MFB_ck2 XFRT_MFB ck2 3.0251e-17
* device instance cc_XFRT_MFB_ck3 r0 *1 0,0
Ccc_XFRT_MFB_ck3 XFRT_MFB ck3 3.0251e-17
* device instance cc_XFRT_MFB_ck4 r0 *1 0,0
Ccc_XFRT_MFB_ck4 XFRT_MFB ck4 3.0251e-17
* device instance cc_XFRT_MFB_ck5 r0 *1 0,0
Ccc_XFRT_MFB_ck5 XFRT_MFB ck5 3.0251e-17
* device instance cc_XFRT_MFB_mod0 r0 *1 0,0
Ccc_XFRT_MFB_mod0 XFRT_MFB mod0 2.4201e-17
* device instance cc_XFRT_MFB_mod1 r0 *1 0,0
Ccc_XFRT_MFB_mod1 XFRT_MFB mod1 2.4201e-17
* device instance cc_XFRT_MFB_mod2 r0 *1 0,0
Ccc_XFRT_MFB_mod2 XFRT_MFB mod2 2.4201e-17
* device instance cc_XFRT_MFB_mod3 r0 *1 0,0
Ccc_XFRT_MFB_mod3 XFRT_MFB mod3 2.4201e-17
* device instance cc_XFRT_MFB_mod4 r0 *1 0,0
Ccc_XFRT_MFB_mod4 XFRT_MFB mod4 2.4201e-17
* device instance cc_XFRT_MFB_net1 r0 *1 0,0
Ccc_XFRT_MFB_net1 XFRT_MFB net1 1.21e-17
* device instance cc_XFRT_S_XFRT_SB r0 *1 0,0
Ccc_XFRT_S_XFRT_SB XFRT_S XFRT_SB 3.0251e-17
* device instance cc_XFRT_S_XFRT_SFB r0 *1 0,0
Ccc_XFRT_S_XFRT_SFB XFRT_S XFRT_SFB 3.4688e-17
* device instance cc_XFRT_S_ck1 r0 *1 0,0
Ccc_XFRT_S_ck1 XFRT_S ck1 3.0251e-17
* device instance cc_XFRT_S_ck2 r0 *1 0,0
Ccc_XFRT_S_ck2 XFRT_S ck2 3.0251e-17
* device instance cc_XFRT_S_ck3 r0 *1 0,0
Ccc_XFRT_S_ck3 XFRT_S ck3 3.0251e-17
* device instance cc_XFRT_S_ck4 r0 *1 0,0
Ccc_XFRT_S_ck4 XFRT_S ck4 3.0251e-17
* device instance cc_XFRT_S_ck5 r0 *1 0,0
Ccc_XFRT_S_ck5 XFRT_S ck5 3.0251e-17
* device instance cc_XFRT_S_mod0 r0 *1 0,0
Ccc_XFRT_S_mod0 XFRT_S mod0 2.4201e-17
* device instance cc_XFRT_S_mod1 r0 *1 0,0
Ccc_XFRT_S_mod1 XFRT_S mod1 2.4201e-17
* device instance cc_XFRT_S_mod2 r0 *1 0,0
Ccc_XFRT_S_mod2 XFRT_S mod2 2.4201e-17
* device instance cc_XFRT_S_mod3 r0 *1 0,0
Ccc_XFRT_S_mod3 XFRT_S mod3 2.4201e-17
* device instance cc_XFRT_S_mod4 r0 *1 0,0
Ccc_XFRT_S_mod4 XFRT_S mod4 2.4201e-17
* device instance cc_XFRT_S_net1 r0 *1 0,0
Ccc_XFRT_S_net1 XFRT_S net1 1.21e-17
* device instance cc_XFRT_SB_XFRT_SFB r0 *1 0,0
Ccc_XFRT_SB_XFRT_SFB XFRT_SB XFRT_SFB 2.4201e-17
* device instance cc_XFRT_SB_ck1 r0 *1 0,0
Ccc_XFRT_SB_ck1 XFRT_SB ck1 3.0251e-17
* device instance cc_XFRT_SB_ck2 r0 *1 0,0
Ccc_XFRT_SB_ck2 XFRT_SB ck2 3.0251e-17
* device instance cc_XFRT_SB_ck3 r0 *1 0,0
Ccc_XFRT_SB_ck3 XFRT_SB ck3 3.0251e-17
* device instance cc_XFRT_SB_ck4 r0 *1 0,0
Ccc_XFRT_SB_ck4 XFRT_SB ck4 3.0251e-17
* device instance cc_XFRT_SB_ck5 r0 *1 0,0
Ccc_XFRT_SB_ck5 XFRT_SB ck5 3.0251e-17
* device instance cc_XFRT_SB_mod0 r0 *1 0,0
Ccc_XFRT_SB_mod0 XFRT_SB mod0 2.4201e-17
* device instance cc_XFRT_SB_mod1 r0 *1 0,0
Ccc_XFRT_SB_mod1 XFRT_SB mod1 2.4201e-17
* device instance cc_XFRT_SB_mod2 r0 *1 0,0
Ccc_XFRT_SB_mod2 XFRT_SB mod2 2.4201e-17
* device instance cc_XFRT_SB_mod3 r0 *1 0,0
Ccc_XFRT_SB_mod3 XFRT_SB mod3 2.4201e-17
* device instance cc_XFRT_SB_mod4 r0 *1 0,0
Ccc_XFRT_SB_mod4 XFRT_SB mod4 2.4201e-17
* device instance cc_XFRT_SB_net1 r0 *1 0,0
Ccc_XFRT_SB_net1 XFRT_SB net1 1.21e-17
* device instance cc_XFRT_SFB_ck1 r0 *1 0,0
Ccc_XFRT_SFB_ck1 XFRT_SFB ck1 3.0251e-17
* device instance cc_XFRT_SFB_ck2 r0 *1 0,0
Ccc_XFRT_SFB_ck2 XFRT_SFB ck2 3.0251e-17
* device instance cc_XFRT_SFB_ck3 r0 *1 0,0
Ccc_XFRT_SFB_ck3 XFRT_SFB ck3 3.0251e-17
* device instance cc_XFRT_SFB_ck4 r0 *1 0,0
Ccc_XFRT_SFB_ck4 XFRT_SFB ck4 3.0251e-17
* device instance cc_XFRT_SFB_ck5 r0 *1 0,0
Ccc_XFRT_SFB_ck5 XFRT_SFB ck5 3.0251e-17
* device instance cc_XFRT_SFB_mod0 r0 *1 0,0
Ccc_XFRT_SFB_mod0 XFRT_SFB mod0 2.4201e-17
* device instance cc_XFRT_SFB_mod1 r0 *1 0,0
Ccc_XFRT_SFB_mod1 XFRT_SFB mod1 2.4201e-17
* device instance cc_XFRT_SFB_mod2 r0 *1 0,0
Ccc_XFRT_SFB_mod2 XFRT_SFB mod2 2.4201e-17
* device instance cc_XFRT_SFB_mod3 r0 *1 0,0
Ccc_XFRT_SFB_mod3 XFRT_SFB mod3 2.4201e-17
* device instance cc_XFRT_SFB_mod4 r0 *1 0,0
Ccc_XFRT_SFB_mod4 XFRT_SFB mod4 2.4201e-17
* device instance cc_XFRT_SFB_net1 r0 *1 0,0
Ccc_XFRT_SFB_net1 XFRT_SFB net1 1.21e-17
* device instance cc_ck1_ck2 r0 *1 0,0
Ccc_ck1_ck2 ck1 ck2 4.8402e-17
* device instance cc_ck1_ck3 r0 *1 0,0
Ccc_ck1_ck3 ck1 ck3 3.0251e-17
* device instance cc_ck1_ck4 r0 *1 0,0
Ccc_ck1_ck4 ck1 ck4 3.0251e-17
* device instance cc_ck1_ck5 r0 *1 0,0
Ccc_ck1_ck5 ck1 ck5 3.0251e-17
* device instance cc_ck1_mod0 r0 *1 0,0
Ccc_ck1_mod0 ck1 mod0 3.6302e-17
* device instance cc_ck1_mod1 r0 *1 0,0
Ccc_ck1_mod1 ck1 mod1 3.6302e-17
* device instance cc_ck1_mod2 r0 *1 0,0
Ccc_ck1_mod2 ck1 mod2 2.4201e-17
* device instance cc_ck1_mod3 r0 *1 0,0
Ccc_ck1_mod3 ck1 mod3 2.4201e-17
* device instance cc_ck1_mod4 r0 *1 0,0
Ccc_ck1_mod4 ck1 mod4 2.4201e-17
* device instance cc_ck1_net1 r0 *1 0,0
Ccc_ck1_net1 ck1 net1 1.8151e-17
* device instance cc_ck2_ck3 r0 *1 0,0
Ccc_ck2_ck3 ck2 ck3 4.8402e-17
* device instance cc_ck2_ck4 r0 *1 0,0
Ccc_ck2_ck4 ck2 ck4 3.0251e-17
* device instance cc_ck2_ck5 r0 *1 0,0
Ccc_ck2_ck5 ck2 ck5 3.0251e-17
* device instance cc_ck2_mod0 r0 *1 0,0
Ccc_ck2_mod0 ck2 mod0 3.0251e-17
* device instance cc_ck2_mod1 r0 *1 0,0
Ccc_ck2_mod1 ck2 mod1 3.6302e-17
* device instance cc_ck2_mod2 r0 *1 0,0
Ccc_ck2_mod2 ck2 mod2 3.6302e-17
* device instance cc_ck2_mod3 r0 *1 0,0
Ccc_ck2_mod3 ck2 mod3 2.4201e-17
* device instance cc_ck2_mod4 r0 *1 0,0
Ccc_ck2_mod4 ck2 mod4 2.4201e-17
* device instance cc_ck2_net1 r0 *1 0,0
Ccc_ck2_net1 ck2 net1 1.21e-17
* device instance cc_ck3_ck4 r0 *1 0,0
Ccc_ck3_ck4 ck3 ck4 4.8402e-17
* device instance cc_ck3_ck5 r0 *1 0,0
Ccc_ck3_ck5 ck3 ck5 3.0251e-17
* device instance cc_ck3_mod0 r0 *1 0,0
Ccc_ck3_mod0 ck3 mod0 2.4201e-17
* device instance cc_ck3_mod1 r0 *1 0,0
Ccc_ck3_mod1 ck3 mod1 3.0251e-17
* device instance cc_ck3_mod2 r0 *1 0,0
Ccc_ck3_mod2 ck3 mod2 3.6302e-17
* device instance cc_ck3_mod3 r0 *1 0,0
Ccc_ck3_mod3 ck3 mod3 3.6302e-17
* device instance cc_ck3_mod4 r0 *1 0,0
Ccc_ck3_mod4 ck3 mod4 2.4201e-17
* device instance cc_ck3_net1 r0 *1 0,0
Ccc_ck3_net1 ck3 net1 1.21e-17
* device instance cc_ck4_ck5 r0 *1 0,0
Ccc_ck4_ck5 ck4 ck5 4.8402e-17
* device instance cc_ck4_mod0 r0 *1 0,0
Ccc_ck4_mod0 ck4 mod0 2.4201e-17
* device instance cc_ck4_mod1 r0 *1 0,0
Ccc_ck4_mod1 ck4 mod1 2.4201e-17
* device instance cc_ck4_mod2 r0 *1 0,0
Ccc_ck4_mod2 ck4 mod2 3.0251e-17
* device instance cc_ck4_mod3 r0 *1 0,0
Ccc_ck4_mod3 ck4 mod3 3.6302e-17
* device instance cc_ck4_mod4 r0 *1 0,0
Ccc_ck4_mod4 ck4 mod4 3.6302e-17
* device instance cc_ck4_net1 r0 *1 0,0
Ccc_ck4_net1 ck4 net1 1.21e-17
* device instance cc_ck5_mod0 r0 *1 0,0
Ccc_ck5_mod0 ck5 mod0 2.4201e-17
* device instance cc_ck5_mod1 r0 *1 0,0
Ccc_ck5_mod1 ck5 mod1 2.4201e-17
* device instance cc_ck5_mod2 r0 *1 0,0
Ccc_ck5_mod2 ck5 mod2 2.4201e-17
* device instance cc_ck5_mod3 r0 *1 0,0
Ccc_ck5_mod3 ck5 mod3 3.0251e-17
* device instance cc_ck5_mod4 r0 *1 0,0
Ccc_ck5_mod4 ck5 mod4 3.6302e-17
* device instance cc_ck5_net1 r0 *1 0,0
Ccc_ck5_net1 ck5 net1 1.21e-17
* device instance cc_mod0_mod1 r0 *1 0,0
Ccc_mod0_mod1 mod0 mod1 3.6302e-17
* device instance cc_mod0_mod2 r0 *1 0,0
Ccc_mod0_mod2 mod0 mod2 2.4201e-17
* device instance cc_mod0_mod3 r0 *1 0,0
Ccc_mod0_mod3 mod0 mod3 2.4201e-17
* device instance cc_mod0_mod4 r0 *1 0,0
Ccc_mod0_mod4 mod0 mod4 2.4201e-17
* device instance cc_mod0_net1 r0 *1 0,0
Ccc_mod0_net1 mod0 net1 2.4201e-17
* device instance cc_mod1_mod2 r0 *1 0,0
Ccc_mod1_mod2 mod1 mod2 3.6302e-17
* device instance cc_mod1_mod3 r0 *1 0,0
Ccc_mod1_mod3 mod1 mod3 2.4201e-17
* device instance cc_mod1_mod4 r0 *1 0,0
Ccc_mod1_mod4 mod1 mod4 2.4201e-17
* device instance cc_mod1_net1 r0 *1 0,0
Ccc_mod1_net1 mod1 net1 1.21e-17
* device instance cc_mod2_mod3 r0 *1 0,0
Ccc_mod2_mod3 mod2 mod3 3.6302e-17
* device instance cc_mod2_mod4 r0 *1 0,0
Ccc_mod2_mod4 mod2 mod4 2.4201e-17
* device instance cc_mod2_net1 r0 *1 0,0
Ccc_mod2_net1 mod2 net1 1.21e-17
* device instance cc_mod3_mod4 r0 *1 0,0
Ccc_mod3_mod4 mod3 mod4 3.6302e-17
* device instance cc_mod3_net1 r0 *1 0,0
Ccc_mod3_net1 mod3 net1 1.21e-17
* device instance cc_mod4_net1 r0 *1 0,0
Ccc_mod4_net1 mod4 net1 1.21e-17
* device instance vsubs_dctie r0 *1 0,0
Rvsubs_dctie vsubs 0 1e+12
.ENDS pll_divider_chain
