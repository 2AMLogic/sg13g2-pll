* extracted by klt extract --deck sg13cmos5l
* parasitic model (--parasitics):
* - capacitance: net-to-ground for every net's own (non-coupled) area/perimeter, plus net-to-net for the vertical-overlap coupling `coupling` describes below -- a coupled net pair gets a direct capacitor between their two hub nodes, not just capacitors to the deck's ground/substrate net
* - coupling: vertical overlap (crossover) unconditionally -- where one net's conductor on an adjacent metal level sits directly over another *distinct* net's conductor, that overlap area is charged between the two nets instead of to ground (issue #760) -- plus lateral (same-layer, sidewall) coupling, but only for a net pair naming one of the caller's declared `--critical-net` nets (issue #976): facing-edge length within that layer's own minimum-spacing lookback is charged between the two nets, *additively* (not deducted from either net's substrate fringe term, unlike the vertical case -- a known simplification). Any same-layer pair with neither side named `--critical-net`, and fringe shielding in general, are still not modelled
* - resistance: single lumped series resistance per net, distributed as a star across that net's device terminals (issue #592) -- not a per-segment, distributed RC ladder, *unless* `--distributed-rc` names this net via `--critical-net` (issue #977, Epic #709 Phase 2b): then the net's terminals are ordered along their approximate physical spread and its total R/C is broken into a chain of per-segment resistors (segment length proportional to inter-terminal distance) with a ground capacitor at each terminal node (proportional to its adjacent segment length/2), instead of one star hub -- still an approximation (terminal position is a device-placement proxy, not true per-segment routing geometry), but a strictly finer-grained one than the single-hub star
* - frequency: quasi-static -- one frequency-independent R and C per net; no skin effect, no distributed transmission-line behavior
.GLOBAL vsubs

* cell pll_divider_chain
* pin CKIN
* pin CKIN_VCO
* pin DIVOUT
* pin FB
* pin P0
* pin P1
* pin P2
* pin P3
* pin P4
* pin P5
* pin VDD_DIV
* pin VSS
* pin XD0.XDFFM.CLKB
* pin XD0.XDFFM.M
* pin XD0.XDFFM.MB
* pin XD0.XDFFM.S
* pin XD0.XDFFM.SB
* pin XD0.XDFFQ.CLKB
* pin XD0.XDFFQ.M
* pin XD0.XDFFQ.MB
* pin XD0.XDFFQ.S
* pin XD0.XDFFQ.SB
* pin XD0.XN2.mid1
* pin XD0.XN3.mid1
* pin XD0.XN3.mid2
* pin XD0.XNOR.midp
* pin XD0.dmodout
* pin XD0.dq
* pin XD0.nm
* pin XD0.nt
* pin XD0.t1
* pin XD1.XDFFM.CLKB
* pin XD1.XDFFM.M
* pin XD1.XDFFM.MB
* pin XD1.XDFFM.S
* pin XD1.XDFFM.SB
* pin XD1.XDFFQ.CLKB
* pin XD1.XDFFQ.M
* pin XD1.XDFFQ.MB
* pin XD1.XDFFQ.S
* pin XD1.XDFFQ.SB
* pin XD1.XN2.mid1
* pin XD1.XN3.mid1
* pin XD1.XN3.mid2
* pin XD1.XNOR.midp
* pin XD1.dmodout
* pin XD1.dq
* pin XD1.nm
* pin XD1.nt
* pin XD1.t1
* pin XD2.XDFFM.CLKB
* pin XD2.XDFFM.M
* pin XD2.XDFFM.MB
* pin XD2.XDFFM.S
* pin XD2.XDFFM.SB
* pin XD2.XDFFQ.CLKB
* pin XD2.XDFFQ.M
* pin XD2.XDFFQ.MB
* pin XD2.XDFFQ.S
* pin XD2.XDFFQ.SB
* pin XD2.XN2.mid1
* pin XD2.XN3.mid1
* pin XD2.XN3.mid2
* pin XD2.XNOR.midp
* pin XD2.dmodout
* pin XD2.dq
* pin XD2.nm
* pin XD2.nt
* pin XD2.t1
* pin XD3.XDFFM.CLKB
* pin XD3.XDFFM.M
* pin XD3.XDFFM.MB
* pin XD3.XDFFM.S
* pin XD3.XDFFM.SB
* pin XD3.XDFFQ.CLKB
* pin XD3.XDFFQ.M
* pin XD3.XDFFQ.MB
* pin XD3.XDFFQ.S
* pin XD3.XDFFQ.SB
* pin XD3.XN2.mid1
* pin XD3.XN3.mid1
* pin XD3.XN3.mid2
* pin XD3.XNOR.midp
* pin XD3.dmodout
* pin XD3.dq
* pin XD3.nm
* pin XD3.nt
* pin XD3.t1
* pin XD4.XDFFM.CLKB
* pin XD4.XDFFM.M
* pin XD4.XDFFM.MB
* pin XD4.XDFFM.S
* pin XD4.XDFFM.SB
* pin XD4.XDFFQ.CLKB
* pin XD4.XDFFQ.M
* pin XD4.XDFFQ.MB
* pin XD4.XDFFQ.S
* pin XD4.XDFFQ.SB
* pin XD4.XN2.mid1
* pin XD4.XN3.mid1
* pin XD4.XN3.mid2
* pin XD4.XNOR.midp
* pin XD4.dmodout
* pin XD4.dq
* pin XD4.nm
* pin XD4.nt
* pin XD4.t1
* pin XD5.XDFFM.CLKB
* pin XD5.XDFFM.M
* pin XD5.XDFFM.MB
* pin XD5.XDFFM.S
* pin XD5.XDFFM.SB
* pin XD5.XDFFQ.CLKB
* pin XD5.XDFFQ.M
* pin XD5.XDFFQ.MB
* pin XD5.XDFFQ.S
* pin XD5.XDFFQ.SB
* pin XD5.XN2.mid1
* pin XD5.XN3.mid1
* pin XD5.XN3.mid2
* pin XD5.XNOR.midp
* pin XD5.dmodout
* pin XD5.dq
* pin XD5.nm
* pin XD5.nt
* pin XD5.t1
* pin XFRT.CLKB
* pin XFRT.M
* pin XFRT.MB
* pin XFRT.S
* pin XFRT.SB
* pin ck1
* pin ck2
* pin ck3
* pin ck4
* pin ck5
* pin mod0
* pin mod1
* pin mod2
* pin mod3
* pin mod4
* pin net1
.SUBCKT pll_divider_chain CKIN CKIN_VCO DIVOUT FB P0 P1 P2 P3 P4 P5 VDD_DIV VSS
+ XD0.XDFFM.CLKB XD0.XDFFM.M XD0.XDFFM.MB XD0.XDFFM.S XD0.XDFFM.SB
+ XD0.XDFFQ.CLKB XD0.XDFFQ.M XD0.XDFFQ.MB XD0.XDFFQ.S XD0.XDFFQ.SB XD0.XN2.mid1
+ XD0.XN3.mid1 XD0.XN3.mid2 XD0.XNOR.midp XD0.dmodout XD0.dq XD0.nm XD0.nt
+ XD0.t1 XD1.XDFFM.CLKB XD1.XDFFM.M XD1.XDFFM.MB XD1.XDFFM.S XD1.XDFFM.SB
+ XD1.XDFFQ.CLKB XD1.XDFFQ.M XD1.XDFFQ.MB XD1.XDFFQ.S XD1.XDFFQ.SB XD1.XN2.mid1
+ XD1.XN3.mid1 XD1.XN3.mid2 XD1.XNOR.midp XD1.dmodout XD1.dq XD1.nm XD1.nt
+ XD1.t1 XD2.XDFFM.CLKB XD2.XDFFM.M XD2.XDFFM.MB XD2.XDFFM.S XD2.XDFFM.SB
+ XD2.XDFFQ.CLKB XD2.XDFFQ.M XD2.XDFFQ.MB XD2.XDFFQ.S XD2.XDFFQ.SB XD2.XN2.mid1
+ XD2.XN3.mid1 XD2.XN3.mid2 XD2.XNOR.midp XD2.dmodout XD2.dq XD2.nm XD2.nt
+ XD2.t1 XD3.XDFFM.CLKB XD3.XDFFM.M XD3.XDFFM.MB XD3.XDFFM.S XD3.XDFFM.SB
+ XD3.XDFFQ.CLKB XD3.XDFFQ.M XD3.XDFFQ.MB XD3.XDFFQ.S XD3.XDFFQ.SB XD3.XN2.mid1
+ XD3.XN3.mid1 XD3.XN3.mid2 XD3.XNOR.midp XD3.dmodout XD3.dq XD3.nm XD3.nt
+ XD3.t1 XD4.XDFFM.CLKB XD4.XDFFM.M XD4.XDFFM.MB XD4.XDFFM.S XD4.XDFFM.SB
+ XD4.XDFFQ.CLKB XD4.XDFFQ.M XD4.XDFFQ.MB XD4.XDFFQ.S XD4.XDFFQ.SB XD4.XN2.mid1
+ XD4.XN3.mid1 XD4.XN3.mid2 XD4.XNOR.midp XD4.dmodout XD4.dq XD4.nm XD4.nt
+ XD4.t1 XD5.XDFFM.CLKB XD5.XDFFM.M XD5.XDFFM.MB XD5.XDFFM.S XD5.XDFFM.SB
+ XD5.XDFFQ.CLKB XD5.XDFFQ.M XD5.XDFFQ.MB XD5.XDFFQ.S XD5.XDFFQ.SB XD5.XN2.mid1
+ XD5.XN3.mid1 XD5.XN3.mid2 XD5.XNOR.midp XD5.dmodout XD5.dq XD5.nm XD5.nt
+ XD5.t1 XFRT.CLKB XFRT.M XFRT.MB XFRT.S XFRT.SB ck1 ck2 ck3 ck4 ck5 mod0 mod1
+ mod2 mod3 mod4 net1
* device instance $1 r0 *1 2.3,3.11 nfet
M$1 XD0.nt__t5 mod0__t4 XD0.XN3.mid1__t0 VSS__t88 nfet L=0.5U W=2U AS=0.8P
+ AD=0.8P PS=4.8U PD=4.8U
* device instance $2 r0 *1 6.26,3.11 nfet
M$2 XD0.XN3.mid1__t1 P0__t1 XD0.XN3.mid2__t1 VSS__t89 nfet L=0.5U W=2U AS=0.8P
+ AD=0.8P PS=4.8U PD=4.8U
* device instance $3 r0 *1 10.22,3.11 nfet
M$3 XD0.XN3.mid2__t0 net1__t2 VSS__t7 VSS__t90 nfet L=0.5U W=2U AS=0.8P AD=0.8P
+ PS=4.8U PD=4.8U
* device instance $4 r0 *1 14.18,3.11 nfet
M$4 XD0.t1__t3 XD0.nt__t4 VSS__t8 VSS__t91 nfet L=0.5U W=2U AS=0.8P AD=0.8P
+ PS=4.8U PD=4.8U
* device instance $5 r0 *1 18.14,3.11 nfet
M$5 XD0.dq__t2 ck1__t9 VSS__t9 VSS__t92 nfet L=0.5U W=2U AS=0.8P AD=0.8P
+ PS=4.8U PD=4.8U
* device instance $6 r0 *1 22.1,3.11 nfet
M$6 XD0.dq__t3 XD0.t1__t2 VSS__t10 VSS__t93 nfet L=0.5U W=2U AS=0.8P AD=0.8P
+ PS=4.8U PD=4.8U
* device instance $7 r0 *1 26.06,3.11 nfet
M$7 XD0.XDFFQ.CLKB__t5 CKIN__t6 VSS__t29 VSS__t94 nfet L=0.5U W=2U AS=0.8P
+ AD=0.8P PS=4.8U PD=4.8U
* device instance $8 r0 *1 30.02,3.11 nfet
M$8 XD0.dq__t4 XD0.XDFFQ.CLKB__t3 XD0.XDFFQ.M__t6 VSS__t95 nfet L=0.5U W=2U
+ AS=0.8P AD=0.8P PS=4.8U PD=4.8U
* device instance $9 r0 *1 33.98,3.11 nfet
M$9 XD0.XDFFQ.MB__t2 XD0.XDFFQ.M__t0 VSS__t36 VSS__t96 nfet L=0.5U W=2U AS=0.8P
+ AD=0.8P PS=4.8U PD=4.8U
* device instance $10 r0 *1 37.94,3.11 nfet
M$10 XD0.XDFFQ.MB__t3 CKIN__t7 XD0.XDFFQ.M__t7 VSS__t97 nfet L=0.5U W=2U
+ AS=0.8P AD=0.8P PS=4.8U PD=4.8U
* device instance $11 r0 *1 41.9,3.11 nfet
M$11 XD0.XDFFQ.M__t5 CKIN__t8 XD0.XDFFQ.S__t4 VSS__t98 nfet L=0.5U W=2U AS=0.8P
+ AD=0.8P PS=4.8U PD=4.8U
* device instance $12 r0 *1 45.86,3.11 nfet
M$12 XD0.XDFFQ.SB__t4 XD0.XDFFQ.S__t3 VSS__t37 VSS__t99 nfet L=0.5U W=2U
+ AS=0.8P AD=0.8P PS=4.8U PD=4.8U
* device instance $13 r0 *1 49.82,3.11 nfet
M$13 XD0.XDFFQ.SB__t5 XD0.XDFFQ.CLKB__t4 XD0.XDFFQ.S__t5 VSS__t100 nfet L=0.5U
+ W=2U AS=0.8P AD=0.8P PS=4.8U PD=4.8U
* device instance $14 r0 *1 53.78,3.11 nfet
M$14 ck1__t17 XD0.XDFFQ.SB__t3 VSS__t38 VSS__t101 nfet L=0.5U W=2U AS=0.8P
+ AD=0.8P PS=4.8U PD=4.8U
* device instance $15 r0 *1 57.74,3.11 nfet
M$15 XD0.nm__t4 mod0__t6 XD0.XN2.mid1__t1 VSS__t102 nfet L=0.5U W=2U AS=0.8P
+ AD=0.8P PS=4.8U PD=4.8U
* device instance $16 r0 *1 61.7,3.11 nfet
M$16 XD0.XN2.mid1__t0 ck1__t16 VSS__t39 VSS__t103 nfet L=0.5U W=2U AS=0.8P
+ AD=0.8P PS=4.8U PD=4.8U
* device instance $17 r0 *1 65.66,3.11 nfet
M$17 XD0.dmodout__t3 XD0.nm__t3 VSS__t44 VSS__t104 nfet L=0.5U W=2U AS=0.8P
+ AD=0.8P PS=4.8U PD=4.8U
* device instance $18 r0 *1 69.62,3.11 nfet
M$18 XD0.XDFFM.CLKB__t5 CKIN__t9 VSS__t40 VSS__t105 nfet L=0.5U W=2U AS=0.8P
+ AD=0.8P PS=4.8U PD=4.8U
* device instance $19 r0 *1 73.58,3.11 nfet
M$19 XD0.dmodout__t2 XD0.XDFFM.CLKB__t3 XD0.XDFFM.M__t6 VSS__t106 nfet L=0.5U
+ W=2U AS=0.8P AD=0.8P PS=4.8U PD=4.8U
* device instance $20 r0 *1 77.54,3.11 nfet
M$20 XD0.XDFFM.MB__t2 XD0.XDFFM.M__t4 VSS__t41 VSS__t107 nfet L=0.5U W=2U
+ AS=0.8P AD=0.8P PS=4.8U PD=4.8U
* device instance $21 r0 *1 81.5,3.11 nfet
M$21 XD0.XDFFM.MB__t3 CKIN__t10 XD0.XDFFM.M__t7 VSS__t108 nfet L=0.5U W=2U
+ AS=0.8P AD=0.8P PS=4.8U PD=4.8U
* device instance $22 r0 *1 85.46,3.11 nfet
M$22 XD0.XDFFM.M__t5 CKIN__t11 XD0.XDFFM.S__t4 VSS__t109 nfet L=0.5U W=2U
+ AS=0.8P AD=0.8P PS=4.8U PD=4.8U
* device instance $23 r0 *1 89.42,3.11 nfet
M$23 XD0.XDFFM.SB__t4 XD0.XDFFM.S__t3 VSS__t42 VSS__t110 nfet L=0.5U W=2U
+ AS=0.8P AD=0.8P PS=4.8U PD=4.8U
* device instance $24 r0 *1 93.38,3.11 nfet
M$24 XD0.XDFFM.SB__t5 XD0.XDFFM.CLKB__t4 XD0.XDFFM.S__t5 VSS__t111 nfet L=0.5U
+ W=2U AS=0.8P AD=0.8P PS=4.8U PD=4.8U
* device instance $25 r0 *1 97.34,3.11 nfet
M$25 net1__t3 XD0.XDFFM.SB__t3 VSS__t43 VSS__t112 nfet L=0.5U W=2U AS=0.8P
+ AD=0.8P PS=4.8U PD=4.8U
* device instance $26 r0 *1 101.3,3.11 nfet
M$26 XD1.nt__t5 mod1__t6 XD1.XN3.mid1__t1 VSS__t113 nfet L=0.5U W=2U AS=0.8P
+ AD=0.8P PS=4.8U PD=4.8U
* device instance $27 r0 *1 105.26,3.11 nfet
M$27 XD1.XN3.mid1__t0 P1__t1 XD1.XN3.mid2__t1 VSS__t114 nfet L=0.5U W=2U
+ AS=0.8P AD=0.8P PS=4.8U PD=4.8U
* device instance $28 r0 *1 109.22,3.11 nfet
M$28 XD1.XN3.mid2__t0 mod0__t5 VSS__t23 VSS__t115 nfet L=0.5U W=2U AS=0.8P
+ AD=0.8P PS=4.8U PD=4.8U
* device instance $29 r0 *1 113.18,3.11 nfet
M$29 XD1.t1__t3 XD1.nt__t4 VSS__t24 VSS__t116 nfet L=0.5U W=2U AS=0.8P AD=0.8P
+ PS=4.8U PD=4.8U
* device instance $30 r0 *1 117.14,3.11 nfet
M$30 XD1.dq__t2 ck2__t9 VSS__t25 VSS__t117 nfet L=0.5U W=2U AS=0.8P AD=0.8P
+ PS=4.8U PD=4.8U
* device instance $31 r0 *1 121.1,3.11 nfet
M$31 XD1.dq__t3 XD1.t1__t2 VSS__t26 VSS__t118 nfet L=0.5U W=2U AS=0.8P AD=0.8P
+ PS=4.8U PD=4.8U
* device instance $32 r0 *1 125.06,3.11 nfet
M$32 XD1.XDFFQ.CLKB__t5 ck1__t11 VSS__t27 VSS__t119 nfet L=0.5U W=2U AS=0.8P
+ AD=0.8P PS=4.8U PD=4.8U
* device instance $33 r0 *1 129.02,3.11 nfet
M$33 XD1.dq__t4 XD1.XDFFQ.CLKB__t3 XD1.XDFFQ.M__t6 VSS__t120 nfet L=0.5U W=2U
+ AS=0.8P AD=0.8P PS=4.8U PD=4.8U
* device instance $34 r0 *1 132.98,3.11 nfet
M$34 XD1.XDFFQ.MB__t2 XD1.XDFFQ.M__t4 VSS__t28 VSS__t121 nfet L=0.5U W=2U
+ AS=0.8P AD=0.8P PS=4.8U PD=4.8U
* device instance $35 r0 *1 136.94,3.11 nfet
M$35 XD1.XDFFQ.MB__t3 ck1__t12 XD1.XDFFQ.M__t7 VSS__t122 nfet L=0.5U W=2U
+ AS=0.8P AD=0.8P PS=4.8U PD=4.8U
* device instance $36 r0 *1 140.9,3.11 nfet
M$36 XD1.XDFFQ.M__t5 ck1__t13 XD1.XDFFQ.S__t4 VSS__t123 nfet L=0.5U W=2U
+ AS=0.8P AD=0.8P PS=4.8U PD=4.8U
* device instance $37 r0 *1 144.86,3.11 nfet
M$37 XD1.XDFFQ.SB__t5 XD1.XDFFQ.S__t3 VSS__t35 VSS__t124 nfet L=0.5U W=2U
+ AS=0.8P AD=0.8P PS=4.8U PD=4.8U
* device instance $38 r0 *1 148.82,3.11 nfet
M$38 XD1.XDFFQ.SB__t4 XD1.XDFFQ.CLKB__t4 XD1.XDFFQ.S__t5 VSS__t125 nfet L=0.5U
+ W=2U AS=0.8P AD=0.8P PS=4.8U PD=4.8U
* device instance $39 r0 *1 152.78,3.11 nfet
M$39 ck2__t17 XD1.XDFFQ.SB__t3 VSS__t30 VSS__t126 nfet L=0.5U W=2U AS=0.8P
+ AD=0.8P PS=4.8U PD=4.8U
* device instance $40 r0 *1 156.74,3.11 nfet
M$40 XD1.nm__t4 mod1__t5 XD1.XN2.mid1__t1 VSS__t127 nfet L=0.5U W=2U AS=0.8P
+ AD=0.8P PS=4.8U PD=4.8U
* device instance $41 r0 *1 160.7,3.11 nfet
M$41 XD1.XN2.mid1__t0 ck2__t10 VSS__t31 VSS__t128 nfet L=0.5U W=2U AS=0.8P
+ AD=0.8P PS=4.8U PD=4.8U
* device instance $42 r0 *1 164.66,3.11 nfet
M$42 XD1.dmodout__t2 XD1.nm__t3 VSS__t32 VSS__t129 nfet L=0.5U W=2U AS=0.8P
+ AD=0.8P PS=4.8U PD=4.8U
* device instance $43 r0 *1 168.62,3.11 nfet
M$43 XD1.XDFFM.CLKB__t5 ck1__t14 VSS__t33 VSS__t130 nfet L=0.5U W=2U AS=0.8P
+ AD=0.8P PS=4.8U PD=4.8U
* device instance $44 r0 *1 172.58,3.11 nfet
M$44 XD1.dmodout__t3 XD1.XDFFM.CLKB__t4 XD1.XDFFM.M__t6 VSS__t131 nfet L=0.5U
+ W=2U AS=0.8P AD=0.8P PS=4.8U PD=4.8U
* device instance $45 r0 *1 176.54,3.11 nfet
M$45 XD1.XDFFM.MB__t2 XD1.XDFFM.M__t4 VSS__t34 VSS__t132 nfet L=0.5U W=2U
+ AS=0.8P AD=0.8P PS=4.8U PD=4.8U
* device instance $46 r0 *1 180.5,3.11 nfet
M$46 XD1.XDFFM.MB__t3 ck1__t15 XD1.XDFFM.M__t7 VSS__t133 nfet L=0.5U W=2U
+ AS=0.8P AD=0.8P PS=4.8U PD=4.8U
* device instance $47 r0 *1 184.46,3.11 nfet
M$47 XD1.XDFFM.M__t5 ck1__t10 XD1.XDFFM.S__t5 VSS__t134 nfet L=0.5U W=2U
+ AS=0.8P AD=0.8P PS=4.8U PD=4.8U
* device instance $48 r0 *1 188.42,3.11 nfet
M$48 XD1.XDFFM.SB__t4 XD1.XDFFM.S__t3 VSS__t5 VSS__t135 nfet L=0.5U W=2U
+ AS=0.8P AD=0.8P PS=4.8U PD=4.8U
* device instance $49 r0 *1 192.38,3.11 nfet
M$49 XD1.XDFFM.SB__t5 XD1.XDFFM.CLKB__t3 XD1.XDFFM.S__t4 VSS__t136 nfet L=0.5U
+ W=2U AS=0.8P AD=0.8P PS=4.8U PD=4.8U
* device instance $50 r0 *1 196.34,3.11 nfet
M$50 mod0__t7 XD1.XDFFM.SB__t3 VSS__t6 VSS__t137 nfet L=0.5U W=2U AS=0.8P
+ AD=0.8P PS=4.8U PD=4.8U
* device instance $51 r0 *1 200.3,3.11 nfet
M$51 XD2.nt__t5 mod2__t4 XD2.XN3.mid1__t1 VSS__t138 nfet L=0.5U W=2U AS=0.8P
+ AD=0.8P PS=4.8U PD=4.8U
* device instance $52 r0 *1 204.26,3.11 nfet
M$52 XD2.XN3.mid1__t0 P2__t1 XD2.XN3.mid2__t1 VSS__t139 nfet L=0.5U W=2U
+ AS=0.8P AD=0.8P PS=4.8U PD=4.8U
* device instance $53 r0 *1 208.22,3.11 nfet
M$53 XD2.XN3.mid2__t0 mod1__t4 VSS__t2 VSS__t140 nfet L=0.5U W=2U AS=0.8P
+ AD=0.8P PS=4.8U PD=4.8U
* device instance $54 r0 *1 212.18,3.11 nfet
M$54 XD2.t1__t3 XD2.nt__t4 VSS__t3 VSS__t141 nfet L=0.5U W=2U AS=0.8P AD=0.8P
+ PS=4.8U PD=4.8U
* device instance $55 r0 *1 216.14,3.11 nfet
M$55 XD2.dq__t2 ck3__t10 VSS__t4 VSS__t142 nfet L=0.5U W=2U AS=0.8P AD=0.8P
+ PS=4.8U PD=4.8U
* device instance $56 r0 *1 220.1,3.11 nfet
M$56 XD2.dq__t3 XD2.t1__t2 VSS__t68 VSS__t143 nfet L=0.5U W=2U AS=0.8P AD=0.8P
+ PS=4.8U PD=4.8U
* device instance $57 r0 *1 224.06,3.11 nfet
M$57 XD2.XDFFQ.CLKB__t5 ck2__t12 VSS__t69 VSS__t144 nfet L=0.5U W=2U AS=0.8P
+ AD=0.8P PS=4.8U PD=4.8U
* device instance $58 r0 *1 228.02,3.11 nfet
M$58 XD2.dq__t4 XD2.XDFFQ.CLKB__t3 XD2.XDFFQ.M__t6 VSS__t145 nfet L=0.5U W=2U
+ AS=0.8P AD=0.8P PS=4.8U PD=4.8U
* device instance $59 r0 *1 231.98,3.11 nfet
M$59 XD2.XDFFQ.MB__t2 XD2.XDFFQ.M__t4 VSS__t70 VSS__t146 nfet L=0.5U W=2U
+ AS=0.8P AD=0.8P PS=4.8U PD=4.8U
* device instance $60 r0 *1 235.94,3.11 nfet
M$60 XD2.XDFFQ.MB__t3 ck2__t13 XD2.XDFFQ.M__t7 VSS__t147 nfet L=0.5U W=2U
+ AS=0.8P AD=0.8P PS=4.8U PD=4.8U
* device instance $61 r0 *1 239.9,3.11 nfet
M$61 XD2.XDFFQ.M__t5 ck2__t14 XD2.XDFFQ.S__t4 VSS__t148 nfet L=0.5U W=2U
+ AS=0.8P AD=0.8P PS=4.8U PD=4.8U
* device instance $62 r0 *1 243.86,3.11 nfet
M$62 XD2.XDFFQ.SB__t5 XD2.XDFFQ.S__t3 VSS__t76 VSS__t149 nfet L=0.5U W=2U
+ AS=0.8P AD=0.8P PS=4.8U PD=4.8U
* device instance $63 r0 *1 247.82,3.11 nfet
M$63 XD2.XDFFQ.SB__t4 XD2.XDFFQ.CLKB__t4 XD2.XDFFQ.S__t5 VSS__t150 nfet L=0.5U
+ W=2U AS=0.8P AD=0.8P PS=4.8U PD=4.8U
* device instance $64 r0 *1 251.78,3.11 nfet
M$64 ck3__t17 XD2.XDFFQ.SB__t3 VSS__t71 VSS__t151 nfet L=0.5U W=2U AS=0.8P
+ AD=0.8P PS=4.8U PD=4.8U
* device instance $65 r0 *1 255.74,3.11 nfet
M$65 XD2.nm__t4 mod2__t6 XD2.XN2.mid1__t1 VSS__t152 nfet L=0.5U W=2U AS=0.8P
+ AD=0.8P PS=4.8U PD=4.8U
* device instance $66 r0 *1 259.7,3.11 nfet
M$66 XD2.XN2.mid1__t0 ck3__t14 VSS__t72 VSS__t153 nfet L=0.5U W=2U AS=0.8P
+ AD=0.8P PS=4.8U PD=4.8U
* device instance $67 r0 *1 263.66,3.11 nfet
M$67 XD2.dmodout__t2 XD2.nm__t3 VSS__t73 VSS__t154 nfet L=0.5U W=2U AS=0.8P
+ AD=0.8P PS=4.8U PD=4.8U
* device instance $68 r0 *1 267.62,3.11 nfet
M$68 XD2.XDFFM.CLKB__t5 ck2__t15 VSS__t74 VSS__t155 nfet L=0.5U W=2U AS=0.8P
+ AD=0.8P PS=4.8U PD=4.8U
* device instance $69 r0 *1 271.58,3.11 nfet
M$69 XD2.dmodout__t3 XD2.XDFFM.CLKB__t4 XD2.XDFFM.M__t6 VSS__t156 nfet L=0.5U
+ W=2U AS=0.8P AD=0.8P PS=4.8U PD=4.8U
* device instance $70 r0 *1 275.54,3.11 nfet
M$70 XD2.XDFFM.MB__t2 XD2.XDFFM.M__t4 VSS__t75 VSS__t157 nfet L=0.5U W=2U
+ AS=0.8P AD=0.8P PS=4.8U PD=4.8U
* device instance $71 r0 *1 279.5,3.11 nfet
M$71 XD2.XDFFM.MB__t3 ck2__t16 XD2.XDFFM.M__t7 VSS__t158 nfet L=0.5U W=2U
+ AS=0.8P AD=0.8P PS=4.8U PD=4.8U
* device instance $72 r0 *1 283.46,3.11 nfet
M$72 XD2.XDFFM.M__t5 ck2__t11 XD2.XDFFM.S__t5 VSS__t159 nfet L=0.5U W=2U
+ AS=0.8P AD=0.8P PS=4.8U PD=4.8U
* device instance $73 r0 *1 287.42,3.11 nfet
M$73 XD2.XDFFM.SB__t4 XD2.XDFFM.S__t3 VSS__t11 VSS__t160 nfet L=0.5U W=2U
+ AS=0.8P AD=0.8P PS=4.8U PD=4.8U
* device instance $74 r0 *1 291.38,3.11 nfet
M$74 XD2.XDFFM.SB__t5 XD2.XDFFM.CLKB__t3 XD2.XDFFM.S__t4 VSS__t161 nfet L=0.5U
+ W=2U AS=0.8P AD=0.8P PS=4.8U PD=4.8U
* device instance $75 r0 *1 295.34,3.11 nfet
M$75 mod1__t7 XD2.XDFFM.SB__t3 VSS__t12 VSS__t162 nfet L=0.5U W=2U AS=0.8P
+ AD=0.8P PS=4.8U PD=4.8U
* device instance $76 r0 *1 299.3,3.11 nfet
M$76 XD3.nt__t5 mod3__t4 XD3.XN3.mid1__t1 VSS__t163 nfet L=0.5U W=2U AS=0.8P
+ AD=0.8P PS=4.8U PD=4.8U
* device instance $77 r0 *1 303.26,3.11 nfet
M$77 XD3.XN3.mid1__t0 P3__t1 XD3.XN3.mid2__t1 VSS__t164 nfet L=0.5U W=2U
+ AS=0.8P AD=0.8P PS=4.8U PD=4.8U
* device instance $78 r0 *1 307.22,3.11 nfet
M$78 XD3.XN3.mid2__t0 mod2__t5 VSS__t13 VSS__t165 nfet L=0.5U W=2U AS=0.8P
+ AD=0.8P PS=4.8U PD=4.8U
* device instance $79 r0 *1 311.18,3.11 nfet
M$79 XD3.t1__t3 XD3.nt__t4 VSS__t14 VSS__t166 nfet L=0.5U W=2U AS=0.8P AD=0.8P
+ PS=4.8U PD=4.8U
* device instance $80 r0 *1 315.14,3.11 nfet
M$80 XD3.dq__t2 ck4__t9 VSS__t15 VSS__t167 nfet L=0.5U W=2U AS=0.8P AD=0.8P
+ PS=4.8U PD=4.8U
* device instance $81 r0 *1 319.1,3.11 nfet
M$81 XD3.dq__t3 XD3.t1__t2 VSS__t16 VSS__t168 nfet L=0.5U W=2U AS=0.8P AD=0.8P
+ PS=4.8U PD=4.8U
* device instance $82 r0 *1 323.06,3.11 nfet
M$82 XD3.XDFFQ.CLKB__t5 ck3__t13 VSS__t22 VSS__t169 nfet L=0.5U W=2U AS=0.8P
+ AD=0.8P PS=4.8U PD=4.8U
* device instance $83 r0 *1 327.02,3.11 nfet
M$83 XD3.dq__t4 XD3.XDFFQ.CLKB__t3 XD3.XDFFQ.M__t6 VSS__t170 nfet L=0.5U W=2U
+ AS=0.8P AD=0.8P PS=4.8U PD=4.8U
* device instance $84 r0 *1 330.98,3.11 nfet
M$84 XD3.XDFFQ.MB__t2 XD3.XDFFQ.M__t4 VSS__t18 VSS__t171 nfet L=0.5U W=2U
+ AS=0.8P AD=0.8P PS=4.8U PD=4.8U
* device instance $85 r0 *1 334.94,3.11 nfet
M$85 XD3.XDFFQ.MB__t3 ck3__t11 XD3.XDFFQ.M__t7 VSS__t172 nfet L=0.5U W=2U
+ AS=0.8P AD=0.8P PS=4.8U PD=4.8U
* device instance $86 r0 *1 338.9,3.11 nfet
M$86 XD3.XDFFQ.M__t5 ck3__t12 XD3.XDFFQ.S__t4 VSS__t173 nfet L=0.5U W=2U
+ AS=0.8P AD=0.8P PS=4.8U PD=4.8U
* device instance $87 r0 *1 342.86,3.11 nfet
M$87 XD3.XDFFQ.SB__t4 XD3.XDFFQ.S__t3 VSS__t19 VSS__t174 nfet L=0.5U W=2U
+ AS=0.8P AD=0.8P PS=4.8U PD=4.8U
* device instance $88 r0 *1 346.82,3.11 nfet
M$88 XD3.XDFFQ.SB__t5 XD3.XDFFQ.CLKB__t4 XD3.XDFFQ.S__t5 VSS__t175 nfet L=0.5U
+ W=2U AS=0.8P AD=0.8P PS=4.8U PD=4.8U
* device instance $89 r0 *1 350.78,3.11 nfet
M$89 ck4__t17 XD3.XDFFQ.SB__t3 VSS__t20 VSS__t176 nfet L=0.5U W=2U AS=0.8P
+ AD=0.8P PS=4.8U PD=4.8U
* device instance $90 r0 *1 354.74,3.11 nfet
M$90 XD3.nm__t4 mod3__t5 XD3.XN2.mid1__t1 VSS__t177 nfet L=0.5U W=2U AS=0.8P
+ AD=0.8P PS=4.8U PD=4.8U
* device instance $91 r0 *1 358.7,3.11 nfet
M$91 XD3.XN2.mid1__t0 ck4__t10 VSS__t21 VSS__t178 nfet L=0.5U W=2U AS=0.8P
+ AD=0.8P PS=4.8U PD=4.8U
* device instance $92 r0 *1 362.66,3.11 nfet
M$92 XD3.dmodout__t3 XD3.nm__t3 VSS__t17 VSS__t179 nfet L=0.5U W=2U AS=0.8P
+ AD=0.8P PS=4.8U PD=4.8U
* device instance $93 r0 *1 366.62,3.11 nfet
M$93 XD3.XDFFM.CLKB__t5 ck3__t9 VSS__t0 VSS__t180 nfet L=0.5U W=2U AS=0.8P
+ AD=0.8P PS=4.8U PD=4.8U
* device instance $94 r0 *1 370.58,3.11 nfet
M$94 XD3.dmodout__t2 XD3.XDFFM.CLKB__t3 XD3.XDFFM.M__t6 VSS__t181 nfet L=0.5U
+ W=2U AS=0.8P AD=0.8P PS=4.8U PD=4.8U
* device instance $95 r0 *1 374.54,3.11 nfet
M$95 XD3.XDFFM.MB__t2 XD3.XDFFM.M__t4 VSS__t1 VSS__t182 nfet L=0.5U W=2U
+ AS=0.8P AD=0.8P PS=4.8U PD=4.8U
* device instance $96 r0 *1 378.5,3.11 nfet
M$96 XD3.XDFFM.MB__t3 ck3__t16 XD3.XDFFM.M__t7 VSS__t183 nfet L=0.5U W=2U
+ AS=0.8P AD=0.8P PS=4.8U PD=4.8U
* device instance $97 r0 *1 382.46,3.11 nfet
M$97 XD3.XDFFM.M__t5 ck3__t15 XD3.XDFFM.S__t4 VSS__t184 nfet L=0.5U W=2U
+ AS=0.8P AD=0.8P PS=4.8U PD=4.8U
* device instance $98 r0 *1 386.42,3.11 nfet
M$98 XD3.XDFFM.SB__t4 XD3.XDFFM.S__t3 VSS__t83 VSS__t185 nfet L=0.5U W=2U
+ AS=0.8P AD=0.8P PS=4.8U PD=4.8U
* device instance $99 r0 *1 390.38,3.11 nfet
M$99 XD3.XDFFM.SB__t5 XD3.XDFFM.CLKB__t4 XD3.XDFFM.S__t5 VSS__t186 nfet L=0.5U
+ W=2U AS=0.8P AD=0.8P PS=4.8U PD=4.8U
* device instance $100 r0 *1 394.34,3.11 nfet
M$100 mod2__t7 XD3.XDFFM.SB__t3 VSS__t84 VSS__t187 nfet L=0.5U W=2U AS=0.8P
+ AD=0.8P PS=4.8U PD=4.8U
* device instance $101 r0 *1 398.3,3.11 nfet
M$101 XD4.nt__t5 mod4__t6 XD4.XN3.mid1__t1 VSS__t188 nfet L=0.5U W=2U AS=0.8P
+ AD=0.8P PS=4.8U PD=4.8U
* device instance $102 r0 *1 402.26,3.11 nfet
M$102 XD4.XN3.mid1__t0 P4__t1 XD4.XN3.mid2__t1 VSS__t189 nfet L=0.5U W=2U
+ AS=0.8P AD=0.8P PS=4.8U PD=4.8U
* device instance $103 r0 *1 406.22,3.11 nfet
M$103 XD4.XN3.mid2__t0 mod3__t6 VSS__t85 VSS__t190 nfet L=0.5U W=2U AS=0.8P
+ AD=0.8P PS=4.8U PD=4.8U
* device instance $104 r0 *1 410.18,3.11 nfet
M$104 XD4.t1__t3 XD4.nt__t4 VSS__t86 VSS__t191 nfet L=0.5U W=2U AS=0.8P AD=0.8P
+ PS=4.8U PD=4.8U
* device instance $105 r0 *1 414.14,3.11 nfet
M$105 XD4.dq__t4 ck5__t16 VSS__t87 VSS__t192 nfet L=0.5U W=2U AS=0.8P AD=0.8P
+ PS=4.8U PD=4.8U
* device instance $106 r0 *1 418.1,3.11 nfet
M$106 XD4.dq__t3 XD4.t1__t2 VSS__t82 VSS__t193 nfet L=0.5U W=2U AS=0.8P AD=0.8P
+ PS=4.8U PD=4.8U
* device instance $107 r0 *1 422.06,3.11 nfet
M$107 XD4.XDFFQ.CLKB__t5 ck4__t16 VSS__t66 VSS__t194 nfet L=0.5U W=2U AS=0.8P
+ AD=0.8P PS=4.8U PD=4.8U
* device instance $108 r0 *1 426.02,3.11 nfet
M$108 XD4.dq__t2 XD4.XDFFQ.CLKB__t4 XD4.XDFFQ.M__t7 VSS__t195 nfet L=0.5U W=2U
+ AS=0.8P AD=0.8P PS=4.8U PD=4.8U
* device instance $109 r0 *1 429.98,3.11 nfet
M$109 XD4.XDFFQ.MB__t3 XD4.XDFFQ.M__t4 VSS__t67 VSS__t196 nfet L=0.5U W=2U
+ AS=0.8P AD=0.8P PS=4.8U PD=4.8U
* device instance $110 r0 *1 433.94,3.11 nfet
M$110 XD4.XDFFQ.MB__t2 ck4__t11 XD4.XDFFQ.M__t6 VSS__t197 nfet L=0.5U W=2U
+ AS=0.8P AD=0.8P PS=4.8U PD=4.8U
* device instance $111 r0 *1 437.9,3.11 nfet
M$111 XD4.XDFFQ.M__t5 ck4__t12 XD4.XDFFQ.S__t4 VSS__t198 nfet L=0.5U W=2U
+ AS=0.8P AD=0.8P PS=4.8U PD=4.8U
* device instance $112 r0 *1 441.86,3.11 nfet
M$112 XD4.XDFFQ.SB__t4 XD4.XDFFQ.S__t3 VSS__t55 VSS__t199 nfet L=0.5U W=2U
+ AS=0.8P AD=0.8P PS=4.8U PD=4.8U
* device instance $113 r0 *1 445.82,3.11 nfet
M$113 XD4.XDFFQ.SB__t5 XD4.XDFFQ.CLKB__t3 XD4.XDFFQ.S__t5 VSS__t200 nfet L=0.5U
+ W=2U AS=0.8P AD=0.8P PS=4.8U PD=4.8U
* device instance $114 r0 *1 449.78,3.11 nfet
M$114 ck5__t17 XD4.XDFFQ.SB__t3 VSS__t56 VSS__t201 nfet L=0.5U W=2U AS=0.8P
+ AD=0.8P PS=4.8U PD=4.8U
* device instance $115 r0 *1 453.74,3.11 nfet
M$115 XD4.nm__t4 mod4__t4 XD4.XN2.mid1__t1 VSS__t202 nfet L=0.5U W=2U AS=0.8P
+ AD=0.8P PS=4.8U PD=4.8U
* device instance $116 r0 *1 457.7,3.11 nfet
M$116 XD4.XN2.mid1__t0 ck5__t15 VSS__t57 VSS__t203 nfet L=0.5U W=2U AS=0.8P
+ AD=0.8P PS=4.8U PD=4.8U
* device instance $117 r0 *1 461.66,3.11 nfet
M$117 XD4.dmodout__t2 XD4.nm__t3 VSS__t58 VSS__t204 nfet L=0.5U W=2U AS=0.8P
+ AD=0.8P PS=4.8U PD=4.8U
* device instance $118 r0 *1 465.62,3.11 nfet
M$118 XD4.XDFFM.CLKB__t5 ck4__t13 VSS__t59 VSS__t205 nfet L=0.5U W=2U AS=0.8P
+ AD=0.8P PS=4.8U PD=4.8U
* device instance $119 r0 *1 469.58,3.11 nfet
M$119 XD4.dmodout__t3 XD4.XDFFM.CLKB__t3 XD4.XDFFM.M__t6 VSS__t206 nfet L=0.5U
+ W=2U AS=0.8P AD=0.8P PS=4.8U PD=4.8U
* device instance $120 r0 *1 473.54,3.11 nfet
M$120 XD4.XDFFM.MB__t3 XD4.XDFFM.M__t4 VSS__t65 VSS__t207 nfet L=0.5U W=2U
+ AS=0.8P AD=0.8P PS=4.8U PD=4.8U
* device instance $121 r0 *1 477.5,3.11 nfet
M$121 XD4.XDFFM.MB__t2 ck4__t14 XD4.XDFFM.M__t7 VSS__t208 nfet L=0.5U W=2U
+ AS=0.8P AD=0.8P PS=4.8U PD=4.8U
* device instance $122 r0 *1 481.46,3.11 nfet
M$122 XD4.XDFFM.M__t5 ck4__t15 XD4.XDFFM.S__t4 VSS__t209 nfet L=0.5U W=2U
+ AS=0.8P AD=0.8P PS=4.8U PD=4.8U
* device instance $123 r0 *1 485.42,3.11 nfet
M$123 XD4.XDFFM.SB__t4 XD4.XDFFM.S__t3 VSS__t61 VSS__t210 nfet L=0.5U W=2U
+ AS=0.8P AD=0.8P PS=4.8U PD=4.8U
* device instance $124 r0 *1 489.38,3.11 nfet
M$124 XD4.XDFFM.SB__t5 XD4.XDFFM.CLKB__t4 XD4.XDFFM.S__t5 VSS__t211 nfet L=0.5U
+ W=2U AS=0.8P AD=0.8P PS=4.8U PD=4.8U
* device instance $125 r0 *1 493.34,3.11 nfet
M$125 mod3__t7 XD4.XDFFM.SB__t3 VSS__t62 VSS__t212 nfet L=0.5U W=2U AS=0.8P
+ AD=0.8P PS=4.8U PD=4.8U
* device instance $126 r0 *1 497.3,3.11 nfet
M$126 XD5.nt__t5 VDD_DIV__t261 XD5.XN3.mid1__t1 VSS__t213 nfet L=0.5U W=2U
+ AS=0.8P AD=0.8P PS=4.8U PD=4.8U
* device instance $127 r0 *1 501.26,3.11 nfet
M$127 XD5.XN3.mid1__t0 P5__t1 XD5.XN3.mid2__t1 VSS__t214 nfet L=0.5U W=2U
+ AS=0.8P AD=0.8P PS=4.8U PD=4.8U
* device instance $128 r0 *1 505.22,3.11 nfet
M$128 XD5.XN3.mid2__t0 mod4__t5 VSS__t63 VSS__t215 nfet L=0.5U W=2U AS=0.8P
+ AD=0.8P PS=4.8U PD=4.8U
* device instance $129 r0 *1 509.18,3.11 nfet
M$129 XD5.t1__t3 XD5.nt__t4 VSS__t64 VSS__t216 nfet L=0.5U W=2U AS=0.8P AD=0.8P
+ PS=4.8U PD=4.8U
* device instance $130 r0 *1 513.14,3.11 nfet
M$130 XD5.dq__t4 DIVOUT__t5 VSS__t60 VSS__t217 nfet L=0.5U W=2U AS=0.8P AD=0.8P
+ PS=4.8U PD=4.8U
* device instance $131 r0 *1 517.1,3.11 nfet
M$131 XD5.dq__t2 XD5.t1__t2 VSS__t45 VSS__t218 nfet L=0.5U W=2U AS=0.8P AD=0.8P
+ PS=4.8U PD=4.8U
* device instance $132 r0 *1 521.06,3.11 nfet
M$132 XD5.XDFFQ.CLKB__t5 ck5__t9 VSS__t46 VSS__t219 nfet L=0.5U W=2U AS=0.8P
+ AD=0.8P PS=4.8U PD=4.8U
* device instance $133 r0 *1 525.02,3.11 nfet
M$133 XD5.dq__t3 XD5.XDFFQ.CLKB__t3 XD5.XDFFQ.M__t6 VSS__t220 nfet L=0.5U W=2U
+ AS=0.8P AD=0.8P PS=4.8U PD=4.8U
* device instance $134 r0 *1 528.98,3.11 nfet
M$134 XD5.XDFFQ.MB__t2 XD5.XDFFQ.M__t4 VSS__t47 VSS__t221 nfet L=0.5U W=2U
+ AS=0.8P AD=0.8P PS=4.8U PD=4.8U
* device instance $135 r0 *1 532.94,3.11 nfet
M$135 XD5.XDFFQ.MB__t3 ck5__t10 XD5.XDFFQ.M__t7 VSS__t222 nfet L=0.5U W=2U
+ AS=0.8P AD=0.8P PS=4.8U PD=4.8U
* device instance $136 r0 *1 536.9,3.11 nfet
M$136 XD5.XDFFQ.M__t5 ck5__t11 XD5.XDFFQ.S__t4 VSS__t223 nfet L=0.5U W=2U
+ AS=0.8P AD=0.8P PS=4.8U PD=4.8U
* device instance $137 r0 *1 540.86,3.11 nfet
M$137 XD5.XDFFQ.SB__t4 XD5.XDFFQ.S__t3 VSS__t48 VSS__t224 nfet L=0.5U W=2U
+ AS=0.8P AD=0.8P PS=4.8U PD=4.8U
* device instance $138 r0 *1 544.82,3.11 nfet
M$138 XD5.XDFFQ.SB__t5 XD5.XDFFQ.CLKB__t4 XD5.XDFFQ.S__t5 VSS__t225 nfet L=0.5U
+ W=2U AS=0.8P AD=0.8P PS=4.8U PD=4.8U
* device instance $139 r0 *1 548.78,3.11 nfet
M$139 DIVOUT__t6 XD5.XDFFQ.SB__t3 VSS__t49 VSS__t226 nfet L=0.5U W=2U AS=0.8P
+ AD=0.8P PS=4.8U PD=4.8U
* device instance $140 r0 *1 552.74,3.11 nfet
M$140 XD5.nm__t4 VDD_DIV__t260 XD5.XN2.mid1__t1 VSS__t227 nfet L=0.5U W=2U
+ AS=0.8P AD=0.8P PS=4.8U PD=4.8U
* device instance $141 r0 *1 556.7,3.11 nfet
M$141 XD5.XN2.mid1__t0 DIVOUT__t4 VSS__t50 VSS__t228 nfet L=0.5U W=2U AS=0.8P
+ AD=0.8P PS=4.8U PD=4.8U
* device instance $142 r0 *1 560.66,3.11 nfet
M$142 XD5.dmodout__t2 XD5.nm__t3 VSS__t51 VSS__t229 nfet L=0.5U W=2U AS=0.8P
+ AD=0.8P PS=4.8U PD=4.8U
* device instance $143 r0 *1 564.62,3.11 nfet
M$143 XD5.XDFFM.CLKB__t5 ck5__t12 VSS__t52 VSS__t230 nfet L=0.5U W=2U AS=0.8P
+ AD=0.8P PS=4.8U PD=4.8U
* device instance $144 r0 *1 568.58,3.11 nfet
M$144 XD5.dmodout__t3 XD5.XDFFM.CLKB__t3 XD5.XDFFM.M__t6 VSS__t231 nfet L=0.5U
+ W=2U AS=0.8P AD=0.8P PS=4.8U PD=4.8U
* device instance $145 r0 *1 572.54,3.11 nfet
M$145 XD5.XDFFM.MB__t2 XD5.XDFFM.M__t4 VSS__t53 VSS__t232 nfet L=0.5U W=2U
+ AS=0.8P AD=0.8P PS=4.8U PD=4.8U
* device instance $146 r0 *1 576.5,3.11 nfet
M$146 XD5.XDFFM.MB__t3 ck5__t13 XD5.XDFFM.M__t7 VSS__t233 nfet L=0.5U W=2U
+ AS=0.8P AD=0.8P PS=4.8U PD=4.8U
* device instance $147 r0 *1 580.46,3.11 nfet
M$147 XD5.XDFFM.M__t5 ck5__t14 XD5.XDFFM.S__t4 VSS__t234 nfet L=0.5U W=2U
+ AS=0.8P AD=0.8P PS=4.8U PD=4.8U
* device instance $148 r0 *1 584.42,3.11 nfet
M$148 XD5.XDFFM.SB__t4 XD5.XDFFM.S__t3 VSS__t54 VSS__t235 nfet L=0.5U W=2U
+ AS=0.8P AD=0.8P PS=4.8U PD=4.8U
* device instance $149 r0 *1 588.38,3.11 nfet
M$149 XD5.XDFFM.SB__t5 XD5.XDFFM.CLKB__t4 XD5.XDFFM.S__t5 VSS__t236 nfet L=0.5U
+ W=2U AS=0.8P AD=0.8P PS=4.8U PD=4.8U
* device instance $150 r0 *1 592.34,3.11 nfet
M$150 mod4__t7 XD5.XDFFM.SB__t3 VSS__t77 VSS__t237 nfet L=0.5U W=2U AS=0.8P
+ AD=0.8P PS=4.8U PD=4.8U
* device instance $151 r0 *1 596.3,3.11 nfet
M$151 XFRT.CLKB__t5 CKIN_VCO__t3 VSS__t78 VSS__t238 nfet L=0.5U W=2U AS=0.8P
+ AD=0.8P PS=4.8U PD=4.8U
* device instance $152 r0 *1 600.26,3.11 nfet
M$152 DIVOUT__t7 XFRT.CLKB__t3 XFRT.M__t6 VSS__t239 nfet L=0.5U W=2U AS=0.8P
+ AD=0.8P PS=4.8U PD=4.8U
* device instance $153 r0 *1 604.22,3.11 nfet
M$153 XFRT.MB__t2 XFRT.M__t4 VSS__t79 VSS__t240 nfet L=0.5U W=2U AS=0.8P
+ AD=0.8P PS=4.8U PD=4.8U
* device instance $154 r0 *1 608.18,3.11 nfet
M$154 XFRT.MB__t3 CKIN_VCO__t4 XFRT.M__t7 VSS__t241 nfet L=0.5U W=2U AS=0.8P
+ AD=0.8P PS=4.8U PD=4.8U
* device instance $155 r0 *1 612.14,3.11 nfet
M$155 XFRT.M__t5 CKIN_VCO__t5 XFRT.S__t4 VSS__t242 nfet L=0.5U W=2U AS=0.8P
+ AD=0.8P PS=4.8U PD=4.8U
* device instance $156 r0 *1 616.1,3.11 nfet
M$156 XFRT.SB__t4 XFRT.S__t3 VSS__t80 VSS__t243 nfet L=0.5U W=2U AS=0.8P
+ AD=0.8P PS=4.8U PD=4.8U
* device instance $157 r0 *1 620.06,3.11 nfet
M$157 XFRT.SB__t5 XFRT.CLKB__t4 XFRT.S__t5 VSS__t244 nfet L=0.5U W=2U AS=0.8P
+ AD=0.8P PS=4.8U PD=4.8U
* device instance $158 r0 *1 624.02,3.11 nfet
M$158 FB__t1 XFRT.SB__t3 VSS__t81 VSS__t245 nfet L=0.5U W=2U AS=0.8P AD=0.8P
+ PS=4.8U PD=4.8U
* device instance $159 r0 *1 636.12,3.11 pfet
M$159 XD0.nt__t3 mod0__t2 VDD_DIV__t1 VDD_DIV__t0 pfet L=0.5U W=5U AS=2P AD=2P
+ PS=10.8U PD=10.8U
* device instance $160 r0 *1 643.08,3.11 pfet
M$160 XD0.nt__t1 P0__t0 VDD_DIV__t45 VDD_DIV__t167 pfet L=0.5U W=5U AS=2P AD=2P
+ PS=10.8U PD=10.8U
* device instance $161 r0 *1 650.04,3.11 pfet
M$161 XD0.nt__t2 net1__t0 VDD_DIV__t46 VDD_DIV__t168 pfet L=0.5U W=5U AS=2P
+ AD=2P PS=10.8U PD=10.8U
* device instance $162 r0 *1 657,3.11 pfet
M$162 XD0.t1__t1 XD0.nt__t0 VDD_DIV__t47 VDD_DIV__t169 pfet L=0.5U W=5U AS=2P
+ AD=2P PS=10.8U PD=10.8U
* device instance $163 r0 *1 663.96,3.11 pfet
M$163 XD0.XNOR.midp__t0 ck1__t3 VDD_DIV__t53 VDD_DIV__t180 pfet L=0.5U W=5U
+ AS=2P AD=2P PS=10.8U PD=10.8U
* device instance $164 r0 *1 670.92,3.11 pfet
M$164 XD0.dq__t0 XD0.t1__t0 XD0.XNOR.midp__t1 VDD_DIV__t171 pfet L=0.5U W=5U
+ AS=2P AD=2P PS=10.8U PD=10.8U
* device instance $165 r0 *1 677.88,3.11 pfet
M$165 XD0.XDFFQ.CLKB__t2 CKIN__t3 VDD_DIV__t49 VDD_DIV__t172 pfet L=0.5U W=5U
+ AS=2P AD=2P PS=10.8U PD=10.8U
* device instance $166 r0 *1 684.84,3.11 pfet
M$166 XD0.XDFFQ.M__t2 CKIN__t4 XD0.dq__t1 VDD_DIV__t173 pfet L=0.5U W=5U AS=2P
+ AD=2P PS=10.8U PD=10.8U
* device instance $167 r0 *1 691.8,3.11 pfet
M$167 XD0.XDFFQ.MB__t0 XD0.XDFFQ.M__t1 VDD_DIV__t50 VDD_DIV__t174 pfet L=0.5U
+ W=5U AS=2P AD=2P PS=10.8U PD=10.8U
* device instance $168 r0 *1 698.76,3.11 pfet
M$168 XD0.XDFFQ.M__t3 XD0.XDFFQ.CLKB__t0 XD0.XDFFQ.MB__t1 VDD_DIV__t175 pfet
+ L=0.5U W=5U AS=2P AD=2P PS=10.8U PD=10.8U
* device instance $169 r0 *1 705.72,3.11 pfet
M$169 XD0.XDFFQ.S__t1 XD0.XDFFQ.CLKB__t1 XD0.XDFFQ.M__t4 VDD_DIV__t176 pfet
+ L=0.5U W=5U AS=2P AD=2P PS=10.8U PD=10.8U
* device instance $170 r0 *1 712.68,3.11 pfet
M$170 XD0.XDFFQ.SB__t1 XD0.XDFFQ.S__t0 VDD_DIV__t51 VDD_DIV__t177 pfet L=0.5U
+ W=5U AS=2P AD=2P PS=10.8U PD=10.8U
* device instance $171 r0 *1 719.64,3.11 pfet
M$171 XD0.XDFFQ.S__t2 CKIN__t5 XD0.XDFFQ.SB__t2 VDD_DIV__t178 pfet L=0.5U W=5U
+ AS=2P AD=2P PS=10.8U PD=10.8U
* device instance $172 r0 *1 726.6,3.11 pfet
M$172 ck1__t8 XD0.XDFFQ.SB__t0 VDD_DIV__t52 VDD_DIV__t179 pfet L=0.5U W=5U
+ AS=2P AD=2P PS=10.8U PD=10.8U
* device instance $173 r0 *1 733.56,3.11 pfet
M$173 XD0.nm__t2 mod0__t1 VDD_DIV__t48 VDD_DIV__t170 pfet L=0.5U W=5U AS=2P
+ AD=2P PS=10.8U PD=10.8U
* device instance $174 r0 *1 740.52,3.11 pfet
M$174 XD0.nm__t1 ck1__t0 VDD_DIV__t29 VDD_DIV__t142 pfet L=0.5U W=5U AS=2P
+ AD=2P PS=10.8U PD=10.8U
* device instance $175 r0 *1 747.48,3.11 pfet
M$175 XD0.dmodout__t0 XD0.nm__t0 VDD_DIV__t30 VDD_DIV__t143 pfet L=0.5U W=5U
+ AS=2P AD=2P PS=10.8U PD=10.8U
* device instance $176 r0 *1 754.44,3.11 pfet
M$176 XD0.XDFFM.CLKB__t2 CKIN__t0 VDD_DIV__t31 VDD_DIV__t144 pfet L=0.5U W=5U
+ AS=2P AD=2P PS=10.8U PD=10.8U
* device instance $177 r0 *1 761.4,3.11 pfet
M$177 XD0.XDFFM.M__t1 CKIN__t1 XD0.dmodout__t1 VDD_DIV__t145 pfet L=0.5U W=5U
+ AS=2P AD=2P PS=10.8U PD=10.8U
* device instance $178 r0 *1 768.36,3.11 pfet
M$178 XD0.XDFFM.MB__t0 XD0.XDFFM.M__t0 VDD_DIV__t32 VDD_DIV__t146 pfet L=0.5U
+ W=5U AS=2P AD=2P PS=10.8U PD=10.8U
* device instance $179 r0 *1 775.32,3.11 pfet
M$179 XD0.XDFFM.M__t2 XD0.XDFFM.CLKB__t0 XD0.XDFFM.MB__t1 VDD_DIV__t147 pfet
+ L=0.5U W=5U AS=2P AD=2P PS=10.8U PD=10.8U
* device instance $180 r0 *1 782.28,3.11 pfet
M$180 XD0.XDFFM.S__t1 XD0.XDFFM.CLKB__t1 XD0.XDFFM.M__t3 VDD_DIV__t148 pfet
+ L=0.5U W=5U AS=2P AD=2P PS=10.8U PD=10.8U
* device instance $181 r0 *1 789.24,3.11 pfet
M$181 XD0.XDFFM.SB__t1 XD0.XDFFM.S__t0 VDD_DIV__t33 VDD_DIV__t149 pfet L=0.5U
+ W=5U AS=2P AD=2P PS=10.8U PD=10.8U
* device instance $182 r0 *1 796.2,3.11 pfet
M$182 XD0.XDFFM.S__t2 CKIN__t2 XD0.XDFFM.SB__t2 VDD_DIV__t160 pfet L=0.5U W=5U
+ AS=2P AD=2P PS=10.8U PD=10.8U
* device instance $183 r0 *1 803.16,3.11 pfet
M$183 net1__t1 XD0.XDFFM.SB__t0 VDD_DIV__t35 VDD_DIV__t151 pfet L=0.5U W=5U
+ AS=2P AD=2P PS=10.8U PD=10.8U
* device instance $184 r0 *1 810.12,3.11 pfet
M$184 XD1.nt__t1 mod1__t1 VDD_DIV__t36 VDD_DIV__t152 pfet L=0.5U W=5U AS=2P
+ AD=2P PS=10.8U PD=10.8U
* device instance $185 r0 *1 817.08,3.11 pfet
M$185 XD1.nt__t2 P1__t0 VDD_DIV__t37 VDD_DIV__t153 pfet L=0.5U W=5U AS=2P AD=2P
+ PS=10.8U PD=10.8U
* device instance $186 r0 *1 824.04,3.11 pfet
M$186 XD1.nt__t3 mod0__t0 VDD_DIV__t38 VDD_DIV__t154 pfet L=0.5U W=5U AS=2P
+ AD=2P PS=10.8U PD=10.8U
* device instance $187 r0 *1 831,3.11 pfet
M$187 XD1.t1__t1 XD1.nt__t0 VDD_DIV__t39 VDD_DIV__t155 pfet L=0.5U W=5U AS=2P
+ AD=2P PS=10.8U PD=10.8U
* device instance $188 r0 *1 837.96,3.11 pfet
M$188 XD1.XNOR.midp__t0 ck2__t6 VDD_DIV__t40 VDD_DIV__t156 pfet L=0.5U W=5U
+ AS=2P AD=2P PS=10.8U PD=10.8U
* device instance $189 r0 *1 844.92,3.11 pfet
M$189 XD1.dq__t0 XD1.t1__t0 XD1.XNOR.midp__t1 VDD_DIV__t157 pfet L=0.5U W=5U
+ AS=2P AD=2P PS=10.8U PD=10.8U
* device instance $190 r0 *1 851.88,3.11 pfet
M$190 XD1.XDFFQ.CLKB__t2 ck1__t1 VDD_DIV__t41 VDD_DIV__t158 pfet L=0.5U W=5U
+ AS=2P AD=2P PS=10.8U PD=10.8U
* device instance $191 r0 *1 858.84,3.11 pfet
M$191 XD1.XDFFQ.M__t1 ck1__t2 XD1.dq__t1 VDD_DIV__t159 pfet L=0.5U W=5U AS=2P
+ AD=2P PS=10.8U PD=10.8U
* device instance $192 r0 *1 865.8,3.11 pfet
M$192 XD1.XDFFQ.MB__t0 XD1.XDFFQ.M__t0 VDD_DIV__t11 VDD_DIV__t111 pfet L=0.5U
+ W=5U AS=2P AD=2P PS=10.8U PD=10.8U
* device instance $193 r0 *1 872.76,3.11 pfet
M$193 XD1.XDFFQ.M__t2 XD1.XDFFQ.CLKB__t0 XD1.XDFFQ.MB__t1 VDD_DIV__t165 pfet
+ L=0.5U W=5U AS=2P AD=2P PS=10.8U PD=10.8U
* device instance $194 r0 *1 879.72,3.11 pfet
M$194 XD1.XDFFQ.S__t1 XD1.XDFFQ.CLKB__t1 XD1.XDFFQ.M__t3 VDD_DIV__t166 pfet
+ L=0.5U W=5U AS=2P AD=2P PS=10.8U PD=10.8U
* device instance $195 r0 *1 886.68,3.11 pfet
M$195 XD1.XDFFQ.SB__t1 XD1.XDFFQ.S__t0 VDD_DIV__t81 VDD_DIV__t224 pfet L=0.5U
+ W=5U AS=2P AD=2P PS=10.8U PD=10.8U
* device instance $196 r0 *1 893.64,3.11 pfet
M$196 XD1.XDFFQ.S__t2 ck1__t4 XD1.XDFFQ.SB__t2 VDD_DIV__t225 pfet L=0.5U W=5U
+ AS=2P AD=2P PS=10.8U PD=10.8U
* device instance $197 r0 *1 900.6,3.11 pfet
M$197 ck2__t8 XD1.XDFFQ.SB__t0 VDD_DIV__t82 VDD_DIV__t226 pfet L=0.5U W=5U
+ AS=2P AD=2P PS=10.8U PD=10.8U
* device instance $198 r0 *1 907.56,3.11 pfet
M$198 XD1.nm__t1 mod1__t2 VDD_DIV__t83 VDD_DIV__t227 pfet L=0.5U W=5U AS=2P
+ AD=2P PS=10.8U PD=10.8U
* device instance $199 r0 *1 914.52,3.11 pfet
M$199 XD1.nm__t2 ck2__t7 VDD_DIV__t84 VDD_DIV__t228 pfet L=0.5U W=5U AS=2P
+ AD=2P PS=10.8U PD=10.8U
* device instance $200 r0 *1 921.48,3.11 pfet
M$200 XD1.dmodout__t0 XD1.nm__t0 VDD_DIV__t91 VDD_DIV__t239 pfet L=0.5U W=5U
+ AS=2P AD=2P PS=10.8U PD=10.8U
* device instance $201 r0 *1 928.44,3.11 pfet
M$201 XD1.XDFFM.CLKB__t2 ck1__t5 VDD_DIV__t86 VDD_DIV__t230 pfet L=0.5U W=5U
+ AS=2P AD=2P PS=10.8U PD=10.8U
* device instance $202 r0 *1 935.4,3.11 pfet
M$202 XD1.XDFFM.M__t1 ck1__t6 XD1.dmodout__t1 VDD_DIV__t231 pfet L=0.5U W=5U
+ AS=2P AD=2P PS=10.8U PD=10.8U
* device instance $203 r0 *1 942.36,3.11 pfet
M$203 XD1.XDFFM.MB__t0 XD1.XDFFM.M__t0 VDD_DIV__t87 VDD_DIV__t232 pfet L=0.5U
+ W=5U AS=2P AD=2P PS=10.8U PD=10.8U
* device instance $204 r0 *1 949.32,3.11 pfet
M$204 XD1.XDFFM.M__t2 XD1.XDFFM.CLKB__t0 XD1.XDFFM.MB__t1 VDD_DIV__t233 pfet
+ L=0.5U W=5U AS=2P AD=2P PS=10.8U PD=10.8U
* device instance $205 r0 *1 956.28,3.11 pfet
M$205 XD1.XDFFM.S__t1 XD1.XDFFM.CLKB__t1 XD1.XDFFM.M__t3 VDD_DIV__t234 pfet
+ L=0.5U W=5U AS=2P AD=2P PS=10.8U PD=10.8U
* device instance $206 r0 *1 963.24,3.11 pfet
M$206 XD1.XDFFM.SB__t1 XD1.XDFFM.S__t0 VDD_DIV__t88 VDD_DIV__t235 pfet L=0.5U
+ W=5U AS=2P AD=2P PS=10.8U PD=10.8U
* device instance $207 r0 *1 970.2,3.11 pfet
M$207 XD1.XDFFM.S__t2 ck1__t7 XD1.XDFFM.SB__t2 VDD_DIV__t236 pfet L=0.5U W=5U
+ AS=2P AD=2P PS=10.8U PD=10.8U
* device instance $208 r0 *1 977.16,3.11 pfet
M$208 mod0__t3 XD1.XDFFM.SB__t0 VDD_DIV__t89 VDD_DIV__t237 pfet L=0.5U W=5U
+ AS=2P AD=2P PS=10.8U PD=10.8U
* device instance $209 r0 *1 984.12,3.11 pfet
M$209 XD2.nt__t3 mod2__t2 VDD_DIV__t90 VDD_DIV__t238 pfet L=0.5U W=5U AS=2P
+ AD=2P PS=10.8U PD=10.8U
* device instance $210 r0 *1 991.08,3.11 pfet
M$210 XD2.nt__t2 P2__t0 VDD_DIV__t59 VDD_DIV__t189 pfet L=0.5U W=5U AS=2P AD=2P
+ PS=10.8U PD=10.8U
* device instance $211 r0 *1 998.04,3.11 pfet
M$211 XD2.nt__t1 mod1__t0 VDD_DIV__t17 VDD_DIV__t122 pfet L=0.5U W=5U AS=2P
+ AD=2P PS=10.8U PD=10.8U
* device instance $212 r0 *1 1005,3.11 pfet
M$212 XD2.t1__t1 XD2.nt__t0 VDD_DIV__t18 VDD_DIV__t123 pfet L=0.5U W=5U AS=2P
+ AD=2P PS=10.8U PD=10.8U
* device instance $213 r0 *1 1011.96,3.11 pfet
M$213 XD2.XNOR.midp__t0 ck3__t3 VDD_DIV__t19 VDD_DIV__t124 pfet L=0.5U W=5U
+ AS=2P AD=2P PS=10.8U PD=10.8U
* device instance $214 r0 *1 1018.92,3.11 pfet
M$214 XD2.dq__t0 XD2.t1__t0 XD2.XNOR.midp__t1 VDD_DIV__t125 pfet L=0.5U W=5U
+ AS=2P AD=2P PS=10.8U PD=10.8U
* device instance $215 r0 *1 1025.88,3.11 pfet
M$215 XD2.XDFFQ.CLKB__t2 ck2__t1 VDD_DIV__t20 VDD_DIV__t126 pfet L=0.5U W=5U
+ AS=2P AD=2P PS=10.8U PD=10.8U
* device instance $216 r0 *1 1032.84,3.11 pfet
M$216 XD2.XDFFQ.M__t1 ck2__t2 XD2.dq__t1 VDD_DIV__t127 pfet L=0.5U W=5U AS=2P
+ AD=2P PS=10.8U PD=10.8U
* device instance $217 r0 *1 1039.8,3.11 pfet
M$217 XD2.XDFFQ.MB__t0 XD2.XDFFQ.M__t0 VDD_DIV__t21 VDD_DIV__t128 pfet L=0.5U
+ W=5U AS=2P AD=2P PS=10.8U PD=10.8U
* device instance $218 r0 *1 1046.76,3.11 pfet
M$218 XD2.XDFFQ.M__t2 XD2.XDFFQ.CLKB__t0 XD2.XDFFQ.MB__t1 VDD_DIV__t129 pfet
+ L=0.5U W=5U AS=2P AD=2P PS=10.8U PD=10.8U
* device instance $219 r0 *1 1053.72,3.11 pfet
M$219 XD2.XDFFQ.S__t1 XD2.XDFFQ.CLKB__t1 XD2.XDFFQ.M__t3 VDD_DIV__t130 pfet
+ L=0.5U W=5U AS=2P AD=2P PS=10.8U PD=10.8U
* device instance $220 r0 *1 1060.68,3.11 pfet
M$220 XD2.XDFFQ.SB__t1 XD2.XDFFQ.S__t0 VDD_DIV__t28 VDD_DIV__t141 pfet L=0.5U
+ W=5U AS=2P AD=2P PS=10.8U PD=10.8U
* device instance $221 r0 *1 1067.64,3.11 pfet
M$221 XD2.XDFFQ.S__t2 ck2__t3 XD2.XDFFQ.SB__t2 VDD_DIV__t132 pfet L=0.5U W=5U
+ AS=2P AD=2P PS=10.8U PD=10.8U
* device instance $222 r0 *1 1074.6,3.11 pfet
M$222 ck3__t8 XD2.XDFFQ.SB__t0 VDD_DIV__t22 VDD_DIV__t133 pfet L=0.5U W=5U
+ AS=2P AD=2P PS=10.8U PD=10.8U
* device instance $223 r0 *1 1081.56,3.11 pfet
M$223 XD2.nm__t1 mod2__t1 VDD_DIV__t23 VDD_DIV__t134 pfet L=0.5U W=5U AS=2P
+ AD=2P PS=10.8U PD=10.8U
* device instance $224 r0 *1 1088.52,3.11 pfet
M$224 XD2.nm__t2 ck3__t4 VDD_DIV__t24 VDD_DIV__t135 pfet L=0.5U W=5U AS=2P
+ AD=2P PS=10.8U PD=10.8U
* device instance $225 r0 *1 1095.48,3.11 pfet
M$225 XD2.dmodout__t0 XD2.nm__t0 VDD_DIV__t25 VDD_DIV__t136 pfet L=0.5U W=5U
+ AS=2P AD=2P PS=10.8U PD=10.8U
* device instance $226 r0 *1 1102.44,3.11 pfet
M$226 XD2.XDFFM.CLKB__t2 ck2__t4 VDD_DIV__t26 VDD_DIV__t137 pfet L=0.5U W=5U
+ AS=2P AD=2P PS=10.8U PD=10.8U
* device instance $227 r0 *1 1109.4,3.11 pfet
M$227 XD2.XDFFM.M__t1 ck2__t5 XD2.dmodout__t1 VDD_DIV__t138 pfet L=0.5U W=5U
+ AS=2P AD=2P PS=10.8U PD=10.8U
* device instance $228 r0 *1 1116.36,3.11 pfet
M$228 XD2.XDFFM.MB__t0 XD2.XDFFM.M__t0 VDD_DIV__t27 VDD_DIV__t139 pfet L=0.5U
+ W=5U AS=2P AD=2P PS=10.8U PD=10.8U
* device instance $229 r0 *1 1123.32,3.11 pfet
M$229 XD2.XDFFM.M__t2 XD2.XDFFM.CLKB__t1 XD2.XDFFM.MB__t1 VDD_DIV__t140 pfet
+ L=0.5U W=5U AS=2P AD=2P PS=10.8U PD=10.8U
* device instance $230 r0 *1 1130.28,3.11 pfet
M$230 XD2.XDFFM.S__t2 XD2.XDFFM.CLKB__t0 XD2.XDFFM.M__t3 VDD_DIV__t131 pfet
+ L=0.5U W=5U AS=2P AD=2P PS=10.8U PD=10.8U
* device instance $231 r0 *1 1137.24,3.11 pfet
M$231 XD2.XDFFM.SB__t1 XD2.XDFFM.S__t0 VDD_DIV__t4 VDD_DIV__t103 pfet L=0.5U
+ W=5U AS=2P AD=2P PS=10.8U PD=10.8U
* device instance $232 r0 *1 1144.2,3.11 pfet
M$232 XD2.XDFFM.S__t1 ck2__t0 XD2.XDFFM.SB__t2 VDD_DIV__t104 pfet L=0.5U W=5U
+ AS=2P AD=2P PS=10.8U PD=10.8U
* device instance $233 r0 *1 1151.16,3.11 pfet
M$233 mod1__t3 XD2.XDFFM.SB__t0 VDD_DIV__t5 VDD_DIV__t105 pfet L=0.5U W=5U
+ AS=2P AD=2P PS=10.8U PD=10.8U
* device instance $234 r0 *1 1158.12,3.11 pfet
M$234 XD3.nt__t1 mod3__t0 VDD_DIV__t6 VDD_DIV__t106 pfet L=0.5U W=5U AS=2P
+ AD=2P PS=10.8U PD=10.8U
* device instance $235 r0 *1 1165.08,3.11 pfet
M$235 XD3.nt__t2 P3__t0 VDD_DIV__t7 VDD_DIV__t107 pfet L=0.5U W=5U AS=2P AD=2P
+ PS=10.8U PD=10.8U
* device instance $236 r0 *1 1172.04,3.11 pfet
M$236 XD3.nt__t3 mod2__t0 VDD_DIV__t8 VDD_DIV__t108 pfet L=0.5U W=5U AS=2P
+ AD=2P PS=10.8U PD=10.8U
* device instance $237 r0 *1 1179,3.11 pfet
M$237 XD3.t1__t1 XD3.nt__t0 VDD_DIV__t9 VDD_DIV__t109 pfet L=0.5U W=5U AS=2P
+ AD=2P PS=10.8U PD=10.8U
* device instance $238 r0 *1 1185.96,3.11 pfet
M$238 XD3.XNOR.midp__t0 ck4__t0 VDD_DIV__t10 VDD_DIV__t110 pfet L=0.5U W=5U
+ AS=2P AD=2P PS=10.8U PD=10.8U
* device instance $239 r0 *1 1192.92,3.11 pfet
M$239 XD3.dq__t0 XD3.t1__t0 XD3.XNOR.midp__t1 VDD_DIV__t121 pfet L=0.5U W=5U
+ AS=2P AD=2P PS=10.8U PD=10.8U
* device instance $240 r0 *1 1199.88,3.11 pfet
M$240 XD3.XDFFQ.CLKB__t2 ck3__t0 VDD_DIV__t12 VDD_DIV__t112 pfet L=0.5U W=5U
+ AS=2P AD=2P PS=10.8U PD=10.8U
* device instance $241 r0 *1 1206.84,3.11 pfet
M$241 XD3.XDFFQ.M__t1 ck3__t1 XD3.dq__t1 VDD_DIV__t113 pfet L=0.5U W=5U AS=2P
+ AD=2P PS=10.8U PD=10.8U
* device instance $242 r0 *1 1213.8,3.11 pfet
M$242 XD3.XDFFQ.MB__t0 XD3.XDFFQ.M__t0 VDD_DIV__t13 VDD_DIV__t114 pfet L=0.5U
+ W=5U AS=2P AD=2P PS=10.8U PD=10.8U
* device instance $243 r0 *1 1220.76,3.11 pfet
M$243 XD3.XDFFQ.M__t2 XD3.XDFFQ.CLKB__t0 XD3.XDFFQ.MB__t1 VDD_DIV__t115 pfet
+ L=0.5U W=5U AS=2P AD=2P PS=10.8U PD=10.8U
* device instance $244 r0 *1 1227.72,3.11 pfet
M$244 XD3.XDFFQ.S__t1 XD3.XDFFQ.CLKB__t1 XD3.XDFFQ.M__t3 VDD_DIV__t116 pfet
+ L=0.5U W=5U AS=2P AD=2P PS=10.8U PD=10.8U
* device instance $245 r0 *1 1234.68,3.11 pfet
M$245 XD3.XDFFQ.SB__t1 XD3.XDFFQ.S__t0 VDD_DIV__t14 VDD_DIV__t117 pfet L=0.5U
+ W=5U AS=2P AD=2P PS=10.8U PD=10.8U
* device instance $246 r0 *1 1241.64,3.11 pfet
M$246 XD3.XDFFQ.S__t2 ck3__t2 XD3.XDFFQ.SB__t2 VDD_DIV__t118 pfet L=0.5U W=5U
+ AS=2P AD=2P PS=10.8U PD=10.8U
* device instance $247 r0 *1 1248.6,3.11 pfet
M$247 ck4__t8 XD3.XDFFQ.SB__t0 VDD_DIV__t15 VDD_DIV__t119 pfet L=0.5U W=5U
+ AS=2P AD=2P PS=10.8U PD=10.8U
* device instance $248 r0 *1 1255.56,3.11 pfet
M$248 XD3.nm__t1 mod3__t1 VDD_DIV__t16 VDD_DIV__t120 pfet L=0.5U W=5U AS=2P
+ AD=2P PS=10.8U PD=10.8U
* device instance $249 r0 *1 1262.52,3.11 pfet
M$249 XD3.nm__t2 ck4__t1 VDD_DIV__t34 VDD_DIV__t150 pfet L=0.5U W=5U AS=2P
+ AD=2P PS=10.8U PD=10.8U
* device instance $250 r0 *1 1269.48,3.11 pfet
M$250 XD3.dmodout__t0 XD3.nm__t0 VDD_DIV__t42 VDD_DIV__t161 pfet L=0.5U W=5U
+ AS=2P AD=2P PS=10.8U PD=10.8U
* device instance $251 r0 *1 1276.44,3.11 pfet
M$251 XD3.XDFFM.CLKB__t2 ck3__t5 VDD_DIV__t43 VDD_DIV__t162 pfet L=0.5U W=5U
+ AS=2P AD=2P PS=10.8U PD=10.8U
* device instance $252 r0 *1 1283.4,3.11 pfet
M$252 XD3.XDFFM.M__t1 ck3__t6 XD3.dmodout__t1 VDD_DIV__t163 pfet L=0.5U W=5U
+ AS=2P AD=2P PS=10.8U PD=10.8U
* device instance $253 r0 *1 1290.36,3.11 pfet
M$253 XD3.XDFFM.MB__t0 XD3.XDFFM.M__t0 VDD_DIV__t44 VDD_DIV__t164 pfet L=0.5U
+ W=5U AS=2P AD=2P PS=10.8U PD=10.8U
* device instance $254 r0 *1 1297.32,3.11 pfet
M$254 XD3.XDFFM.M__t2 XD3.XDFFM.CLKB__t0 XD3.XDFFM.MB__t1 VDD_DIV__t200 pfet
+ L=0.5U W=5U AS=2P AD=2P PS=10.8U PD=10.8U
* device instance $255 r0 *1 1304.28,3.11 pfet
M$255 XD3.XDFFM.S__t1 XD3.XDFFM.CLKB__t1 XD3.XDFFM.M__t3 VDD_DIV__t201 pfet
+ L=0.5U W=5U AS=2P AD=2P PS=10.8U PD=10.8U
* device instance $256 r0 *1 1311.24,3.11 pfet
M$256 XD3.XDFFM.SB__t1 XD3.XDFFM.S__t0 VDD_DIV__t67 VDD_DIV__t202 pfet L=0.5U
+ W=5U AS=2P AD=2P PS=10.8U PD=10.8U
* device instance $257 r0 *1 1318.2,3.11 pfet
M$257 XD3.XDFFM.S__t2 ck3__t7 XD3.XDFFM.SB__t2 VDD_DIV__t203 pfet L=0.5U W=5U
+ AS=2P AD=2P PS=10.8U PD=10.8U
* device instance $258 r0 *1 1325.16,3.11 pfet
M$258 mod2__t3 XD3.XDFFM.SB__t0 VDD_DIV__t68 VDD_DIV__t204 pfet L=0.5U W=5U
+ AS=2P AD=2P PS=10.8U PD=10.8U
* device instance $259 r0 *1 1332.12,3.11 pfet
M$259 XD4.nt__t1 mod4__t1 VDD_DIV__t69 VDD_DIV__t205 pfet L=0.5U W=5U AS=2P
+ AD=2P PS=10.8U PD=10.8U
* device instance $260 r0 *1 1339.08,3.11 pfet
M$260 XD4.nt__t2 P4__t0 VDD_DIV__t70 VDD_DIV__t206 pfet L=0.5U W=5U AS=2P AD=2P
+ PS=10.8U PD=10.8U
* device instance $261 r0 *1 1346.04,3.11 pfet
M$261 XD4.nt__t3 mod3__t2 VDD_DIV__t71 VDD_DIV__t207 pfet L=0.5U W=5U AS=2P
+ AD=2P PS=10.8U PD=10.8U
* device instance $262 r0 *1 1353,3.11 pfet
M$262 XD4.t1__t1 XD4.nt__t0 VDD_DIV__t72 VDD_DIV__t208 pfet L=0.5U W=5U AS=2P
+ AD=2P PS=10.8U PD=10.8U
* device instance $263 r0 *1 1359.96,3.11 pfet
M$263 XD4.XNOR.midp__t0 ck5__t3 VDD_DIV__t78 VDD_DIV__t219 pfet L=0.5U W=5U
+ AS=2P AD=2P PS=10.8U PD=10.8U
* device instance $264 r0 *1 1366.92,3.11 pfet
M$264 XD4.dq__t0 XD4.t1__t0 XD4.XNOR.midp__t1 VDD_DIV__t210 pfet L=0.5U W=5U
+ AS=2P AD=2P PS=10.8U PD=10.8U
* device instance $265 r0 *1 1373.88,3.11 pfet
M$265 XD4.XDFFQ.CLKB__t2 ck4__t5 VDD_DIV__t74 VDD_DIV__t211 pfet L=0.5U W=5U
+ AS=2P AD=2P PS=10.8U PD=10.8U
* device instance $266 r0 *1 1380.84,3.11 pfet
M$266 XD4.XDFFQ.M__t1 ck4__t6 XD4.dq__t1 VDD_DIV__t212 pfet L=0.5U W=5U AS=2P
+ AD=2P PS=10.8U PD=10.8U
* device instance $267 r0 *1 1387.8,3.11 pfet
M$267 XD4.XDFFQ.MB__t0 XD4.XDFFQ.M__t0 VDD_DIV__t75 VDD_DIV__t213 pfet L=0.5U
+ W=5U AS=2P AD=2P PS=10.8U PD=10.8U
* device instance $268 r0 *1 1394.76,3.11 pfet
M$268 XD4.XDFFQ.M__t2 XD4.XDFFQ.CLKB__t0 XD4.XDFFQ.MB__t1 VDD_DIV__t214 pfet
+ L=0.5U W=5U AS=2P AD=2P PS=10.8U PD=10.8U
* device instance $269 r0 *1 1401.72,3.11 pfet
M$269 XD4.XDFFQ.S__t1 XD4.XDFFQ.CLKB__t1 XD4.XDFFQ.M__t3 VDD_DIV__t215 pfet
+ L=0.5U W=5U AS=2P AD=2P PS=10.8U PD=10.8U
* device instance $270 r0 *1 1408.68,3.11 pfet
M$270 XD4.XDFFQ.SB__t1 XD4.XDFFQ.S__t0 VDD_DIV__t76 VDD_DIV__t216 pfet L=0.5U
+ W=5U AS=2P AD=2P PS=10.8U PD=10.8U
* device instance $271 r0 *1 1415.64,3.11 pfet
M$271 XD4.XDFFQ.S__t2 ck4__t7 XD4.XDFFQ.SB__t2 VDD_DIV__t217 pfet L=0.5U W=5U
+ AS=2P AD=2P PS=10.8U PD=10.8U
* device instance $272 r0 *1 1422.6,3.11 pfet
M$272 ck5__t8 XD4.XDFFQ.SB__t0 VDD_DIV__t77 VDD_DIV__t218 pfet L=0.5U W=5U
+ AS=2P AD=2P PS=10.8U PD=10.8U
* device instance $273 r0 *1 1429.56,3.11 pfet
M$273 XD4.nm__t2 mod4__t2 VDD_DIV__t73 VDD_DIV__t209 pfet L=0.5U W=5U AS=2P
+ AD=2P PS=10.8U PD=10.8U
* device instance $274 r0 *1 1436.52,3.11 pfet
M$274 XD4.nm__t1 ck5__t0 VDD_DIV__t54 VDD_DIV__t181 pfet L=0.5U W=5U AS=2P
+ AD=2P PS=10.8U PD=10.8U
* device instance $275 r0 *1 1443.48,3.11 pfet
M$275 XD4.dmodout__t0 XD4.nm__t0 VDD_DIV__t55 VDD_DIV__t182 pfet L=0.5U W=5U
+ AS=2P AD=2P PS=10.8U PD=10.8U
* device instance $276 r0 *1 1450.44,3.11 pfet
M$276 XD4.XDFFM.CLKB__t2 ck4__t2 VDD_DIV__t56 VDD_DIV__t183 pfet L=0.5U W=5U
+ AS=2P AD=2P PS=10.8U PD=10.8U
* device instance $277 r0 *1 1457.4,3.11 pfet
M$277 XD4.XDFFM.M__t1 ck4__t3 XD4.dmodout__t1 VDD_DIV__t184 pfet L=0.5U W=5U
+ AS=2P AD=2P PS=10.8U PD=10.8U
* device instance $278 r0 *1 1464.36,3.11 pfet
M$278 XD4.XDFFM.MB__t0 XD4.XDFFM.M__t0 VDD_DIV__t57 VDD_DIV__t185 pfet L=0.5U
+ W=5U AS=2P AD=2P PS=10.8U PD=10.8U
* device instance $279 r0 *1 1471.32,3.11 pfet
M$279 XD4.XDFFM.M__t2 XD4.XDFFM.CLKB__t0 XD4.XDFFM.MB__t1 VDD_DIV__t186 pfet
+ L=0.5U W=5U AS=2P AD=2P PS=10.8U PD=10.8U
* device instance $280 r0 *1 1478.28,3.11 pfet
M$280 XD4.XDFFM.S__t1 XD4.XDFFM.CLKB__t1 XD4.XDFFM.M__t3 VDD_DIV__t187 pfet
+ L=0.5U W=5U AS=2P AD=2P PS=10.8U PD=10.8U
* device instance $281 r0 *1 1485.24,3.11 pfet
M$281 XD4.XDFFM.SB__t1 XD4.XDFFM.S__t0 VDD_DIV__t58 VDD_DIV__t188 pfet L=0.5U
+ W=5U AS=2P AD=2P PS=10.8U PD=10.8U
* device instance $282 r0 *1 1492.2,3.11 pfet
M$282 XD4.XDFFM.S__t2 ck4__t4 XD4.XDFFM.SB__t2 VDD_DIV__t199 pfet L=0.5U W=5U
+ AS=2P AD=2P PS=10.8U PD=10.8U
* device instance $283 r0 *1 1499.16,3.11 pfet
M$283 mod3__t3 XD4.XDFFM.SB__t0 VDD_DIV__t60 VDD_DIV__t190 pfet L=0.5U W=5U
+ AS=2P AD=2P PS=10.8U PD=10.8U
* device instance $284 r0 *1 1506.12,3.11 pfet
M$284 XD5.nt__t1 VDD_DIV__t2 VDD_DIV__t61 VDD_DIV__t191 pfet L=0.5U W=5U AS=2P
+ AD=2P PS=10.8U PD=10.8U
* device instance $285 r0 *1 1513.08,3.11 pfet
M$285 XD5.nt__t2 P5__t0 VDD_DIV__t62 VDD_DIV__t192 pfet L=0.5U W=5U AS=2P AD=2P
+ PS=10.8U PD=10.8U
* device instance $286 r0 *1 1520.04,3.11 pfet
M$286 XD5.nt__t3 mod4__t0 VDD_DIV__t63 VDD_DIV__t193 pfet L=0.5U W=5U AS=2P
+ AD=2P PS=10.8U PD=10.8U
* device instance $287 r0 *1 1527,3.11 pfet
M$287 XD5.t1__t1 XD5.nt__t0 VDD_DIV__t64 VDD_DIV__t194 pfet L=0.5U W=5U AS=2P
+ AD=2P PS=10.8U PD=10.8U
* device instance $288 r0 *1 1533.96,3.11 pfet
M$288 XD5.XNOR.midp__t0 DIVOUT__t0 VDD_DIV__t65 VDD_DIV__t195 pfet L=0.5U W=5U
+ AS=2P AD=2P PS=10.8U PD=10.8U
* device instance $289 r0 *1 1540.92,3.11 pfet
M$289 XD5.dq__t0 XD5.t1__t0 XD5.XNOR.midp__t1 VDD_DIV__t196 pfet L=0.5U W=5U
+ AS=2P AD=2P PS=10.8U PD=10.8U
* device instance $290 r0 *1 1547.88,3.11 pfet
M$290 XD5.XDFFQ.CLKB__t2 ck5__t1 VDD_DIV__t66 VDD_DIV__t197 pfet L=0.5U W=5U
+ AS=2P AD=2P PS=10.8U PD=10.8U
* device instance $291 r0 *1 1554.84,3.11 pfet
M$291 XD5.XDFFQ.M__t1 ck5__t2 XD5.dq__t1 VDD_DIV__t198 pfet L=0.5U W=5U AS=2P
+ AD=2P PS=10.8U PD=10.8U
* device instance $292 r0 *1 1561.8,3.11 pfet
M$292 XD5.XDFFQ.MB__t0 XD5.XDFFQ.M__t0 VDD_DIV__t85 VDD_DIV__t229 pfet L=0.5U
+ W=5U AS=2P AD=2P PS=10.8U PD=10.8U
* device instance $293 r0 *1 1568.76,3.11 pfet
M$293 XD5.XDFFQ.M__t2 XD5.XDFFQ.CLKB__t0 XD5.XDFFQ.MB__t1 VDD_DIV__t240 pfet
+ L=0.5U W=5U AS=2P AD=2P PS=10.8U PD=10.8U
* device instance $294 r0 *1 1575.72,3.11 pfet
M$294 XD5.XDFFQ.S__t1 XD5.XDFFQ.CLKB__t1 XD5.XDFFQ.M__t3 VDD_DIV__t241 pfet
+ L=0.5U W=5U AS=2P AD=2P PS=10.8U PD=10.8U
* device instance $295 r0 *1 1582.68,3.11 pfet
M$295 XD5.XDFFQ.SB__t1 XD5.XDFFQ.S__t0 VDD_DIV__t92 VDD_DIV__t242 pfet L=0.5U
+ W=5U AS=2P AD=2P PS=10.8U PD=10.8U
* device instance $296 r0 *1 1589.64,3.11 pfet
M$296 XD5.XDFFQ.S__t2 ck5__t4 XD5.XDFFQ.SB__t2 VDD_DIV__t243 pfet L=0.5U W=5U
+ AS=2P AD=2P PS=10.8U PD=10.8U
* device instance $297 r0 *1 1596.6,3.11 pfet
M$297 DIVOUT__t2 XD5.XDFFQ.SB__t0 VDD_DIV__t93 VDD_DIV__t244 pfet L=0.5U W=5U
+ AS=2P AD=2P PS=10.8U PD=10.8U
* device instance $298 r0 *1 1603.56,3.11 pfet
M$298 XD5.nm__t1 VDD_DIV__t3 VDD_DIV__t94 VDD_DIV__t245 pfet L=0.5U W=5U AS=2P
+ AD=2P PS=10.8U PD=10.8U
* device instance $299 r0 *1 1610.52,3.11 pfet
M$299 XD5.nm__t2 DIVOUT__t1 VDD_DIV__t95 VDD_DIV__t246 pfet L=0.5U W=5U AS=2P
+ AD=2P PS=10.8U PD=10.8U
* device instance $300 r0 *1 1617.48,3.11 pfet
M$300 XD5.dmodout__t0 XD5.nm__t0 VDD_DIV__t96 VDD_DIV__t247 pfet L=0.5U W=5U
+ AS=2P AD=2P PS=10.8U PD=10.8U
* device instance $301 r0 *1 1624.44,3.11 pfet
M$301 XD5.XDFFM.CLKB__t2 ck5__t5 VDD_DIV__t97 VDD_DIV__t248 pfet L=0.5U W=5U
+ AS=2P AD=2P PS=10.8U PD=10.8U
* device instance $302 r0 *1 1631.4,3.11 pfet
M$302 XD5.XDFFM.M__t2 ck5__t7 XD5.dmodout__t1 VDD_DIV__t259 pfet L=0.5U W=5U
+ AS=2P AD=2P PS=10.8U PD=10.8U
* device instance $303 r0 *1 1638.36,3.11 pfet
M$303 XD5.XDFFM.MB__t0 XD5.XDFFM.M__t0 VDD_DIV__t98 VDD_DIV__t250 pfet L=0.5U
+ W=5U AS=2P AD=2P PS=10.8U PD=10.8U
* device instance $304 r0 *1 1645.32,3.11 pfet
M$304 XD5.XDFFM.M__t1 XD5.XDFFM.CLKB__t0 XD5.XDFFM.MB__t1 VDD_DIV__t251 pfet
+ L=0.5U W=5U AS=2P AD=2P PS=10.8U PD=10.8U
* device instance $305 r0 *1 1652.28,3.11 pfet
M$305 XD5.XDFFM.S__t1 XD5.XDFFM.CLKB__t1 XD5.XDFFM.M__t3 VDD_DIV__t252 pfet
+ L=0.5U W=5U AS=2P AD=2P PS=10.8U PD=10.8U
* device instance $306 r0 *1 1659.24,3.11 pfet
M$306 XD5.XDFFM.SB__t1 XD5.XDFFM.S__t0 VDD_DIV__t99 VDD_DIV__t253 pfet L=0.5U
+ W=5U AS=2P AD=2P PS=10.8U PD=10.8U
* device instance $307 r0 *1 1666.2,3.11 pfet
M$307 XD5.XDFFM.S__t2 ck5__t6 XD5.XDFFM.SB__t2 VDD_DIV__t254 pfet L=0.5U W=5U
+ AS=2P AD=2P PS=10.8U PD=10.8U
* device instance $308 r0 *1 1673.16,3.11 pfet
M$308 mod4__t3 XD5.XDFFM.SB__t0 VDD_DIV__t100 VDD_DIV__t255 pfet L=0.5U W=5U
+ AS=2P AD=2P PS=10.8U PD=10.8U
* device instance $309 r0 *1 1680.12,3.11 pfet
M$309 XFRT.CLKB__t2 CKIN_VCO__t1 VDD_DIV__t101 VDD_DIV__t256 pfet L=0.5U W=5U
+ AS=2P AD=2P PS=10.8U PD=10.8U
* device instance $310 r0 *1 1687.08,3.11 pfet
M$310 XFRT.M__t2 CKIN_VCO__t2 DIVOUT__t3 VDD_DIV__t257 pfet L=0.5U W=5U AS=2P
+ AD=2P PS=10.8U PD=10.8U
* device instance $311 r0 *1 1694.04,3.11 pfet
M$311 XFRT.MB__t0 XFRT.M__t0 VDD_DIV__t102 VDD_DIV__t258 pfet L=0.5U W=5U AS=2P
+ AD=2P PS=10.8U PD=10.8U
* device instance $312 r0 *1 1701,3.11 pfet
M$312 XFRT.M__t1 XFRT.CLKB__t1 XFRT.MB__t1 VDD_DIV__t249 pfet L=0.5U W=5U AS=2P
+ AD=2P PS=10.8U PD=10.8U
* device instance $313 r0 *1 1707.96,3.11 pfet
M$313 XFRT.S__t1 XFRT.CLKB__t0 XFRT.M__t3 VDD_DIV__t220 pfet L=0.5U W=5U AS=2P
+ AD=2P PS=10.8U PD=10.8U
* device instance $314 r0 *1 1714.92,3.11 pfet
M$314 XFRT.SB__t1 XFRT.S__t0 VDD_DIV__t79 VDD_DIV__t221 pfet L=0.5U W=5U AS=2P
+ AD=2P PS=10.8U PD=10.8U
* device instance $315 r0 *1 1721.88,3.11 pfet
M$315 XFRT.S__t2 CKIN_VCO__t0 XFRT.SB__t2 VDD_DIV__t222 pfet L=0.5U W=5U AS=2P
+ AD=2P PS=10.8U PD=10.8U
* device instance $316 r0 *1 1728.84,3.11 pfet
M$316 FB__t0 XFRT.SB__t0 VDD_DIV__t80 VDD_DIV__t223 pfet L=0.5U W=5U AS=2P
+ AD=2P PS=10.8U PD=10.8U
* device instance CKIN_t0 r0 *1 0,0
RCKIN_t0 CKIN__t0 CKIN 21.8729881316
* device instance CKIN_t1 r0 *1 0,0
RCKIN_t1 CKIN__t1 CKIN 22.2962185941
* device instance CKIN_t2 r0 *1 0,0
RCKIN_t2 CKIN__t2 CKIN 24.4123709071
* device instance CKIN_t3 r0 *1 0,0
RCKIN_t3 CKIN__t3 CKIN 17.217453043
* device instance CKIN_t4 r0 *1 0,0
RCKIN_t4 CKIN__t4 CKIN 17.6406835056
* device instance CKIN_t5 r0 *1 0,0
RCKIN_t5 CKIN__t5 CKIN 19.7568358186
* device instance CKIN_t6 r0 *1 0,0
RCKIN_t6 CKIN__t6 CKIN 22.4190527227
* device instance CKIN_t7 r0 *1 0,0
RCKIN_t7 CKIN__t7 CKIN 21.6966421055
* device instance CKIN_t8 r0 *1 0,0
RCKIN_t8 CKIN__t8 CKIN 21.4558385664
* device instance CKIN_t9 r0 *1 0,0
RCKIN_t9 CKIN__t9 CKIN 19.770213793
* device instance CKIN_t10 r0 *1 0,0
RCKIN_t10 CKIN__t10 CKIN 19.0478031758
* device instance CKIN_t11 r0 *1 0,0
RCKIN_t11 CKIN__t11 CKIN 18.8069996367
* device instance CKIN r0 *1 0,0
CCKIN CKIN vsubs 5.4048321e-14
* device instance CKIN_VCO_t0 r0 *1 0,0
RCKIN_VCO_t0 CKIN_VCO__t0 CKIN_VCO 59.5074222603
* device instance CKIN_VCO_t1 r0 *1 0,0
RCKIN_VCO_t1 CKIN_VCO__t1 CKIN_VCO 55.154822198
* device instance CKIN_VCO_t2 r0 *1 0,0
RCKIN_VCO_t2 CKIN_VCO__t2 CKIN_VCO 55.8802555417
* device instance CKIN_VCO_t3 r0 *1 0,0
RCKIN_VCO_t3 CKIN_VCO__t3 CKIN_VCO 57.8105753011
* device instance CKIN_VCO_t4 r0 *1 0,0
RCKIN_VCO_t4 CKIN_VCO__t4 CKIN_VCO 56.5723356282
* device instance CKIN_VCO_t5 r0 *1 0,0
RCKIN_VCO_t5 CKIN_VCO__t5 CKIN_VCO 56.1595890706
* device instance CKIN_VCO r0 *1 0,0
CCKIN_VCO CKIN_VCO vsubs 7.5090819e-14
* device instance DIVOUT_t0 r0 *1 0,0
RDIVOUT_t0 DIVOUT__t0 DIVOUT 39.3473427769
* device instance DIVOUT_t1 r0 *1 0,0
RDIVOUT_t1 DIVOUT__t1 DIVOUT 45.9961301059
* device instance DIVOUT_t2 r0 *1 0,0
RDIVOUT_t2 DIVOUT__t2 DIVOUT 44.7872596824
* device instance DIVOUT_t3 r0 *1 0,0
RDIVOUT_t3 DIVOUT__t3 DIVOUT 52.6449174348
* device instance DIVOUT_t4 r0 *1 0,0
RDIVOUT_t4 DIVOUT__t4 DIVOUT 45.5219611036
* device instance DIVOUT_t5 r0 *1 0,0
RDIVOUT_t5 DIVOUT__t5 DIVOUT 49.3048918252
* device instance DIVOUT_t6 r0 *1 0,0
RDIVOUT_t6 DIVOUT__t6 DIVOUT 46.2097666893
* device instance DIVOUT_t7 r0 *1 0,0
RDIVOUT_t7 DIVOUT__t7 DIVOUT 41.7390303819
* device instance DIVOUT r0 *1 0,0
CDIVOUT DIVOUT vsubs 8.0420769e-14
* device instance FB_t0 r0 *1 0,0
RFB_t0 FB__t0 FB 165.0756
* device instance FB_t1 r0 *1 0,0
RFB_t1 FB__t1 FB 165.0756
* device instance FB r0 *1 0,0
CFB FB vsubs 7.2643492e-14
* device instance P0_t0 r0 *1 0,0
RP0_t0 P0__t0 P0 95.48695
* device instance P0_t1 r0 *1 0,0
RP0_t1 P0__t1 P0 95.48695
* device instance P0 r0 *1 0,0
CP0 P0 vsubs 4.1920864e-14
* device instance P1_t0 r0 *1 0,0
RP1_t0 P1__t0 P1 106.66265
* device instance P1_t1 r0 *1 0,0
RP1_t1 P1__t1 P1 106.66265
* device instance P1 r0 *1 0,0
CP1 P1 vsubs 4.6880563e-14
* device instance P2_t0 r0 *1 0,0
RP2_t0 P2__t0 P2 117.83845
* device instance P2_t1 r0 *1 0,0
RP2_t1 P2__t1 P2 117.83845
* device instance P2 r0 *1 0,0
CP2 P2 vsubs 5.1840262e-14
* device instance P3_t0 r0 *1 0,0
RP3_t0 P3__t0 P3 129.01425
* device instance P3_t1 r0 *1 0,0
RP3_t1 P3__t1 P3 129.01425
* device instance P3 r0 *1 0,0
CP3 P3 vsubs 5.6799961e-14
* device instance P4_t0 r0 *1 0,0
RP4_t0 P4__t0 P4 140.19005
* device instance P4_t1 r0 *1 0,0
RP4_t1 P4__t1 P4 140.19005
* device instance P4 r0 *1 0,0
CP4 P4 vsubs 6.175966e-14
* device instance P5_t0 r0 *1 0,0
RP5_t0 P5__t0 P5 151.3659
* device instance P5_t1 r0 *1 0,0
RP5_t1 P5__t1 P5 151.3659
* device instance P5 r0 *1 0,0
CP5 P5 vsubs 6.6719359e-14
* device instance VDD_DIV_t0 r0 *1 0,0
RVDD_DIV_t0 VDD_DIV__t0 VDD_DIV 8.37518349835
* device instance VDD_DIV_t1 r0 *1 0,0
RVDD_DIV_t1 VDD_DIV__t1 VDD_DIV 8.37518349835
* device instance VDD_DIV_t2 r0 *1 0,0
RVDD_DIV_t2 VDD_DIV__t2 VDD_DIV 5.13712006493
* device instance VDD_DIV_t3 r0 *1 0,0
RVDD_DIV_t3 VDD_DIV__t3 VDD_DIV 6.65049806402
* device instance VDD_DIV_t4 r0 *1 0,0
RVDD_DIV_t4 VDD_DIV__t4 VDD_DIV 0.5920966459
* device instance VDD_DIV_t5 r0 *1 0,0
RVDD_DIV_t5 VDD_DIV__t5 VDD_DIV 0.375899788888
* device instance VDD_DIV_t6 r0 *1 0,0
RVDD_DIV_t6 VDD_DIV__t6 VDD_DIV 0.267801360382
* device instance VDD_DIV_t7 r0 *1 0,0
RVDD_DIV_t7 VDD_DIV__t7 VDD_DIV 0.159702931875
* device instance VDD_DIV_t8 r0 *1 0,0
RVDD_DIV_t8 VDD_DIV__t8 VDD_DIV 0.0516045033689
* device instance VDD_DIV_t9 r0 *1 0,0
RVDD_DIV_t9 VDD_DIV__t9 VDD_DIV 0.0564939251374
* device instance VDD_DIV_t10 r0 *1 0,0
RVDD_DIV_t10 VDD_DIV__t10 VDD_DIV 0.164592353644
* device instance VDD_DIV_t11 r0 *1 0,0
RVDD_DIV_t11 VDD_DIV__t11 VDD_DIV 4.80793535765
* device instance VDD_DIV_t12 r0 *1 0,0
RVDD_DIV_t12 VDD_DIV__t12 VDD_DIV 0.380789210656
* device instance VDD_DIV_t13 r0 *1 0,0
RVDD_DIV_t13 VDD_DIV__t13 VDD_DIV 0.596986067669
* device instance VDD_DIV_t14 r0 *1 0,0
RVDD_DIV_t14 VDD_DIV__t14 VDD_DIV 0.921281353188
* device instance VDD_DIV_t15 r0 *1 0,0
RVDD_DIV_t15 VDD_DIV__t15 VDD_DIV 1.1374782102
* device instance VDD_DIV_t16 r0 *1 0,0
RVDD_DIV_t16 VDD_DIV__t16 VDD_DIV 1.24557663871
* device instance VDD_DIV_t17 r0 *1 0,0
RVDD_DIV_t17 VDD_DIV__t17 VDD_DIV 2.75406521603
* device instance VDD_DIV_t18 r0 *1 0,0
RVDD_DIV_t18 VDD_DIV__t18 VDD_DIV 2.64596678752
* device instance VDD_DIV_t19 r0 *1 0,0
RVDD_DIV_t19 VDD_DIV__t19 VDD_DIV 2.53786835901
* device instance VDD_DIV_t20 r0 *1 0,0
RVDD_DIV_t20 VDD_DIV__t20 VDD_DIV 2.321671502
* device instance VDD_DIV_t21 r0 *1 0,0
RVDD_DIV_t21 VDD_DIV__t21 VDD_DIV 2.10547464499
* device instance VDD_DIV_t22 r0 *1 0,0
RVDD_DIV_t22 VDD_DIV__t22 VDD_DIV 1.56498250246
* device instance VDD_DIV_t23 r0 *1 0,0
RVDD_DIV_t23 VDD_DIV__t23 VDD_DIV 1.45688407395
* device instance VDD_DIV_t24 r0 *1 0,0
RVDD_DIV_t24 VDD_DIV__t24 VDD_DIV 1.34878564544
* device instance VDD_DIV_t25 r0 *1 0,0
RVDD_DIV_t25 VDD_DIV__t25 VDD_DIV 1.24068721694
* device instance VDD_DIV_t26 r0 *1 0,0
RVDD_DIV_t26 VDD_DIV__t26 VDD_DIV 1.13258878843
* device instance VDD_DIV_t27 r0 *1 0,0
RVDD_DIV_t27 VDD_DIV__t27 VDD_DIV 0.916391931419
* device instance VDD_DIV_t28 r0 *1 0,0
RVDD_DIV_t28 VDD_DIV__t28 VDD_DIV 1.78117935947
* device instance VDD_DIV_t29 r0 *1 0,0
RVDD_DIV_t29 VDD_DIV__t29 VDD_DIV 6.75370707076
* device instance VDD_DIV_t30 r0 *1 0,0
RVDD_DIV_t30 VDD_DIV__t30 VDD_DIV 6.64560864225
* device instance VDD_DIV_t31 r0 *1 0,0
RVDD_DIV_t31 VDD_DIV__t31 VDD_DIV 6.53751021375
* device instance VDD_DIV_t32 r0 *1 0,0
RVDD_DIV_t32 VDD_DIV__t32 VDD_DIV 6.32131335673
* device instance VDD_DIV_t33 r0 *1 0,0
RVDD_DIV_t33 VDD_DIV__t33 VDD_DIV 5.99701807122
* device instance VDD_DIV_t34 r0 *1 0,0
RVDD_DIV_t34 VDD_DIV__t34 VDD_DIV 1.35367506721
* device instance VDD_DIV_t35 r0 *1 0,0
RVDD_DIV_t35 VDD_DIV__t35 VDD_DIV 5.7808212142
* device instance VDD_DIV_t36 r0 *1 0,0
RVDD_DIV_t36 VDD_DIV__t36 VDD_DIV 5.6727227857
* device instance VDD_DIV_t37 r0 *1 0,0
RVDD_DIV_t37 VDD_DIV__t37 VDD_DIV 5.56462435719
* device instance VDD_DIV_t38 r0 *1 0,0
RVDD_DIV_t38 VDD_DIV__t38 VDD_DIV 5.45652592868
* device instance VDD_DIV_t39 r0 *1 0,0
RVDD_DIV_t39 VDD_DIV__t39 VDD_DIV 5.34842750018
* device instance VDD_DIV_t40 r0 *1 0,0
RVDD_DIV_t40 VDD_DIV__t40 VDD_DIV 5.24032907167
* device instance VDD_DIV_t41 r0 *1 0,0
RVDD_DIV_t41 VDD_DIV__t41 VDD_DIV 5.02413221466
* device instance VDD_DIV_t42 r0 *1 0,0
RVDD_DIV_t42 VDD_DIV__t42 VDD_DIV 1.46177349572
* device instance VDD_DIV_t43 r0 *1 0,0
RVDD_DIV_t43 VDD_DIV__t43 VDD_DIV 1.56987192423
* device instance VDD_DIV_t44 r0 *1 0,0
RVDD_DIV_t44 VDD_DIV__t44 VDD_DIV 1.78606878124
* device instance VDD_DIV_t45 r0 *1 0,0
RVDD_DIV_t45 VDD_DIV__t45 VDD_DIV 8.26708506985
* device instance VDD_DIV_t46 r0 *1 0,0
RVDD_DIV_t46 VDD_DIV__t46 VDD_DIV 8.15898664134
* device instance VDD_DIV_t47 r0 *1 0,0
RVDD_DIV_t47 VDD_DIV__t47 VDD_DIV 8.05088821284
* device instance VDD_DIV_t48 r0 *1 0,0
RVDD_DIV_t48 VDD_DIV__t48 VDD_DIV 6.86180549927
* device instance VDD_DIV_t49 r0 *1 0,0
RVDD_DIV_t49 VDD_DIV__t49 VDD_DIV 7.72659292732
* device instance VDD_DIV_t50 r0 *1 0,0
RVDD_DIV_t50 VDD_DIV__t50 VDD_DIV 7.5103960703
* device instance VDD_DIV_t51 r0 *1 0,0
RVDD_DIV_t51 VDD_DIV__t51 VDD_DIV 7.18610078478
* device instance VDD_DIV_t52 r0 *1 0,0
RVDD_DIV_t52 VDD_DIV__t52 VDD_DIV 6.96990392777
* device instance VDD_DIV_t53 r0 *1 0,0
RVDD_DIV_t53 VDD_DIV__t53 VDD_DIV 7.94278978433
* device instance VDD_DIV_t54 r0 *1 0,0
RVDD_DIV_t54 VDD_DIV__t54 VDD_DIV 4.05613577987
* device instance VDD_DIV_t55 r0 *1 0,0
RVDD_DIV_t55 VDD_DIV__t55 VDD_DIV 4.16423420838
* device instance VDD_DIV_t56 r0 *1 0,0
RVDD_DIV_t56 VDD_DIV__t56 VDD_DIV 4.27233263688
* device instance VDD_DIV_t57 r0 *1 0,0
RVDD_DIV_t57 VDD_DIV__t57 VDD_DIV 4.4885294939
* device instance VDD_DIV_t58 r0 *1 0,0
RVDD_DIV_t58 VDD_DIV__t58 VDD_DIV 4.81282477941
* device instance VDD_DIV_t59 r0 *1 0,0
RVDD_DIV_t59 VDD_DIV__t59 VDD_DIV 2.86216364453
* device instance VDD_DIV_t60 r0 *1 0,0
RVDD_DIV_t60 VDD_DIV__t60 VDD_DIV 5.02902163643
* device instance VDD_DIV_t61 r0 *1 0,0
RVDD_DIV_t61 VDD_DIV__t61 VDD_DIV 5.13712006493
* device instance VDD_DIV_t62 r0 *1 0,0
RVDD_DIV_t62 VDD_DIV__t62 VDD_DIV 5.24521849344
* device instance VDD_DIV_t63 r0 *1 0,0
RVDD_DIV_t63 VDD_DIV__t63 VDD_DIV 5.35331692195
* device instance VDD_DIV_t64 r0 *1 0,0
RVDD_DIV_t64 VDD_DIV__t64 VDD_DIV 5.46141535045
* device instance VDD_DIV_t65 r0 *1 0,0
RVDD_DIV_t65 VDD_DIV__t65 VDD_DIV 5.56951377896
* device instance VDD_DIV_t66 r0 *1 0,0
RVDD_DIV_t66 VDD_DIV__t66 VDD_DIV 5.78571063597
* device instance VDD_DIV_t67 r0 *1 0,0
RVDD_DIV_t67 VDD_DIV__t67 VDD_DIV 2.11036406676
* device instance VDD_DIV_t68 r0 *1 0,0
RVDD_DIV_t68 VDD_DIV__t68 VDD_DIV 2.32656092377
* device instance VDD_DIV_t69 r0 *1 0,0
RVDD_DIV_t69 VDD_DIV__t69 VDD_DIV 2.43465935228
* device instance VDD_DIV_t70 r0 *1 0,0
RVDD_DIV_t70 VDD_DIV__t70 VDD_DIV 2.54275778078
* device instance VDD_DIV_t71 r0 *1 0,0
RVDD_DIV_t71 VDD_DIV__t71 VDD_DIV 2.65085620929
* device instance VDD_DIV_t72 r0 *1 0,0
RVDD_DIV_t72 VDD_DIV__t72 VDD_DIV 2.75895463779
* device instance VDD_DIV_t73 r0 *1 0,0
RVDD_DIV_t73 VDD_DIV__t73 VDD_DIV 3.94803735136
* device instance VDD_DIV_t74 r0 *1 0,0
RVDD_DIV_t74 VDD_DIV__t74 VDD_DIV 3.08324992331
* device instance VDD_DIV_t75 r0 *1 0,0
RVDD_DIV_t75 VDD_DIV__t75 VDD_DIV 3.29944678033
* device instance VDD_DIV_t76 r0 *1 0,0
RVDD_DIV_t76 VDD_DIV__t76 VDD_DIV 3.62374206585
* device instance VDD_DIV_t77 r0 *1 0,0
RVDD_DIV_t77 VDD_DIV__t77 VDD_DIV 3.83993892286
* device instance VDD_DIV_t78 r0 *1 0,0
RVDD_DIV_t78 VDD_DIV__t78 VDD_DIV 2.8670530663
* device instance VDD_DIV_t79 r0 *1 0,0
RVDD_DIV_t79 VDD_DIV__t79 VDD_DIV 8.38007292012
* device instance VDD_DIV_t80 r0 *1 0,0
RVDD_DIV_t80 VDD_DIV__t80 VDD_DIV 8.59626977714
* device instance VDD_DIV_t81 r0 *1 0,0
RVDD_DIV_t81 VDD_DIV__t81 VDD_DIV 4.48364007213
* device instance VDD_DIV_t82 r0 *1 0,0
RVDD_DIV_t82 VDD_DIV__t82 VDD_DIV 4.26744321511
* device instance VDD_DIV_t83 r0 *1 0,0
RVDD_DIV_t83 VDD_DIV__t83 VDD_DIV 4.15934478661
* device instance VDD_DIV_t84 r0 *1 0,0
RVDD_DIV_t84 VDD_DIV__t84 VDD_DIV 4.0512463581
* device instance VDD_DIV_t85 r0 *1 0,0
RVDD_DIV_t85 VDD_DIV__t85 VDD_DIV 6.00190749298
* device instance VDD_DIV_t86 r0 *1 0,0
RVDD_DIV_t86 VDD_DIV__t86 VDD_DIV 3.83504950109
* device instance VDD_DIV_t87 r0 *1 0,0
RVDD_DIV_t87 VDD_DIV__t87 VDD_DIV 3.61885264408
* device instance VDD_DIV_t88 r0 *1 0,0
RVDD_DIV_t88 VDD_DIV__t88 VDD_DIV 3.29455735856
* device instance VDD_DIV_t89 r0 *1 0,0
RVDD_DIV_t89 VDD_DIV__t89 VDD_DIV 3.07836050155
* device instance VDD_DIV_t90 r0 *1 0,0
RVDD_DIV_t90 VDD_DIV__t90 VDD_DIV 2.97026207304
* device instance VDD_DIV_t91 r0 *1 0,0
RVDD_DIV_t91 VDD_DIV__t91 VDD_DIV 3.9431479296
* device instance VDD_DIV_t92 r0 *1 0,0
RVDD_DIV_t92 VDD_DIV__t92 VDD_DIV 6.3262027785
* device instance VDD_DIV_t93 r0 *1 0,0
RVDD_DIV_t93 VDD_DIV__t93 VDD_DIV 6.54239963552
* device instance VDD_DIV_t94 r0 *1 0,0
RVDD_DIV_t94 VDD_DIV__t94 VDD_DIV 6.65049806402
* device instance VDD_DIV_t95 r0 *1 0,0
RVDD_DIV_t95 VDD_DIV__t95 VDD_DIV 6.75859649253
* device instance VDD_DIV_t96 r0 *1 0,0
RVDD_DIV_t96 VDD_DIV__t96 VDD_DIV 6.86669492103
* device instance VDD_DIV_t97 r0 *1 0,0
RVDD_DIV_t97 VDD_DIV__t97 VDD_DIV 6.97479334954
* device instance VDD_DIV_t98 r0 *1 0,0
RVDD_DIV_t98 VDD_DIV__t98 VDD_DIV 7.19099020655
* device instance VDD_DIV_t99 r0 *1 0,0
RVDD_DIV_t99 VDD_DIV__t99 VDD_DIV 7.51528549207
* device instance VDD_DIV_t100 r0 *1 0,0
RVDD_DIV_t100 VDD_DIV__t100 VDD_DIV 7.73148234908
* device instance VDD_DIV_t101 r0 *1 0,0
RVDD_DIV_t101 VDD_DIV__t101 VDD_DIV 7.83958077759
* device instance VDD_DIV_t102 r0 *1 0,0
RVDD_DIV_t102 VDD_DIV__t102 VDD_DIV 8.0557776346
* device instance VDD_DIV_t103 r0 *1 0,0
RVDD_DIV_t103 VDD_DIV__t103 VDD_DIV 0.5920966459
* device instance VDD_DIV_t104 r0 *1 0,0
RVDD_DIV_t104 VDD_DIV__t104 VDD_DIV 0.483998217394
* device instance VDD_DIV_t105 r0 *1 0,0
RVDD_DIV_t105 VDD_DIV__t105 VDD_DIV 0.375899788888
* device instance VDD_DIV_t106 r0 *1 0,0
RVDD_DIV_t106 VDD_DIV__t106 VDD_DIV 0.267801360382
* device instance VDD_DIV_t107 r0 *1 0,0
RVDD_DIV_t107 VDD_DIV__t107 VDD_DIV 0.159702931875
* device instance VDD_DIV_t108 r0 *1 0,0
RVDD_DIV_t108 VDD_DIV__t108 VDD_DIV 0.0516045033689
* device instance VDD_DIV_t109 r0 *1 0,0
RVDD_DIV_t109 VDD_DIV__t109 VDD_DIV 0.0564939251374
* device instance VDD_DIV_t110 r0 *1 0,0
RVDD_DIV_t110 VDD_DIV__t110 VDD_DIV 0.164592353644
* device instance VDD_DIV_t111 r0 *1 0,0
RVDD_DIV_t111 VDD_DIV__t111 VDD_DIV 4.80793535765
* device instance VDD_DIV_t112 r0 *1 0,0
RVDD_DIV_t112 VDD_DIV__t112 VDD_DIV 0.380789210656
* device instance VDD_DIV_t113 r0 *1 0,0
RVDD_DIV_t113 VDD_DIV__t113 VDD_DIV 0.488887639163
* device instance VDD_DIV_t114 r0 *1 0,0
RVDD_DIV_t114 VDD_DIV__t114 VDD_DIV 0.596986067669
* device instance VDD_DIV_t115 r0 *1 0,0
RVDD_DIV_t115 VDD_DIV__t115 VDD_DIV 0.705084496175
* device instance VDD_DIV_t116 r0 *1 0,0
RVDD_DIV_t116 VDD_DIV__t116 VDD_DIV 0.813182924681
* device instance VDD_DIV_t117 r0 *1 0,0
RVDD_DIV_t117 VDD_DIV__t117 VDD_DIV 0.921281353188
* device instance VDD_DIV_t118 r0 *1 0,0
RVDD_DIV_t118 VDD_DIV__t118 VDD_DIV 1.02937978169
* device instance VDD_DIV_t119 r0 *1 0,0
RVDD_DIV_t119 VDD_DIV__t119 VDD_DIV 1.1374782102
* device instance VDD_DIV_t120 r0 *1 0,0
RVDD_DIV_t120 VDD_DIV__t120 VDD_DIV 1.24557663871
* device instance VDD_DIV_t121 r0 *1 0,0
RVDD_DIV_t121 VDD_DIV__t121 VDD_DIV 0.27269078215
* device instance VDD_DIV_t122 r0 *1 0,0
RVDD_DIV_t122 VDD_DIV__t122 VDD_DIV 2.75406521603
* device instance VDD_DIV_t123 r0 *1 0,0
RVDD_DIV_t123 VDD_DIV__t123 VDD_DIV 2.64596678752
* device instance VDD_DIV_t124 r0 *1 0,0
RVDD_DIV_t124 VDD_DIV__t124 VDD_DIV 2.53786835901
* device instance VDD_DIV_t125 r0 *1 0,0
RVDD_DIV_t125 VDD_DIV__t125 VDD_DIV 2.42976993051
* device instance VDD_DIV_t126 r0 *1 0,0
RVDD_DIV_t126 VDD_DIV__t126 VDD_DIV 2.321671502
* device instance VDD_DIV_t127 r0 *1 0,0
RVDD_DIV_t127 VDD_DIV__t127 VDD_DIV 2.21357307349
* device instance VDD_DIV_t128 r0 *1 0,0
RVDD_DIV_t128 VDD_DIV__t128 VDD_DIV 2.10547464499
* device instance VDD_DIV_t129 r0 *1 0,0
RVDD_DIV_t129 VDD_DIV__t129 VDD_DIV 1.99737621648
* device instance VDD_DIV_t130 r0 *1 0,0
RVDD_DIV_t130 VDD_DIV__t130 VDD_DIV 1.88927778798
* device instance VDD_DIV_t131 r0 *1 0,0
RVDD_DIV_t131 VDD_DIV__t131 VDD_DIV 0.700195074407
* device instance VDD_DIV_t132 r0 *1 0,0
RVDD_DIV_t132 VDD_DIV__t132 VDD_DIV 1.67308093096
* device instance VDD_DIV_t133 r0 *1 0,0
RVDD_DIV_t133 VDD_DIV__t133 VDD_DIV 1.56498250246
* device instance VDD_DIV_t134 r0 *1 0,0
RVDD_DIV_t134 VDD_DIV__t134 VDD_DIV 1.45688407395
* device instance VDD_DIV_t135 r0 *1 0,0
RVDD_DIV_t135 VDD_DIV__t135 VDD_DIV 1.34878564544
* device instance VDD_DIV_t136 r0 *1 0,0
RVDD_DIV_t136 VDD_DIV__t136 VDD_DIV 1.24068721694
* device instance VDD_DIV_t137 r0 *1 0,0
RVDD_DIV_t137 VDD_DIV__t137 VDD_DIV 1.13258878843
* device instance VDD_DIV_t138 r0 *1 0,0
RVDD_DIV_t138 VDD_DIV__t138 VDD_DIV 1.02449035993
* device instance VDD_DIV_t139 r0 *1 0,0
RVDD_DIV_t139 VDD_DIV__t139 VDD_DIV 0.916391931419
* device instance VDD_DIV_t140 r0 *1 0,0
RVDD_DIV_t140 VDD_DIV__t140 VDD_DIV 0.808293502913
* device instance VDD_DIV_t141 r0 *1 0,0
RVDD_DIV_t141 VDD_DIV__t141 VDD_DIV 1.78117935947
* device instance VDD_DIV_t142 r0 *1 0,0
RVDD_DIV_t142 VDD_DIV__t142 VDD_DIV 6.75370707076
* device instance VDD_DIV_t143 r0 *1 0,0
RVDD_DIV_t143 VDD_DIV__t143 VDD_DIV 6.64560864225
* device instance VDD_DIV_t144 r0 *1 0,0
RVDD_DIV_t144 VDD_DIV__t144 VDD_DIV 6.53751021375
* device instance VDD_DIV_t145 r0 *1 0,0
RVDD_DIV_t145 VDD_DIV__t145 VDD_DIV 6.42941178524
* device instance VDD_DIV_t146 r0 *1 0,0
RVDD_DIV_t146 VDD_DIV__t146 VDD_DIV 6.32131335673
* device instance VDD_DIV_t147 r0 *1 0,0
RVDD_DIV_t147 VDD_DIV__t147 VDD_DIV 6.21321492823
* device instance VDD_DIV_t148 r0 *1 0,0
RVDD_DIV_t148 VDD_DIV__t148 VDD_DIV 6.10511649972
* device instance VDD_DIV_t149 r0 *1 0,0
RVDD_DIV_t149 VDD_DIV__t149 VDD_DIV 5.99701807122
* device instance VDD_DIV_t150 r0 *1 0,0
RVDD_DIV_t150 VDD_DIV__t150 VDD_DIV 1.35367506721
* device instance VDD_DIV_t151 r0 *1 0,0
RVDD_DIV_t151 VDD_DIV__t151 VDD_DIV 5.7808212142
* device instance VDD_DIV_t152 r0 *1 0,0
RVDD_DIV_t152 VDD_DIV__t152 VDD_DIV 5.6727227857
* device instance VDD_DIV_t153 r0 *1 0,0
RVDD_DIV_t153 VDD_DIV__t153 VDD_DIV 5.56462435719
* device instance VDD_DIV_t154 r0 *1 0,0
RVDD_DIV_t154 VDD_DIV__t154 VDD_DIV 5.45652592868
* device instance VDD_DIV_t155 r0 *1 0,0
RVDD_DIV_t155 VDD_DIV__t155 VDD_DIV 5.34842750018
* device instance VDD_DIV_t156 r0 *1 0,0
RVDD_DIV_t156 VDD_DIV__t156 VDD_DIV 5.24032907167
* device instance VDD_DIV_t157 r0 *1 0,0
RVDD_DIV_t157 VDD_DIV__t157 VDD_DIV 5.13223064317
* device instance VDD_DIV_t158 r0 *1 0,0
RVDD_DIV_t158 VDD_DIV__t158 VDD_DIV 5.02413221466
* device instance VDD_DIV_t159 r0 *1 0,0
RVDD_DIV_t159 VDD_DIV__t159 VDD_DIV 4.91603378615
* device instance VDD_DIV_t160 r0 *1 0,0
RVDD_DIV_t160 VDD_DIV__t160 VDD_DIV 5.88891964271
* device instance VDD_DIV_t161 r0 *1 0,0
RVDD_DIV_t161 VDD_DIV__t161 VDD_DIV 1.46177349572
* device instance VDD_DIV_t162 r0 *1 0,0
RVDD_DIV_t162 VDD_DIV__t162 VDD_DIV 1.56987192423
* device instance VDD_DIV_t163 r0 *1 0,0
RVDD_DIV_t163 VDD_DIV__t163 VDD_DIV 1.67797035273
* device instance VDD_DIV_t164 r0 *1 0,0
RVDD_DIV_t164 VDD_DIV__t164 VDD_DIV 1.78606878124
* device instance VDD_DIV_t165 r0 *1 0,0
RVDD_DIV_t165 VDD_DIV__t165 VDD_DIV 4.69983692914
* device instance VDD_DIV_t166 r0 *1 0,0
RVDD_DIV_t166 VDD_DIV__t166 VDD_DIV 4.59173850063
* device instance VDD_DIV_t167 r0 *1 0,0
RVDD_DIV_t167 VDD_DIV__t167 VDD_DIV 8.26708506985
* device instance VDD_DIV_t168 r0 *1 0,0
RVDD_DIV_t168 VDD_DIV__t168 VDD_DIV 8.15898664134
* device instance VDD_DIV_t169 r0 *1 0,0
RVDD_DIV_t169 VDD_DIV__t169 VDD_DIV 8.05088821284
* device instance VDD_DIV_t170 r0 *1 0,0
RVDD_DIV_t170 VDD_DIV__t170 VDD_DIV 6.86180549927
* device instance VDD_DIV_t171 r0 *1 0,0
RVDD_DIV_t171 VDD_DIV__t171 VDD_DIV 7.83469135582
* device instance VDD_DIV_t172 r0 *1 0,0
RVDD_DIV_t172 VDD_DIV__t172 VDD_DIV 7.72659292732
* device instance VDD_DIV_t173 r0 *1 0,0
RVDD_DIV_t173 VDD_DIV__t173 VDD_DIV 7.61849449881
* device instance VDD_DIV_t174 r0 *1 0,0
RVDD_DIV_t174 VDD_DIV__t174 VDD_DIV 7.5103960703
* device instance VDD_DIV_t175 r0 *1 0,0
RVDD_DIV_t175 VDD_DIV__t175 VDD_DIV 7.4022976418
* device instance VDD_DIV_t176 r0 *1 0,0
RVDD_DIV_t176 VDD_DIV__t176 VDD_DIV 7.29419921329
* device instance VDD_DIV_t177 r0 *1 0,0
RVDD_DIV_t177 VDD_DIV__t177 VDD_DIV 7.18610078478
* device instance VDD_DIV_t178 r0 *1 0,0
RVDD_DIV_t178 VDD_DIV__t178 VDD_DIV 7.07800235628
* device instance VDD_DIV_t179 r0 *1 0,0
RVDD_DIV_t179 VDD_DIV__t179 VDD_DIV 6.96990392777
* device instance VDD_DIV_t180 r0 *1 0,0
RVDD_DIV_t180 VDD_DIV__t180 VDD_DIV 7.94278978433
* device instance VDD_DIV_t181 r0 *1 0,0
RVDD_DIV_t181 VDD_DIV__t181 VDD_DIV 4.05613577987
* device instance VDD_DIV_t182 r0 *1 0,0
RVDD_DIV_t182 VDD_DIV__t182 VDD_DIV 4.16423420838
* device instance VDD_DIV_t183 r0 *1 0,0
RVDD_DIV_t183 VDD_DIV__t183 VDD_DIV 4.27233263688
* device instance VDD_DIV_t184 r0 *1 0,0
RVDD_DIV_t184 VDD_DIV__t184 VDD_DIV 4.38043106539
* device instance VDD_DIV_t185 r0 *1 0,0
RVDD_DIV_t185 VDD_DIV__t185 VDD_DIV 4.4885294939
* device instance VDD_DIV_t186 r0 *1 0,0
RVDD_DIV_t186 VDD_DIV__t186 VDD_DIV 4.5966279224
* device instance VDD_DIV_t187 r0 *1 0,0
RVDD_DIV_t187 VDD_DIV__t187 VDD_DIV 4.70472635091
* device instance VDD_DIV_t188 r0 *1 0,0
RVDD_DIV_t188 VDD_DIV__t188 VDD_DIV 4.81282477941
* device instance VDD_DIV_t189 r0 *1 0,0
RVDD_DIV_t189 VDD_DIV__t189 VDD_DIV 2.86216364453
* device instance VDD_DIV_t190 r0 *1 0,0
RVDD_DIV_t190 VDD_DIV__t190 VDD_DIV 5.02902163643
* device instance VDD_DIV_t191 r0 *1 0,0
RVDD_DIV_t191 VDD_DIV__t191 VDD_DIV 5.13712006493
* device instance VDD_DIV_t192 r0 *1 0,0
RVDD_DIV_t192 VDD_DIV__t192 VDD_DIV 5.24521849344
* device instance VDD_DIV_t193 r0 *1 0,0
RVDD_DIV_t193 VDD_DIV__t193 VDD_DIV 5.35331692195
* device instance VDD_DIV_t194 r0 *1 0,0
RVDD_DIV_t194 VDD_DIV__t194 VDD_DIV 5.46141535045
* device instance VDD_DIV_t195 r0 *1 0,0
RVDD_DIV_t195 VDD_DIV__t195 VDD_DIV 5.56951377896
* device instance VDD_DIV_t196 r0 *1 0,0
RVDD_DIV_t196 VDD_DIV__t196 VDD_DIV 5.67761220747
* device instance VDD_DIV_t197 r0 *1 0,0
RVDD_DIV_t197 VDD_DIV__t197 VDD_DIV 5.78571063597
* device instance VDD_DIV_t198 r0 *1 0,0
RVDD_DIV_t198 VDD_DIV__t198 VDD_DIV 5.89380906448
* device instance VDD_DIV_t199 r0 *1 0,0
RVDD_DIV_t199 VDD_DIV__t199 VDD_DIV 4.92092320792
* device instance VDD_DIV_t200 r0 *1 0,0
RVDD_DIV_t200 VDD_DIV__t200 VDD_DIV 1.89416720974
* device instance VDD_DIV_t201 r0 *1 0,0
RVDD_DIV_t201 VDD_DIV__t201 VDD_DIV 2.00226563825
* device instance VDD_DIV_t202 r0 *1 0,0
RVDD_DIV_t202 VDD_DIV__t202 VDD_DIV 2.11036406676
* device instance VDD_DIV_t203 r0 *1 0,0
RVDD_DIV_t203 VDD_DIV__t203 VDD_DIV 2.21846249526
* device instance VDD_DIV_t204 r0 *1 0,0
RVDD_DIV_t204 VDD_DIV__t204 VDD_DIV 2.32656092377
* device instance VDD_DIV_t205 r0 *1 0,0
RVDD_DIV_t205 VDD_DIV__t205 VDD_DIV 2.43465935228
* device instance VDD_DIV_t206 r0 *1 0,0
RVDD_DIV_t206 VDD_DIV__t206 VDD_DIV 2.54275778078
* device instance VDD_DIV_t207 r0 *1 0,0
RVDD_DIV_t207 VDD_DIV__t207 VDD_DIV 2.65085620929
* device instance VDD_DIV_t208 r0 *1 0,0
RVDD_DIV_t208 VDD_DIV__t208 VDD_DIV 2.75895463779
* device instance VDD_DIV_t209 r0 *1 0,0
RVDD_DIV_t209 VDD_DIV__t209 VDD_DIV 3.94803735136
* device instance VDD_DIV_t210 r0 *1 0,0
RVDD_DIV_t210 VDD_DIV__t210 VDD_DIV 2.97515149481
* device instance VDD_DIV_t211 r0 *1 0,0
RVDD_DIV_t211 VDD_DIV__t211 VDD_DIV 3.08324992331
* device instance VDD_DIV_t212 r0 *1 0,0
RVDD_DIV_t212 VDD_DIV__t212 VDD_DIV 3.19134835182
* device instance VDD_DIV_t213 r0 *1 0,0
RVDD_DIV_t213 VDD_DIV__t213 VDD_DIV 3.29944678033
* device instance VDD_DIV_t214 r0 *1 0,0
RVDD_DIV_t214 VDD_DIV__t214 VDD_DIV 3.40754520883
* device instance VDD_DIV_t215 r0 *1 0,0
RVDD_DIV_t215 VDD_DIV__t215 VDD_DIV 3.51564363734
* device instance VDD_DIV_t216 r0 *1 0,0
RVDD_DIV_t216 VDD_DIV__t216 VDD_DIV 3.62374206585
* device instance VDD_DIV_t217 r0 *1 0,0
RVDD_DIV_t217 VDD_DIV__t217 VDD_DIV 3.73184049435
* device instance VDD_DIV_t218 r0 *1 0,0
RVDD_DIV_t218 VDD_DIV__t218 VDD_DIV 3.83993892286
* device instance VDD_DIV_t219 r0 *1 0,0
RVDD_DIV_t219 VDD_DIV__t219 VDD_DIV 2.8670530663
* device instance VDD_DIV_t220 r0 *1 0,0
RVDD_DIV_t220 VDD_DIV__t220 VDD_DIV 8.27197449162
* device instance VDD_DIV_t221 r0 *1 0,0
RVDD_DIV_t221 VDD_DIV__t221 VDD_DIV 8.38007292012
* device instance VDD_DIV_t222 r0 *1 0,0
RVDD_DIV_t222 VDD_DIV__t222 VDD_DIV 8.48817134863
* device instance VDD_DIV_t223 r0 *1 0,0
RVDD_DIV_t223 VDD_DIV__t223 VDD_DIV 8.59626977714
* device instance VDD_DIV_t224 r0 *1 0,0
RVDD_DIV_t224 VDD_DIV__t224 VDD_DIV 4.48364007213
* device instance VDD_DIV_t225 r0 *1 0,0
RVDD_DIV_t225 VDD_DIV__t225 VDD_DIV 4.37554164362
* device instance VDD_DIV_t226 r0 *1 0,0
RVDD_DIV_t226 VDD_DIV__t226 VDD_DIV 4.26744321511
* device instance VDD_DIV_t227 r0 *1 0,0
RVDD_DIV_t227 VDD_DIV__t227 VDD_DIV 4.15934478661
* device instance VDD_DIV_t228 r0 *1 0,0
RVDD_DIV_t228 VDD_DIV__t228 VDD_DIV 4.0512463581
* device instance VDD_DIV_t229 r0 *1 0,0
RVDD_DIV_t229 VDD_DIV__t229 VDD_DIV 6.00190749298
* device instance VDD_DIV_t230 r0 *1 0,0
RVDD_DIV_t230 VDD_DIV__t230 VDD_DIV 3.83504950109
* device instance VDD_DIV_t231 r0 *1 0,0
RVDD_DIV_t231 VDD_DIV__t231 VDD_DIV 3.72695107258
* device instance VDD_DIV_t232 r0 *1 0,0
RVDD_DIV_t232 VDD_DIV__t232 VDD_DIV 3.61885264408
* device instance VDD_DIV_t233 r0 *1 0,0
RVDD_DIV_t233 VDD_DIV__t233 VDD_DIV 3.51075421557
* device instance VDD_DIV_t234 r0 *1 0,0
RVDD_DIV_t234 VDD_DIV__t234 VDD_DIV 3.40265578706
* device instance VDD_DIV_t235 r0 *1 0,0
RVDD_DIV_t235 VDD_DIV__t235 VDD_DIV 3.29455735856
* device instance VDD_DIV_t236 r0 *1 0,0
RVDD_DIV_t236 VDD_DIV__t236 VDD_DIV 3.18645893005
* device instance VDD_DIV_t237 r0 *1 0,0
RVDD_DIV_t237 VDD_DIV__t237 VDD_DIV 3.07836050155
* device instance VDD_DIV_t238 r0 *1 0,0
RVDD_DIV_t238 VDD_DIV__t238 VDD_DIV 2.97026207304
* device instance VDD_DIV_t239 r0 *1 0,0
RVDD_DIV_t239 VDD_DIV__t239 VDD_DIV 3.9431479296
* device instance VDD_DIV_t240 r0 *1 0,0
RVDD_DIV_t240 VDD_DIV__t240 VDD_DIV 6.11000592149
* device instance VDD_DIV_t241 r0 *1 0,0
RVDD_DIV_t241 VDD_DIV__t241 VDD_DIV 6.21810435
* device instance VDD_DIV_t242 r0 *1 0,0
RVDD_DIV_t242 VDD_DIV__t242 VDD_DIV 6.3262027785
* device instance VDD_DIV_t243 r0 *1 0,0
RVDD_DIV_t243 VDD_DIV__t243 VDD_DIV 6.43430120701
* device instance VDD_DIV_t244 r0 *1 0,0
RVDD_DIV_t244 VDD_DIV__t244 VDD_DIV 6.54239963552
* device instance VDD_DIV_t245 r0 *1 0,0
RVDD_DIV_t245 VDD_DIV__t245 VDD_DIV 6.65049806402
* device instance VDD_DIV_t246 r0 *1 0,0
RVDD_DIV_t246 VDD_DIV__t246 VDD_DIV 6.75859649253
* device instance VDD_DIV_t247 r0 *1 0,0
RVDD_DIV_t247 VDD_DIV__t247 VDD_DIV 6.86669492103
* device instance VDD_DIV_t248 r0 *1 0,0
RVDD_DIV_t248 VDD_DIV__t248 VDD_DIV 6.97479334954
* device instance VDD_DIV_t249 r0 *1 0,0
RVDD_DIV_t249 VDD_DIV__t249 VDD_DIV 8.16387606311
* device instance VDD_DIV_t250 r0 *1 0,0
RVDD_DIV_t250 VDD_DIV__t250 VDD_DIV 7.19099020655
* device instance VDD_DIV_t251 r0 *1 0,0
RVDD_DIV_t251 VDD_DIV__t251 VDD_DIV 7.29908863506
* device instance VDD_DIV_t252 r0 *1 0,0
RVDD_DIV_t252 VDD_DIV__t252 VDD_DIV 7.40718706357
* device instance VDD_DIV_t253 r0 *1 0,0
RVDD_DIV_t253 VDD_DIV__t253 VDD_DIV 7.51528549207
* device instance VDD_DIV_t254 r0 *1 0,0
RVDD_DIV_t254 VDD_DIV__t254 VDD_DIV 7.62338392058
* device instance VDD_DIV_t255 r0 *1 0,0
RVDD_DIV_t255 VDD_DIV__t255 VDD_DIV 7.73148234908
* device instance VDD_DIV_t256 r0 *1 0,0
RVDD_DIV_t256 VDD_DIV__t256 VDD_DIV 7.83958077759
* device instance VDD_DIV_t257 r0 *1 0,0
RVDD_DIV_t257 VDD_DIV__t257 VDD_DIV 7.9476792061
* device instance VDD_DIV_t258 r0 *1 0,0
RVDD_DIV_t258 VDD_DIV__t258 VDD_DIV 8.0557776346
* device instance VDD_DIV_t259 r0 *1 0,0
RVDD_DIV_t259 VDD_DIV__t259 VDD_DIV 7.08289177805
* device instance VDD_DIV_t260 r0 *1 0,0
RVDD_DIV_t260 VDD_DIV__t260 VDD_DIV 9.67019024675
* device instance VDD_DIV_t261 r0 *1 0,0
RVDD_DIV_t261 VDD_DIV__t261 VDD_DIV 10.5312501428
* device instance VDD_DIV r0 *1 0,0
CVDD_DIV VDD_DIV vsubs 3.16785294e-13
* device instance VSS_t0 r0 *1 0,0
RVSS_t0 VSS__t0 VSS 0.984287899848
* device instance VSS_t1 r0 *1 0,0
RVSS_t1 VSS__t1 VSS 1.12777520258
* device instance VSS_t2 r0 *1 0,0
RVSS_t2 VSS__t2 VSS 1.88545815482
* device instance VSS_t3 r0 *1 0,0
RVSS_t3 VSS__t3 VSS 1.81371450345
* device instance VSS_t4 r0 *1 0,0
RVSS_t4 VSS__t4 VSS 1.74197085209
* device instance VSS_t5 r0 *1 0,0
RVSS_t5 VSS__t5 VSS 2.24417641165
* device instance VSS_t6 r0 *1 0,0
RVSS_t6 VSS__t6 VSS 2.10068910892
* device instance VSS_t7 r0 *1 0,0
RVSS_t7 VSS__t7 VSS 5.47264072315
* device instance VSS_t8 r0 *1 0,0
RVSS_t8 VSS__t8 VSS 5.40089707179
* device instance VSS_t9 r0 *1 0,0
RVSS_t9 VSS__t9 VSS 5.32915342042
* device instance VSS_t10 r0 *1 0,0
RVSS_t10 VSS__t10 VSS 5.25740976905
* device instance VSS_t11 r0 *1 0,0
RVSS_t11 VSS__t11 VSS 0.450585127486
* device instance VSS_t12 r0 *1 0,0
RVSS_t12 VSS__t12 VSS 0.307097824753
* device instance VSS_t13 r0 *1 0,0
RVSS_t13 VSS__t13 VSS 0.0918668706525
* device instance VSS_t14 r0 *1 0,0
RVSS_t14 VSS__t14 VSS 0.0201232192858
* device instance VSS_t15 r0 *1 0,0
RVSS_t15 VSS__t15 VSS 0.0516204320809
* device instance VSS_t16 r0 *1 0,0
RVSS_t16 VSS__t16 VSS 0.123364083448
* device instance VSS_t17 r0 *1 0,0
RVSS_t17 VSS__t17 VSS 0.912544248481
* device instance VSS_t18 r0 *1 0,0
RVSS_t18 VSS__t18 VSS 0.338595037548
* device instance VSS_t19 r0 *1 0,0
RVSS_t19 VSS__t19 VSS 0.553825991648
* device instance VSS_t20 r0 *1 0,0
RVSS_t20 VSS__t20 VSS 0.697313294381
* device instance VSS_t21 r0 *1 0,0
RVSS_t21 VSS__t21 VSS 0.840800597114
* device instance VSS_t22 r0 *1 0,0
RVSS_t22 VSS__t22 VSS 0.195107734814
* device instance VSS_t23 r0 *1 0,0
RVSS_t23 VSS__t23 VSS 3.67904943899
* device instance VSS_t24 r0 *1 0,0
RVSS_t24 VSS__t24 VSS 3.60730578762
* device instance VSS_t25 r0 *1 0,0
RVSS_t25 VSS__t25 VSS 3.53556213625
* device instance VSS_t26 r0 *1 0,0
RVSS_t26 VSS__t26 VSS 3.46381848489
* device instance VSS_t27 r0 *1 0,0
RVSS_t27 VSS__t27 VSS 3.39207483352
* device instance VSS_t28 r0 *1 0,0
RVSS_t28 VSS__t28 VSS 3.24858753079
* device instance VSS_t29 r0 *1 0,0
RVSS_t29 VSS__t29 VSS 5.18566611769
* device instance VSS_t30 r0 *1 0,0
RVSS_t30 VSS__t30 VSS 2.88986927395
* device instance VSS_t31 r0 *1 0,0
RVSS_t31 VSS__t31 VSS 2.74638197122
* device instance VSS_t32 r0 *1 0,0
RVSS_t32 VSS__t32 VSS 2.67463831985
* device instance VSS_t33 r0 *1 0,0
RVSS_t33 VSS__t33 VSS 2.60289466849
* device instance VSS_t34 r0 *1 0,0
RVSS_t34 VSS__t34 VSS 2.45940736575
* device instance VSS_t35 r0 *1 0,0
RVSS_t35 VSS__t35 VSS 3.03335657669
* device instance VSS_t36 r0 *1 0,0
RVSS_t36 VSS__t36 VSS 5.04217881495
* device instance VSS_t37 r0 *1 0,0
RVSS_t37 VSS__t37 VSS 4.82694786085
* device instance VSS_t38 r0 *1 0,0
RVSS_t38 VSS__t38 VSS 4.68346055812
* device instance VSS_t39 r0 *1 0,0
RVSS_t39 VSS__t39 VSS 4.53997325539
* device instance VSS_t40 r0 *1 0,0
RVSS_t40 VSS__t40 VSS 4.39648595265
* device instance VSS_t41 r0 *1 0,0
RVSS_t41 VSS__t41 VSS 4.25299864992
* device instance VSS_t42 r0 *1 0,0
RVSS_t42 VSS__t42 VSS 4.03776769582
* device instance VSS_t43 r0 *1 0,0
RVSS_t43 VSS__t43 VSS 3.89428039309
* device instance VSS_t44 r0 *1 0,0
RVSS_t44 VSS__t44 VSS 4.46822960402
* device instance VSS_t45 r0 *1 0,0
RVSS_t45 VSS__t45 VSS 3.71054665178
* device instance VSS_t46 r0 *1 0,0
RVSS_t46 VSS__t46 VSS 3.78229030315
* device instance VSS_t47 r0 *1 0,0
RVSS_t47 VSS__t47 VSS 3.92577760588
* device instance VSS_t48 r0 *1 0,0
RVSS_t48 VSS__t48 VSS 4.14100855998
* device instance VSS_t49 r0 *1 0,0
RVSS_t49 VSS__t49 VSS 4.28449586272
* device instance VSS_t50 r0 *1 0,0
RVSS_t50 VSS__t50 VSS 4.42798316545
* device instance VSS_t51 r0 *1 0,0
RVSS_t51 VSS__t51 VSS 4.49972681682
* device instance VSS_t52 r0 *1 0,0
RVSS_t52 VSS__t52 VSS 4.57147046818
* device instance VSS_t53 r0 *1 0,0
RVSS_t53 VSS__t53 VSS 4.71495777092
* device instance VSS_t54 r0 *1 0,0
RVSS_t54 VSS__t54 VSS 4.93018872502
* device instance VSS_t55 r0 *1 0,0
RVSS_t55 VSS__t55 VSS 2.34741727581
* device instance VSS_t56 r0 *1 0,0
RVSS_t56 VSS__t56 VSS 2.49090457855
* device instance VSS_t57 r0 *1 0,0
RVSS_t57 VSS__t57 VSS 2.63439188128
* device instance VSS_t58 r0 *1 0,0
RVSS_t58 VSS__t58 VSS 2.70613553265
* device instance VSS_t59 r0 *1 0,0
RVSS_t59 VSS__t59 VSS 2.77787918401
* device instance VSS_t60 r0 *1 0,0
RVSS_t60 VSS__t60 VSS 3.63880300042
* device instance VSS_t61 r0 *1 0,0
RVSS_t61 VSS__t61 VSS 3.13659744085
* device instance VSS_t62 r0 *1 0,0
RVSS_t62 VSS__t62 VSS 3.28008474358
* device instance VSS_t63 r0 *1 0,0
RVSS_t63 VSS__t63 VSS 3.49531569768
* device instance VSS_t64 r0 *1 0,0
RVSS_t64 VSS__t64 VSS 3.56705934905
* device instance VSS_t65 r0 *1 0,0
RVSS_t65 VSS__t65 VSS 2.92136648675
* device instance VSS_t66 r0 *1 0,0
RVSS_t66 VSS__t66 VSS 1.98869901898
* device instance VSS_t67 r0 *1 0,0
RVSS_t67 VSS__t67 VSS 2.13218632171
* device instance VSS_t68 r0 *1 0,0
RVSS_t68 VSS__t68 VSS 1.67022720072
* device instance VSS_t69 r0 *1 0,0
RVSS_t69 VSS__t69 VSS 1.59848354935
* device instance VSS_t70 r0 *1 0,0
RVSS_t70 VSS__t70 VSS 1.45499624662
* device instance VSS_t71 r0 *1 0,0
RVSS_t71 VSS__t71 VSS 1.09627798979
* device instance VSS_t72 r0 *1 0,0
RVSS_t72 VSS__t72 VSS 0.952790687053
* device instance VSS_t73 r0 *1 0,0
RVSS_t73 VSS__t73 VSS 0.881047035686
* device instance VSS_t74 r0 *1 0,0
RVSS_t74 VSS__t74 VSS 0.809303384319
* device instance VSS_t75 r0 *1 0,0
RVSS_t75 VSS__t75 VSS 0.665816081586
* device instance VSS_t76 r0 *1 0,0
RVSS_t76 VSS__t76 VSS 1.23976529252
* device instance VSS_t77 r0 *1 0,0
RVSS_t77 VSS__t77 VSS 5.07367602775
* device instance VSS_t78 r0 *1 0,0
RVSS_t78 VSS__t78 VSS 5.14541967912
* device instance VSS_t79 r0 *1 0,0
RVSS_t79 VSS__t79 VSS 5.28890698185
* device instance VSS_t80 r0 *1 0,0
RVSS_t80 VSS__t80 VSS 5.50413793595
* device instance VSS_t81 r0 *1 0,0
RVSS_t81 VSS__t81 VSS 5.64762523868
* device instance VSS_t82 r0 *1 0,0
RVSS_t82 VSS__t82 VSS 1.91695536761
* device instance VSS_t83 r0 *1 0,0
RVSS_t83 VSS__t83 VSS 1.34300615668
* device instance VSS_t84 r0 *1 0,0
RVSS_t84 VSS__t84 VSS 1.48649345941
* device instance VSS_t85 r0 *1 0,0
RVSS_t85 VSS__t85 VSS 1.70172441351
* device instance VSS_t86 r0 *1 0,0
RVSS_t86 VSS__t86 VSS 1.77346806488
* device instance VSS_t87 r0 *1 0,0
RVSS_t87 VSS__t87 VSS 1.84521171625
* device instance VSS_t88 r0 *1 0,0
RVSS_t88 VSS__t88 VSS 5.61612802589
* device instance VSS_t89 r0 *1 0,0
RVSS_t89 VSS__t89 VSS 5.54438437452
* device instance VSS_t90 r0 *1 0,0
RVSS_t90 VSS__t90 VSS 5.47264072315
* device instance VSS_t91 r0 *1 0,0
RVSS_t91 VSS__t91 VSS 5.40089707179
* device instance VSS_t92 r0 *1 0,0
RVSS_t92 VSS__t92 VSS 5.32915342042
* device instance VSS_t93 r0 *1 0,0
RVSS_t93 VSS__t93 VSS 5.25740976905
* device instance VSS_t94 r0 *1 0,0
RVSS_t94 VSS__t94 VSS 5.18566611769
* device instance VSS_t95 r0 *1 0,0
RVSS_t95 VSS__t95 VSS 5.11392246632
* device instance VSS_t96 r0 *1 0,0
RVSS_t96 VSS__t96 VSS 5.04217881495
* device instance VSS_t97 r0 *1 0,0
RVSS_t97 VSS__t97 VSS 4.97043516359
* device instance VSS_t98 r0 *1 0,0
RVSS_t98 VSS__t98 VSS 4.89869151222
* device instance VSS_t99 r0 *1 0,0
RVSS_t99 VSS__t99 VSS 4.82694786085
* device instance VSS_t100 r0 *1 0,0
RVSS_t100 VSS__t100 VSS 4.75520420949
* device instance VSS_t101 r0 *1 0,0
RVSS_t101 VSS__t101 VSS 4.68346055812
* device instance VSS_t102 r0 *1 0,0
RVSS_t102 VSS__t102 VSS 4.61171690675
* device instance VSS_t103 r0 *1 0,0
RVSS_t103 VSS__t103 VSS 4.53997325539
* device instance VSS_t104 r0 *1 0,0
RVSS_t104 VSS__t104 VSS 4.46822960402
* device instance VSS_t105 r0 *1 0,0
RVSS_t105 VSS__t105 VSS 4.39648595265
* device instance VSS_t106 r0 *1 0,0
RVSS_t106 VSS__t106 VSS 4.32474230129
* device instance VSS_t107 r0 *1 0,0
RVSS_t107 VSS__t107 VSS 4.25299864992
* device instance VSS_t108 r0 *1 0,0
RVSS_t108 VSS__t108 VSS 4.18125499855
* device instance VSS_t109 r0 *1 0,0
RVSS_t109 VSS__t109 VSS 4.10951134719
* device instance VSS_t110 r0 *1 0,0
RVSS_t110 VSS__t110 VSS 4.03776769582
* device instance VSS_t111 r0 *1 0,0
RVSS_t111 VSS__t111 VSS 3.96602404445
* device instance VSS_t112 r0 *1 0,0
RVSS_t112 VSS__t112 VSS 3.89428039309
* device instance VSS_t113 r0 *1 0,0
RVSS_t113 VSS__t113 VSS 3.82253674172
* device instance VSS_t114 r0 *1 0,0
RVSS_t114 VSS__t114 VSS 3.75079309035
* device instance VSS_t115 r0 *1 0,0
RVSS_t115 VSS__t115 VSS 3.67904943899
* device instance VSS_t116 r0 *1 0,0
RVSS_t116 VSS__t116 VSS 3.60730578762
* device instance VSS_t117 r0 *1 0,0
RVSS_t117 VSS__t117 VSS 3.53556213625
* device instance VSS_t118 r0 *1 0,0
RVSS_t118 VSS__t118 VSS 3.46381848489
* device instance VSS_t119 r0 *1 0,0
RVSS_t119 VSS__t119 VSS 3.39207483352
* device instance VSS_t120 r0 *1 0,0
RVSS_t120 VSS__t120 VSS 3.32033118215
* device instance VSS_t121 r0 *1 0,0
RVSS_t121 VSS__t121 VSS 3.24858753079
* device instance VSS_t122 r0 *1 0,0
RVSS_t122 VSS__t122 VSS 3.17684387942
* device instance VSS_t123 r0 *1 0,0
RVSS_t123 VSS__t123 VSS 3.10510022805
* device instance VSS_t124 r0 *1 0,0
RVSS_t124 VSS__t124 VSS 3.03335657669
* device instance VSS_t125 r0 *1 0,0
RVSS_t125 VSS__t125 VSS 2.96161292532
* device instance VSS_t126 r0 *1 0,0
RVSS_t126 VSS__t126 VSS 2.88986927395
* device instance VSS_t127 r0 *1 0,0
RVSS_t127 VSS__t127 VSS 2.81812562259
* device instance VSS_t128 r0 *1 0,0
RVSS_t128 VSS__t128 VSS 2.74638197122
* device instance VSS_t129 r0 *1 0,0
RVSS_t129 VSS__t129 VSS 2.67463831985
* device instance VSS_t130 r0 *1 0,0
RVSS_t130 VSS__t130 VSS 2.60289466849
* device instance VSS_t131 r0 *1 0,0
RVSS_t131 VSS__t131 VSS 2.53115101712
* device instance VSS_t132 r0 *1 0,0
RVSS_t132 VSS__t132 VSS 2.45940736575
* device instance VSS_t133 r0 *1 0,0
RVSS_t133 VSS__t133 VSS 2.38766371439
* device instance VSS_t134 r0 *1 0,0
RVSS_t134 VSS__t134 VSS 2.31592006302
* device instance VSS_t135 r0 *1 0,0
RVSS_t135 VSS__t135 VSS 2.24417641165
* device instance VSS_t136 r0 *1 0,0
RVSS_t136 VSS__t136 VSS 2.17243276029
* device instance VSS_t137 r0 *1 0,0
RVSS_t137 VSS__t137 VSS 2.10068910892
* device instance VSS_t138 r0 *1 0,0
RVSS_t138 VSS__t138 VSS 2.02894545755
* device instance VSS_t139 r0 *1 0,0
RVSS_t139 VSS__t139 VSS 1.95720180619
* device instance VSS_t140 r0 *1 0,0
RVSS_t140 VSS__t140 VSS 1.88545815482
* device instance VSS_t141 r0 *1 0,0
RVSS_t141 VSS__t141 VSS 1.81371450345
* device instance VSS_t142 r0 *1 0,0
RVSS_t142 VSS__t142 VSS 1.74197085209
* device instance VSS_t143 r0 *1 0,0
RVSS_t143 VSS__t143 VSS 1.67022720072
* device instance VSS_t144 r0 *1 0,0
RVSS_t144 VSS__t144 VSS 1.59848354935
* device instance VSS_t145 r0 *1 0,0
RVSS_t145 VSS__t145 VSS 1.52673989799
* device instance VSS_t146 r0 *1 0,0
RVSS_t146 VSS__t146 VSS 1.45499624662
* device instance VSS_t147 r0 *1 0,0
RVSS_t147 VSS__t147 VSS 1.38325259525
* device instance VSS_t148 r0 *1 0,0
RVSS_t148 VSS__t148 VSS 1.31150894389
* device instance VSS_t149 r0 *1 0,0
RVSS_t149 VSS__t149 VSS 1.23976529252
* device instance VSS_t150 r0 *1 0,0
RVSS_t150 VSS__t150 VSS 1.16802164115
* device instance VSS_t151 r0 *1 0,0
RVSS_t151 VSS__t151 VSS 1.09627798979
* device instance VSS_t152 r0 *1 0,0
RVSS_t152 VSS__t152 VSS 1.02453433842
* device instance VSS_t153 r0 *1 0,0
RVSS_t153 VSS__t153 VSS 0.952790687053
* device instance VSS_t154 r0 *1 0,0
RVSS_t154 VSS__t154 VSS 0.881047035686
* device instance VSS_t155 r0 *1 0,0
RVSS_t155 VSS__t155 VSS 0.809303384319
* device instance VSS_t156 r0 *1 0,0
RVSS_t156 VSS__t156 VSS 0.737559732953
* device instance VSS_t157 r0 *1 0,0
RVSS_t157 VSS__t157 VSS 0.665816081586
* device instance VSS_t158 r0 *1 0,0
RVSS_t158 VSS__t158 VSS 0.594072430219
* device instance VSS_t159 r0 *1 0,0
RVSS_t159 VSS__t159 VSS 0.522328778853
* device instance VSS_t160 r0 *1 0,0
RVSS_t160 VSS__t160 VSS 0.450585127486
* device instance VSS_t161 r0 *1 0,0
RVSS_t161 VSS__t161 VSS 0.378841476119
* device instance VSS_t162 r0 *1 0,0
RVSS_t162 VSS__t162 VSS 0.307097824753
* device instance VSS_t163 r0 *1 0,0
RVSS_t163 VSS__t163 VSS 0.235354173386
* device instance VSS_t164 r0 *1 0,0
RVSS_t164 VSS__t164 VSS 0.163610522019
* device instance VSS_t165 r0 *1 0,0
RVSS_t165 VSS__t165 VSS 0.0918668706525
* device instance VSS_t166 r0 *1 0,0
RVSS_t166 VSS__t166 VSS 0.0201232192858
* device instance VSS_t167 r0 *1 0,0
RVSS_t167 VSS__t167 VSS 0.0516204320809
* device instance VSS_t168 r0 *1 0,0
RVSS_t168 VSS__t168 VSS 0.123364083448
* device instance VSS_t169 r0 *1 0,0
RVSS_t169 VSS__t169 VSS 0.195107734814
* device instance VSS_t170 r0 *1 0,0
RVSS_t170 VSS__t170 VSS 0.266851386181
* device instance VSS_t171 r0 *1 0,0
RVSS_t171 VSS__t171 VSS 0.338595037548
* device instance VSS_t172 r0 *1 0,0
RVSS_t172 VSS__t172 VSS 0.410338688914
* device instance VSS_t173 r0 *1 0,0
RVSS_t173 VSS__t173 VSS 0.482082340281
* device instance VSS_t174 r0 *1 0,0
RVSS_t174 VSS__t174 VSS 0.553825991648
* device instance VSS_t175 r0 *1 0,0
RVSS_t175 VSS__t175 VSS 0.625569643014
* device instance VSS_t176 r0 *1 0,0
RVSS_t176 VSS__t176 VSS 0.697313294381
* device instance VSS_t177 r0 *1 0,0
RVSS_t177 VSS__t177 VSS 0.769056945748
* device instance VSS_t178 r0 *1 0,0
RVSS_t178 VSS__t178 VSS 0.840800597114
* device instance VSS_t179 r0 *1 0,0
RVSS_t179 VSS__t179 VSS 0.912544248481
* device instance VSS_t180 r0 *1 0,0
RVSS_t180 VSS__t180 VSS 0.984287899848
* device instance VSS_t181 r0 *1 0,0
RVSS_t181 VSS__t181 VSS 1.05603155121
* device instance VSS_t182 r0 *1 0,0
RVSS_t182 VSS__t182 VSS 1.12777520258
* device instance VSS_t183 r0 *1 0,0
RVSS_t183 VSS__t183 VSS 1.19951885395
* device instance VSS_t184 r0 *1 0,0
RVSS_t184 VSS__t184 VSS 1.27126250531
* device instance VSS_t185 r0 *1 0,0
RVSS_t185 VSS__t185 VSS 1.34300615668
* device instance VSS_t186 r0 *1 0,0
RVSS_t186 VSS__t186 VSS 1.41474980805
* device instance VSS_t187 r0 *1 0,0
RVSS_t187 VSS__t187 VSS 1.48649345941
* device instance VSS_t188 r0 *1 0,0
RVSS_t188 VSS__t188 VSS 1.55823711078
* device instance VSS_t189 r0 *1 0,0
RVSS_t189 VSS__t189 VSS 1.62998076215
* device instance VSS_t190 r0 *1 0,0
RVSS_t190 VSS__t190 VSS 1.70172441351
* device instance VSS_t191 r0 *1 0,0
RVSS_t191 VSS__t191 VSS 1.77346806488
* device instance VSS_t192 r0 *1 0,0
RVSS_t192 VSS__t192 VSS 1.84521171625
* device instance VSS_t193 r0 *1 0,0
RVSS_t193 VSS__t193 VSS 1.91695536761
* device instance VSS_t194 r0 *1 0,0
RVSS_t194 VSS__t194 VSS 1.98869901898
* device instance VSS_t195 r0 *1 0,0
RVSS_t195 VSS__t195 VSS 2.06044267035
* device instance VSS_t196 r0 *1 0,0
RVSS_t196 VSS__t196 VSS 2.13218632171
* device instance VSS_t197 r0 *1 0,0
RVSS_t197 VSS__t197 VSS 2.20392997308
* device instance VSS_t198 r0 *1 0,0
RVSS_t198 VSS__t198 VSS 2.27567362445
* device instance VSS_t199 r0 *1 0,0
RVSS_t199 VSS__t199 VSS 2.34741727581
* device instance VSS_t200 r0 *1 0,0
RVSS_t200 VSS__t200 VSS 2.41916092718
* device instance VSS_t201 r0 *1 0,0
RVSS_t201 VSS__t201 VSS 2.49090457855
* device instance VSS_t202 r0 *1 0,0
RVSS_t202 VSS__t202 VSS 2.56264822991
* device instance VSS_t203 r0 *1 0,0
RVSS_t203 VSS__t203 VSS 2.63439188128
* device instance VSS_t204 r0 *1 0,0
RVSS_t204 VSS__t204 VSS 2.70613553265
* device instance VSS_t205 r0 *1 0,0
RVSS_t205 VSS__t205 VSS 2.77787918401
* device instance VSS_t206 r0 *1 0,0
RVSS_t206 VSS__t206 VSS 2.84962283538
* device instance VSS_t207 r0 *1 0,0
RVSS_t207 VSS__t207 VSS 2.92136648675
* device instance VSS_t208 r0 *1 0,0
RVSS_t208 VSS__t208 VSS 2.99311013811
* device instance VSS_t209 r0 *1 0,0
RVSS_t209 VSS__t209 VSS 3.06485378948
* device instance VSS_t210 r0 *1 0,0
RVSS_t210 VSS__t210 VSS 3.13659744085
* device instance VSS_t211 r0 *1 0,0
RVSS_t211 VSS__t211 VSS 3.20834109221
* device instance VSS_t212 r0 *1 0,0
RVSS_t212 VSS__t212 VSS 3.28008474358
* device instance VSS_t213 r0 *1 0,0
RVSS_t213 VSS__t213 VSS 3.35182839495
* device instance VSS_t214 r0 *1 0,0
RVSS_t214 VSS__t214 VSS 3.42357204632
* device instance VSS_t215 r0 *1 0,0
RVSS_t215 VSS__t215 VSS 3.49531569768
* device instance VSS_t216 r0 *1 0,0
RVSS_t216 VSS__t216 VSS 3.56705934905
* device instance VSS_t217 r0 *1 0,0
RVSS_t217 VSS__t217 VSS 3.63880300042
* device instance VSS_t218 r0 *1 0,0
RVSS_t218 VSS__t218 VSS 3.71054665178
* device instance VSS_t219 r0 *1 0,0
RVSS_t219 VSS__t219 VSS 3.78229030315
* device instance VSS_t220 r0 *1 0,0
RVSS_t220 VSS__t220 VSS 3.85403395452
* device instance VSS_t221 r0 *1 0,0
RVSS_t221 VSS__t221 VSS 3.92577760588
* device instance VSS_t222 r0 *1 0,0
RVSS_t222 VSS__t222 VSS 3.99752125725
* device instance VSS_t223 r0 *1 0,0
RVSS_t223 VSS__t223 VSS 4.06926490862
* device instance VSS_t224 r0 *1 0,0
RVSS_t224 VSS__t224 VSS 4.14100855998
* device instance VSS_t225 r0 *1 0,0
RVSS_t225 VSS__t225 VSS 4.21275221135
* device instance VSS_t226 r0 *1 0,0
RVSS_t226 VSS__t226 VSS 4.28449586272
* device instance VSS_t227 r0 *1 0,0
RVSS_t227 VSS__t227 VSS 4.35623951408
* device instance VSS_t228 r0 *1 0,0
RVSS_t228 VSS__t228 VSS 4.42798316545
* device instance VSS_t229 r0 *1 0,0
RVSS_t229 VSS__t229 VSS 4.49972681682
* device instance VSS_t230 r0 *1 0,0
RVSS_t230 VSS__t230 VSS 4.57147046818
* device instance VSS_t231 r0 *1 0,0
RVSS_t231 VSS__t231 VSS 4.64321411955
* device instance VSS_t232 r0 *1 0,0
RVSS_t232 VSS__t232 VSS 4.71495777092
* device instance VSS_t233 r0 *1 0,0
RVSS_t233 VSS__t233 VSS 4.78670142228
* device instance VSS_t234 r0 *1 0,0
RVSS_t234 VSS__t234 VSS 4.85844507365
* device instance VSS_t235 r0 *1 0,0
RVSS_t235 VSS__t235 VSS 4.93018872502
* device instance VSS_t236 r0 *1 0,0
RVSS_t236 VSS__t236 VSS 5.00193237638
* device instance VSS_t237 r0 *1 0,0
RVSS_t237 VSS__t237 VSS 5.07367602775
* device instance VSS_t238 r0 *1 0,0
RVSS_t238 VSS__t238 VSS 5.14541967912
* device instance VSS_t239 r0 *1 0,0
RVSS_t239 VSS__t239 VSS 5.21716333048
* device instance VSS_t240 r0 *1 0,0
RVSS_t240 VSS__t240 VSS 5.28890698185
* device instance VSS_t241 r0 *1 0,0
RVSS_t241 VSS__t241 VSS 5.36065063322
* device instance VSS_t242 r0 *1 0,0
RVSS_t242 VSS__t242 VSS 5.43239428458
* device instance VSS_t243 r0 *1 0,0
RVSS_t243 VSS__t243 VSS 5.50413793595
* device instance VSS_t244 r0 *1 0,0
RVSS_t244 VSS__t244 VSS 5.57588158732
* device instance VSS_t245 r0 *1 0,0
RVSS_t245 VSS__t245 VSS 5.64762523868
* device instance VSS r0 *1 0,0
CVSS VSS vsubs 1.94019687e-13
* device instance XD0_XDFFM_CLKB_t0 r0 *1 0,0
RXD0_XDFFM_CLKB_t0 XD0.XDFFM.CLKB__t0 XD0.XDFFM.CLKB 39.4082207222
* device instance XD0_XDFFM_CLKB_t1 r0 *1 0,0
RXD0_XDFFM_CLKB_t1 XD0.XDFFM.CLKB__t1 XD0.XDFFM.CLKB 40.1906518054
* device instance XD0_XDFFM_CLKB_t2 r0 *1 0,0
RXD0_XDFFM_CLKB_t2 XD0.XDFFM.CLKB__t2 XD0.XDFFM.CLKB 37.0609274725
* device instance XD0_XDFFM_CLKB_t3 r0 *1 0,0
RXD0_XDFFM_CLKB_t3 XD0.XDFFM.CLKB__t3 XD0.XDFFM.CLKB 39.480168408
* device instance XD0_XDFFM_CLKB_t4 r0 *1 0,0
RXD0_XDFFM_CLKB_t4 XD0.XDFFM.CLKB__t4 XD0.XDFFM.CLKB 37.2542868781
* device instance XD0_XDFFM_CLKB_t5 r0 *1 0,0
RXD0_XDFFM_CLKB_t5 XD0.XDFFM.CLKB__t5 XD0.XDFFM.CLKB 39.9253447139
* device instance XD0_XDFFM_CLKB r0 *1 0,0
CXD0_XDFFM_CLKB XD0.XDFFM.CLKB vsubs 5.1724346e-14
* device instance XD0_XDFFM_M_t0 r0 *1 0,0
RXD0_XDFFM_M_t0 XD0.XDFFM.M__t0 XD0.XDFFM.M 30.5831703547
* device instance XD0_XDFFM_M_t1 r0 *1 0,0
RXD0_XDFFM_M_t1 XD0.XDFFM.M__t1 XD0.XDFFM.M 29.9620110642
* device instance XD0_XDFFM_M_t2 r0 *1 0,0
RXD0_XDFFM_M_t2 XD0.XDFFM.M__t2 XD0.XDFFM.M 31.2043296453
* device instance XD0_XDFFM_M_t3 r0 *1 0,0
RXD0_XDFFM_M_t3 XD0.XDFFM.M__t3 XD0.XDFFM.M 31.8254889358
* device instance XD0_XDFFM_M_t4 r0 *1 0,0
RXD0_XDFFM_M_t4 XD0.XDFFM.M__t4 XD0.XDFFM.M 31.0704591085
* device instance XD0_XDFFM_M_t5 r0 *1 0,0
RXD0_XDFFM_M_t5 XD0.XDFFM.M__t5 XD0.XDFFM.M 30.3636226745
* device instance XD0_XDFFM_M_t6 r0 *1 0,0
RXD0_XDFFM_M_t6 XD0.XDFFM.M__t6 XD0.XDFFM.M 31.4238773255
* device instance XD0_XDFFM_M_t7 r0 *1 0,0
RXD0_XDFFM_M_t7 XD0.XDFFM.M__t7 XD0.XDFFM.M 30.7170408915
* device instance XD0_XDFFM_M r0 *1 0,0
CXD0_XDFFM_M XD0.XDFFM.M vsubs 5.489909e-14
* device instance XD0_XDFFM_MB_t0 r0 *1 0,0
RXD0_XDFFM_MB_t0 XD0.XDFFM.MB__t0 XD0.XDFFM.MB 55.7941466663
* device instance XD0_XDFFM_MB_t1 r0 *1 0,0
RXD0_XDFFM_MB_t1 XD0.XDFFM.MB__t1 XD0.XDFFM.MB 56.9273533337
* device instance XD0_XDFFM_MB_t2 r0 *1 0,0
RXD0_XDFFM_MB_t2 XD0.XDFFM.MB__t2 XD0.XDFFM.MB 56.6831277588
* device instance XD0_XDFFM_MB_t3 r0 *1 0,0
RXD0_XDFFM_MB_t3 XD0.XDFFM.MB__t3 XD0.XDFFM.MB 56.0383722412
* device instance XD0_XDFFM_MB r0 *1 0,0
CXD0_XDFFM_MB XD0.XDFFM.MB vsubs 4.9839184e-14
* device instance XD0_XDFFM_S_t0 r0 *1 0,0
RXD0_XDFFM_S_t0 XD0.XDFFM.S__t0 XD0.XDFFM.S 39.8985
* device instance XD0_XDFFM_S_t1 r0 *1 0,0
RXD0_XDFFM_S_t1 XD0.XDFFM.S__t1 XD0.XDFFM.S 39.1048857563
* device instance XD0_XDFFM_S_t2 r0 *1 0,0
RXD0_XDFFM_S_t2 XD0.XDFFM.S__t2 XD0.XDFFM.S 40.6921142437
* device instance XD0_XDFFM_S_t3 r0 *1 0,0
RXD0_XDFFM_S_t3 XD0.XDFFM.S__t3 XD0.XDFFM.S 39.8985
* device instance XD0_XDFFM_S_t4 r0 *1 0,0
RXD0_XDFFM_S_t4 XD0.XDFFM.S__t4 XD0.XDFFM.S 40.3500391386
* device instance XD0_XDFFM_S_t5 r0 *1 0,0
RXD0_XDFFM_S_t5 XD0.XDFFM.S__t5 XD0.XDFFM.S 39.4469608614
* device instance XD0_XDFFM_S r0 *1 0,0
CXD0_XDFFM_S XD0.XDFFM.S vsubs 5.3159062e-14
* device instance XD0_XDFFM_SB_t0 r0 *1 0,0
RXD0_XDFFM_SB_t0 XD0.XDFFM.SB__t0 XD0.XDFFM.SB 40.8621786778
* device instance XD0_XDFFM_SB_t1 r0 *1 0,0
RXD0_XDFFM_SB_t1 XD0.XDFFM.SB__t1 XD0.XDFFM.SB 39.2749879889
* device instance XD0_XDFFM_SB_t2 r0 *1 0,0
RXD0_XDFFM_SB_t2 XD0.XDFFM.SB__t2 XD0.XDFFM.SB 40.0685833333
* device instance XD0_XDFFM_SB_t3 r0 *1 0,0
RXD0_XDFFM_SB_t3 XD0.XDFFM.SB__t3 XD0.XDFFM.SB 39.6170549477
* device instance XD0_XDFFM_SB_t4 r0 *1 0,0
RXD0_XDFFM_SB_t4 XD0.XDFFM.SB__t4 XD0.XDFFM.SB 40.520111719
* device instance XD0_XDFFM_SB_t5 r0 *1 0,0
RXD0_XDFFM_SB_t5 XD0.XDFFM.SB__t5 XD0.XDFFM.SB 40.0685833333
* device instance XD0_XDFFM_SB r0 *1 0,0
CXD0_XDFFM_SB XD0.XDFFM.SB vsubs 5.3412247e-14
* device instance XD0_XDFFQ_CLKB_t0 r0 *1 0,0
RXD0_XDFFQ_CLKB_t0 XD0.XDFFQ.CLKB__t0 XD0.XDFFQ.CLKB 38.6901785161
* device instance XD0_XDFFQ_CLKB_t1 r0 *1 0,0
RXD0_XDFFQ_CLKB_t1 XD0.XDFFQ.CLKB__t1 XD0.XDFFQ.CLKB 39.4962962903
* device instance XD0_XDFFQ_CLKB_t2 r0 *1 0,0
RXD0_XDFFQ_CLKB_t2 XD0.XDFFQ.CLKB__t2 XD0.XDFFQ.CLKB 36.2718251935
* device instance XD0_XDFFQ_CLKB_t3 r0 *1 0,0
RXD0_XDFFQ_CLKB_t3 XD0.XDFFQ.CLKB__t3 XD0.XDFFQ.CLKB 38.7643042885
* device instance XD0_XDFFQ_CLKB_t4 r0 *1 0,0
RXD0_XDFFQ_CLKB_t4 XD0.XDFFQ.CLKB__t4 XD0.XDFFQ.CLKB 36.4710382067
* device instance XD0_XDFFQ_CLKB_t5 r0 *1 0,0
RXD0_XDFFQ_CLKB_t5 XD0.XDFFQ.CLKB__t5 XD0.XDFFQ.CLKB 39.2229575048
* device instance XD0_XDFFQ_CLKB r0 *1 0,0
CXD0_XDFFQ_CLKB XD0.XDFFQ.CLKB vsubs 5.0950424e-14
* device instance XD0_XDFFQ_M_t0 r0 *1 0,0
RXD0_XDFFQ_M_t0 XD0.XDFFQ.M__t0 XD0.XDFFQ.M 30.7468689316
* device instance XD0_XDFFQ_M_t1 r0 *1 0,0
RXD0_XDFFQ_M_t1 XD0.XDFFQ.M__t1 XD0.XDFFQ.M 30.2406636959
* device instance XD0_XDFFQ_M_t2 r0 *1 0,0
RXD0_XDFFQ_M_t2 XD0.XDFFQ.M__t2 XD0.XDFFQ.M 29.5953910878
* device instance XD0_XDFFQ_M_t3 r0 *1 0,0
RXD0_XDFFQ_M_t3 XD0.XDFFQ.M__t3 XD0.XDFFQ.M 30.8859363041
* device instance XD0_XDFFQ_M_t4 r0 *1 0,0
RXD0_XDFFQ_M_t4 XD0.XDFFQ.M__t4 XD0.XDFFQ.M 31.5312089122
* device instance XD0_XDFFQ_M_t5 r0 *1 0,0
RXD0_XDFFQ_M_t5 XD0.XDFFQ.M__t5 XD0.XDFFQ.M 30.0125932051
* device instance XD0_XDFFQ_M_t6 r0 *1 0,0
RXD0_XDFFQ_M_t6 XD0.XDFFQ.M__t6 XD0.XDFFQ.M 31.1140067949
* device instance XD0_XDFFQ_M_t7 r0 *1 0,0
RXD0_XDFFQ_M_t7 XD0.XDFFQ.M__t7 XD0.XDFFQ.M 30.3797310684
* device instance XD0_XDFFQ_M r0 *1 0,0
CXD0_XDFFQ_M XD0.XDFFQ.M vsubs 5.4576191e-14
* device instance XD0_XDFFQ_MB_t0 r0 *1 0,0
RXD0_XDFFQ_MB_t0 XD0.XDFFQ.MB__t0 XD0.XDFFQ.MB 54.2416235167
* device instance XD0_XDFFQ_MB_t1 r0 *1 0,0
RXD0_XDFFQ_MB_t1 XD0.XDFFQ.MB__t1 XD0.XDFFQ.MB 55.3990264833
* device instance XD0_XDFFQ_MB_t2 r0 *1 0,0
RXD0_XDFFQ_MB_t2 XD0.XDFFQ.MB__t2 XD0.XDFFQ.MB 55.1495861888
* device instance XD0_XDFFQ_MB_t3 r0 *1 0,0
RXD0_XDFFQ_MB_t3 XD0.XDFFQ.MB__t3 XD0.XDFFQ.MB 54.4910638112
* device instance XD0_XDFFQ_MB r0 *1 0,0
CXD0_XDFFQ_MB XD0.XDFFQ.MB vsubs 4.861424e-14
* device instance XD0_XDFFQ_S_t0 r0 *1 0,0
RXD0_XDFFQ_S_t0 XD0.XDFFQ.S__t0 XD0.XDFFQ.S 39.1648
* device instance XD0_XDFFQ_S_t1 r0 *1 0,0
RXD0_XDFFQ_S_t1 XD0.XDFFQ.S__t1 XD0.XDFFQ.S 38.3472270178
* device instance XD0_XDFFQ_S_t2 r0 *1 0,0
RXD0_XDFFQ_S_t2 XD0.XDFFQ.S__t2 XD0.XDFFQ.S 39.9823729822
* device instance XD0_XDFFQ_S_t3 r0 *1 0,0
RXD0_XDFFQ_S_t3 XD0.XDFFQ.S__t3 XD0.XDFFQ.S 39.1648
* device instance XD0_XDFFQ_S_t4 r0 *1 0,0
RXD0_XDFFQ_S_t4 XD0.XDFFQ.S__t4 XD0.XDFFQ.S 39.6299708347
* device instance XD0_XDFFQ_S_t5 r0 *1 0,0
RXD0_XDFFQ_S_t5 XD0.XDFFQ.S__t5 XD0.XDFFQ.S 38.6996291653
* device instance XD0_XDFFQ_S r0 *1 0,0
CXD0_XDFFQ_S XD0.XDFFQ.S vsubs 5.2383504e-14
* device instance XD0_XDFFQ_SB_t0 r0 *1 0,0
RXD0_XDFFQ_SB_t0 XD0.XDFFQ.SB__t0 XD0.XDFFQ.SB 40.1523291785
* device instance XD0_XDFFQ_SB_t1 r0 *1 0,0
RXD0_XDFFQ_SB_t1 XD0.XDFFQ.SB__t1 XD0.XDFFQ.SB 38.5174374882
* device instance XD0_XDFFQ_SB_t2 r0 *1 0,0
RXD0_XDFFQ_SB_t2 XD0.XDFFQ.SB__t2 XD0.XDFFQ.SB 39.3348833333
* device instance XD0_XDFFQ_SB_t3 r0 *1 0,0
RXD0_XDFFQ_SB_t3 XD0.XDFFQ.SB__t3 XD0.XDFFQ.SB 38.8697848352
* device instance XD0_XDFFQ_SB_t4 r0 *1 0,0
RXD0_XDFFQ_SB_t4 XD0.XDFFQ.SB__t4 XD0.XDFFQ.SB 39.7999818314
* device instance XD0_XDFFQ_SB_t5 r0 *1 0,0
RXD0_XDFFQ_SB_t5 XD0.XDFFQ.SB__t5 XD0.XDFFQ.SB 39.3348833333
* device instance XD0_XDFFQ_SB r0 *1 0,0
CXD0_XDFFQ_SB XD0.XDFFQ.SB vsubs 5.2635054e-14
* device instance XD0_XN2_mid1_t0 r0 *1 0,0
RXD0_XN2_mid1_t0 XD0.XN2.mid1__t0 XD0.XN2.mid1 6.7882
* device instance XD0_XN2_mid1_t1 r0 *1 0,0
RXD0_XN2_mid1_t1 XD0.XN2.mid1__t1 XD0.XN2.mid1 6.7882
* device instance XD0_XN2_mid1 r0 *1 0,0
CXD0_XN2_mid1 XD0.XN2.mid1 vsubs 3.356409e-15
* device instance XD0_XN3_mid1_t0 r0 *1 0,0
RXD0_XN3_mid1_t0 XD0.XN3.mid1__t0 XD0.XN3.mid1 6.9642
* device instance XD0_XN3_mid1_t1 r0 *1 0,0
RXD0_XN3_mid1_t1 XD0.XN3.mid1__t1 XD0.XN3.mid1 6.9642
* device instance XD0_XN3_mid1 r0 *1 0,0
CXD0_XN3_mid1 XD0.XN3.mid1 vsubs 3.46952e-15
* device instance XD0_XN3_mid2_t0 r0 *1 0,0
RXD0_XN3_mid2_t0 XD0.XN3.mid2__t0 XD0.XN3.mid2 7.14015
* device instance XD0_XN3_mid2_t1 r0 *1 0,0
RXD0_XN3_mid2_t1 XD0.XN3.mid2__t1 XD0.XN3.mid2 7.14015
* device instance XD0_XN3_mid2 r0 *1 0,0
CXD0_XN3_mid2 XD0.XN3.mid2 vsubs 3.559168e-15
* device instance XD0_XNOR_midp_t0 r0 *1 0,0
RXD0_XNOR_midp_t0 XD0.XNOR.midp__t0 XD0.XNOR.midp 8.84255
* device instance XD0_XNOR_midp_t1 r0 *1 0,0
RXD0_XNOR_midp_t1 XD0.XNOR.midp__t1 XD0.XNOR.midp 8.84255
* device instance XD0_XNOR_midp r0 *1 0,0
CXD0_XNOR_midp XD0.XNOR.midp vsubs 4.239063e-15
* device instance XD0_dmodout_t0 r0 *1 0,0
RXD0_dmodout_t0 XD0.dmodout__t0 XD0.dmodout 57.1368847106
* device instance XD0_dmodout_t1 r0 *1 0,0
RXD0_dmodout_t1 XD0.dmodout__t1 XD0.dmodout 59.5078652894
* device instance XD0_dmodout_t2 r0 *1 0,0
RXD0_dmodout_t2 XD0.dmodout__t2 XD0.dmodout 57.6478719043
* device instance XD0_dmodout_t3 r0 *1 0,0
RXD0_dmodout_t3 XD0.dmodout__t3 XD0.dmodout 58.9968780957
* device instance XD0_dmodout r0 *1 0,0
CXD0_dmodout XD0.dmodout vsubs 5.1915022e-14
* device instance XD0_dq_t0 r0 *1 0,0
RXD0_dq_t0 XD0.dq__t0 XD0.dq 57.0891623598
* device instance XD0_dq_t1 r0 *1 0,0
RXD0_dq_t1 XD0.dq__t1 XD0.dq 59.1494376402
* device instance XD0_dq_t2 r0 *1 0,0
RXD0_dq_t2 XD0.dq__t2 XD0.dq 39.527683727
* device instance XD0_dq_t3 r0 *1 0,0
RXD0_dq_t3 XD0.dq__t3 XD0.dq 38.9415709318
* device instance XD0_dq_t4 r0 *1 0,0
RXD0_dq_t4 XD0.dq__t4 XD0.dq 37.7693453412
* device instance XD0_dq r0 *1 0,0
CXD0_dq XD0.dq vsubs 5.1925491e-14
* device instance XD0_nm_t0 r0 *1 0,0
RXD0_nm_t0 XD0.nm__t0 XD0.nm 40.7783533598
* device instance XD0_nm_t1 r0 *1 0,0
RXD0_nm_t1 XD0.nm__t1 XD0.nm 39.7592166667
* device instance XD0_nm_t2 r0 *1 0,0
RXD0_nm_t2 XD0.nm__t2 XD0.nm 38.7400799736
* device instance XD0_nm_t3 r0 *1 0,0
RXD0_nm_t3 XD0.nm__t3 XD0.nm 59.0589713643
* device instance XD0_nm_t4 r0 *1 0,0
RXD0_nm_t4 XD0.nm__t4 XD0.nm 60.2186786357
* device instance XD0_nm r0 *1 0,0
CXD0_nm XD0.nm vsubs 5.3317856e-14
* device instance XD0_nt_t0 r0 *1 0,0
RXD0_nt_t0 XD0.nt__t0 XD0.nt 31.1798502334
* device instance XD0_nt_t1 r0 *1 0,0
RXD0_nt_t1 XD0.nt__t1 XD0.nt 29.2354165889
* device instance XD0_nt_t2 r0 *1 0,0
RXD0_nt_t2 XD0.nt__t2 XD0.nt 30.2076334111
* device instance XD0_nt_t3 r0 *1 0,0
RXD0_nt_t3 XD0.nt__t3 XD0.nt 28.2631997666
* device instance XD0_nt_t4 r0 *1 0,0
RXD0_nt_t4 XD0.nt__t4 XD0.nt 58.6133132293
* device instance XD0_nt_t5 r0 *1 0,0
RXD0_nt_t5 XD0.nt__t5 XD0.nt 60.2727867707
* device instance XD0_nt r0 *1 0,0
CXD0_nt XD0.nt vsubs 5.3298834e-14
* device instance XD0_t1_t0 r0 *1 0,0
RXD0_t1_t0 XD0.t1__t0 XD0.t1 56.6567124926
* device instance XD0_t1_t1 r0 *1 0,0
RXD0_t1_t1 XD0.t1__t1 XD0.t1 54.2658875074
* device instance XD0_t1_t2 r0 *1 0,0
RXD0_t1_t2 XD0.t1__t2 XD0.t1 54.7811515128
* device instance XD0_t1_t3 r0 *1 0,0
RXD0_t1_t3 XD0.t1__t3 XD0.t1 56.1414484872
* device instance XD0_t1 r0 *1 0,0
CXD0_t1 XD0.t1 vsubs 4.9546116e-14
* device instance XD1_XDFFM_CLKB_t0 r0 *1 0,0
RXD1_XDFFM_CLKB_t0 XD1.XDFFM.CLKB__t0 XD1.XDFFM.CLKB 46.4514975353
* device instance XD1_XDFFM_CLKB_t1 r0 *1 0,0
RXD1_XDFFM_CLKB_t1 XD1.XDFFM.CLKB__t1 XD1.XDFFM.CLKB 47.2846438382
* device instance XD1_XDFFM_CLKB_t2 r0 *1 0,0
RXD1_XDFFM_CLKB_t2 XD1.XDFFM.CLKB__t2 XD1.XDFFM.CLKB 43.9520586265
* device instance XD1_XDFFM_CLKB_t3 r0 *1 0,0
RXD1_XDFFM_CLKB_t3 XD1.XDFFM.CLKB__t3 XD1.XDFFM.CLKB 44.1579511037
* device instance XD1_XDFFM_CLKB_t4 r0 *1 0,0
RXD1_XDFFM_CLKB_t4 XD1.XDFFM.CLKB__t4 XD1.XDFFM.CLKB 46.5281086896
* device instance XD1_XDFFM_CLKB_t5 r0 *1 0,0
RXD1_XDFFM_CLKB_t5 XD1.XDFFM.CLKB__t5 XD1.XDFFM.CLKB 47.0021402067
* device instance XD1_XDFFM_CLKB r0 *1 0,0
CXD1_XDFFM_CLKB XD1.XDFFM.CLKB vsubs 6.1808621e-14
* device instance XD1_XDFFM_M_t0 r0 *1 0,0
RXD1_XDFFM_M_t0 XD1.XDFFM.M__t0 XD1.XDFFM.M 36.6511738238
* device instance XD1_XDFFM_M_t1 r0 *1 0,0
RXD1_XDFFM_M_t1 XD1.XDFFM.M__t1 XD1.XDFFM.M 35.9801964715
* device instance XD1_XDFFM_M_t2 r0 *1 0,0
RXD1_XDFFM_M_t2 XD1.XDFFM.M__t2 XD1.XDFFM.M 37.3221511762
* device instance XD1_XDFFM_M_t3 r0 *1 0,0
RXD1_XDFFM_M_t3 XD1.XDFFM.M__t3 XD1.XDFFM.M 37.9931285285
* device instance XD1_XDFFM_M_t4 r0 *1 0,0
RXD1_XDFFM_M_t4 XD1.XDFFM.M__t4 XD1.XDFFM.M 37.1775439882
* device instance XD1_XDFFM_M_t5 r0 *1 0,0
RXD1_XDFFM_M_t5 XD1.XDFFM.M__t5 XD1.XDFFM.M 36.4140180355
* device instance XD1_XDFFM_M_t6 r0 *1 0,0
RXD1_XDFFM_M_t6 XD1.XDFFM.M__t6 XD1.XDFFM.M 37.5593069645
* device instance XD1_XDFFM_M_t7 r0 *1 0,0
RXD1_XDFFM_M_t7 XD1.XDFFM.M__t7 XD1.XDFFM.M 36.7957810118
* device instance XD1_XDFFM_M r0 *1 0,0
CXD1_XDFFM_M XD1.XDFFM.M vsubs 6.6705433e-14
* device instance XD1_XDFFM_MB_t0 r0 *1 0,0
RXD1_XDFFM_MB_t0 XD1.XDFFM.MB__t0 XD1.XDFFM.MB 64.6123173513
* device instance XD1_XDFFM_MB_t1 r0 *1 0,0
RXD1_XDFFM_MB_t1 XD1.XDFFM.MB__t1 XD1.XDFFM.MB 65.7951826487
* device instance XD1_XDFFM_MB_t2 r0 *1 0,0
RXD1_XDFFM_MB_t2 XD1.XDFFM.MB__t2 XD1.XDFFM.MB 65.5402547829
* device instance XD1_XDFFM_MB_t3 r0 *1 0,0
RXD1_XDFFM_MB_t3 XD1.XDFFM.MB__t3 XD1.XDFFM.MB 64.8672452171
* device instance XD1_XDFFM_MB r0 *1 0,0
CXD1_XDFFM_MB XD1.XDFFM.MB vsubs 5.8201391e-14
* device instance XD1_XDFFM_S_t0 r0 *1 0,0
RXD1_XDFFM_S_t0 XD1.XDFFM.S__t0 XD1.XDFFM.S 46.9082333333
* device instance XD1_XDFFM_S_t1 r0 *1 0,0
RXD1_XDFFM_S_t1 XD1.XDFFM.S__t1 XD1.XDFFM.S 46.0655052055
* device instance XD1_XDFFM_S_t2 r0 *1 0,0
RXD1_XDFFM_S_t2 XD1.XDFFM.S__t2 XD1.XDFFM.S 47.7509614612
* device instance XD1_XDFFM_S_t3 r0 *1 0,0
RXD1_XDFFM_S_t3 XD1.XDFFM.S__t3 XD1.XDFFM.S 46.9082333333
* device instance XD1_XDFFM_S_t4 r0 *1 0,0
RXD1_XDFFM_S_t4 XD1.XDFFM.S__t4 XD1.XDFFM.S 46.4287500882
* device instance XD1_XDFFM_S_t5 r0 *1 0,0
RXD1_XDFFM_S_t5 XD1.XDFFM.S__t5 XD1.XDFFM.S 47.3877165785
* device instance XD1_XDFFM_S r0 *1 0,0
CXD1_XDFFM_S XD1.XDFFM.S vsubs 6.324278e-14
* device instance XD1_XDFFM_SB_t0 r0 *1 0,0
RXD1_XDFFM_SB_t0 XD1.XDFFM.SB__t0 XD1.XDFFM.SB 47.9208722185
* device instance XD1_XDFFM_SB_t1 r0 *1 0,0
RXD1_XDFFM_SB_t1 XD1.XDFFM.SB__t1 XD1.XDFFM.SB 46.2358277815
* device instance XD1_XDFFM_SB_t2 r0 *1 0,0
RXD1_XDFFM_SB_t2 XD1.XDFFM.SB__t2 XD1.XDFFM.SB 47.07835
* device instance XD1_XDFFM_SB_t3 r0 *1 0,0
RXD1_XDFFM_SB_t3 XD1.XDFFM.SB__t3 XD1.XDFFM.SB 46.5989839102
* device instance XD1_XDFFM_SB_t4 r0 *1 0,0
RXD1_XDFFM_SB_t4 XD1.XDFFM.SB__t4 XD1.XDFFM.SB 47.5577160898
* device instance XD1_XDFFM_SB_t5 r0 *1 0,0
RXD1_XDFFM_SB_t5 XD1.XDFFM.SB__t5 XD1.XDFFM.SB 47.07835
* device instance XD1_XDFFM_SB r0 *1 0,0
CXD1_XDFFM_SB XD1.XDFFM.SB vsubs 6.349433e-14
* device instance XD1_XDFFQ_CLKB_t0 r0 *1 0,0
RXD1_XDFFQ_CLKB_t0 XD1.XDFFQ.CLKB__t0 XD1.XDFFQ.CLKB 45.7337331498
* device instance XD1_XDFFQ_CLKB_t1 r0 *1 0,0
RXD1_XDFFQ_CLKB_t1 XD1.XDFFQ.CLKB__t1 XD1.XDFFQ.CLKB 46.5904328745
* device instance XD1_XDFFQ_CLKB_t2 r0 *1 0,0
RXD1_XDFFQ_CLKB_t2 XD1.XDFFQ.CLKB__t2 XD1.XDFFQ.CLKB 43.1636339756
* device instance XD1_XDFFQ_CLKB_t3 r0 *1 0,0
RXD1_XDFFQ_CLKB_t3 XD1.XDFFQ.CLKB__t3 XD1.XDFFQ.CLKB 45.812510136
* device instance XD1_XDFFQ_CLKB_t4 r0 *1 0,0
RXD1_XDFFQ_CLKB_t4 XD1.XDFFQ.CLKB__t4 XD1.XDFFQ.CLKB 43.375347126
* device instance XD1_XDFFQ_CLKB_t5 r0 *1 0,0
RXD1_XDFFQ_CLKB_t5 XD1.XDFFQ.CLKB__t5 XD1.XDFFQ.CLKB 46.299942738
* device instance XD1_XDFFQ_CLKB r0 *1 0,0
CXD1_XDFFQ_CLKB XD1.XDFFQ.CLKB vsubs 6.10347e-14
* device instance XD1_XDFFQ_M_t0 r0 *1 0,0
RXD1_XDFFQ_M_t0 XD1.XDFFQ.M__t0 XD1.XDFFQ.M 36.3090887134
* device instance XD1_XDFFQ_M_t1 r0 *1 0,0
RXD1_XDFFQ_M_t1 XD1.XDFFQ.M__t1 XD1.XDFFQ.M 35.6142161401
* device instance XD1_XDFFQ_M_t2 r0 *1 0,0
RXD1_XDFFQ_M_t2 XD1.XDFFQ.M__t2 XD1.XDFFQ.M 37.0039612866
* device instance XD1_XDFFQ_M_t3 r0 *1 0,0
RXD1_XDFFQ_M_t3 XD1.XDFFQ.M__t3 XD1.XDFFQ.M 37.6988338599
* device instance XD1_XDFFQ_M_t4 r0 *1 0,0
RXD1_XDFFQ_M_t4 XD1.XDFFQ.M__t4 XD1.XDFFQ.M 36.8542042665
* device instance XD1_XDFFQ_M_t5 r0 *1 0,0
RXD1_XDFFQ_M_t5 XD1.XDFFQ.M__t5 XD1.XDFFQ.M 36.0634872004
* device instance XD1_XDFFQ_M_t6 r0 *1 0,0
RXD1_XDFFQ_M_t6 XD1.XDFFQ.M__t6 XD1.XDFFQ.M 37.2495627996
* device instance XD1_XDFFQ_M_t7 r0 *1 0,0
RXD1_XDFFQ_M_t7 XD1.XDFFQ.M__t7 XD1.XDFFQ.M 36.4588457335
* device instance XD1_XDFFQ_M r0 *1 0,0
CXD1_XDFFQ_M XD1.XDFFQ.M vsubs 6.6382535e-14
* device instance XD1_XDFFQ_MB_t0 r0 *1 0,0
RXD1_XDFFQ_MB_t0 XD1.XDFFQ.MB__t0 XD1.XDFFQ.MB 63.0602111886
* device instance XD1_XDFFQ_MB_t1 r0 *1 0,0
RXD1_XDFFQ_MB_t1 XD1.XDFFQ.MB__t1 XD1.XDFFQ.MB 64.2670388114
* device instance XD1_XDFFQ_MB_t2 r0 *1 0,0
RXD1_XDFFQ_MB_t2 XD1.XDFFQ.MB__t2 XD1.XDFFQ.MB 64.0069466513
* device instance XD1_XDFFQ_MB_t3 r0 *1 0,0
RXD1_XDFFQ_MB_t3 XD1.XDFFQ.MB__t3 XD1.XDFFQ.MB 63.3203033487
* device instance XD1_XDFFQ_MB r0 *1 0,0
CXD1_XDFFQ_MB XD1.XDFFQ.MB vsubs 5.6976447e-14
* device instance XD1_XDFFQ_S_t0 r0 *1 0,0
RXD1_XDFFQ_S_t0 XD1.XDFFQ.S__t0 XD1.XDFFQ.S 46.1747833333
* device instance XD1_XDFFQ_S_t1 r0 *1 0,0
RXD1_XDFFQ_S_t1 XD1.XDFFQ.S__t1 XD1.XDFFQ.S 45.3083292286
* device instance XD1_XDFFQ_S_t2 r0 *1 0,0
RXD1_XDFFQ_S_t2 XD1.XDFFQ.S__t2 XD1.XDFFQ.S 47.0412374381
* device instance XD1_XDFFQ_S_t3 r0 *1 0,0
RXD1_XDFFQ_S_t3 XD1.XDFFQ.S__t3 XD1.XDFFQ.S 46.1747833333
* device instance XD1_XDFFQ_S_t4 r0 *1 0,0
RXD1_XDFFQ_S_t4 XD1.XDFFQ.S__t4 XD1.XDFFQ.S 46.6677658412
* device instance XD1_XDFFQ_S_t5 r0 *1 0,0
RXD1_XDFFQ_S_t5 XD1.XDFFQ.S__t5 XD1.XDFFQ.S 45.6818008254
* device instance XD1_XDFFQ_S r0 *1 0,0
CXD1_XDFFQ_S XD1.XDFFQ.S vsubs 6.2468859e-14
* device instance XD1_XDFFQ_SB_t0 r0 *1 0,0
RXD1_XDFFQ_SB_t0 XD1.XDFFQ.SB__t0 XD1.XDFFQ.SB 47.2110435085
* device instance XD1_XDFFQ_SB_t1 r0 *1 0,0
RXD1_XDFFQ_SB_t1 XD1.XDFFQ.SB__t1 XD1.XDFFQ.SB 45.4787564915
* device instance XD1_XDFFQ_SB_t2 r0 *1 0,0
RXD1_XDFFQ_SB_t2 XD1.XDFFQ.SB__t2 XD1.XDFFQ.SB 46.3449
* device instance XD1_XDFFQ_SB_t3 r0 *1 0,0
RXD1_XDFFQ_SB_t3 XD1.XDFFQ.SB__t3 XD1.XDFFQ.SB 45.8520942107
* device instance XD1_XDFFQ_SB_t4 r0 *1 0,0
RXD1_XDFFQ_SB_t4 XD1.XDFFQ.SB__t4 XD1.XDFFQ.SB 46.3449
* device instance XD1_XDFFQ_SB_t5 r0 *1 0,0
RXD1_XDFFQ_SB_t5 XD1.XDFFQ.SB__t5 XD1.XDFFQ.SB 46.8377057893
* device instance XD1_XDFFQ_SB r0 *1 0,0
CXD1_XDFFQ_SB XD1.XDFFQ.SB vsubs 6.2720409e-14
* device instance XD1_XN2_mid1_t0 r0 *1 0,0
RXD1_XN2_mid1_t0 XD1.XN2.mid1__t0 XD1.XN2.mid1 10.13175
* device instance XD1_XN2_mid1_t1 r0 *1 0,0
RXD1_XN2_mid1_t1 XD1.XN2.mid1__t1 XD1.XN2.mid1 10.13175
* device instance XD1_XN2_mid1 r0 *1 0,0
CXD1_XN2_mid1 XD1.XN2.mid1 vsubs 5.049026e-15
* device instance XD1_XN3_mid1_t0 r0 *1 0,0
RXD1_XN3_mid1_t0 XD1.XN3.mid1__t0 XD1.XN3.mid1 10.30775
* device instance XD1_XN3_mid1_t1 r0 *1 0,0
RXD1_XN3_mid1_t1 XD1.XN3.mid1__t1 XD1.XN3.mid1 10.30775
* device instance XD1_XN3_mid1 r0 *1 0,0
CXD1_XN3_mid1 XD1.XN3.mid1 vsubs 5.158865e-15
* device instance XD1_XN3_mid2_t0 r0 *1 0,0
RXD1_XN3_mid2_t0 XD1.XN3.mid2__t0 XD1.XN3.mid2 10.48375
* device instance XD1_XN3_mid2_t1 r0 *1 0,0
RXD1_XN3_mid2_t1 XD1.XN3.mid2__t1 XD1.XN3.mid2 10.48375
* device instance XD1_XN3_mid2 r0 *1 0,0
CXD1_XN3_mid2 XD1.XN3.mid2 vsubs 5.248512e-15
* device instance XD1_XNOR_midp_t0 r0 *1 0,0
RXD1_XNOR_midp_t0 XD1.XNOR.midp__t0 XD1.XNOR.midp 12.18615
* device instance XD1_XNOR_midp_t1 r0 *1 0,0
RXD1_XNOR_midp_t1 XD1.XNOR.midp__t1 XD1.XNOR.midp 12.18615
* device instance XD1_XNOR_midp r0 *1 0,0
CXD1_XNOR_midp XD1.XNOR.midp vsubs 5.990583e-15
* device instance XD1_dmodout_t0 r0 *1 0,0
RXD1_dmodout_t0 XD1.dmodout__t0 XD1.dmodout 65.9354120844
* device instance XD1_dmodout_t1 r0 *1 0,0
RXD1_dmodout_t1 XD1.dmodout__t1 XD1.dmodout 68.3963879156
* device instance XD1_dmodout_t2 r0 *1 0,0
RXD1_dmodout_t2 XD1.dmodout__t2 XD1.dmodout 67.8660051933
* device instance XD1_dmodout_t3 r0 *1 0,0
RXD1_dmodout_t3 XD1.dmodout__t3 XD1.dmodout 66.4657948067
* device instance XD1_dmodout r0 *1 0,0
CXD1_dmodout XD1.dmodout vsubs 6.0276149e-14
* device instance XD1_dq_t0 r0 *1 0,0
RXD1_dq_t0 XD1.dq__t0 XD1.dq 66.7205532613
* device instance XD1_dq_t1 r0 *1 0,0
RXD1_dq_t1 XD1.dq__t1 XD1.dq 68.8768467387
* device instance XD1_dq_t2 r0 *1 0,0
RXD1_dq_t2 XD1.dq__t2 XD1.dq 46.0170377558
* device instance XD1_dq_t3 r0 *1 0,0
RXD1_dq_t3 XD1.dq__t3 XD1.dq 45.4036094389
* device instance XD1_dq_t4 r0 *1 0,0
RXD1_dq_t4 XD1.dq__t4 XD1.dq 44.1767528053
* device instance XD1_dq r0 *1 0,0
CXD1_dq XD1.dq vsubs 6.1129654e-14
* device instance XD1_nm_t0 r0 *1 0,0
RXD1_nm_t0 XD1.nm__t0 XD1.nm 47.2788729807
* device instance XD1_nm_t1 r0 *1 0,0
RXD1_nm_t1 XD1.nm__t1 XD1.nm 45.1454936859
* device instance XD1_nm_t2 r0 *1 0,0
RXD1_nm_t2 XD1.nm__t2 XD1.nm 46.2121833333
* device instance XD1_nm_t3 r0 *1 0,0
RXD1_nm_t3 XD1.nm__t3 XD1.nm 68.711365373
* device instance XD1_nm_t4 r0 *1 0,0
RXD1_nm_t4 XD1.nm__t4 XD1.nm 69.925184627
* device instance XD1_nm r0 *1 0,0
CXD1_nm XD1.nm vsubs 6.2556902e-14
* device instance XD1_nt_t0 r0 *1 0,0
RXD1_nt_t0 XD1.nt__t0 XD1.nt 36.5150444233
* device instance XD1_nt_t1 r0 *1 0,0
RXD1_nt_t1 XD1.nt__t1 XD1.nt 33.4433555767
* device instance XD1_nt_t2 r0 *1 0,0
RXD1_nt_t2 XD1.nt__t2 XD1.nt 34.4672518589
* device instance XD1_nt_t3 r0 *1 0,0
RXD1_nt_t3 XD1.nt__t3 XD1.nt 35.4911481411
* device instance XD1_nt_t4 r0 *1 0,0
RXD1_nt_t4 XD1.nt__t4 XD1.nt 69.0845574833
* device instance XD1_nt_t5 r0 *1 0,0
RXD1_nt_t5 XD1.nt__t5 XD1.nt 70.8322425167
* device instance XD1_nt r0 *1 0,0
CXD1_nt XD1.nt vsubs 6.3410368e-14
* device instance XD1_t1_t0 r0 *1 0,0
RXD1_t1_t0 XD1.t1__t0 XD1.t1 65.5467137788
* device instance XD1_t1_t1 r0 *1 0,0
RXD1_t1_t1 XD1.t1__t1 XD1.t1 63.0630862212
* device instance XD1_t1_t2 r0 *1 0,0
RXD1_t1_t2 XD1.t1__t2 XD1.t1 63.5983507811
* device instance XD1_t1_t3 r0 *1 0,0
RXD1_t1_t3 XD1.t1__t3 XD1.t1 65.0114492189
* device instance XD1_t1 r0 *1 0,0
CXD1_t1 XD1.t1 vsubs 5.790613e-14
* device instance XD2_XDFFM_CLKB_t0 r0 *1 0,0
RXD2_XDFFM_CLKB_t0 XD2.XDFFM.CLKB__t0 XD2.XDFFM.CLKB 54.3644138616
* device instance XD2_XDFFM_CLKB_t1 r0 *1 0,0
RXD2_XDFFM_CLKB_t1 XD2.XDFFM.CLKB__t1 XD2.XDFFM.CLKB 53.4895755447
* device instance XD2_XDFFM_CLKB_t2 r0 *1 0,0
RXD2_XDFFM_CLKB_t2 XD2.XDFFM.CLKB__t2 XD2.XDFFM.CLKB 50.8650605937
* device instance XD2_XDFFM_CLKB_t3 r0 *1 0,0
RXD2_XDFFM_CLKB_t3 XD2.XDFFM.CLKB__t3 XD2.XDFFM.CLKB 51.0812562697
* device instance XD2_XDFFM_CLKB_t4 r0 *1 0,0
RXD2_XDFFM_CLKB_t4 XD2.XDFFM.CLKB__t4 XD2.XDFFM.CLKB 53.5700204474
* device instance XD2_XDFFM_CLKB_t5 r0 *1 0,0
RXD2_XDFFM_CLKB_t5 XD2.XDFFM.CLKB__t5 XD2.XDFFM.CLKB 54.0677732829
* device instance XD2_XDFFM_CLKB r0 *1 0,0
CXD2_XDFFM_CLKB XD2.XDFFM.CLKB vsubs 7.1889067e-14
* device instance XD2_XDFFM_M_t0 r0 *1 0,0
RXD2_XDFFM_M_t0 XD2.XDFFM.M__t0 XD2.XDFFM.M 42.7243196956
* device instance XD2_XDFFM_M_t1 r0 *1 0,0
RXD2_XDFFM_M_t1 XD2.XDFFM.M__t1 XD2.XDFFM.M 42.0123840868
* device instance XD2_XDFFM_M_t2 r0 *1 0,0
RXD2_XDFFM_M_t2 XD2.XDFFM.M__t2 XD2.XDFFM.M 43.4362553044
* device instance XD2_XDFFM_M_t3 r0 *1 0,0
RXD2_XDFFM_M_t3 XD2.XDFFM.M__t3 XD2.XDFFM.M 44.1481909132
* device instance XD2_XDFFM_M_t4 r0 *1 0,0
RXD2_XDFFM_M_t4 XD2.XDFFM.M__t4 XD2.XDFFM.M 43.282820906
* device instance XD2_XDFFM_M_t5 r0 *1 0,0
RXD2_XDFFM_M_t5 XD2.XDFFM.M__t5 XD2.XDFFM.M 42.4726872821
* device instance XD2_XDFFM_M_t6 r0 *1 0,0
RXD2_XDFFM_M_t6 XD2.XDFFM.M__t6 XD2.XDFFM.M 43.6878877179
* device instance XD2_XDFFM_M_t7 r0 *1 0,0
RXD2_XDFFM_M_t7 XD2.XDFFM.M__t7 XD2.XDFFM.M 42.877754094
* device instance XD2_XDFFM_M r0 *1 0,0
CXD2_XDFFM_M XD2.XDFFM.M vsubs 7.8506312e-14
* device instance XD2_XDFFM_MB_t0 r0 *1 0,0
RXD2_XDFFM_MB_t0 XD2.XDFFM.MB__t0 XD2.XDFFM.MB 73.4355542597
* device instance XD2_XDFFM_MB_t1 r0 *1 0,0
RXD2_XDFFM_MB_t1 XD2.XDFFM.MB__t1 XD2.XDFFM.MB 74.6592457403
* device instance XD2_XDFFM_MB_t2 r0 *1 0,0
RXD2_XDFFM_MB_t2 XD2.XDFFM.MB__t2 XD2.XDFFM.MB 74.3955191281
* device instance XD2_XDFFM_MB_t3 r0 *1 0,0
RXD2_XDFFM_MB_t3 XD2.XDFFM.MB__t3 XD2.XDFFM.MB 73.6992808719
* device instance XD2_XDFFM_MB r0 *1 0,0
CXD2_XDFFM_MB XD2.XDFFM.MB vsubs 6.6561405e-14
* device instance XD2_XDFFM_S_t0 r0 *1 0,0
RXD2_XDFFM_S_t0 XD2.XDFFM.S__t0 XD2.XDFFM.S 53.9185666667
* device instance XD2_XDFFM_S_t1 r0 *1 0,0
RXD2_XDFFM_S_t1 XD2.XDFFM.S__t1 XD2.XDFFM.S 54.8017495148
* device instance XD2_XDFFM_S_t2 r0 *1 0,0
RXD2_XDFFM_S_t2 XD2.XDFFM.S__t2 XD2.XDFFM.S 53.0353838185
* device instance XD2_XDFFM_S_t3 r0 *1 0,0
RXD2_XDFFM_S_t3 XD2.XDFFM.S__t3 XD2.XDFFM.S 53.9185666667
* device instance XD2_XDFFM_S_t4 r0 *1 0,0
RXD2_XDFFM_S_t4 XD2.XDFFM.S__t4 XD2.XDFFM.S 53.4160660807
* device instance XD2_XDFFM_S_t5 r0 *1 0,0
RXD2_XDFFM_S_t5 XD2.XDFFM.S__t5 XD2.XDFFM.S 54.4210672527
* device instance XD2_XDFFM_S r0 *1 0,0
CXD2_XDFFM_S XD2.XDFFM.S vsubs 7.3323227e-14
* device instance XD2_XDFFM_SB_t0 r0 *1 0,0
RXD2_XDFFM_SB_t0 XD2.XDFFM.SB__t0 XD2.XDFFM.SB 54.97155301
* device instance XD2_XDFFM_SB_t1 r0 *1 0,0
RXD2_XDFFM_SB_t1 XD2.XDFFM.SB__t1 XD2.XDFFM.SB 53.20584699
* device instance XD2_XDFFM_SB_t2 r0 *1 0,0
RXD2_XDFFM_SB_t2 XD2.XDFFM.SB__t2 XD2.XDFFM.SB 54.0887
* device instance XD2_XDFFM_SB_t3 r0 *1 0,0
RXD2_XDFFM_SB_t3 XD2.XDFFM.SB__t3 XD2.XDFFM.SB 53.5863870805
* device instance XD2_XDFFM_SB_t4 r0 *1 0,0
RXD2_XDFFM_SB_t4 XD2.XDFFM.SB__t4 XD2.XDFFM.SB 54.5910129195
* device instance XD2_XDFFM_SB_t5 r0 *1 0,0
RXD2_XDFFM_SB_t5 XD2.XDFFM.SB__t5 XD2.XDFFM.SB 54.0887
* device instance XD2_XDFFM_SB r0 *1 0,0
CXD2_XDFFM_SB XD2.XDFFM.SB vsubs 7.3574776e-14
* device instance XD2_XDFFQ_CLKB_t0 r0 *1 0,0
RXD2_XDFFQ_CLKB_t0 XD2.XDFFQ.CLKB__t0 XD2.XDFFQ.CLKB 52.7715565824
* device instance XD2_XDFFQ_CLKB_t1 r0 *1 0,0
RXD2_XDFFQ_CLKB_t1 XD2.XDFFQ.CLKB__t1 XD2.XDFFQ.CLKB 53.6694664561
* device instance XD2_XDFFQ_CLKB_t2 r0 *1 0,0
RXD2_XDFFQ_CLKB_t2 XD2.XDFFQ.CLKB__t2 XD2.XDFFQ.CLKB 50.0778269615
* device instance XD2_XDFFQ_CLKB_t3 r0 *1 0,0
RXD2_XDFFQ_CLKB_t3 XD2.XDFFQ.CLKB__t3 XD2.XDFFQ.CLKB 52.8541230076
* device instance XD2_XDFFQ_CLKB_t4 r0 *1 0,0
RXD2_XDFFQ_CLKB_t4 XD2.XDFFQ.CLKB__t4 XD2.XDFFQ.CLKB 50.2997242291
* device instance XD2_XDFFQ_CLKB_t5 r0 *1 0,0
RXD2_XDFFQ_CLKB_t5 XD2.XDFFQ.CLKB__t5 XD2.XDFFQ.CLKB 53.3650027633
* device instance XD2_XDFFQ_CLKB r0 *1 0,0
CXD2_XDFFQ_CLKB XD2.XDFFQ.CLKB vsubs 7.1115146e-14
* device instance XD2_XDFFQ_M_t0 r0 *1 0,0
RXD2_XDFFQ_M_t0 XD2.XDFFQ.M__t0 XD2.XDFFQ.M 42.382581094
* device instance XD2_XDFFQ_M_t1 r0 *1 0,0
RXD2_XDFFQ_M_t1 XD2.XDFFQ.M__t1 XD2.XDFFQ.M 41.647293282
* device instance XD2_XDFFQ_M_t2 r0 *1 0,0
RXD2_XDFFQ_M_t2 XD2.XDFFQ.M__t2 XD2.XDFFQ.M 43.117868906
* device instance XD2_XDFFQ_M_t3 r0 *1 0,0
RXD2_XDFFQ_M_t3 XD2.XDFFQ.M__t3 XD2.XDFFQ.M 43.853156718
* device instance XD2_XDFFQ_M_t4 r0 *1 0,0
RXD2_XDFFQ_M_t4 XD2.XDFFQ.M__t4 XD2.XDFFQ.M 42.9594017051
* device instance XD2_XDFFQ_M_t5 r0 *1 0,0
RXD2_XDFFQ_M_t5 XD2.XDFFQ.M__t5 XD2.XDFFQ.M 42.1226948846
* device instance XD2_XDFFQ_M_t6 r0 *1 0,0
RXD2_XDFFQ_M_t6 XD2.XDFFQ.M__t6 XD2.XDFFQ.M 43.3777551154
* device instance XD2_XDFFQ_M_t7 r0 *1 0,0
RXD2_XDFFQ_M_t7 XD2.XDFFQ.M__t7 XD2.XDFFQ.M 42.5410482949
* device instance XD2_XDFFQ_M r0 *1 0,0
CXD2_XDFFQ_M XD2.XDFFQ.M vsubs 7.8183414e-14
* device instance XD2_XDFFQ_MB_t0 r0 *1 0,0
RXD2_XDFFQ_MB_t0 XD2.XDFFQ.MB__t0 XD2.XDFFQ.MB 71.8838004077
* device instance XD2_XDFFQ_MB_t1 r0 *1 0,0
RXD2_XDFFQ_MB_t1 XD2.XDFFQ.MB__t1 XD2.XDFFQ.MB 73.1308995923
* device instance XD2_XDFFQ_MB_t2 r0 *1 0,0
RXD2_XDFFQ_MB_t2 XD2.XDFFQ.MB__t2 XD2.XDFFQ.MB 72.8621282163
* device instance XD2_XDFFQ_MB_t3 r0 *1 0,0
RXD2_XDFFQ_MB_t3 XD2.XDFFQ.MB__t3 XD2.XDFFQ.MB 72.1525717837
* device instance XD2_XDFFQ_MB r0 *1 0,0
CXD2_XDFFQ_MB XD2.XDFFQ.MB vsubs 6.5336461e-14
* device instance XD2_XDFFQ_S_t0 r0 *1 0,0
RXD2_XDFFQ_S_t0 XD2.XDFFQ.S__t0 XD2.XDFFQ.S 53.1851833333
* device instance XD2_XDFFQ_S_t1 r0 *1 0,0
RXD2_XDFFQ_S_t1 XD2.XDFFQ.S__t1 XD2.XDFFQ.S 52.2788174853
* device instance XD2_XDFFQ_S_t2 r0 *1 0,0
RXD2_XDFFQ_S_t2 XD2.XDFFQ.S__t2 XD2.XDFFQ.S 54.0915491814
* device instance XD2_XDFFQ_S_t3 r0 *1 0,0
RXD2_XDFFQ_S_t3 XD2.XDFFQ.S__t3 XD2.XDFFQ.S 53.1851833333
* device instance XD2_XDFFQ_S_t4 r0 *1 0,0
RXD2_XDFFQ_S_t4 XD2.XDFFQ.S__t4 XD2.XDFFQ.S 53.7008742469
* device instance XD2_XDFFQ_S_t5 r0 *1 0,0
RXD2_XDFFQ_S_t5 XD2.XDFFQ.S__t5 XD2.XDFFQ.S 52.6694924198
* device instance XD2_XDFFQ_S r0 *1 0,0
CXD2_XDFFQ_S XD2.XDFFQ.S vsubs 7.2549306e-14
* device instance XD2_XDFFQ_SB_t0 r0 *1 0,0
RXD2_XDFFQ_SB_t0 XD2.XDFFQ.SB__t0 XD2.XDFFQ.SB 54.2612376156
* device instance XD2_XDFFQ_SB_t1 r0 *1 0,0
RXD2_XDFFQ_SB_t1 XD2.XDFFQ.SB__t1 XD2.XDFFQ.SB 52.4493623844
* device instance XD2_XDFFQ_SB_t2 r0 *1 0,0
RXD2_XDFFQ_SB_t2 XD2.XDFFQ.SB__t2 XD2.XDFFQ.SB 53.3553
* device instance XD2_XDFFQ_SB_t3 r0 *1 0,0
RXD2_XDFFQ_SB_t3 XD2.XDFFQ.SB__t3 XD2.XDFFQ.SB 52.839852736
* device instance XD2_XDFFQ_SB_t4 r0 *1 0,0
RXD2_XDFFQ_SB_t4 XD2.XDFFQ.SB__t4 XD2.XDFFQ.SB 53.3553
* device instance XD2_XDFFQ_SB_t5 r0 *1 0,0
RXD2_XDFFQ_SB_t5 XD2.XDFFQ.SB__t5 XD2.XDFFQ.SB 53.870747264
* device instance XD2_XDFFQ_SB r0 *1 0,0
CXD2_XDFFQ_SB XD2.XDFFQ.SB vsubs 7.2800855e-14
* device instance XD2_XN2_mid1_t0 r0 *1 0,0
RXD2_XN2_mid1_t0 XD2.XN2.mid1__t0 XD2.XN2.mid1 13.47555
* device instance XD2_XN2_mid1_t1 r0 *1 0,0
RXD2_XN2_mid1_t1 XD2.XN2.mid1__t1 XD2.XN2.mid1 13.47555
* device instance XD2_XN2_mid1 r0 *1 0,0
CXD2_XN2_mid1 XD2.XN2.mid1 vsubs 6.741642e-15
* device instance XD2_XN3_mid1_t0 r0 *1 0,0
RXD2_XN3_mid1_t0 XD2.XN3.mid1__t0 XD2.XN3.mid1 13.65155
* device instance XD2_XN3_mid1_t1 r0 *1 0,0
RXD2_XN3_mid1_t1 XD2.XN3.mid1__t1 XD2.XN3.mid1 13.65155
* device instance XD2_XN3_mid1 r0 *1 0,0
CXD2_XN3_mid1 XD2.XN3.mid1 vsubs 6.851481e-15
* device instance XD2_XN3_mid2_t0 r0 *1 0,0
RXD2_XN3_mid2_t0 XD2.XN3.mid2__t0 XD2.XN3.mid2 13.82755
* device instance XD2_XN3_mid2_t1 r0 *1 0,0
RXD2_XN3_mid2_t1 XD2.XN3.mid2__t1 XD2.XN3.mid2 13.82755
* device instance XD2_XN3_mid2 r0 *1 0,0
CXD2_XN3_mid2 XD2.XN3.mid2 vsubs 6.941129e-15
* device instance XD2_XNOR_midp_t0 r0 *1 0,0
RXD2_XNOR_midp_t0 XD2.XNOR.midp__t0 XD2.XNOR.midp 15.52995
* device instance XD2_XNOR_midp_t1 r0 *1 0,0
RXD2_XNOR_midp_t1 XD2.XNOR.midp__t1 XD2.XNOR.midp 15.52995
* device instance XD2_XNOR_midp r0 *1 0,0
CXD2_XNOR_midp XD2.XNOR.midp vsubs 7.738831e-15
* device instance XD2_dmodout_t0 r0 *1 0,0
RXD2_dmodout_t0 XD2.dmodout__t0 XD2.dmodout 74.7422704385
* device instance XD2_dmodout_t1 r0 *1 0,0
RXD2_dmodout_t1 XD2.dmodout__t1 XD2.dmodout 77.2770795615
* device instance XD2_dmodout_t2 r0 *1 0,0
RXD2_dmodout_t2 XD2.dmodout__t2 XD2.dmodout 76.7307844919
* device instance XD2_dmodout_t3 r0 *1 0,0
RXD2_dmodout_t3 XD2.dmodout__t3 XD2.dmodout 75.2885655081
* device instance XD2_dmodout r0 *1 0,0
CXD2_dmodout XD2.dmodout vsubs 6.8636163e-14
* device instance XD2_dq_t0 r0 *1 0,0
RXD2_dq_t0 XD2.dq__t0 XD2.dq 76.3612162761
* device instance XD2_dq_t1 r0 *1 0,0
RXD2_dq_t1 XD2.dq__t1 XD2.dq 78.5956337239
* device instance XD2_dq_t2 r0 *1 0,0
RXD2_dq_t2 XD2.dq__t2 XD2.dq 52.4998209859
* device instance XD2_dq_t3 r0 *1 0,0
RXD2_dq_t3 XD2.dq__t3 XD2.dq 51.8641677465
* device instance XD2_dq_t4 r0 *1 0,0
RXD2_dq_t4 XD2.dq__t4 XD2.dq 50.5928612676
* device instance XD2_dq r0 *1 0,0
CXD2_dq XD2.dq vsubs 7.0335977e-14
* device instance XD2_nm_t0 r0 *1 0,0
RXD2_nm_t0 XD2.nm__t0 XD2.nm 53.7709736412
* device instance XD2_nm_t1 r0 *1 0,0
RXD2_nm_t1 XD2.nm__t1 XD2.nm 51.5596930254
* device instance XD2_nm_t2 r0 *1 0,0
RXD2_nm_t2 XD2.nm__t2 XD2.nm 52.6653333333
* device instance XD2_nm_t3 r0 *1 0,0
RXD2_nm_t3 XD2.nm__t3 XD2.nm 78.3689287903
* device instance XD2_nm_t4 r0 *1 0,0
RXD2_nm_t4 XD2.nm__t4 XD2.nm 79.6270712097
* device instance XD2_nm r0 *1 0,0
CXD2_nm XD2.nm vsubs 7.179104e-14
* device instance XD2_nt_t0 r0 *1 0,0
RXD2_nt_t0 XD2.nt__t0 XD2.nt 41.8356573682
* device instance XD2_nt_t1 r0 *1 0,0
RXD2_nt_t1 XD2.nt__t1 XD2.nt 40.7699107894
* device instance XD2_nt_t2 r0 *1 0,0
RXD2_nt_t2 XD2.nt__t2 XD2.nt 39.7041642106
* device instance XD2_nt_t3 r0 *1 0,0
RXD2_nt_t3 XD2.nt__t3 XD2.nt 38.6384176318
* device instance XD2_nt_t4 r0 *1 0,0
RXD2_nt_t4 XD2.nt__t4 XD2.nt 79.5645154198
* device instance XD2_nt_t5 r0 *1 0,0
RXD2_nt_t5 XD2.nt__t5 XD2.nt 81.3836345802
* device instance XD2_nt r0 *1 0,0
CXD2_nt XD2.nt vsubs 7.3518629e-14
* device instance XD2_t1_t0 r0 *1 0,0
RXD2_t1_t0 XD2.t1__t0 XD2.t1 74.4281726245
* device instance XD2_t1_t1 r0 *1 0,0
RXD2_t1_t1 XD2.t1__t1 XD2.t1 71.8692273755
* device instance XD2_t1_t2 r0 *1 0,0
RXD2_t1_t2 XD2.t1__t2 XD2.t1 72.4207241964
* device instance XD2_t1_t3 r0 *1 0,0
RXD2_t1_t3 XD2.t1__t3 XD2.t1 73.8766758036
* device instance XD2_t1 r0 *1 0,0
CXD2_t1 XD2.t1 vsubs 6.6266144e-14
* device instance XD3_XDFFM_CLKB_t0 r0 *1 0,0
RXD3_XDFFM_CLKB_t0 XD3.XDFFM.CLKB__t0 XD3.XDFFM.CLKB 60.523291284
* device instance XD3_XDFFM_CLKB_t1 r0 *1 0,0
RXD3_XDFFM_CLKB_t1 XD3.XDFFM.CLKB__t1 XD3.XDFFM.CLKB 61.43300321
* device instance XD3_XDFFM_CLKB_t2 r0 *1 0,0
RXD3_XDFFM_CLKB_t2 XD3.XDFFM.CLKB__t2 XD3.XDFFM.CLKB 57.794155506
* device instance XD3_XDFFM_CLKB_t3 r0 *1 0,0
RXD3_XDFFM_CLKB_t3 XD3.XDFFM.CLKB__t3 XD3.XDFFM.CLKB 60.6069429554
* device instance XD3_XDFFM_CLKB_t4 r0 *1 0,0
RXD3_XDFFM_CLKB_t4 XD3.XDFFM.CLKB__t4 XD3.XDFFM.CLKB 58.0189693728
* device instance XD3_XDFFM_CLKB_t5 r0 *1 0,0
RXD3_XDFFM_CLKB_t5 XD3.XDFFM.CLKB__t5 XD3.XDFFM.CLKB 61.1245376719
* device instance XD3_XDFFM_CLKB r0 *1 0,0
CXD3_XDFFM_CLKB XD3.XDFFM.CLKB vsubs 8.1969513e-14
* device instance XD3_XDFFM_M_t0 r0 *1 0,0
RXD3_XDFFM_M_t0 XD3.XDFFM.M__t0 XD3.XDFFM.M 48.8010003881
* device instance XD3_XDFFM_M_t1 r0 *1 0,0
RXD3_XDFFM_M_t1 XD3.XDFFM.M__t1 XD3.XDFFM.M 48.0548011643
* device instance XD3_XDFFM_M_t2 r0 *1 0,0
RXD3_XDFFM_M_t2 XD3.XDFFM.M__t2 XD3.XDFFM.M 49.5471996119
* device instance XD3_XDFFM_M_t3 r0 *1 0,0
RXD3_XDFFM_M_t3 XD3.XDFFM.M__t3 XD3.XDFFM.M 50.2933988357
* device instance XD3_XDFFM_M_t4 r0 *1 0,0
RXD3_XDFFM_M_t4 XD3.XDFFM.M__t4 XD3.XDFFM.M 49.3863808137
* device instance XD3_XDFFM_M_t5 r0 *1 0,0
RXD3_XDFFM_M_t5 XD3.XDFFM.M__t5 XD3.XDFFM.M 48.537257559
* device instance XD3_XDFFM_M_t6 r0 *1 0,0
RXD3_XDFFM_M_t6 XD3.XDFFM.M__t6 XD3.XDFFM.M 49.810942441
* device instance XD3_XDFFM_M_t7 r0 *1 0,0
RXD3_XDFFM_M_t7 XD3.XDFFM.M__t7 XD3.XDFFM.M 48.9618191863
* device instance XD3_XDFFM_M r0 *1 0,0
CXD3_XDFFM_M XD3.XDFFM.M vsubs 9.030719e-14
* device instance XD3_XDFFM_MB_t0 r0 *1 0,0
RXD3_XDFFM_MB_t0 XD3.XDFFM.MB__t0 XD3.XDFFM.MB 82.2623027853
* device instance XD3_XDFFM_MB_t1 r0 *1 0,0
RXD3_XDFFM_MB_t1 XD3.XDFFM.MB__t1 XD3.XDFFM.MB 83.5201472147
* device instance XD3_XDFFM_MB_t2 r0 *1 0,0
RXD3_XDFFM_MB_t2 XD3.XDFFM.MB__t2 XD3.XDFFM.MB 83.2490600532
* device instance XD3_XDFFM_MB_t3 r0 *1 0,0
RXD3_XDFFM_MB_t3 XD3.XDFFM.MB__t3 XD3.XDFFM.MB 82.5333899468
* device instance XD3_XDFFM_MB r0 *1 0,0
CXD3_XDFFM_MB XD3.XDFFM.MB vsubs 7.4921419e-14
* device instance XD3_XDFFM_S_t0 r0 *1 0,0
RXD3_XDFFM_S_t0 XD3.XDFFM.S__t0 XD3.XDFFM.S 60.9290666667
* device instance XD3_XDFFM_S_t1 r0 *1 0,0
RXD3_XDFFM_S_t1 XD3.XDFFM.S__t1 XD3.XDFFM.S 60.0119880914
* device instance XD3_XDFFM_S_t2 r0 *1 0,0
RXD3_XDFFM_S_t2 XD3.XDFFM.S__t2 XD3.XDFFM.S 61.846145242
* device instance XD3_XDFFM_S_t3 r0 *1 0,0
RXD3_XDFFM_S_t3 XD3.XDFFM.S__t3 XD3.XDFFM.S 60.9290666667
* device instance XD3_XDFFM_S_t4 r0 *1 0,0
RXD3_XDFFM_S_t4 XD3.XDFFM.S__t4 XD3.XDFFM.S 61.4508527526
* device instance XD3_XDFFM_S_t5 r0 *1 0,0
RXD3_XDFFM_S_t5 XD3.XDFFM.S__t5 XD3.XDFFM.S 60.4072805807
* device instance XD3_XDFFM_S r0 *1 0,0
CXD3_XDFFM_S XD3.XDFFM.S vsubs 8.3403673e-14
* device instance XD3_XDFFM_SB_t0 r0 *1 0,0
RXD3_XDFFM_SB_t0 XD3.XDFFM.SB__t0 XD3.XDFFM.SB 62.0158488848
* device instance XD3_XDFFM_SB_t1 r0 *1 0,0
RXD3_XDFFM_SB_t1 XD3.XDFFM.SB__t1 XD3.XDFFM.SB 60.1825177818
* device instance XD3_XDFFM_SB_t2 r0 *1 0,0
RXD3_XDFFM_SB_t2 XD3.XDFFM.SB__t2 XD3.XDFFM.SB 61.0991833333
* device instance XD3_XDFFM_SB_t3 r0 *1 0,0
RXD3_XDFFM_SB_t3 XD3.XDFFM.SB__t3 XD3.XDFFM.SB 60.5776322437
* device instance XD3_XDFFM_SB_t4 r0 *1 0,0
RXD3_XDFFM_SB_t4 XD3.XDFFM.SB__t4 XD3.XDFFM.SB 61.620734423
* device instance XD3_XDFFM_SB_t5 r0 *1 0,0
RXD3_XDFFM_SB_t5 XD3.XDFFM.SB__t5 XD3.XDFFM.SB 61.0991833333
* device instance XD3_XDFFM_SB r0 *1 0,0
CXD3_XDFFM_SB XD3.XDFFM.SB vsubs 8.3655222e-14
* device instance XD3_XDFFQ_CLKB_t0 r0 *1 0,0
RXD3_XDFFQ_CLKB_t0 XD3.XDFFQ.CLKB__t0 XD3.XDFFQ.CLKB 59.804868859
* device instance XD3_XDFFQ_CLKB_t1 r0 *1 0,0
RXD3_XDFFQ_CLKB_t1 XD3.XDFFQ.CLKB__t1 XD3.XDFFQ.CLKB 60.7369971476
* device instance XD3_XDFFQ_CLKB_t2 r0 *1 0,0
RXD3_XDFFQ_CLKB_t2 XD3.XDFFQ.CLKB__t2 XD3.XDFFQ.CLKB 57.0084839933
* device instance XD3_XDFFQ_CLKB_t3 r0 *1 0,0
RXD3_XDFFQ_CLKB_t3 XD3.XDFFQ.CLKB__t3 XD3.XDFFQ.CLKB 59.8905818051
* device instance XD3_XDFFQ_CLKB_t4 r0 *1 0,0
RXD3_XDFFQ_CLKB_t4 XD3.XDFFQ.CLKB__t4 XD3.XDFFQ.CLKB 57.2388375359
* device instance XD3_XDFFQ_CLKB_t5 r0 *1 0,0
RXD3_XDFFQ_CLKB_t5 XD3.XDFFQ.CLKB__t5 XD3.XDFFQ.CLKB 60.420930659
* device instance XD3_XDFFQ_CLKB r0 *1 0,0
CXD3_XDFFQ_CLKB XD3.XDFFQ.CLKB vsubs 8.1195592e-14
* device instance XD3_XDFFQ_M_t0 r0 *1 0,0
RXD3_XDFFQ_M_t0 XD3.XDFFQ.M__t0 XD3.XDFFQ.M 48.4596375464
* device instance XD3_XDFFQ_M_t1 r0 *1 0,0
RXD3_XDFFQ_M_t1 XD3.XDFFQ.M__t1 XD3.XDFFQ.M 47.6907876391
* device instance XD3_XDFFQ_M_t2 r0 *1 0,0
RXD3_XDFFQ_M_t2 XD3.XDFFQ.M__t2 XD3.XDFFQ.M 49.2284874536
* device instance XD3_XDFFQ_M_t3 r0 *1 0,0
RXD3_XDFFQ_M_t3 XD3.XDFFQ.M__t3 XD3.XDFFQ.M 49.9973373609
* device instance XD3_XDFFQ_M_t4 r0 *1 0,0
RXD3_XDFFQ_M_t4 XD3.XDFFQ.M__t4 XD3.XDFFQ.M 49.0627870426
* device instance XD3_XDFFQ_M_t5 r0 *1 0,0
RXD3_XDFFQ_M_t5 XD3.XDFFQ.M__t5 XD3.XDFFQ.M 48.1878888722
* device instance XD3_XDFFQ_M_t6 r0 *1 0,0
RXD3_XDFFQ_M_t6 XD3.XDFFQ.M__t6 XD3.XDFFQ.M 49.5002361278
* device instance XD3_XDFFQ_M_t7 r0 *1 0,0
RXD3_XDFFQ_M_t7 XD3.XDFFQ.M__t7 XD3.XDFFQ.M 48.6253379574
* device instance XD3_XDFFQ_M r0 *1 0,0
CXD3_XDFFQ_M XD3.XDFFQ.M vsubs 8.9984292e-14
* device instance XD3_XDFFQ_MB_t0 r0 *1 0,0
RXD3_XDFFQ_MB_t0 XD3.XDFFQ.MB__t0 XD3.XDFFQ.MB 80.7109043084
* device instance XD3_XDFFQ_MB_t1 r0 *1 0,0
RXD3_XDFFQ_MB_t1 XD3.XDFFQ.MB__t1 XD3.XDFFQ.MB 81.9914456916
* device instance XD3_XDFFQ_MB_t2 r0 *1 0,0
RXD3_XDFFQ_MB_t2 XD3.XDFFQ.MB__t2 XD3.XDFFQ.MB 81.7154669452
* device instance XD3_XDFFQ_MB_t3 r0 *1 0,0
RXD3_XDFFQ_MB_t3 XD3.XDFFQ.MB__t3 XD3.XDFFQ.MB 80.9868830548
* device instance XD3_XDFFQ_MB r0 *1 0,0
CXD3_XDFFQ_MB XD3.XDFFQ.MB vsubs 7.3696475e-14
* device instance XD3_XDFFQ_S_t0 r0 *1 0,0
RXD3_XDFFQ_S_t0 XD3.XDFFQ.S__t0 XD3.XDFFQ.S 60.1957
* device instance XD3_XDFFQ_S_t1 r0 *1 0,0
RXD3_XDFFQ_S_t1 XD3.XDFFQ.S__t1 XD3.XDFFQ.S 59.2561335583
* device instance XD3_XDFFQ_S_t2 r0 *1 0,0
RXD3_XDFFQ_S_t2 XD3.XDFFQ.S__t2 XD3.XDFFQ.S 61.1352664417
* device instance XD3_XDFFQ_S_t3 r0 *1 0,0
RXD3_XDFFQ_S_t3 XD3.XDFFQ.S__t3 XD3.XDFFQ.S 60.1957
* device instance XD3_XDFFQ_S_t4 r0 *1 0,0
RXD3_XDFFQ_S_t4 XD3.XDFFQ.S__t4 XD3.XDFFQ.S 60.7302809065
* device instance XD3_XDFFQ_S_t5 r0 *1 0,0
RXD3_XDFFQ_S_t5 XD3.XDFFQ.S__t5 XD3.XDFFQ.S 59.6611190935
* device instance XD3_XDFFQ_S r0 *1 0,0
CXD3_XDFFQ_S XD3.XDFFQ.S vsubs 8.2629752e-14
* device instance XD3_XDFFQ_SB_t0 r0 *1 0,0
RXD3_XDFFQ_SB_t0 XD3.XDFFQ.SB__t0 XD3.XDFFQ.SB 61.3048794592
* device instance XD3_XDFFQ_SB_t1 r0 *1 0,0
RXD3_XDFFQ_SB_t1 XD3.XDFFQ.SB__t1 XD3.XDFFQ.SB 59.4267538741
* device instance XD3_XDFFQ_SB_t2 r0 *1 0,0
RXD3_XDFFQ_SB_t2 XD3.XDFFQ.SB__t2 XD3.XDFFQ.SB 60.3658166667
* device instance XD3_XDFFQ_SB_t3 r0 *1 0,0
RXD3_XDFFQ_SB_t3 XD3.XDFFQ.SB__t3 XD3.XDFFQ.SB 59.8315223192
* device instance XD3_XDFFQ_SB_t4 r0 *1 0,0
RXD3_XDFFQ_SB_t4 XD3.XDFFQ.SB__t4 XD3.XDFFQ.SB 60.9001110141
* device instance XD3_XDFFQ_SB_t5 r0 *1 0,0
RXD3_XDFFQ_SB_t5 XD3.XDFFQ.SB__t5 XD3.XDFFQ.SB 60.3658166667
* device instance XD3_XDFFQ_SB r0 *1 0,0
CXD3_XDFFQ_SB XD3.XDFFQ.SB vsubs 8.2881301e-14
* device instance XD3_XN2_mid1_t0 r0 *1 0,0
RXD3_XN2_mid1_t0 XD3.XN2.mid1__t0 XD3.XN2.mid1 16.81945
* device instance XD3_XN2_mid1_t1 r0 *1 0,0
RXD3_XN2_mid1_t1 XD3.XN2.mid1__t1 XD3.XN2.mid1 16.81945
* device instance XD3_XN2_mid1 r0 *1 0,0
CXD3_XN2_mid1 XD3.XN2.mid1 vsubs 8.434259e-15
* device instance XD3_XN3_mid1_t0 r0 *1 0,0
RXD3_XN3_mid1_t0 XD3.XN3.mid1__t0 XD3.XN3.mid1 16.99545
* device instance XD3_XN3_mid1_t1 r0 *1 0,0
RXD3_XN3_mid1_t1 XD3.XN3.mid1__t1 XD3.XN3.mid1 16.99545
* device instance XD3_XN3_mid1 r0 *1 0,0
CXD3_XN3_mid1 XD3.XN3.mid1 vsubs 8.544098e-15
* device instance XD3_XN3_mid2_t0 r0 *1 0,0
RXD3_XN3_mid2_t0 XD3.XN3.mid2__t0 XD3.XN3.mid2 17.17145
* device instance XD3_XN3_mid2_t1 r0 *1 0,0
RXD3_XN3_mid2_t1 XD3.XN3.mid2__t1 XD3.XN3.mid2 17.17145
* device instance XD3_XN3_mid2 r0 *1 0,0
CXD3_XN3_mid2 XD3.XN3.mid2 vsubs 8.633746e-15
* device instance XD3_XNOR_midp_t0 r0 *1 0,0
RXD3_XNOR_midp_t0 XD3.XNOR.midp__t0 XD3.XNOR.midp 18.87385
* device instance XD3_XNOR_midp_t1 r0 *1 0,0
RXD3_XNOR_midp_t1 XD3.XNOR.midp__t1 XD3.XNOR.midp 18.87385
* device instance XD3_XNOR_midp r0 *1 0,0
CXD3_XNOR_midp XD3.XNOR.midp vsubs 9.487078e-15
* device instance XD3_dmodout_t0 r0 *1 0,0
RXD3_dmodout_t0 XD3.dmodout__t0 XD3.dmodout 83.555313628
* device instance XD3_dmodout_t1 r0 *1 0,0
RXD3_dmodout_t1 XD3.dmodout__t1 XD3.dmodout 86.151786372
* device instance XD3_dmodout_t2 r0 *1 0,0
RXD3_dmodout_t2 XD3.dmodout__t2 XD3.dmodout 84.1148982711
* device instance XD3_dmodout_t3 r0 *1 0,0
RXD3_dmodout_t3 XD3.dmodout__t3 XD3.dmodout 85.5922017289
* device instance XD3_dmodout r0 *1 0,0
CXD3_dmodout XD3.dmodout vsubs 7.6996177e-14
* device instance XD3_dq_t0 r0 *1 0,0
RXD3_dq_t0 XD3.dq__t0 XD3.dq 86.0086650234
* device instance XD3_dq_t1 r0 *1 0,0
RXD3_dq_t1 XD3.dq__t1 XD3.dq 88.3078849766
* device instance XD3_dq_t2 r0 *1 0,0
RXD3_dq_t2 XD3.dq__t2 XD3.dq 58.9776345799
* device instance XD3_dq_t3 r0 *1 0,0
RXD3_dq_t3 XD3.dq__t3 XD3.dq 58.323546145
* device instance XD3_dq_t4 r0 *1 0,0
RXD3_dq_t4 XD3.dq__t4 XD3.dq 57.0153692751
* device instance XD3_dq r0 *1 0,0
CXD3_dq XD3.dq vsubs 7.9542299e-14
* device instance XD3_nm_t0 r0 *1 0,0
RXD3_nm_t0 XD3.nm__t0 XD3.nm 60.2566949002
* device instance XD3_nm_t1 r0 *1 0,0
RXD3_nm_t1 XD3.nm__t1 XD3.nm 57.9804384332
* device instance XD3_nm_t2 r0 *1 0,0
RXD3_nm_t2 XD3.nm__t2 XD3.nm 59.1185666667
* device instance XD3_nm_t3 r0 *1 0,0
RXD3_nm_t3 XD3.nm__t3 XD3.nm 88.0302942809
* device instance XD3_nm_t4 r0 *1 0,0
RXD3_nm_t4 XD3.nm__t4 XD3.nm 89.3254057191
* device instance XD3_nm r0 *1 0,0
CXD3_nm XD3.nm vsubs 8.1025178e-14
* device instance XD3_nt_t0 r0 *1 0,0
RXD3_nt_t0 XD3.nt__t0 XD3.nt 47.145440935
* device instance XD3_nt_t1 r0 *1 0,0
RXD3_nt_t1 XD3.nt__t1 XD3.nt 43.844459065
* device instance XD3_nt_t2 r0 *1 0,0
RXD3_nt_t2 XD3.nt__t2 XD3.nt 44.944786355
* device instance XD3_nt_t3 r0 *1 0,0
RXD3_nt_t3 XD3.nt__t3 XD3.nt 46.045113645
* device instance XD3_nt_t4 r0 *1 0,0
RXD3_nt_t4 XD3.nt__t4 XD3.nt 90.0508275715
* device instance XD3_nt_t5 r0 *1 0,0
RXD3_nt_t5 XD3.nt__t5 XD3.nt 91.9289724285
* device instance XD3_nt r0 *1 0,0
CXD3_nt XD3.nt vsubs 8.3626891e-14
* device instance XD3_t1_t0 r0 *1 0,0
RXD3_t1_t0 XD3.t1__t0 XD3.t1 83.3032462782
* device instance XD3_t1_t1 r0 *1 0,0
RXD3_t1_t1 XD3.t1__t1 XD3.t1 80.6819537218
* device instance XD3_t1_t2 r0 *1 0,0
RXD3_t1_t2 XD3.t1__t2 XD3.t1 81.2468874624
* device instance XD3_t1_t3 r0 *1 0,0
RXD3_t1_t3 XD3.t1__t3 XD3.t1 82.7383125376
* device instance XD3_t1 r0 *1 0,0
CXD3_t1 XD3.t1 vsubs 7.4626158e-14
* device instance XD4_XDFFM_CLKB_t0 r0 *1 0,0
RXD4_XDFFM_CLKB_t0 XD4.XDFFM.CLKB__t0 XD4.XDFFM.CLKB 67.5535750136
* device instance XD4_XDFFM_CLKB_t1 r0 *1 0,0
RXD4_XDFFM_CLKB_t1 XD4.XDFFM.CLKB__t1 XD4.XDFFM.CLKB 68.492887534
* device instance XD4_XDFFM_CLKB_t2 r0 *1 0,0
RXD4_XDFFM_CLKB_t2 XD4.XDFFM.CLKB__t2 XD4.XDFFM.CLKB 64.7356374524
* device instance XD4_XDFFM_CLKB_t3 r0 *1 0,0
RXD4_XDFFM_CLKB_t3 XD4.XDFFM.CLKB__t3 XD4.XDFFM.CLKB 67.6399485787
* device instance XD4_XDFFM_CLKB_t4 r0 *1 0,0
RXD4_XDFFM_CLKB_t4 XD4.XDFFM.CLKB__t4 XD4.XDFFM.CLKB 64.9677664086
* device instance XD4_XDFFM_CLKB_t5 r0 *1 0,0
RXD4_XDFFM_CLKB_t5 XD4.XDFFM.CLKB__t5 XD4.XDFFM.CLKB 68.1743850127
* device instance XD4_XDFFM_CLKB r0 *1 0,0
CXD4_XDFFM_CLKB XD4.XDFFM.CLKB vsubs 9.204996e-14
* device instance XD4_XDFFM_M_t0 r0 *1 0,0
RXD4_XDFFM_M_t0 XD4.XDFFM.M__t0 XD4.XDFFM.M 54.8803452142
* device instance XD4_XDFFM_M_t1 r0 *1 0,0
RXD4_XDFFM_M_t1 XD4.XDFFM.M__t1 XD4.XDFFM.M 54.1050606427
* device instance XD4_XDFFM_M_t2 r0 *1 0,0
RXD4_XDFFM_M_t2 XD4.XDFFM.M__t2 XD4.XDFFM.M 55.6556297858
* device instance XD4_XDFFM_M_t3 r0 *1 0,0
RXD4_XDFFM_M_t3 XD4.XDFFM.M__t3 XD4.XDFFM.M 56.4309143573
* device instance XD4_XDFFM_M_t4 r0 *1 0,0
RXD4_XDFFM_M_t4 XD4.XDFFM.M__t4 XD4.XDFFM.M 55.4885425936
* device instance XD4_XDFFM_M_t5 r0 *1 0,0
RXD4_XDFFM_M_t5 XD4.XDFFM.M__t5 XD4.XDFFM.M 54.6063222191
* device instance XD4_XDFFM_M_t6 r0 *1 0,0
RXD4_XDFFM_M_t6 XD4.XDFFM.M__t6 XD4.XDFFM.M 55.9296527809
* device instance XD4_XDFFM_M_t7 r0 *1 0,0
RXD4_XDFFM_M_t7 XD4.XDFFM.M__t7 XD4.XDFFM.M 55.0474324064
* device instance XD4_XDFFM_M r0 *1 0,0
CXD4_XDFFM_M XD4.XDFFM.M vsubs 1.02108069e-13
* device instance XD4_XDFFM_MB_t0 r0 *1 0,0
RXD4_XDFFM_MB_t0 XD4.XDFFM.MB__t0 XD4.XDFFM.MB 91.0917070804
* device instance XD4_XDFFM_MB_t1 r0 *1 0,0
RXD4_XDFFM_MB_t1 XD4.XDFFM.MB__t1 XD4.XDFFM.MB 92.3785429196
* device instance XD4_XDFFM_MB_t2 r0 *1 0,0
RXD4_XDFFM_MB_t2 XD4.XDFFM.MB__t2 XD4.XDFFM.MB 91.3690423906
* device instance XD4_XDFFM_MB_t3 r0 *1 0,0
RXD4_XDFFM_MB_t3 XD4.XDFFM.MB__t3 XD4.XDFFM.MB 92.1012076094
* device instance XD4_XDFFM_MB r0 *1 0,0
CXD4_XDFFM_MB XD4.XDFFM.MB vsubs 8.3281433e-14
* device instance XD4_XDFFM_S_t0 r0 *1 0,0
RXD4_XDFFM_S_t0 XD4.XDFFM.S__t0 XD4.XDFFM.S 67.9396166667
* device instance XD4_XDFFM_S_t1 r0 *1 0,0
RXD4_XDFFM_S_t1 XD4.XDFFM.S__t1 XD4.XDFFM.S 66.9937269425
* device instance XD4_XDFFM_S_t2 r0 *1 0,0
RXD4_XDFFM_S_t2 XD4.XDFFM.S__t2 XD4.XDFFM.S 68.8855063908
* device instance XD4_XDFFM_S_t3 r0 *1 0,0
RXD4_XDFFM_S_t3 XD4.XDFFM.S__t3 XD4.XDFFM.S 67.9396166667
* device instance XD4_XDFFM_S_t4 r0 *1 0,0
RXD4_XDFFM_S_t4 XD4.XDFFM.S__t4 XD4.XDFFM.S 68.4777953028
* device instance XD4_XDFFM_S_t5 r0 *1 0,0
RXD4_XDFFM_S_t5 XD4.XDFFM.S__t5 XD4.XDFFM.S 67.4014380305
* device instance XD4_XDFFM_S r0 *1 0,0
CXD4_XDFFM_S XD4.XDFFM.S vsubs 9.3484119e-14
* device instance XD4_XDFFM_SB_t0 r0 *1 0,0
RXD4_XDFFM_SB_t0 XD4.XDFFM.SB__t0 XD4.XDFFM.SB 69.055171631
* device instance XD4_XDFFM_SB_t1 r0 *1 0,0
RXD4_XDFFM_SB_t1 XD4.XDFFM.SB__t1 XD4.XDFFM.SB 67.164328369
* device instance XD4_XDFFM_SB_t2 r0 *1 0,0
RXD4_XDFFM_SB_t2 XD4.XDFFM.SB__t2 XD4.XDFFM.SB 68.10975
* device instance XD4_XDFFM_SB_t3 r0 *1 0,0
RXD4_XDFFM_SB_t3 XD4.XDFFM.SB__t3 XD4.XDFFM.SB 67.5718376927
* device instance XD4_XDFFM_SB_t4 r0 *1 0,0
RXD4_XDFFM_SB_t4 XD4.XDFFM.SB__t4 XD4.XDFFM.SB 68.6476623073
* device instance XD4_XDFFM_SB_t5 r0 *1 0,0
RXD4_XDFFM_SB_t5 XD4.XDFFM.SB__t5 XD4.XDFFM.SB 68.10975
* device instance XD4_XDFFM_SB r0 *1 0,0
CXD4_XDFFM_SB XD4.XDFFM.SB vsubs 9.3735669e-14
* device instance XD4_XDFFQ_CLKB_t0 r0 *1 0,0
RXD4_XDFFQ_CLKB_t0 XD4.XDFFQ.CLKB__t0 XD4.XDFFQ.CLKB 66.8346796427
* device instance XD4_XDFFQ_CLKB_t1 r0 *1 0,0
RXD4_XDFFQ_CLKB_t1 XD4.XDFFQ.CLKB__t1 XD4.XDFFQ.CLKB 67.7956741067
* device instance XD4_XDFFQ_CLKB_t2 r0 *1 0,0
RXD4_XDFFQ_CLKB_t2 XD4.XDFFQ.CLKB__t2 XD4.XDFFQ.CLKB 63.9516962506
* device instance XD4_XDFFQ_CLKB_t3 r0 *1 0,0
RXD4_XDFFQ_CLKB_t3 XD4.XDFFQ.CLKB__t3 XD4.XDFFQ.CLKB 64.1891833883
* device instance XD4_XDFFQ_CLKB_t4 r0 *1 0,0
RXD4_XDFFQ_CLKB_t4 XD4.XDFFQ.CLKB__t4 XD4.XDFFQ.CLKB 66.9230469497
* device instance XD4_XDFFQ_CLKB_t5 r0 *1 0,0
RXD4_XDFFQ_CLKB_t5 XD4.XDFFQ.CLKB__t5 XD4.XDFFQ.CLKB 67.469819662
* device instance XD4_XDFFQ_CLKB r0 *1 0,0
CXD4_XDFFQ_CLKB XD4.XDFFQ.CLKB vsubs 9.1276038e-14
* device instance XD4_XDFFQ_M_t0 r0 *1 0,0
RXD4_XDFFQ_M_t0 XD4.XDFFQ.M__t0 XD4.XDFFQ.M 54.5393799426
* device instance XD4_XDFFQ_M_t1 r0 *1 0,0
RXD4_XDFFQ_M_t1 XD4.XDFFQ.M__t1 XD4.XDFFQ.M 53.7422148277
* device instance XD4_XDFFQ_M_t2 r0 *1 0,0
RXD4_XDFFQ_M_t2 XD4.XDFFQ.M__t2 XD4.XDFFQ.M 55.3365450574
* device instance XD4_XDFFQ_M_t3 r0 *1 0,0
RXD4_XDFFQ_M_t3 XD4.XDFFQ.M__t3 XD4.XDFFQ.M 56.1337101723
* device instance XD4_XDFFQ_M_t4 r0 *1 0,0
RXD4_XDFFQ_M_t4 XD4.XDFFQ.M__t4 XD4.XDFFQ.M 55.164742231
* device instance XD4_XDFFQ_M_t5 r0 *1 0,0
RXD4_XDFFQ_M_t5 XD4.XDFFQ.M__t5 XD4.XDFFQ.M 54.2576233071
* device instance XD4_XDFFQ_M_t6 r0 *1 0,0
RXD4_XDFFQ_M_t6 XD4.XDFFQ.M__t6 XD4.XDFFQ.M 54.711182769
* device instance XD4_XDFFQ_M_t7 r0 *1 0,0
RXD4_XDFFQ_M_t7 XD4.XDFFQ.M__t7 XD4.XDFFQ.M 55.6183016929
* device instance XD4_XDFFQ_M r0 *1 0,0
CXD4_XDFFQ_M XD4.XDFFQ.M vsubs 1.0178517e-13
* device instance XD4_XDFFQ_MB_t0 r0 *1 0,0
RXD4_XDFFQ_MB_t0 XD4.XDFFQ.MB__t0 XD4.XDFFQ.MB 89.5407220073
* device instance XD4_XDFFQ_MB_t1 r0 *1 0,0
RXD4_XDFFQ_MB_t1 XD4.XDFFQ.MB__t1 XD4.XDFFQ.MB 90.8494779927
* device instance XD4_XDFFQ_MB_t2 r0 *1 0,0
RXD4_XDFFQ_MB_t2 XD4.XDFFQ.MB__t2 XD4.XDFFQ.MB 89.8227814869
* device instance XD4_XDFFQ_MB_t3 r0 *1 0,0
RXD4_XDFFQ_MB_t3 XD4.XDFFQ.MB__t3 XD4.XDFFQ.MB 90.5674185131
* device instance XD4_XDFFQ_MB r0 *1 0,0
CXD4_XDFFQ_MB XD4.XDFFQ.MB vsubs 8.2056489e-14
* device instance XD4_XDFFQ_S_t0 r0 *1 0,0
RXD4_XDFFQ_S_t0 XD4.XDFFQ.S__t0 XD4.XDFFQ.S 67.2062666667
* device instance XD4_XDFFQ_S_t1 r0 *1 0,0
RXD4_XDFFQ_S_t1 XD4.XDFFQ.S__t1 XD4.XDFFQ.S 66.2386499107
* device instance XD4_XDFFQ_S_t2 r0 *1 0,0
RXD4_XDFFQ_S_t2 XD4.XDFFQ.S__t2 XD4.XDFFQ.S 68.1738834226
* device instance XD4_XDFFQ_S_t3 r0 *1 0,0
RXD4_XDFFQ_S_t3 XD4.XDFFQ.S__t3 XD4.XDFFQ.S 67.2062666667
* device instance XD4_XDFFQ_S_t4 r0 *1 0,0
RXD4_XDFFQ_S_t4 XD4.XDFFQ.S__t4 XD4.XDFFQ.S 67.7568072347
* device instance XD4_XDFFQ_S_t5 r0 *1 0,0
RXD4_XDFFQ_S_t5 XD4.XDFFQ.S__t5 XD4.XDFFQ.S 66.6557260986
* device instance XD4_XDFFQ_S r0 *1 0,0
CXD4_XDFFQ_S XD4.XDFFQ.S vsubs 9.2710198e-14
* device instance XD4_XDFFQ_SB_t0 r0 *1 0,0
RXD4_XDFFQ_SB_t0 XD4.XDFFQ.SB__t0 XD4.XDFFQ.SB 68.3434655256
* device instance XD4_XDFFQ_SB_t1 r0 *1 0,0
RXD4_XDFFQ_SB_t1 XD4.XDFFQ.SB__t1 XD4.XDFFQ.SB 66.4093344744
* device instance XD4_XDFFQ_SB_t2 r0 *1 0,0
RXD4_XDFFQ_SB_t2 XD4.XDFFQ.SB__t2 XD4.XDFFQ.SB 67.3764
* device instance XD4_XDFFQ_SB_t3 r0 *1 0,0
RXD4_XDFFQ_SB_t3 XD4.XDFFQ.SB__t3 XD4.XDFFQ.SB 66.826173063
* device instance XD4_XDFFQ_SB_t4 r0 *1 0,0
RXD4_XDFFQ_SB_t4 XD4.XDFFQ.SB__t4 XD4.XDFFQ.SB 67.926626937
* device instance XD4_XDFFQ_SB_t5 r0 *1 0,0
RXD4_XDFFQ_SB_t5 XD4.XDFFQ.SB__t5 XD4.XDFFQ.SB 67.3764
* device instance XD4_XDFFQ_SB r0 *1 0,0
CXD4_XDFFQ_SB XD4.XDFFQ.SB vsubs 9.2961747e-14
* device instance XD4_XN2_mid1_t0 r0 *1 0,0
RXD4_XN2_mid1_t0 XD4.XN2.mid1__t0 XD4.XN2.mid1 20.1634
* device instance XD4_XN2_mid1_t1 r0 *1 0,0
RXD4_XN2_mid1_t1 XD4.XN2.mid1__t1 XD4.XN2.mid1 20.1634
* device instance XD4_XN2_mid1 r0 *1 0,0
CXD4_XN2_mid1 XD4.XN2.mid1 vsubs 1.0126876e-14
* device instance XD4_XN3_mid1_t0 r0 *1 0,0
RXD4_XN3_mid1_t0 XD4.XN3.mid1__t0 XD4.XN3.mid1 20.33935
* device instance XD4_XN3_mid1_t1 r0 *1 0,0
RXD4_XN3_mid1_t1 XD4.XN3.mid1__t1 XD4.XN3.mid1 20.33935
* device instance XD4_XN3_mid1 r0 *1 0,0
CXD4_XN3_mid1 XD4.XN3.mid1 vsubs 1.0236715e-14
* device instance XD4_XN3_mid2_t0 r0 *1 0,0
RXD4_XN3_mid2_t0 XD4.XN3.mid2__t0 XD4.XN3.mid2 20.51535
* device instance XD4_XN3_mid2_t1 r0 *1 0,0
RXD4_XN3_mid2_t1 XD4.XN3.mid2__t1 XD4.XN3.mid2 20.51535
* device instance XD4_XN3_mid2 r0 *1 0,0
CXD4_XN3_mid2 XD4.XN3.mid2 vsubs 1.0326363e-14
* device instance XD4_XNOR_midp_t0 r0 *1 0,0
RXD4_XNOR_midp_t0 XD4.XNOR.midp__t0 XD4.XNOR.midp 22.2178
* device instance XD4_XNOR_midp_t1 r0 *1 0,0
RXD4_XNOR_midp_t1 XD4.XNOR.midp__t1 XD4.XNOR.midp 22.2178
* device instance XD4_XNOR_midp r0 *1 0,0
CXD4_XNOR_midp XD4.XNOR.midp vsubs 1.1235326e-14
* device instance XD4_dmodout_t0 r0 *1 0,0
RXD4_dmodout_t0 XD4.dmodout__t0 XD4.dmodout 92.3731021684
* device instance XD4_dmodout_t1 r0 *1 0,0
RXD4_dmodout_t1 XD4.dmodout__t1 XD4.dmodout 95.0218478316
* device instance XD4_dmodout_t2 r0 *1 0,0
RXD4_dmodout_t2 XD4.dmodout__t2 XD4.dmodout 94.4509974731
* device instance XD4_dmodout_t3 r0 *1 0,0
RXD4_dmodout_t3 XD4.dmodout__t3 XD4.dmodout 92.9439525269
* device instance XD4_dmodout r0 *1 0,0
CXD4_dmodout XD4.dmodout vsubs 8.5356191e-14
* device instance XD4_dq_t0 r0 *1 0,0
RXD4_dq_t0 XD4.dq__t0 XD4.dq 95.6612552443
* device instance XD4_dq_t1 r0 *1 0,0
RXD4_dq_t1 XD4.dq__t1 XD4.dq 98.0150947557
* device instance XD4_dq_t2 r0 *1 0,0
RXD4_dq_t2 XD4.dq__t2 XD4.dq 63.4427387374
* device instance XD4_dq_t3 r0 *1 0,0
RXD4_dq_t3 XD4.dq__t3 XD4.dq 64.7819922525
* device instance XD4_dq_t4 r0 *1 0,0
RXD4_dq_t4 XD4.dq__t4 XD4.dq 65.4516190101
* device instance XD4_dq r0 *1 0,0
CXD4_dq XD4.dq vsubs 8.8748622e-14
* device instance XD4_nm_t0 r0 *1 0,0
RXD4_nm_t0 XD4.nm__t0 XD4.nm 66.7374714486
* device instance XD4_nm_t1 r0 *1 0,0
RXD4_nm_t1 XD4.nm__t1 XD4.nm 65.5718333333
* device instance XD4_nm_t2 r0 *1 0,0
RXD4_nm_t2 XD4.nm__t2 XD4.nm 64.4061952181
* device instance XD4_nm_t3 r0 *1 0,0
RXD4_nm_t3 XD4.nm__t3 XD4.nm 97.6945421068
* device instance XD4_nm_t4 r0 *1 0,0
RXD4_nm_t4 XD4.nm__t4 XD4.nm 99.0209578932
* device instance XD4_nm r0 *1 0,0
CXD4_nm XD4.nm vsubs 9.0259315e-14
* device instance XD4_nt_t0 r0 *1 0,0
RXD4_nt_t0 XD4.nt__t0 XD4.nt 52.4469582184
* device instance XD4_nt_t1 r0 *1 0,0
RXD4_nt_t1 XD4.nt__t1 XD4.nt 49.0588167816
* device instance XD4_nt_t2 r0 *1 0,0
RXD4_nt_t2 XD4.nt__t2 XD4.nt 50.1881972605
* device instance XD4_nt_t3 r0 *1 0,0
RXD4_nt_t3 XD4.nt__t3 XD4.nt 51.3175777395
* device instance XD4_nt_t4 r0 *1 0,0
RXD4_nt_t4 XD4.nt__t4 XD4.nt 100.541907177
* device instance XD4_nt_t5 r0 *1 0,0
RXD4_nt_t5 XD4.nt__t5 XD4.nt 102.469642823
* device instance XD4_nt r0 *1 0,0
CXD4_nt XD4.nt vsubs 9.3735153e-14
* device instance XD4_t1_t0 r0 *1 0,0
RXD4_t1_t0 XD4.t1__t0 XD4.t1 92.1734013909
* device instance XD4_t1_t1 r0 *1 0,0
RXD4_t1_t1 XD4.t1__t1 XD4.t1 89.4996486091
* device instance XD4_t1_t2 r0 *1 0,0
RXD4_t1_t2 XD4.t1__t2 XD4.t1 90.0758884328
* device instance XD4_t1_t3 r0 *1 0,0
RXD4_t1_t3 XD4.t1__t3 XD4.t1 91.5971615672
* device instance XD4_t1 r0 *1 0,0
CXD4_t1 XD4.t1 vsubs 8.2986172e-14
* device instance XD5_XDFFM_CLKB_t0 r0 *1 0,0
RXD5_XDFFM_CLKB_t0 XD5.XDFFM.CLKB__t0 XD5.XDFFM.CLKB 74.5811345213
* device instance XD5_XDFFM_CLKB_t1 r0 *1 0,0
RXD5_XDFFM_CLKB_t1 XD5.XDFFM.CLKB__t1 XD5.XDFFM.CLKB 75.5458863032
* device instance XD5_XDFFM_CLKB_t2 r0 *1 0,0
RXD5_XDFFM_CLKB_t2 XD5.XDFFM.CLKB__t2 XD5.XDFFM.CLKB 71.6868791755
* device instance XD5_XDFFM_CLKB_t3 r0 *1 0,0
RXD5_XDFFM_CLKB_t3 XD5.XDFFM.CLKB__t3 XD5.XDFFM.CLKB 74.6698473288
* device instance XD5_XDFFM_CLKB_t4 r0 *1 0,0
RXD5_XDFFM_CLKB_t4 XD5.XDFFM.CLKB__t4 XD5.XDFFM.CLKB 71.9252948457
* device instance XD5_XDFFM_CLKB_t5 r0 *1 0,0
RXD5_XDFFM_CLKB_t5 XD5.XDFFM.CLKB__t5 XD5.XDFFM.CLKB 75.2187578254
* device instance XD5_XDFFM_CLKB r0 *1 0,0
CXD5_XDFFM_CLKB XD5.XDFFM.CLKB vsubs 1.02120589e-13
* device instance XD5_XDFFM_M_t0 r0 *1 0,0
RXD5_XDFFM_M_t0 XD5.XDFFM.M__t0 XD5.XDFFM.M 60.9617711075
* device instance XD5_XDFFM_M_t1 r0 *1 0,0
RXD5_XDFFM_M_t1 XD5.XDFFM.M__t1 XD5.XDFFM.M 61.7620538925
* device instance XD5_XDFFM_M_t2 r0 *1 0,0
RXD5_XDFFM_M_t2 XD5.XDFFM.M__t2 XD5.XDFFM.M 60.1614883226
* device instance XD5_XDFFM_M_t3 r0 *1 0,0
RXD5_XDFFM_M_t3 XD5.XDFFM.M__t3 XD5.XDFFM.M 62.5623366774
* device instance XD5_XDFFM_M_t4 r0 *1 0,0
RXD5_XDFFM_M_t4 XD5.XDFFM.M__t4 XD5.XDFFM.M 61.5895791543
* device instance XD5_XDFFM_M_t5 r0 *1 0,0
RXD5_XDFFM_M_t5 XD5.XDFFM.M__t5 XD5.XDFFM.M 60.678912537
* device instance XD5_XDFFM_M_t6 r0 *1 0,0
RXD5_XDFFM_M_t6 XD5.XDFFM.M__t6 XD5.XDFFM.M 62.044912463
* device instance XD5_XDFFM_M_t7 r0 *1 0,0
RXD5_XDFFM_M_t7 XD5.XDFFM.M__t7 XD5.XDFFM.M 61.1342458457
* device instance XD5_XDFFM_M r0 *1 0,0
CXD5_XDFFM_M XD5.XDFFM.M vsubs 1.13895857e-13
* device instance XD5_XDFFM_MB_t0 r0 *1 0,0
RXD5_XDFFM_MB_t0 XD5.XDFFM.MB__t0 XD5.XDFFM.MB 99.9231734232
* device instance XD5_XDFFM_MB_t1 r0 *1 0,0
RXD5_XDFFM_MB_t1 XD5.XDFFM.MB__t1 XD5.XDFFM.MB 101.234926577
* device instance XD5_XDFFM_MB_t2 r0 *1 0,0
RXD5_XDFFM_MB_t2 XD5.XDFFM.MB__t2 XD5.XDFFM.MB 100.952221156
* device instance XD5_XDFFM_MB_t3 r0 *1 0,0
RXD5_XDFFM_MB_t3 XD5.XDFFM.MB__t3 XD5.XDFFM.MB 100.205878844
* device instance XD5_XDFFM_MB r0 *1 0,0
CXD5_XDFFM_MB XD5.XDFFM.MB vsubs 9.1634902e-14
* device instance XD5_XDFFM_S_t0 r0 *1 0,0
RXD5_XDFFM_S_t0 XD5.XDFFM.S__t0 XD5.XDFFM.S 74.9502166667
* device instance XD5_XDFFM_S_t1 r0 *1 0,0
RXD5_XDFFM_S_t1 XD5.XDFFM.S__t1 XD5.XDFFM.S 73.9795359797
* device instance XD5_XDFFM_S_t2 r0 *1 0,0
RXD5_XDFFM_S_t2 XD5.XDFFM.S__t2 XD5.XDFFM.S 75.9208973537
* device instance XD5_XDFFM_S_t3 r0 *1 0,0
RXD5_XDFFM_S_t3 XD5.XDFFM.S__t3 XD5.XDFFM.S 74.9502166667
* device instance XD5_XDFFM_S_t4 r0 *1 0,0
RXD5_XDFFM_S_t4 XD5.XDFFM.S__t4 XD5.XDFFM.S 75.5025005058
* device instance XD5_XDFFM_S_t5 r0 *1 0,0
RXD5_XDFFM_S_t5 XD5.XDFFM.S__t5 XD5.XDFFM.S 74.3979328275
* device instance XD5_XDFFM_S r0 *1 0,0
CXD5_XDFFM_S XD5.XDFFM.S vsubs 1.03554748e-13
* device instance XD5_XDFFM_SB_t0 r0 *1 0,0
RXD5_XDFFM_SB_t0 XD5.XDFFM.SB__t0 XD5.XDFFM.SB 76.090526163
* device instance XD5_XDFFM_SB_t1 r0 *1 0,0
RXD5_XDFFM_SB_t1 XD5.XDFFM.SB__t1 XD5.XDFFM.SB 74.150173837
* device instance XD5_XDFFM_SB_t2 r0 *1 0,0
RXD5_XDFFM_SB_t2 XD5.XDFFM.SB__t2 XD5.XDFFM.SB 75.12035
* device instance XD5_XDFFM_SB_t3 r0 *1 0,0
RXD5_XDFFM_SB_t3 XD5.XDFFM.SB__t3 XD5.XDFFM.SB 74.5683532176
* device instance XD5_XDFFM_SB_t4 r0 *1 0,0
RXD5_XDFFM_SB_t4 XD5.XDFFM.SB__t4 XD5.XDFFM.SB 75.6723467824
* device instance XD5_XDFFM_SB_t5 r0 *1 0,0
RXD5_XDFFM_SB_t5 XD5.XDFFM.SB__t5 XD5.XDFFM.SB 75.12035
* device instance XD5_XDFFM_SB r0 *1 0,0
CXD5_XDFFM_SB XD5.XDFFM.SB vsubs 1.03806298e-13
* device instance XD5_XDFFQ_CLKB_t0 r0 *1 0,0
RXD5_XDFFQ_CLKB_t0 XD5.XDFFQ.CLKB__t0 XD5.XDFFQ.CLKB 73.8617318731
* device instance XD5_XDFFQ_CLKB_t1 r0 *1 0,0
RXD5_XDFFQ_CLKB_t1 XD5.XDFFQ.CLKB__t1 XD5.XDFFQ.CLKB 74.8474046826
* device instance XD5_XDFFQ_CLKB_t2 r0 *1 0,0
RXD5_XDFFQ_CLKB_t2 XD5.XDFFQ.CLKB__t2 XD5.XDFFQ.CLKB 70.9047134443
* device instance XD5_XDFFQ_CLKB_t3 r0 *1 0,0
RXD5_XDFFQ_CLKB_t3 XD5.XDFFQ.CLKB__t3 XD5.XDFFQ.CLKB 73.9523684532
* device instance XD5_XDFFQ_CLKB_t4 r0 *1 0,0
RXD5_XDFFQ_CLKB_t4 XD5.XDFFQ.CLKB__t4 XD5.XDFFQ.CLKB 71.1482992536
* device instance XD5_XDFFQ_CLKB_t5 r0 *1 0,0
RXD5_XDFFQ_CLKB_t5 XD5.XDFFQ.CLKB__t5 XD5.XDFFQ.CLKB 74.5131822932
* device instance XD5_XDFFQ_CLKB r0 *1 0,0
CXD5_XDFFQ_CLKB XD5.XDFFQ.CLKB vsubs 1.01346667e-13
* device instance XD5_XDFFQ_M_t0 r0 *1 0,0
RXD5_XDFFQ_M_t0 XD5.XDFFQ.M__t0 XD5.XDFFQ.M 60.621212762
* device instance XD5_XDFFQ_M_t1 r0 *1 0,0
RXD5_XDFFQ_M_t1 XD5.XDFFQ.M__t1 XD5.XDFFQ.M 59.799838286
* device instance XD5_XDFFQ_M_t2 r0 *1 0,0
RXD5_XDFFQ_M_t2 XD5.XDFFQ.M__t2 XD5.XDFFQ.M 61.442587238
* device instance XD5_XDFFQ_M_t3 r0 *1 0,0
RXD5_XDFFQ_M_t3 XD5.XDFFQ.M__t3 XD5.XDFFQ.M 62.263961714
* device instance XD5_XDFFQ_M_t4 r0 *1 0,0
RXD5_XDFFQ_M_t4 XD5.XDFFQ.M__t4 XD5.XDFFQ.M 61.2655668768
* device instance XD5_XDFFQ_M_t5 r0 *1 0,0
RXD5_XDFFQ_M_t5 XD5.XDFFQ.M__t5 XD5.XDFFQ.M 60.3308993696
* device instance XD5_XDFFQ_M_t6 r0 *1 0,0
RXD5_XDFFQ_M_t6 XD5.XDFFQ.M__t6 XD5.XDFFQ.M 61.7329006304
* device instance XD5_XDFFQ_M_t7 r0 *1 0,0
RXD5_XDFFQ_M_t7 XD5.XDFFQ.M__t7 XD5.XDFFQ.M 60.7982331232
* device instance XD5_XDFFQ_M r0 *1 0,0
CXD5_XDFFQ_M XD5.XDFFQ.M vsubs 1.13572959e-13
* device instance XD5_XDFFQ_MB_t0 r0 *1 0,0
RXD5_XDFFQ_MB_t0 XD5.XDFFQ.MB__t0 XD5.XDFFQ.MB 98.3725855867
* device instance XD5_XDFFQ_MB_t1 r0 *1 0,0
RXD5_XDFFQ_MB_t1 XD5.XDFFQ.MB__t1 XD5.XDFFQ.MB 99.7054644133
* device instance XD5_XDFFQ_MB_t2 r0 *1 0,0
RXD5_XDFFQ_MB_t2 XD5.XDFFQ.MB__t2 XD5.XDFFQ.MB 99.4182060455
* device instance XD5_XDFFQ_MB_t3 r0 *1 0,0
RXD5_XDFFQ_MB_t3 XD5.XDFFQ.MB__t3 XD5.XDFFQ.MB 98.6598439545
* device instance XD5_XDFFQ_MB r0 *1 0,0
CXD5_XDFFQ_MB XD5.XDFFQ.MB vsubs 9.0409958e-14
* device instance XD5_XDFFQ_S_t0 r0 *1 0,0
RXD5_XDFFQ_S_t0 XD5.XDFFQ.S__t0 XD5.XDFFQ.S 74.2168666667
* device instance XD5_XDFFQ_S_t1 r0 *1 0,0
RXD5_XDFFQ_S_t1 XD5.XDFFQ.S__t1 XD5.XDFFQ.S 73.2252378018
* device instance XD5_XDFFQ_S_t2 r0 *1 0,0
RXD5_XDFFQ_S_t2 XD5.XDFFQ.S__t2 XD5.XDFFQ.S 75.2084955315
* device instance XD5_XDFFQ_S_t3 r0 *1 0,0
RXD5_XDFFQ_S_t3 XD5.XDFFQ.S__t3 XD5.XDFFQ.S 74.2168666667
* device instance XD5_XDFFQ_S_t4 r0 *1 0,0
RXD5_XDFFQ_S_t4 XD5.XDFFQ.S__t4 XD5.XDFFQ.S 74.7810692967
* device instance XD5_XDFFQ_S_t5 r0 *1 0,0
RXD5_XDFFQ_S_t5 XD5.XDFFQ.S__t5 XD5.XDFFQ.S 73.6526640367
* device instance XD5_XDFFQ_S r0 *1 0,0
CXD5_XDFFQ_S XD5.XDFFQ.S vsubs 1.02780827e-13
* device instance XD5_XDFFQ_SB_t0 r0 *1 0,0
RXD5_XDFFQ_SB_t0 XD5.XDFFQ.SB__t0 XD5.XDFFQ.SB 75.3780482571
* device instance XD5_XDFFQ_SB_t1 r0 *1 0,0
RXD5_XDFFQ_SB_t1 XD5.XDFFQ.SB__t1 XD5.XDFFQ.SB 73.3959517429
* device instance XD5_XDFFQ_SB_t2 r0 *1 0,0
RXD5_XDFFQ_SB_t2 XD5.XDFFQ.SB__t2 XD5.XDFFQ.SB 74.387
* device instance XD5_XDFFQ_SB_t3 r0 *1 0,0
RXD5_XDFFQ_SB_t3 XD5.XDFFQ.SB__t3 XD5.XDFFQ.SB 73.8231277158
* device instance XD5_XDFFQ_SB_t4 r0 *1 0,0
RXD5_XDFFQ_SB_t4 XD5.XDFFQ.SB__t4 XD5.XDFFQ.SB 74.9508722842
* device instance XD5_XDFFQ_SB_t5 r0 *1 0,0
RXD5_XDFFQ_SB_t5 XD5.XDFFQ.SB__t5 XD5.XDFFQ.SB 74.387
* device instance XD5_XDFFQ_SB r0 *1 0,0
CXD5_XDFFQ_SB XD5.XDFFQ.SB vsubs 1.03032376e-13
* device instance XD5_XN2_mid1_t0 r0 *1 0,0
RXD5_XN2_mid1_t0 XD5.XN2.mid1__t0 XD5.XN2.mid1 23.50735
* device instance XD5_XN2_mid1_t1 r0 *1 0,0
RXD5_XN2_mid1_t1 XD5.XN2.mid1__t1 XD5.XN2.mid1 23.50735
* device instance XD5_XN2_mid1 r0 *1 0,0
CXD5_XN2_mid1 XD5.XN2.mid1 vsubs 1.1814027e-14
* device instance XD5_XN3_mid1_t0 r0 *1 0,0
RXD5_XN3_mid1_t0 XD5.XN3.mid1__t0 XD5.XN3.mid1 23.68335
* device instance XD5_XN3_mid1_t1 r0 *1 0,0
RXD5_XN3_mid1_t1 XD5.XN3.mid1__t1 XD5.XN3.mid1 23.68335
* device instance XD5_XN3_mid1 r0 *1 0,0
CXD5_XN3_mid1 XD5.XN3.mid1 vsubs 1.1926059e-14
* device instance XD5_XN3_mid2_t0 r0 *1 0,0
RXD5_XN3_mid2_t0 XD5.XN3.mid2__t0 XD5.XN3.mid2 23.8593
* device instance XD5_XN3_mid2_t1 r0 *1 0,0
RXD5_XN3_mid2_t1 XD5.XN3.mid2__t1 XD5.XN3.mid2 23.8593
* device instance XD5_XN3_mid2 r0 *1 0,0
CXD5_XN3_mid2 XD5.XN3.mid2 vsubs 1.2015707e-14
* device instance XD5_XNOR_midp_t0 r0 *1 0,0
RXD5_XNOR_midp_t0 XD5.XNOR.midp__t0 XD5.XNOR.midp 25.56175
* device instance XD5_XNOR_midp_t1 r0 *1 0,0
RXD5_XNOR_midp_t1 XD5.XNOR.midp__t1 XD5.XNOR.midp 25.56175
* device instance XD5_XNOR_midp r0 *1 0,0
CXD5_XNOR_midp XD5.XNOR.midp vsubs 1.2983574e-14
* device instance XD5_dmodout_t0 r0 *1 0,0
RXD5_dmodout_t0 XD5.dmodout__t0 XD5.dmodout 101.194589893
* device instance XD5_dmodout_t1 r0 *1 0,0
RXD5_dmodout_t1 XD5.dmodout__t1 XD5.dmodout 103.888210107
* device instance XD5_dmodout_t2 r0 *1 0,0
RXD5_dmodout_t2 XD5.dmodout__t2 XD5.dmodout 103.307688509
* device instance XD5_dmodout_t3 r0 *1 0,0
RXD5_dmodout_t3 XD5.dmodout__t3 XD5.dmodout 101.775111491
* device instance XD5_dmodout r0 *1 0,0
CXD5_dmodout XD5.dmodout vsubs 9.3709661e-14
* device instance XD5_dq_t0 r0 *1 0,0
RXD5_dq_t0 XD5.dq__t0 XD5.dq 105.317849422
* device instance XD5_dq_t1 r0 *1 0,0
RXD5_dq_t1 XD5.dq__t1 XD5.dq 107.718350578
* device instance XD5_dq_t2 r0 *1 0,0
RXD5_dq_t2 XD5.dq__t2 XD5.dq 71.239700397
* device instance XD5_dq_t3 r0 *1 0,0
RXD5_dq_t3 XD5.dq__t3 XD5.dq 69.8738980151
* device instance XD5_dq_t4 r0 *1 0,0
RXD5_dq_t4 XD5.dq__t4 XD5.dq 71.9226015879
* device instance XD5_dq r0 *1 0,0
CXD5_dq XD5.dq vsubs 9.7945127e-14
* device instance XD5_nm_t0 r0 *1 0,0
RXD5_nm_t0 XD5.nm__t0 XD5.nm 73.2143492016
* device instance XD5_nm_t1 r0 *1 0,0
RXD5_nm_t1 XD5.nm__t1 XD5.nm 70.8358841317
* device instance XD5_nm_t2 r0 *1 0,0
RXD5_nm_t2 XD5.nm__t2 XD5.nm 72.0251166667
* device instance XD5_nm_t3 r0 *1 0,0
RXD5_nm_t3 XD5.nm__t3 XD5.nm 107.361042696
* device instance XD5_nm_t4 r0 *1 0,0
RXD5_nm_t4 XD5.nm__t4 XD5.nm 108.714307304
* device instance XD5_nm r0 *1 0,0
CXD5_nm XD5.nm vsubs 9.9487988e-14
* device instance XD5_nt_t0 r0 *1 0,0
RXD5_nt_t0 XD5.nt__t0 XD5.nt 57.7420502349
* device instance XD5_nt_t1 r0 *1 0,0
RXD5_nt_t1 XD5.nt__t1 XD5.nt 54.2796497651
* device instance XD5_nt_t2 r0 *1 0,0
RXD5_nt_t2 XD5.nt__t2 XD5.nt 55.433783255
* device instance XD5_nt_t3 r0 *1 0,0
RXD5_nt_t3 XD5.nt__t3 XD5.nt 56.587916745
* device instance XD5_nt_t4 r0 *1 0,0
RXD5_nt_t4 XD5.nt__t4 XD5.nt 111.036706763
* device instance XD5_nt_t5 r0 *1 0,0
RXD5_nt_t5 XD5.nt__t5 XD5.nt 113.006693237
* device instance XD5_nt r0 *1 0,0
CXD5_nt XD5.nt vsubs 1.03840142e-13
* device instance XD5_t1_t0 r0 *1 0,0
RXD5_t1_t0 XD5.t1__t0 XD5.t1 101.039727573
* device instance XD5_t1_t1 r0 *1 0,0
RXD5_t1_t1 XD5.t1__t1 XD5.t1 98.3212224266
* device instance XD5_t1_t2 r0 *1 0,0
RXD5_t1_t2 XD5.t1__t2 XD5.t1 98.9071071565
* device instance XD5_t1_t3 r0 *1 0,0
RXD5_t1_t3 XD5.t1__t3 XD5.t1 100.453842843
* device instance XD5_t1 r0 *1 0,0
CXD5_t1 XD5.t1 vsubs 9.1342357e-14
* device instance XFRT_CLKB_t0 r0 *1 0,0
RXFRT_CLKB_t0 XFRT.CLKB__t0 XFRT.CLKB 80.1238508993
* device instance XFRT_CLKB_t1 r0 *1 0,0
RXFRT_CLKB_t1 XFRT.CLKB__t1 XFRT.CLKB 79.1226803597
* device instance XFRT_CLKB_t2 r0 *1 0,0
RXFRT_CLKB_t2 XFRT.CLKB__t2 XFRT.CLKB 76.1191687409
* device instance XFRT_CLKB_t3 r0 *1 0,0
RXFRT_CLKB_t3 XFRT.CLKB__t3 XFRT.CLKB 79.2147420185
* device instance XFRT_CLKB_t4 r0 *1 0,0
RXFRT_CLKB_t4 XFRT.CLKB__t4 XFRT.CLKB 76.366584449
* device instance XFRT_CLKB_t5 r0 *1 0,0
RXFRT_CLKB_t5 XFRT.CLKB__t5 XFRT.CLKB 79.7843735324
* device instance XFRT_CLKB r0 *1 0,0
CXFRT_CLKB XFRT.CLKB vsubs 1.08888876e-13
* device instance XFRT_M_t0 r0 *1 0,0
RXFRT_M_t0 XFRT.M__t0 XFRT.M 65.1675822495
* device instance XFRT_M_t1 r0 *1 0,0
RXFRT_M_t1 XFRT.M__t1 XFRT.M 66.0041427505
* device instance XFRT_M_t2 r0 *1 0,0
RXFRT_M_t2 XFRT.M__t2 XFRT.M 64.3310217484
* device instance XFRT_M_t3 r0 *1 0,0
RXFRT_M_t3 XFRT.M__t3 XFRT.M 66.8407032516
* device instance XFRT_M_t4 r0 *1 0,0
RXFRT_M_t4 XFRT.M__t4 XFRT.M 65.8238495391
* device instance XFRT_M_t5 r0 *1 0,0
RXFRT_M_t5 XFRT.M__t5 XFRT.M 64.8719013827
* device instance XFRT_M_t6 r0 *1 0,0
RXFRT_M_t6 XFRT.M__t6 XFRT.M 66.2998236173
* device instance XFRT_M_t7 r0 *1 0,0
RXFRT_M_t7 XFRT.M__t7 XFRT.M 65.3478754609
* device instance XFRT_M r0 *1 0,0
CXFRT_M XFRT.M vsubs 1.22386214e-13
* device instance XFRT_MB_t0 r0 *1 0,0
RXFRT_MB_t0 XFRT.MB__t0 XFRT.MB 105.008996335
* device instance XFRT_MB_t1 r0 *1 0,0
RXFRT_MB_t1 XFRT.MB__t1 XFRT.MB 106.357003665
* device instance XFRT_MB_t2 r0 *1 0,0
RXFRT_MB_t2 XFRT.MB__t2 XFRT.MB 106.066484844
* device instance XFRT_MB_t3 r0 *1 0,0
RXFRT_MB_t3 XFRT.MB__t3 XFRT.MB 105.299515156
* device instance XFRT_MB r0 *1 0,0
CXFRT_MB XFRT.MB vsubs 9.6683314e-14
* device instance XFRT_S_t0 r0 *1 0,0
RXFRT_S_t0 XFRT.S__t0 XFRT.S 79.4675
* device instance XFRT_S_t1 r0 *1 0,0
RXFRT_S_t1 XFRT.S__t1 XFRT.S 78.4607949892
* device instance XFRT_S_t2 r0 *1 0,0
RXFRT_S_t2 XFRT.S__t2 XFRT.S 80.4742050108
* device instance XFRT_S_t3 r0 *1 0,0
RXFRT_S_t3 XFRT.S__t3 XFRT.S 79.4675
* device instance XFRT_S_t4 r0 *1 0,0
RXFRT_S_t4 XFRT.S__t4 XFRT.S 80.0402804372
* device instance XFRT_S_t5 r0 *1 0,0
RXFRT_S_t5 XFRT.S__t5 XFRT.S 78.8947195628
* device instance XFRT_S r0 *1 0,0
CXFRT_S XFRT.S vsubs 1.10324149e-13
* device instance XFRT_SB_t0 r0 *1 0,0
RXFRT_SB_t0 XFRT.SB__t0 XFRT.SB 80.6437467239
* device instance XFRT_SB_t1 r0 *1 0,0
RXFRT_SB_t1 XFRT.SB__t1 XFRT.SB 78.6315199428
* device instance XFRT_SB_t2 r0 *1 0,0
RXFRT_SB_t2 XFRT.SB__t2 XFRT.SB 79.6376333333
* device instance XFRT_SB_t3 r0 *1 0,0
RXFRT_SB_t3 XFRT.SB__t3 XFRT.SB 79.0651895077
* device instance XFRT_SB_t4 r0 *1 0,0
RXFRT_SB_t4 XFRT.SB__t4 XFRT.SB 80.210077159
* device instance XFRT_SB_t5 r0 *1 0,0
RXFRT_SB_t5 XFRT.SB__t5 XFRT.SB 79.6376333333
* device instance XFRT_SB r0 *1 0,0
CXFRT_SB XFRT.SB vsubs 1.10577335e-13
* device instance ck1_t0 r0 *1 0,0
Rck1_t0 ck1__t0 ck1 29.1601016829
* device instance ck1_t1 r0 *1 0,0
Rck1_t1 ck1__t1 ck1 41.6235521265
* device instance ck1_t2 r0 *1 0,0
Rck1_t2 ck1__t2 ck1 42.4025177792
* device instance ck1_t3 r0 *1 0,0
Rck1_t3 ck1__t3 ck1 20.5914795029
* device instance ck1_t4 r0 *1 0,0
Rck1_t4 ck1__t4 ck1 46.2973460428
* device instance ck1_t5 r0 *1 0,0
Rck1_t5 ck1__t5 ck1 50.1921743064
* device instance ck1_t6 r0 *1 0,0
Rck1_t6 ck1__t6 ck1 50.9711399591
* device instance ck1_t7 r0 *1 0,0
Rck1_t7 ck1__t7 ck1 54.8659682228
* device instance ck1_t8 r0 *1 0,0
Rck1_t8 ck1__t8 ck1 27.6021703774
* device instance ck1_t9 r0 *1 0,0
Rck1_t9 ck1__t9 ck1 51.6889224859
* device instance ck1_t10 r0 *1 0,0
Rck1_t10 ck1__t10 ck1 33.0743294742
* device instance ck1_t11 r0 *1 0,0
Rck1_t11 ck1__t11 ck1 39.722398407
* device instance ck1_t12 r0 *1 0,0
Rck1_t12 ck1__t12 ck1 38.3927846204
* device instance ck1_t13 r0 *1 0,0
Rck1_t13 ck1__t13 ck1 37.9495800249
* device instance ck1_t14 r0 *1 0,0
Rck1_t14 ck1__t14 ck1 34.8471478563
* device instance ck1_t15 r0 *1 0,0
Rck1_t15 ck1__t15 ck1 33.5175340698
* device instance ck1_t16 r0 *1 0,0
Rck1_t16 ck1__t16 ck1 46.8136719352
* device instance ck1_t17 r0 *1 0,0
Rck1_t17 ck1__t17 ck1 47.7000811263
* device instance ck1 r0 *1 0,0
Cck1 ck1 vsubs 1.75793059e-13
* device instance ck2_t0 r0 *1 0,0
Rck2_t0 ck2__t0 ck2 55.3573272047
* device instance ck2_t1 r0 *1 0,0
Rck2_t1 ck2__t1 ck2 42.9457498854
* device instance ck2_t2 r0 *1 0,0
Rck2_t2 ck2__t2 ck2 43.6758426689
* device instance ck2_t3 r0 *1 0,0
Rck2_t3 ck2__t3 ck2 47.3263065864
* device instance ck2_t4 r0 *1 0,0
Rck2_t4 ck2__t4 ck2 50.9767705038
* device instance ck2_t5 r0 *1 0,0
Rck2_t5 ck2__t5 ck2 51.7068632873
* device instance ck2_t6 r0 *1 0,0
Rck2_t6 ck2__t6 ck2 23.2332447313
* device instance ck2_t7 r0 *1 0,0
Rck2_t7 ck2__t7 ck2 31.2642653496
* device instance ck2_t8 r0 *1 0,0
Rck2_t8 ck2__t8 ck2 29.8040797826
* device instance ck2_t9 r0 *1 0,0
Rck2_t9 ck2__t9 ck2 52.3796116184
* device instance ck2_t10 r0 *1 0,0
Rck2_t10 ck2__t10 ck2 47.8102378183
* device instance ck2_t11 r0 *1 0,0
Rck2_t11 ck2__t11 ck2 34.9329116544
* device instance ck2_t12 r0 *1 0,0
Rck2_t12 ck2__t12 ck2 41.1638759273
* device instance ck2_t13 r0 *1 0,0
Rck2_t13 ck2__t13 ck2 39.9176830727
* device instance ck2_t14 r0 *1 0,0
Rck2_t14 ck2__t14 ck2 39.5022854545
* device instance ck2_t15 r0 *1 0,0
Rck2_t15 ck2__t15 ck2 36.5945021272
* device instance ck2_t16 r0 *1 0,0
Rck2_t16 ck2__t16 ck2 35.3483092726
* device instance ck2_t17 r0 *1 0,0
Rck2_t17 ck2__t17 ck2 48.6410330547
* device instance ck2 r0 *1 0,0
Cck2 ck2 vsubs 1.81481395e-13
* device instance ck3_t0 r0 *1 0,0
Rck3_t0 ck3__t0 ck3 44.2810172544
* device instance ck3_t1 r0 *1 0,0
Rck3_t1 ck3__t1 ck3 44.9706426322
* device instance ck3_t2 r0 *1 0,0
Rck3_t2 ck3__t2 ck3 48.4187695212
* device instance ck3_t3 r0 *1 0,0
Rck3_t3 ck3__t3 ck3 25.6611320537
* device instance ck3_t4 r0 *1 0,0
Rck3_t4 ck3__t4 ck3 33.2470112095
* device instance ck3_t5 r0 *1 0,0
Rck3_t5 ck3__t5 ck3 51.8668964102
* device instance ck3_t6 r0 *1 0,0
Rck3_t6 ck3__t6 ck3 52.556521788
* device instance ck3_t7 r0 *1 0,0
Rck3_t7 ck3__t7 ck3 56.004648677
* device instance ck3_t8 r0 *1 0,0
Rck3_t8 ck3__t8 ck3 31.8677604539
* device instance ck3_t9 r0 *1 0,0
Rck3_t9 ck3__t9 ck3 38.2818049161
* device instance ck3_t10 r0 *1 0,0
Rck3_t10 ck3__t10 ck3 53.1919811878
* device instance ck3_t11 r0 *1 0,0
Rck3_t11 ck3__t11 ck3 41.4207893943
* device instance ck3_t12 r0 *1 0,0
Rck3_t12 ck3__t12 ck3 41.0284163345
* device instance ck3_t13 r0 *1 0,0
Rck3_t13 ck3__t13 ck3 42.5979085737
* device instance ck3_t14 r0 *1 0,0
Rck3_t14 ck3__t14 ck3 48.8758775302
* device instance ck3_t15 r0 *1 0,0
Rck3_t15 ck3__t15 ck3 36.7123126769
* device instance ck3_t16 r0 *1 0,0
Rck3_t16 ck3__t16 ck3 37.1046857367
* device instance ck3_t17 r0 *1 0,0
Rck3_t17 ck3__t17 ck3 49.6606236498
* device instance ck3 r0 *1 0,0
Cck3 ck3 vsubs 1.87171366e-13
* device instance ck4_t0 r0 *1 0,0
Rck4_t0 ck4__t0 ck4 27.9259546446
* device instance ck4_t1 r0 *1 0,0
Rck4_t1 ck4__t1 ck4 35.1371899729
* device instance ck4_t2 r0 *1 0,0
Rck4_t2 ck4__t2 ck4 52.8374948697
* device instance ck4_t3 r0 *1 0,0
Rck4_t3 ck4__t3 ck4 53.4930617177
* device instance ck4_t4 r0 *1 0,0
Rck4_t4 ck4__t4 ck4 56.7708959579
* device instance ck4_t5 r0 *1 0,0
Rck4_t5 ck4__t5 ck4 45.6262595414
* device instance ck4_t6 r0 *1 0,0
Rck4_t6 ck4__t6 ck4 46.2818263894
* device instance ck4_t7 r0 *1 0,0
Rck4_t7 ck4__t7 ck4 49.5596606296
* device instance ck4_t8 r0 *1 0,0
Rck4_t8 ck4__t8 ck4 33.8260562769
* device instance ck4_t9 r0 *1 0,0
Rck4_t9 ck4__t9 ck4 54.0971376831
* device instance ck4_t10 r0 *1 0,0
Rck4_t10 ck4__t10 ck4 49.9941934445
* device instance ck4_t11 r0 *1 0,0
Rck4_t11 ck4__t11 ck4 42.9072897598
* device instance ck4_t12 r0 *1 0,0
Rck4_t12 ck4__t12 ck4 42.534294829
* device instance ck4_t13 r0 *1 0,0
Rck4_t13 ck4__t13 ck4 39.9233303136
* device instance ck4_t14 r0 *1 0,0
Rck4_t14 ck4__t14 ck4 38.8043455213
* device instance ck4_t15 r0 *1 0,0
Rck4_t15 ck4__t15 ck4 38.4313505905
* device instance ck4_t16 r0 *1 0,0
Rck4_t16 ck4__t16 ck4 44.0262745521
* device instance ck4_t17 r0 *1 0,0
Rck4_t17 ck4__t17 ck4 50.7401833061
* device instance ck4 r0 *1 0,0
Cck4 ck4 vsubs 1.92861338e-13
* device instance ck5_t0 r0 *1 0,0
Rck5_t0 ck5__t0 ck5 36.955174596
* device instance ck5_t1 r0 *1 0,0
Rck5_t1 ck5__t1 ck5 46.979276582
* device instance ck5_t2 r0 *1 0,0
Rck5_t2 ck5__t2 ck5 47.6057829561
* device instance ck5_t3 r0 *1 0,0
Rck5_t3 ck5__t3 ck5 30.0636044806
* device instance ck5_t4 r0 *1 0,0
Rck5_t4 ck5__t4 ck5 50.7383148267
* device instance ck5_t5 r0 *1 0,0
Rck5_t5 ck5__t5 ck5 53.8708466973
* device instance ck5_t6 r0 *1 0,0
Rck5_t6 ck5__t6 ck5 57.6298849421
* device instance ck5_t7 r0 *1 0,0
Rck5_t7 ck5__t7 ck5 54.4973530715
* device instance ck5_t8 r0 *1 0,0
Rck5_t8 ck5__t8 ck5 35.7021618477
* device instance ck5_t9 r0 *1 0,0
Rck5_t9 ck5__t9 ck5 45.4502169639
* device instance ck5_t10 r0 *1 0,0
Rck5_t10 ck5__t10 ck5 44.3808353943
* device instance ck5_t11 r0 *1 0,0
Rck5_t11 ck5__t11 ck5 44.0243748711
* device instance ck5_t12 r0 *1 0,0
Rck5_t12 ck5__t12 ck5 41.5291512086
* device instance ck5_t13 r0 *1 0,0
Rck5_t13 ck5__t13 ck5 40.459769639
* device instance ck5_t14 r0 *1 0,0
Rck5_t14 ck5__t14 ck5 40.1033091158
* device instance ck5_t15 r0 *1 0,0
Rck5_t15 ck5__t15 ck5 51.1535853352
* device instance ck5_t16 r0 *1 0,0
Rck5_t16 ck5__t16 ck5 55.0746510905
* device instance ck5_t17 r0 *1 0,0
Rck5_t17 ck5__t17 ck5 51.8665063817
* device instance ck5 r0 *1 0,0
Cck5 ck5 vsubs 1.98537072e-13
* device instance mod0_t0 r0 *1 0,0
Rmod0_t0 mod0__t0 mod0 67.1860401985
* device instance mod0_t1 r0 *1 0,0
Rmod0_t1 mod0__t1 mod0 51.2716129584
* device instance mod0_t2 r0 *1 0,0
Rmod0_t2 mod0__t2 mod0 34.1329990076
* device instance mod0_t3 r0 *1 0,0
Rmod0_t3 mod0__t3 mod0 94.1181478355
* device instance mod0_t4 r0 *1 0,0
Rmod0_t4 mod0__t4 mod0 77.3489005646
* device instance mod0_t5 r0 *1 0,0
Rmod0_t5 mod0__t5 mod0 58.5428598871
* device instance mod0_t6 r0 *1 0,0
Rmod0_t6 mod0__t6 mod0 67.5976202133
* device instance mod0_t7 r0 *1 0,0
Rmod0_t7 mod0__t7 mod0 43.219419335
* device instance mod0 r0 *1 0,0
Cmod0 mod0 vsubs 1.16061533e-13
* device instance mod1_t0 r0 *1 0,0
Rmod1_t0 mod1__t0 mod1 69.8159272877
* device instance mod1_t1 r0 *1 0,0
Rmod1_t1 mod1__t1 mod1 38.5395635614
* device instance mod1_t2 r0 *1 0,0
Rmod1_t2 mod1__t2 mod1 54.7569373454
* device instance mod1_t3 r0 *1 0,0
Rmod1_t3 mod1__t3 mod1 95.3003718054
* device instance mod1_t4 r0 *1 0,0
Rmod1_t4 mod1__t4 mod1 61.6373379225
* device instance mod1_t5 r0 *1 0,0
Rmod1_t5 mod1__t5 mod1 70.2053839242
* device instance mod1_t6 r0 *1 0,0
Rmod1_t6 mod1__t6 mod1 79.4325103875
* device instance mod1_t7 r0 *1 0,0
Rmod1_t7 mod1__t7 mod1 47.1375677659
* device instance mod1 r0 *1 0,0
Cmod1 mod1 vsubs 1.21292335e-13
* device instance mod2_t0 r0 *1 0,0
Rmod2_t0 mod2__t0 mod2 72.497988573
* device instance mod2_t1 r0 *1 0,0
Rmod2_t1 mod2__t1 mod2 58.1437104731
* device instance mod2_t2 r0 *1 0,0
Rmod2_t2 mod2__t2 mod2 42.6852571348
* device instance mod2_t3 r0 *1 0,0
Rmod2_t3 mod2__t3 mod2 96.789843819
* device instance mod2_t4 r0 *1 0,0
Rmod2_t4 mod2__t4 mod2 81.6645468026
* device instance mod2_t5 r0 *1 0,0
Rmod2_t5 mod2__t5 mod2 64.7021306395
* device instance mod2_t6 r0 *1 0,0
Rmod2_t6 mod2__t6 mod2 72.8692199032
* device instance mod2_t7 r0 *1 0,0
Rmod2_t7 mod2__t7 mod2 50.8809026547
* device instance mod2 r0 *1 0,0
Cmod2 mod2 vsubs 1.26525886e-13
* device instance mod3_t0 r0 *1 0,0
Rmod3_t0 mod3__t0 mod3 46.6334361344
* device instance mod3_t1 r0 *1 0,0
Rmod3_t1 mod3__t1 mod3 61.4558592063
* device instance mod3_t2 r0 *1 0,0
Rmod3_t2 mod3__t2 mod3 75.2195377731
* device instance mod3_t3 r0 *1 0,0
Rmod3_t3 mod3__t3 mod3 98.5119168862
* device instance mod3_t4 r0 *1 0,0
Rmod3_t4 mod3__t4 mod3 84.0089425873
* device instance mod3_t5 r0 *1 0,0
Rmod3_t5 mod3__t5 mod3 75.5754949774
* device instance mod3_t6 r0 *1 0,0
Rmod3_t6 mod3__t6 mod3 67.7444364825
* device instance mod3_t7 r0 *1 0,0
Rmod3_t7 mod3__t7 mod3 54.4918759527
* device instance mod3 r0 *1 0,0
Cmod3 mod3 vsubs 1.31759437e-13
* device instance mod4_t0 r0 *1 0,0
Rmod4_t0 mod4__t0 mod4 77.9717255747
* device instance mod4_t1 r0 *1 0,0
Rmod4_t1 mod4__t1 mod4 50.4284971263
* device instance mod4_t2 r0 *1 0,0
Rmod4_t2 mod4__t2 mod4 64.7101711366
* device instance mod4_t3 r0 *1 0,0
Rmod4_t3 mod4__t3 mod4 100.414356162
* device instance mod4_t4 r0 *1 0,0
Rmod4_t4 mod4__t4 mod4 78.3146968102
* device instance mod4_t5 r0 *1 0,0
Rmod4_t5 mod4__t5 mod4 70.7693296299
* device instance mod4_t6 r0 *1 0,0
Rmod4_t6 mod4__t6 mod4 86.4404768506
* device instance mod4_t7 r0 *1 0,0
Rmod4_t7 mod4__t7 mod4 58.0002467093
* device instance mod4 r0 *1 0,0
Cmod4 mod4 vsubs 1.36991875e-13
* device instance net1_t0 r0 *1 0,0
Rnet1_t0 net1__t0 net1 65.8113901935
* device instance net1_t1 r0 *1 0,0
Rnet1_t1 net1__t1 net1 104.591609806
* device instance net1_t2 r0 *1 0,0
Rnet1_t2 net1__t2 net1 96.2338038554
* device instance net1_t3 r0 *1 0,0
Rnet1_t3 net1__t3 net1 74.1691961446
* device instance net1 r0 *1 0,0
Cnet1 net1 vsubs 7.9008527e-14
* device instance cc_CKIN_CKIN_VCO r0 *1 0,0
Ccc_CKIN_CKIN_VCO CKIN CKIN_VCO 1.8151e-17
* device instance cc_CKIN_DIVOUT r0 *1 0,0
Ccc_CKIN_DIVOUT CKIN DIVOUT 2.4201e-17
* device instance cc_CKIN_FB r0 *1 0,0
Ccc_CKIN_FB CKIN FB 6.05e-18
* device instance cc_CKIN_P0 r0 *1 0,0
Ccc_CKIN_P0 CKIN P0 6.05e-18
* device instance cc_CKIN_P1 r0 *1 0,0
Ccc_CKIN_P1 CKIN P1 6.05e-18
* device instance cc_CKIN_P2 r0 *1 0,0
Ccc_CKIN_P2 CKIN P2 6.05e-18
* device instance cc_CKIN_P3 r0 *1 0,0
Ccc_CKIN_P3 CKIN P3 6.05e-18
* device instance cc_CKIN_P4 r0 *1 0,0
Ccc_CKIN_P4 CKIN P4 6.05e-18
* device instance cc_CKIN_P5 r0 *1 0,0
Ccc_CKIN_P5 CKIN P5 6.05e-18
* device instance cc_CKIN_VDD_DIV r0 *1 0,0
Ccc_CKIN_VDD_DIV CKIN VDD_DIV 1.08905e-16
* device instance cc_CKIN_VSS r0 *1 0,0
Ccc_CKIN_VSS CKIN VSS 5.08221e-16
* device instance cc_CKIN_XD0_XDFFM_CLKB r0 *1 0,0
Ccc_CKIN_XD0_XDFFM_CLKB CKIN XD0.XDFFM.CLKB 3.6302e-17
* device instance cc_CKIN_XD0_XDFFM_M r0 *1 0,0
Ccc_CKIN_XD0_XDFFM_M CKIN XD0.XDFFM.M 4.8402e-17
* device instance cc_CKIN_XD0_XDFFM_MB r0 *1 0,0
Ccc_CKIN_XD0_XDFFM_MB CKIN XD0.XDFFM.MB 2.4201e-17
* device instance cc_CKIN_XD0_XDFFM_S r0 *1 0,0
Ccc_CKIN_XD0_XDFFM_S CKIN XD0.XDFFM.S 3.0251e-17
* device instance cc_CKIN_XD0_XDFFM_SB r0 *1 0,0
Ccc_CKIN_XD0_XDFFM_SB CKIN XD0.XDFFM.SB 2.4201e-17
* device instance cc_CKIN_XD0_XDFFQ_CLKB r0 *1 0,0
Ccc_CKIN_XD0_XDFFQ_CLKB CKIN XD0.XDFFQ.CLKB 3.6302e-17
* device instance cc_CKIN_XD0_XDFFQ_M r0 *1 0,0
Ccc_CKIN_XD0_XDFFQ_M CKIN XD0.XDFFQ.M 4.8402e-17
* device instance cc_CKIN_XD0_XDFFQ_MB r0 *1 0,0
Ccc_CKIN_XD0_XDFFQ_MB CKIN XD0.XDFFQ.MB 2.4201e-17
* device instance cc_CKIN_XD0_XDFFQ_S r0 *1 0,0
Ccc_CKIN_XD0_XDFFQ_S CKIN XD0.XDFFQ.S 3.6302e-17
* device instance cc_CKIN_XD0_XDFFQ_SB r0 *1 0,0
Ccc_CKIN_XD0_XDFFQ_SB CKIN XD0.XDFFQ.SB 3.6302e-17
* device instance cc_CKIN_XD0_XN2_mid1 r0 *1 0,0
Ccc_CKIN_XD0_XN2_mid1 CKIN XD0.XN2.mid1 1.21e-17
* device instance cc_CKIN_XD0_XNOR_midp r0 *1 0,0
Ccc_CKIN_XD0_XNOR_midp CKIN XD0.XNOR.midp 1.21e-17
* device instance cc_CKIN_XD0_dmodout r0 *1 0,0
Ccc_CKIN_XD0_dmodout CKIN XD0.dmodout 2.4201e-17
* device instance cc_CKIN_XD0_dq r0 *1 0,0
Ccc_CKIN_XD0_dq CKIN XD0.dq 1.8151e-17
* device instance cc_CKIN_XD0_nm r0 *1 0,0
Ccc_CKIN_XD0_nm CKIN XD0.nm 3.0251e-17
* device instance cc_CKIN_XD0_nt r0 *1 0,0
Ccc_CKIN_XD0_nt CKIN XD0.nt 2.4201e-17
* device instance cc_CKIN_XD0_t1 r0 *1 0,0
Ccc_CKIN_XD0_t1 CKIN XD0.t1 1.21e-17
* device instance cc_CKIN_XD1_XDFFM_CLKB r0 *1 0,0
Ccc_CKIN_XD1_XDFFM_CLKB CKIN XD1.XDFFM.CLKB 1.8151e-17
* device instance cc_CKIN_XD1_XDFFM_M r0 *1 0,0
Ccc_CKIN_XD1_XDFFM_M CKIN XD1.XDFFM.M 2.4201e-17
* device instance cc_CKIN_XD1_XDFFM_MB r0 *1 0,0
Ccc_CKIN_XD1_XDFFM_MB CKIN XD1.XDFFM.MB 1.21e-17
* device instance cc_CKIN_XD1_XDFFM_S r0 *1 0,0
Ccc_CKIN_XD1_XDFFM_S CKIN XD1.XDFFM.S 1.8151e-17
* device instance cc_CKIN_XD1_XDFFM_SB r0 *1 0,0
Ccc_CKIN_XD1_XDFFM_SB CKIN XD1.XDFFM.SB 1.8151e-17
* device instance cc_CKIN_XD1_XDFFQ_CLKB r0 *1 0,0
Ccc_CKIN_XD1_XDFFQ_CLKB CKIN XD1.XDFFQ.CLKB 1.8151e-17
* device instance cc_CKIN_XD1_XDFFQ_M r0 *1 0,0
Ccc_CKIN_XD1_XDFFQ_M CKIN XD1.XDFFQ.M 2.4201e-17
* device instance cc_CKIN_XD1_XDFFQ_MB r0 *1 0,0
Ccc_CKIN_XD1_XDFFQ_MB CKIN XD1.XDFFQ.MB 1.21e-17
* device instance cc_CKIN_XD1_XDFFQ_S r0 *1 0,0
Ccc_CKIN_XD1_XDFFQ_S CKIN XD1.XDFFQ.S 1.8151e-17
* device instance cc_CKIN_XD1_XDFFQ_SB r0 *1 0,0
Ccc_CKIN_XD1_XDFFQ_SB CKIN XD1.XDFFQ.SB 1.8151e-17
* device instance cc_CKIN_XD1_XN2_mid1 r0 *1 0,0
Ccc_CKIN_XD1_XN2_mid1 CKIN XD1.XN2.mid1 1.21e-17
* device instance cc_CKIN_XD1_XN3_mid1 r0 *1 0,0
Ccc_CKIN_XD1_XN3_mid1 CKIN XD1.XN3.mid1 1.21e-17
* device instance cc_CKIN_XD1_XN3_mid2 r0 *1 0,0
Ccc_CKIN_XD1_XN3_mid2 CKIN XD1.XN3.mid2 1.21e-17
* device instance cc_CKIN_XD1_dmodout r0 *1 0,0
Ccc_CKIN_XD1_dmodout CKIN XD1.dmodout 1.21e-17
* device instance cc_CKIN_XD1_dq r0 *1 0,0
Ccc_CKIN_XD1_dq CKIN XD1.dq 1.8151e-17
* device instance cc_CKIN_XD1_nm r0 *1 0,0
Ccc_CKIN_XD1_nm CKIN XD1.nm 1.21e-17
* device instance cc_CKIN_XD1_nt r0 *1 0,0
Ccc_CKIN_XD1_nt CKIN XD1.nt 1.21e-17
* device instance cc_CKIN_XD1_t1 r0 *1 0,0
Ccc_CKIN_XD1_t1 CKIN XD1.t1 1.21e-17
* device instance cc_CKIN_XD2_XDFFM_CLKB r0 *1 0,0
Ccc_CKIN_XD2_XDFFM_CLKB CKIN XD2.XDFFM.CLKB 1.8151e-17
* device instance cc_CKIN_XD2_XDFFM_M r0 *1 0,0
Ccc_CKIN_XD2_XDFFM_M CKIN XD2.XDFFM.M 2.4201e-17
* device instance cc_CKIN_XD2_XDFFM_MB r0 *1 0,0
Ccc_CKIN_XD2_XDFFM_MB CKIN XD2.XDFFM.MB 1.21e-17
* device instance cc_CKIN_XD2_XDFFM_S r0 *1 0,0
Ccc_CKIN_XD2_XDFFM_S CKIN XD2.XDFFM.S 1.8151e-17
* device instance cc_CKIN_XD2_XDFFM_SB r0 *1 0,0
Ccc_CKIN_XD2_XDFFM_SB CKIN XD2.XDFFM.SB 1.8151e-17
* device instance cc_CKIN_XD2_XDFFQ_CLKB r0 *1 0,0
Ccc_CKIN_XD2_XDFFQ_CLKB CKIN XD2.XDFFQ.CLKB 1.8151e-17
* device instance cc_CKIN_XD2_XDFFQ_M r0 *1 0,0
Ccc_CKIN_XD2_XDFFQ_M CKIN XD2.XDFFQ.M 2.4201e-17
* device instance cc_CKIN_XD2_XDFFQ_MB r0 *1 0,0
Ccc_CKIN_XD2_XDFFQ_MB CKIN XD2.XDFFQ.MB 1.21e-17
* device instance cc_CKIN_XD2_XDFFQ_S r0 *1 0,0
Ccc_CKIN_XD2_XDFFQ_S CKIN XD2.XDFFQ.S 1.8151e-17
* device instance cc_CKIN_XD2_XDFFQ_SB r0 *1 0,0
Ccc_CKIN_XD2_XDFFQ_SB CKIN XD2.XDFFQ.SB 1.8151e-17
* device instance cc_CKIN_XD2_XN2_mid1 r0 *1 0,0
Ccc_CKIN_XD2_XN2_mid1 CKIN XD2.XN2.mid1 1.21e-17
* device instance cc_CKIN_XD2_XN3_mid1 r0 *1 0,0
Ccc_CKIN_XD2_XN3_mid1 CKIN XD2.XN3.mid1 1.21e-17
* device instance cc_CKIN_XD2_XN3_mid2 r0 *1 0,0
Ccc_CKIN_XD2_XN3_mid2 CKIN XD2.XN3.mid2 1.21e-17
* device instance cc_CKIN_XD2_dmodout r0 *1 0,0
Ccc_CKIN_XD2_dmodout CKIN XD2.dmodout 1.21e-17
* device instance cc_CKIN_XD2_dq r0 *1 0,0
Ccc_CKIN_XD2_dq CKIN XD2.dq 1.8151e-17
* device instance cc_CKIN_XD2_nm r0 *1 0,0
Ccc_CKIN_XD2_nm CKIN XD2.nm 1.21e-17
* device instance cc_CKIN_XD2_nt r0 *1 0,0
Ccc_CKIN_XD2_nt CKIN XD2.nt 1.21e-17
* device instance cc_CKIN_XD2_t1 r0 *1 0,0
Ccc_CKIN_XD2_t1 CKIN XD2.t1 1.21e-17
* device instance cc_CKIN_XD3_XDFFM_CLKB r0 *1 0,0
Ccc_CKIN_XD3_XDFFM_CLKB CKIN XD3.XDFFM.CLKB 1.8151e-17
* device instance cc_CKIN_XD3_XDFFM_M r0 *1 0,0
Ccc_CKIN_XD3_XDFFM_M CKIN XD3.XDFFM.M 2.4201e-17
* device instance cc_CKIN_XD3_XDFFM_MB r0 *1 0,0
Ccc_CKIN_XD3_XDFFM_MB CKIN XD3.XDFFM.MB 1.21e-17
* device instance cc_CKIN_XD3_XDFFM_S r0 *1 0,0
Ccc_CKIN_XD3_XDFFM_S CKIN XD3.XDFFM.S 1.8151e-17
* device instance cc_CKIN_XD3_XDFFM_SB r0 *1 0,0
Ccc_CKIN_XD3_XDFFM_SB CKIN XD3.XDFFM.SB 1.8151e-17
* device instance cc_CKIN_XD3_XDFFQ_CLKB r0 *1 0,0
Ccc_CKIN_XD3_XDFFQ_CLKB CKIN XD3.XDFFQ.CLKB 1.8151e-17
* device instance cc_CKIN_XD3_XDFFQ_M r0 *1 0,0
Ccc_CKIN_XD3_XDFFQ_M CKIN XD3.XDFFQ.M 2.4201e-17
* device instance cc_CKIN_XD3_XDFFQ_MB r0 *1 0,0
Ccc_CKIN_XD3_XDFFQ_MB CKIN XD3.XDFFQ.MB 1.21e-17
* device instance cc_CKIN_XD3_XDFFQ_S r0 *1 0,0
Ccc_CKIN_XD3_XDFFQ_S CKIN XD3.XDFFQ.S 1.8151e-17
* device instance cc_CKIN_XD3_XDFFQ_SB r0 *1 0,0
Ccc_CKIN_XD3_XDFFQ_SB CKIN XD3.XDFFQ.SB 1.8151e-17
* device instance cc_CKIN_XD3_XN2_mid1 r0 *1 0,0
Ccc_CKIN_XD3_XN2_mid1 CKIN XD3.XN2.mid1 1.21e-17
* device instance cc_CKIN_XD3_XN3_mid1 r0 *1 0,0
Ccc_CKIN_XD3_XN3_mid1 CKIN XD3.XN3.mid1 1.21e-17
* device instance cc_CKIN_XD3_XN3_mid2 r0 *1 0,0
Ccc_CKIN_XD3_XN3_mid2 CKIN XD3.XN3.mid2 1.21e-17
* device instance cc_CKIN_XD3_dmodout r0 *1 0,0
Ccc_CKIN_XD3_dmodout CKIN XD3.dmodout 1.21e-17
* device instance cc_CKIN_XD3_dq r0 *1 0,0
Ccc_CKIN_XD3_dq CKIN XD3.dq 1.8151e-17
* device instance cc_CKIN_XD3_nm r0 *1 0,0
Ccc_CKIN_XD3_nm CKIN XD3.nm 1.21e-17
* device instance cc_CKIN_XD3_nt r0 *1 0,0
Ccc_CKIN_XD3_nt CKIN XD3.nt 1.21e-17
* device instance cc_CKIN_XD3_t1 r0 *1 0,0
Ccc_CKIN_XD3_t1 CKIN XD3.t1 1.21e-17
* device instance cc_CKIN_XD4_XDFFM_CLKB r0 *1 0,0
Ccc_CKIN_XD4_XDFFM_CLKB CKIN XD4.XDFFM.CLKB 1.8151e-17
* device instance cc_CKIN_XD4_XDFFM_M r0 *1 0,0
Ccc_CKIN_XD4_XDFFM_M CKIN XD4.XDFFM.M 2.4201e-17
* device instance cc_CKIN_XD4_XDFFM_MB r0 *1 0,0
Ccc_CKIN_XD4_XDFFM_MB CKIN XD4.XDFFM.MB 1.21e-17
* device instance cc_CKIN_XD4_XDFFM_S r0 *1 0,0
Ccc_CKIN_XD4_XDFFM_S CKIN XD4.XDFFM.S 1.8151e-17
* device instance cc_CKIN_XD4_XDFFM_SB r0 *1 0,0
Ccc_CKIN_XD4_XDFFM_SB CKIN XD4.XDFFM.SB 1.8151e-17
* device instance cc_CKIN_XD4_XDFFQ_CLKB r0 *1 0,0
Ccc_CKIN_XD4_XDFFQ_CLKB CKIN XD4.XDFFQ.CLKB 1.8151e-17
* device instance cc_CKIN_XD4_XDFFQ_M r0 *1 0,0
Ccc_CKIN_XD4_XDFFQ_M CKIN XD4.XDFFQ.M 2.4201e-17
* device instance cc_CKIN_XD4_XDFFQ_MB r0 *1 0,0
Ccc_CKIN_XD4_XDFFQ_MB CKIN XD4.XDFFQ.MB 1.21e-17
* device instance cc_CKIN_XD4_XDFFQ_S r0 *1 0,0
Ccc_CKIN_XD4_XDFFQ_S CKIN XD4.XDFFQ.S 1.8151e-17
* device instance cc_CKIN_XD4_XDFFQ_SB r0 *1 0,0
Ccc_CKIN_XD4_XDFFQ_SB CKIN XD4.XDFFQ.SB 1.8151e-17
* device instance cc_CKIN_XD4_XN2_mid1 r0 *1 0,0
Ccc_CKIN_XD4_XN2_mid1 CKIN XD4.XN2.mid1 1.21e-17
* device instance cc_CKIN_XD4_XN3_mid1 r0 *1 0,0
Ccc_CKIN_XD4_XN3_mid1 CKIN XD4.XN3.mid1 1.21e-17
* device instance cc_CKIN_XD4_XN3_mid2 r0 *1 0,0
Ccc_CKIN_XD4_XN3_mid2 CKIN XD4.XN3.mid2 1.21e-17
* device instance cc_CKIN_XD4_dmodout r0 *1 0,0
Ccc_CKIN_XD4_dmodout CKIN XD4.dmodout 1.21e-17
* device instance cc_CKIN_XD4_dq r0 *1 0,0
Ccc_CKIN_XD4_dq CKIN XD4.dq 1.8151e-17
* device instance cc_CKIN_XD4_nm r0 *1 0,0
Ccc_CKIN_XD4_nm CKIN XD4.nm 1.21e-17
* device instance cc_CKIN_XD4_nt r0 *1 0,0
Ccc_CKIN_XD4_nt CKIN XD4.nt 1.21e-17
* device instance cc_CKIN_XD4_t1 r0 *1 0,0
Ccc_CKIN_XD4_t1 CKIN XD4.t1 1.21e-17
* device instance cc_CKIN_XD5_XDFFM_CLKB r0 *1 0,0
Ccc_CKIN_XD5_XDFFM_CLKB CKIN XD5.XDFFM.CLKB 1.8151e-17
* device instance cc_CKIN_XD5_XDFFM_M r0 *1 0,0
Ccc_CKIN_XD5_XDFFM_M CKIN XD5.XDFFM.M 2.4201e-17
* device instance cc_CKIN_XD5_XDFFM_MB r0 *1 0,0
Ccc_CKIN_XD5_XDFFM_MB CKIN XD5.XDFFM.MB 1.21e-17
* device instance cc_CKIN_XD5_XDFFM_S r0 *1 0,0
Ccc_CKIN_XD5_XDFFM_S CKIN XD5.XDFFM.S 1.8151e-17
* device instance cc_CKIN_XD5_XDFFM_SB r0 *1 0,0
Ccc_CKIN_XD5_XDFFM_SB CKIN XD5.XDFFM.SB 1.8151e-17
* device instance cc_CKIN_XD5_XDFFQ_CLKB r0 *1 0,0
Ccc_CKIN_XD5_XDFFQ_CLKB CKIN XD5.XDFFQ.CLKB 1.8151e-17
* device instance cc_CKIN_XD5_XDFFQ_M r0 *1 0,0
Ccc_CKIN_XD5_XDFFQ_M CKIN XD5.XDFFQ.M 2.4201e-17
* device instance cc_CKIN_XD5_XDFFQ_MB r0 *1 0,0
Ccc_CKIN_XD5_XDFFQ_MB CKIN XD5.XDFFQ.MB 1.21e-17
* device instance cc_CKIN_XD5_XDFFQ_S r0 *1 0,0
Ccc_CKIN_XD5_XDFFQ_S CKIN XD5.XDFFQ.S 1.8151e-17
* device instance cc_CKIN_XD5_XDFFQ_SB r0 *1 0,0
Ccc_CKIN_XD5_XDFFQ_SB CKIN XD5.XDFFQ.SB 1.8151e-17
* device instance cc_CKIN_XD5_XN2_mid1 r0 *1 0,0
Ccc_CKIN_XD5_XN2_mid1 CKIN XD5.XN2.mid1 1.21e-17
* device instance cc_CKIN_XD5_XN3_mid1 r0 *1 0,0
Ccc_CKIN_XD5_XN3_mid1 CKIN XD5.XN3.mid1 1.21e-17
* device instance cc_CKIN_XD5_XN3_mid2 r0 *1 0,0
Ccc_CKIN_XD5_XN3_mid2 CKIN XD5.XN3.mid2 1.21e-17
* device instance cc_CKIN_XD5_dmodout r0 *1 0,0
Ccc_CKIN_XD5_dmodout CKIN XD5.dmodout 1.21e-17
* device instance cc_CKIN_XD5_dq r0 *1 0,0
Ccc_CKIN_XD5_dq CKIN XD5.dq 1.8151e-17
* device instance cc_CKIN_XD5_nm r0 *1 0,0
Ccc_CKIN_XD5_nm CKIN XD5.nm 1.21e-17
* device instance cc_CKIN_XD5_nt r0 *1 0,0
Ccc_CKIN_XD5_nt CKIN XD5.nt 1.21e-17
* device instance cc_CKIN_XD5_t1 r0 *1 0,0
Ccc_CKIN_XD5_t1 CKIN XD5.t1 1.21e-17
* device instance cc_CKIN_XFRT_CLKB r0 *1 0,0
Ccc_CKIN_XFRT_CLKB CKIN XFRT.CLKB 1.8151e-17
* device instance cc_CKIN_XFRT_M r0 *1 0,0
Ccc_CKIN_XFRT_M CKIN XFRT.M 2.4201e-17
* device instance cc_CKIN_XFRT_MB r0 *1 0,0
Ccc_CKIN_XFRT_MB CKIN XFRT.MB 1.21e-17
* device instance cc_CKIN_XFRT_S r0 *1 0,0
Ccc_CKIN_XFRT_S CKIN XFRT.S 1.8151e-17
* device instance cc_CKIN_XFRT_SB r0 *1 0,0
Ccc_CKIN_XFRT_SB CKIN XFRT.SB 1.8151e-17
* device instance cc_CKIN_ck1 r0 *1 0,0
Ccc_CKIN_ck1 CKIN ck1 6.6553e-17
* device instance cc_CKIN_ck2 r0 *1 0,0
Ccc_CKIN_ck2 CKIN ck2 5.4452e-17
* device instance cc_CKIN_ck3 r0 *1 0,0
Ccc_CKIN_ck3 CKIN ck3 5.4452e-17
* device instance cc_CKIN_ck4 r0 *1 0,0
Ccc_CKIN_ck4 CKIN ck4 5.4452e-17
* device instance cc_CKIN_ck5 r0 *1 0,0
Ccc_CKIN_ck5 CKIN ck5 5.4452e-17
* device instance cc_CKIN_mod0 r0 *1 0,0
Ccc_CKIN_mod0 CKIN mod0 3.0251e-17
* device instance cc_CKIN_mod1 r0 *1 0,0
Ccc_CKIN_mod1 CKIN mod1 2.4201e-17
* device instance cc_CKIN_mod2 r0 *1 0,0
Ccc_CKIN_mod2 CKIN mod2 2.4201e-17
* device instance cc_CKIN_mod3 r0 *1 0,0
Ccc_CKIN_mod3 CKIN mod3 2.4201e-17
* device instance cc_CKIN_mod4 r0 *1 0,0
Ccc_CKIN_mod4 CKIN mod4 2.4201e-17
* device instance cc_CKIN_net1 r0 *1 0,0
Ccc_CKIN_net1 CKIN net1 1.21e-17
* device instance cc_CKIN_VCO_DIVOUT r0 *1 0,0
Ccc_CKIN_VCO_DIVOUT CKIN_VCO DIVOUT 3.0251e-17
* device instance cc_CKIN_VCO_FB r0 *1 0,0
Ccc_CKIN_VCO_FB CKIN_VCO FB 6.05e-18
* device instance cc_CKIN_VCO_P0 r0 *1 0,0
Ccc_CKIN_VCO_P0 CKIN_VCO P0 6.05e-18
* device instance cc_CKIN_VCO_P1 r0 *1 0,0
Ccc_CKIN_VCO_P1 CKIN_VCO P1 6.05e-18
* device instance cc_CKIN_VCO_P2 r0 *1 0,0
Ccc_CKIN_VCO_P2 CKIN_VCO P2 6.05e-18
* device instance cc_CKIN_VCO_P3 r0 *1 0,0
Ccc_CKIN_VCO_P3 CKIN_VCO P3 6.05e-18
* device instance cc_CKIN_VCO_P4 r0 *1 0,0
Ccc_CKIN_VCO_P4 CKIN_VCO P4 6.05e-18
* device instance cc_CKIN_VCO_P5 r0 *1 0,0
Ccc_CKIN_VCO_P5 CKIN_VCO P5 6.05e-18
* device instance cc_CKIN_VCO_VDD_DIV r0 *1 0,0
Ccc_CKIN_VCO_VDD_DIV CKIN_VCO VDD_DIV 6.17125e-16
* device instance cc_CKIN_VCO_VSS r0 *1 0,0
Ccc_CKIN_VCO_VSS CKIN_VCO VSS 2.4201e-17
* device instance cc_CKIN_VCO_XD0_XDFFM_CLKB r0 *1 0,0
Ccc_CKIN_VCO_XD0_XDFFM_CLKB CKIN_VCO XD0.XDFFM.CLKB 1.8151e-17
* device instance cc_CKIN_VCO_XD0_XDFFM_M r0 *1 0,0
Ccc_CKIN_VCO_XD0_XDFFM_M CKIN_VCO XD0.XDFFM.M 2.4201e-17
* device instance cc_CKIN_VCO_XD0_XDFFM_MB r0 *1 0,0
Ccc_CKIN_VCO_XD0_XDFFM_MB CKIN_VCO XD0.XDFFM.MB 1.21e-17
* device instance cc_CKIN_VCO_XD0_XDFFM_S r0 *1 0,0
Ccc_CKIN_VCO_XD0_XDFFM_S CKIN_VCO XD0.XDFFM.S 1.8151e-17
* device instance cc_CKIN_VCO_XD0_XDFFM_SB r0 *1 0,0
Ccc_CKIN_VCO_XD0_XDFFM_SB CKIN_VCO XD0.XDFFM.SB 1.8151e-17
* device instance cc_CKIN_VCO_XD0_XDFFQ_CLKB r0 *1 0,0
Ccc_CKIN_VCO_XD0_XDFFQ_CLKB CKIN_VCO XD0.XDFFQ.CLKB 1.8151e-17
* device instance cc_CKIN_VCO_XD0_XDFFQ_M r0 *1 0,0
Ccc_CKIN_VCO_XD0_XDFFQ_M CKIN_VCO XD0.XDFFQ.M 2.4201e-17
* device instance cc_CKIN_VCO_XD0_XDFFQ_MB r0 *1 0,0
Ccc_CKIN_VCO_XD0_XDFFQ_MB CKIN_VCO XD0.XDFFQ.MB 1.21e-17
* device instance cc_CKIN_VCO_XD0_XDFFQ_S r0 *1 0,0
Ccc_CKIN_VCO_XD0_XDFFQ_S CKIN_VCO XD0.XDFFQ.S 1.8151e-17
* device instance cc_CKIN_VCO_XD0_XDFFQ_SB r0 *1 0,0
Ccc_CKIN_VCO_XD0_XDFFQ_SB CKIN_VCO XD0.XDFFQ.SB 1.8151e-17
* device instance cc_CKIN_VCO_XD0_XNOR_midp r0 *1 0,0
Ccc_CKIN_VCO_XD0_XNOR_midp CKIN_VCO XD0.XNOR.midp 1.21e-17
* device instance cc_CKIN_VCO_XD0_dmodout r0 *1 0,0
Ccc_CKIN_VCO_XD0_dmodout CKIN_VCO XD0.dmodout 1.21e-17
* device instance cc_CKIN_VCO_XD0_dq r0 *1 0,0
Ccc_CKIN_VCO_XD0_dq CKIN_VCO XD0.dq 1.21e-17
* device instance cc_CKIN_VCO_XD0_nm r0 *1 0,0
Ccc_CKIN_VCO_XD0_nm CKIN_VCO XD0.nm 1.8151e-17
* device instance cc_CKIN_VCO_XD0_nt r0 *1 0,0
Ccc_CKIN_VCO_XD0_nt CKIN_VCO XD0.nt 2.4201e-17
* device instance cc_CKIN_VCO_XD0_t1 r0 *1 0,0
Ccc_CKIN_VCO_XD0_t1 CKIN_VCO XD0.t1 1.21e-17
* device instance cc_CKIN_VCO_XD1_XDFFM_CLKB r0 *1 0,0
Ccc_CKIN_VCO_XD1_XDFFM_CLKB CKIN_VCO XD1.XDFFM.CLKB 1.8151e-17
* device instance cc_CKIN_VCO_XD1_XDFFM_M r0 *1 0,0
Ccc_CKIN_VCO_XD1_XDFFM_M CKIN_VCO XD1.XDFFM.M 2.4201e-17
* device instance cc_CKIN_VCO_XD1_XDFFM_MB r0 *1 0,0
Ccc_CKIN_VCO_XD1_XDFFM_MB CKIN_VCO XD1.XDFFM.MB 1.21e-17
* device instance cc_CKIN_VCO_XD1_XDFFM_S r0 *1 0,0
Ccc_CKIN_VCO_XD1_XDFFM_S CKIN_VCO XD1.XDFFM.S 1.8151e-17
* device instance cc_CKIN_VCO_XD1_XDFFM_SB r0 *1 0,0
Ccc_CKIN_VCO_XD1_XDFFM_SB CKIN_VCO XD1.XDFFM.SB 1.8151e-17
* device instance cc_CKIN_VCO_XD1_XDFFQ_CLKB r0 *1 0,0
Ccc_CKIN_VCO_XD1_XDFFQ_CLKB CKIN_VCO XD1.XDFFQ.CLKB 1.8151e-17
* device instance cc_CKIN_VCO_XD1_XDFFQ_M r0 *1 0,0
Ccc_CKIN_VCO_XD1_XDFFQ_M CKIN_VCO XD1.XDFFQ.M 2.4201e-17
* device instance cc_CKIN_VCO_XD1_XDFFQ_MB r0 *1 0,0
Ccc_CKIN_VCO_XD1_XDFFQ_MB CKIN_VCO XD1.XDFFQ.MB 1.21e-17
* device instance cc_CKIN_VCO_XD1_XDFFQ_S r0 *1 0,0
Ccc_CKIN_VCO_XD1_XDFFQ_S CKIN_VCO XD1.XDFFQ.S 1.8151e-17
* device instance cc_CKIN_VCO_XD1_XDFFQ_SB r0 *1 0,0
Ccc_CKIN_VCO_XD1_XDFFQ_SB CKIN_VCO XD1.XDFFQ.SB 1.8151e-17
* device instance cc_CKIN_VCO_XD1_XNOR_midp r0 *1 0,0
Ccc_CKIN_VCO_XD1_XNOR_midp CKIN_VCO XD1.XNOR.midp 1.21e-17
* device instance cc_CKIN_VCO_XD1_dmodout r0 *1 0,0
Ccc_CKIN_VCO_XD1_dmodout CKIN_VCO XD1.dmodout 1.21e-17
* device instance cc_CKIN_VCO_XD1_dq r0 *1 0,0
Ccc_CKIN_VCO_XD1_dq CKIN_VCO XD1.dq 1.21e-17
* device instance cc_CKIN_VCO_XD1_nm r0 *1 0,0
Ccc_CKIN_VCO_XD1_nm CKIN_VCO XD1.nm 1.8151e-17
* device instance cc_CKIN_VCO_XD1_nt r0 *1 0,0
Ccc_CKIN_VCO_XD1_nt CKIN_VCO XD1.nt 2.4201e-17
* device instance cc_CKIN_VCO_XD1_t1 r0 *1 0,0
Ccc_CKIN_VCO_XD1_t1 CKIN_VCO XD1.t1 1.21e-17
* device instance cc_CKIN_VCO_XD2_XDFFM_CLKB r0 *1 0,0
Ccc_CKIN_VCO_XD2_XDFFM_CLKB CKIN_VCO XD2.XDFFM.CLKB 1.8151e-17
* device instance cc_CKIN_VCO_XD2_XDFFM_M r0 *1 0,0
Ccc_CKIN_VCO_XD2_XDFFM_M CKIN_VCO XD2.XDFFM.M 2.4201e-17
* device instance cc_CKIN_VCO_XD2_XDFFM_MB r0 *1 0,0
Ccc_CKIN_VCO_XD2_XDFFM_MB CKIN_VCO XD2.XDFFM.MB 1.21e-17
* device instance cc_CKIN_VCO_XD2_XDFFM_S r0 *1 0,0
Ccc_CKIN_VCO_XD2_XDFFM_S CKIN_VCO XD2.XDFFM.S 1.8151e-17
* device instance cc_CKIN_VCO_XD2_XDFFM_SB r0 *1 0,0
Ccc_CKIN_VCO_XD2_XDFFM_SB CKIN_VCO XD2.XDFFM.SB 1.8151e-17
* device instance cc_CKIN_VCO_XD2_XDFFQ_CLKB r0 *1 0,0
Ccc_CKIN_VCO_XD2_XDFFQ_CLKB CKIN_VCO XD2.XDFFQ.CLKB 1.8151e-17
* device instance cc_CKIN_VCO_XD2_XDFFQ_M r0 *1 0,0
Ccc_CKIN_VCO_XD2_XDFFQ_M CKIN_VCO XD2.XDFFQ.M 2.4201e-17
* device instance cc_CKIN_VCO_XD2_XDFFQ_MB r0 *1 0,0
Ccc_CKIN_VCO_XD2_XDFFQ_MB CKIN_VCO XD2.XDFFQ.MB 1.21e-17
* device instance cc_CKIN_VCO_XD2_XDFFQ_S r0 *1 0,0
Ccc_CKIN_VCO_XD2_XDFFQ_S CKIN_VCO XD2.XDFFQ.S 1.8151e-17
* device instance cc_CKIN_VCO_XD2_XDFFQ_SB r0 *1 0,0
Ccc_CKIN_VCO_XD2_XDFFQ_SB CKIN_VCO XD2.XDFFQ.SB 1.8151e-17
* device instance cc_CKIN_VCO_XD2_XNOR_midp r0 *1 0,0
Ccc_CKIN_VCO_XD2_XNOR_midp CKIN_VCO XD2.XNOR.midp 1.21e-17
* device instance cc_CKIN_VCO_XD2_dmodout r0 *1 0,0
Ccc_CKIN_VCO_XD2_dmodout CKIN_VCO XD2.dmodout 1.21e-17
* device instance cc_CKIN_VCO_XD2_dq r0 *1 0,0
Ccc_CKIN_VCO_XD2_dq CKIN_VCO XD2.dq 1.21e-17
* device instance cc_CKIN_VCO_XD2_nm r0 *1 0,0
Ccc_CKIN_VCO_XD2_nm CKIN_VCO XD2.nm 1.8151e-17
* device instance cc_CKIN_VCO_XD2_nt r0 *1 0,0
Ccc_CKIN_VCO_XD2_nt CKIN_VCO XD2.nt 2.4201e-17
* device instance cc_CKIN_VCO_XD2_t1 r0 *1 0,0
Ccc_CKIN_VCO_XD2_t1 CKIN_VCO XD2.t1 1.21e-17
* device instance cc_CKIN_VCO_XD3_XDFFM_CLKB r0 *1 0,0
Ccc_CKIN_VCO_XD3_XDFFM_CLKB CKIN_VCO XD3.XDFFM.CLKB 1.8151e-17
* device instance cc_CKIN_VCO_XD3_XDFFM_M r0 *1 0,0
Ccc_CKIN_VCO_XD3_XDFFM_M CKIN_VCO XD3.XDFFM.M 2.4201e-17
* device instance cc_CKIN_VCO_XD3_XDFFM_MB r0 *1 0,0
Ccc_CKIN_VCO_XD3_XDFFM_MB CKIN_VCO XD3.XDFFM.MB 1.21e-17
* device instance cc_CKIN_VCO_XD3_XDFFM_S r0 *1 0,0
Ccc_CKIN_VCO_XD3_XDFFM_S CKIN_VCO XD3.XDFFM.S 1.8151e-17
* device instance cc_CKIN_VCO_XD3_XDFFM_SB r0 *1 0,0
Ccc_CKIN_VCO_XD3_XDFFM_SB CKIN_VCO XD3.XDFFM.SB 1.8151e-17
* device instance cc_CKIN_VCO_XD3_XDFFQ_CLKB r0 *1 0,0
Ccc_CKIN_VCO_XD3_XDFFQ_CLKB CKIN_VCO XD3.XDFFQ.CLKB 1.8151e-17
* device instance cc_CKIN_VCO_XD3_XDFFQ_M r0 *1 0,0
Ccc_CKIN_VCO_XD3_XDFFQ_M CKIN_VCO XD3.XDFFQ.M 2.4201e-17
* device instance cc_CKIN_VCO_XD3_XDFFQ_MB r0 *1 0,0
Ccc_CKIN_VCO_XD3_XDFFQ_MB CKIN_VCO XD3.XDFFQ.MB 1.21e-17
* device instance cc_CKIN_VCO_XD3_XDFFQ_S r0 *1 0,0
Ccc_CKIN_VCO_XD3_XDFFQ_S CKIN_VCO XD3.XDFFQ.S 1.8151e-17
* device instance cc_CKIN_VCO_XD3_XDFFQ_SB r0 *1 0,0
Ccc_CKIN_VCO_XD3_XDFFQ_SB CKIN_VCO XD3.XDFFQ.SB 1.8151e-17
* device instance cc_CKIN_VCO_XD3_XNOR_midp r0 *1 0,0
Ccc_CKIN_VCO_XD3_XNOR_midp CKIN_VCO XD3.XNOR.midp 1.21e-17
* device instance cc_CKIN_VCO_XD3_dmodout r0 *1 0,0
Ccc_CKIN_VCO_XD3_dmodout CKIN_VCO XD3.dmodout 1.21e-17
* device instance cc_CKIN_VCO_XD3_dq r0 *1 0,0
Ccc_CKIN_VCO_XD3_dq CKIN_VCO XD3.dq 1.21e-17
* device instance cc_CKIN_VCO_XD3_nm r0 *1 0,0
Ccc_CKIN_VCO_XD3_nm CKIN_VCO XD3.nm 1.8151e-17
* device instance cc_CKIN_VCO_XD3_nt r0 *1 0,0
Ccc_CKIN_VCO_XD3_nt CKIN_VCO XD3.nt 2.4201e-17
* device instance cc_CKIN_VCO_XD3_t1 r0 *1 0,0
Ccc_CKIN_VCO_XD3_t1 CKIN_VCO XD3.t1 1.21e-17
* device instance cc_CKIN_VCO_XD4_XDFFM_CLKB r0 *1 0,0
Ccc_CKIN_VCO_XD4_XDFFM_CLKB CKIN_VCO XD4.XDFFM.CLKB 1.8151e-17
* device instance cc_CKIN_VCO_XD4_XDFFM_M r0 *1 0,0
Ccc_CKIN_VCO_XD4_XDFFM_M CKIN_VCO XD4.XDFFM.M 2.4201e-17
* device instance cc_CKIN_VCO_XD4_XDFFM_MB r0 *1 0,0
Ccc_CKIN_VCO_XD4_XDFFM_MB CKIN_VCO XD4.XDFFM.MB 1.21e-17
* device instance cc_CKIN_VCO_XD4_XDFFM_S r0 *1 0,0
Ccc_CKIN_VCO_XD4_XDFFM_S CKIN_VCO XD4.XDFFM.S 1.8151e-17
* device instance cc_CKIN_VCO_XD4_XDFFM_SB r0 *1 0,0
Ccc_CKIN_VCO_XD4_XDFFM_SB CKIN_VCO XD4.XDFFM.SB 1.8151e-17
* device instance cc_CKIN_VCO_XD4_XDFFQ_CLKB r0 *1 0,0
Ccc_CKIN_VCO_XD4_XDFFQ_CLKB CKIN_VCO XD4.XDFFQ.CLKB 1.8151e-17
* device instance cc_CKIN_VCO_XD4_XDFFQ_M r0 *1 0,0
Ccc_CKIN_VCO_XD4_XDFFQ_M CKIN_VCO XD4.XDFFQ.M 2.4201e-17
* device instance cc_CKIN_VCO_XD4_XDFFQ_MB r0 *1 0,0
Ccc_CKIN_VCO_XD4_XDFFQ_MB CKIN_VCO XD4.XDFFQ.MB 1.21e-17
* device instance cc_CKIN_VCO_XD4_XDFFQ_S r0 *1 0,0
Ccc_CKIN_VCO_XD4_XDFFQ_S CKIN_VCO XD4.XDFFQ.S 1.8151e-17
* device instance cc_CKIN_VCO_XD4_XDFFQ_SB r0 *1 0,0
Ccc_CKIN_VCO_XD4_XDFFQ_SB CKIN_VCO XD4.XDFFQ.SB 1.8151e-17
* device instance cc_CKIN_VCO_XD4_XNOR_midp r0 *1 0,0
Ccc_CKIN_VCO_XD4_XNOR_midp CKIN_VCO XD4.XNOR.midp 1.21e-17
* device instance cc_CKIN_VCO_XD4_dmodout r0 *1 0,0
Ccc_CKIN_VCO_XD4_dmodout CKIN_VCO XD4.dmodout 1.21e-17
* device instance cc_CKIN_VCO_XD4_dq r0 *1 0,0
Ccc_CKIN_VCO_XD4_dq CKIN_VCO XD4.dq 1.21e-17
* device instance cc_CKIN_VCO_XD4_nm r0 *1 0,0
Ccc_CKIN_VCO_XD4_nm CKIN_VCO XD4.nm 1.8151e-17
* device instance cc_CKIN_VCO_XD4_nt r0 *1 0,0
Ccc_CKIN_VCO_XD4_nt CKIN_VCO XD4.nt 2.4201e-17
* device instance cc_CKIN_VCO_XD4_t1 r0 *1 0,0
Ccc_CKIN_VCO_XD4_t1 CKIN_VCO XD4.t1 1.21e-17
* device instance cc_CKIN_VCO_XD5_XDFFM_CLKB r0 *1 0,0
Ccc_CKIN_VCO_XD5_XDFFM_CLKB CKIN_VCO XD5.XDFFM.CLKB 1.8151e-17
* device instance cc_CKIN_VCO_XD5_XDFFM_M r0 *1 0,0
Ccc_CKIN_VCO_XD5_XDFFM_M CKIN_VCO XD5.XDFFM.M 2.4201e-17
* device instance cc_CKIN_VCO_XD5_XDFFM_MB r0 *1 0,0
Ccc_CKIN_VCO_XD5_XDFFM_MB CKIN_VCO XD5.XDFFM.MB 1.21e-17
* device instance cc_CKIN_VCO_XD5_XDFFM_S r0 *1 0,0
Ccc_CKIN_VCO_XD5_XDFFM_S CKIN_VCO XD5.XDFFM.S 1.8151e-17
* device instance cc_CKIN_VCO_XD5_XDFFM_SB r0 *1 0,0
Ccc_CKIN_VCO_XD5_XDFFM_SB CKIN_VCO XD5.XDFFM.SB 1.8151e-17
* device instance cc_CKIN_VCO_XD5_XDFFQ_CLKB r0 *1 0,0
Ccc_CKIN_VCO_XD5_XDFFQ_CLKB CKIN_VCO XD5.XDFFQ.CLKB 1.8151e-17
* device instance cc_CKIN_VCO_XD5_XDFFQ_M r0 *1 0,0
Ccc_CKIN_VCO_XD5_XDFFQ_M CKIN_VCO XD5.XDFFQ.M 2.4201e-17
* device instance cc_CKIN_VCO_XD5_XDFFQ_MB r0 *1 0,0
Ccc_CKIN_VCO_XD5_XDFFQ_MB CKIN_VCO XD5.XDFFQ.MB 1.21e-17
* device instance cc_CKIN_VCO_XD5_XDFFQ_S r0 *1 0,0
Ccc_CKIN_VCO_XD5_XDFFQ_S CKIN_VCO XD5.XDFFQ.S 1.8151e-17
* device instance cc_CKIN_VCO_XD5_XDFFQ_SB r0 *1 0,0
Ccc_CKIN_VCO_XD5_XDFFQ_SB CKIN_VCO XD5.XDFFQ.SB 1.8151e-17
* device instance cc_CKIN_VCO_XD5_XNOR_midp r0 *1 0,0
Ccc_CKIN_VCO_XD5_XNOR_midp CKIN_VCO XD5.XNOR.midp 1.21e-17
* device instance cc_CKIN_VCO_XD5_dmodout r0 *1 0,0
Ccc_CKIN_VCO_XD5_dmodout CKIN_VCO XD5.dmodout 1.21e-17
* device instance cc_CKIN_VCO_XD5_dq r0 *1 0,0
Ccc_CKIN_VCO_XD5_dq CKIN_VCO XD5.dq 1.21e-17
* device instance cc_CKIN_VCO_XD5_nm r0 *1 0,0
Ccc_CKIN_VCO_XD5_nm CKIN_VCO XD5.nm 1.8151e-17
* device instance cc_CKIN_VCO_XD5_nt r0 *1 0,0
Ccc_CKIN_VCO_XD5_nt CKIN_VCO XD5.nt 2.4201e-17
* device instance cc_CKIN_VCO_XD5_t1 r0 *1 0,0
Ccc_CKIN_VCO_XD5_t1 CKIN_VCO XD5.t1 1.21e-17
* device instance cc_CKIN_VCO_XFRT_CLKB r0 *1 0,0
Ccc_CKIN_VCO_XFRT_CLKB CKIN_VCO XFRT.CLKB 3.6302e-17
* device instance cc_CKIN_VCO_XFRT_M r0 *1 0,0
Ccc_CKIN_VCO_XFRT_M CKIN_VCO XFRT.M 4.8402e-17
* device instance cc_CKIN_VCO_XFRT_MB r0 *1 0,0
Ccc_CKIN_VCO_XFRT_MB CKIN_VCO XFRT.MB 2.4201e-17
* device instance cc_CKIN_VCO_XFRT_S r0 *1 0,0
Ccc_CKIN_VCO_XFRT_S CKIN_VCO XFRT.S 3.0251e-17
* device instance cc_CKIN_VCO_XFRT_SB r0 *1 0,0
Ccc_CKIN_VCO_XFRT_SB CKIN_VCO XFRT.SB 2.4201e-17
* device instance cc_CKIN_VCO_ck1 r0 *1 0,0
Ccc_CKIN_VCO_ck1 CKIN_VCO ck1 5.4452e-17
* device instance cc_CKIN_VCO_ck2 r0 *1 0,0
Ccc_CKIN_VCO_ck2 CKIN_VCO ck2 5.4452e-17
* device instance cc_CKIN_VCO_ck3 r0 *1 0,0
Ccc_CKIN_VCO_ck3 CKIN_VCO ck3 5.4452e-17
* device instance cc_CKIN_VCO_ck4 r0 *1 0,0
Ccc_CKIN_VCO_ck4 CKIN_VCO ck4 5.4452e-17
* device instance cc_CKIN_VCO_ck5 r0 *1 0,0
Ccc_CKIN_VCO_ck5 CKIN_VCO ck5 5.4452e-17
* device instance cc_CKIN_VCO_mod0 r0 *1 0,0
Ccc_CKIN_VCO_mod0 CKIN_VCO mod0 2.4201e-17
* device instance cc_CKIN_VCO_mod1 r0 *1 0,0
Ccc_CKIN_VCO_mod1 CKIN_VCO mod1 2.4201e-17
* device instance cc_CKIN_VCO_mod2 r0 *1 0,0
Ccc_CKIN_VCO_mod2 CKIN_VCO mod2 2.4201e-17
* device instance cc_CKIN_VCO_mod3 r0 *1 0,0
Ccc_CKIN_VCO_mod3 CKIN_VCO mod3 2.4201e-17
* device instance cc_CKIN_VCO_mod4 r0 *1 0,0
Ccc_CKIN_VCO_mod4 CKIN_VCO mod4 2.4201e-17
* device instance cc_CKIN_VCO_net1 r0 *1 0,0
Ccc_CKIN_VCO_net1 CKIN_VCO net1 1.21e-17
* device instance cc_DIVOUT_FB r0 *1 0,0
Ccc_DIVOUT_FB DIVOUT FB 6.05e-18
* device instance cc_DIVOUT_P0 r0 *1 0,0
Ccc_DIVOUT_P0 DIVOUT P0 6.05e-18
* device instance cc_DIVOUT_P1 r0 *1 0,0
Ccc_DIVOUT_P1 DIVOUT P1 6.05e-18
* device instance cc_DIVOUT_P2 r0 *1 0,0
Ccc_DIVOUT_P2 DIVOUT P2 6.05e-18
* device instance cc_DIVOUT_P3 r0 *1 0,0
Ccc_DIVOUT_P3 DIVOUT P3 6.05e-18
* device instance cc_DIVOUT_P4 r0 *1 0,0
Ccc_DIVOUT_P4 DIVOUT P4 6.05e-18
* device instance cc_DIVOUT_P5 r0 *1 0,0
Ccc_DIVOUT_P5 DIVOUT P5 6.05e-18
* device instance cc_DIVOUT_VDD_DIV r0 *1 0,0
Ccc_DIVOUT_VDD_DIV DIVOUT VDD_DIV 6.16319e-16
* device instance cc_DIVOUT_VSS r0 *1 0,0
Ccc_DIVOUT_VSS DIVOUT VSS 1.02048e-16
* device instance cc_DIVOUT_XD0_XDFFM_CLKB r0 *1 0,0
Ccc_DIVOUT_XD0_XDFFM_CLKB DIVOUT XD0.XDFFM.CLKB 1.8151e-17
* device instance cc_DIVOUT_XD0_XDFFM_M r0 *1 0,0
Ccc_DIVOUT_XD0_XDFFM_M DIVOUT XD0.XDFFM.M 2.4201e-17
* device instance cc_DIVOUT_XD0_XDFFM_MB r0 *1 0,0
Ccc_DIVOUT_XD0_XDFFM_MB DIVOUT XD0.XDFFM.MB 1.21e-17
* device instance cc_DIVOUT_XD0_XDFFM_S r0 *1 0,0
Ccc_DIVOUT_XD0_XDFFM_S DIVOUT XD0.XDFFM.S 1.8151e-17
* device instance cc_DIVOUT_XD0_XDFFM_SB r0 *1 0,0
Ccc_DIVOUT_XD0_XDFFM_SB DIVOUT XD0.XDFFM.SB 1.8151e-17
* device instance cc_DIVOUT_XD0_XDFFQ_CLKB r0 *1 0,0
Ccc_DIVOUT_XD0_XDFFQ_CLKB DIVOUT XD0.XDFFQ.CLKB 1.8151e-17
* device instance cc_DIVOUT_XD0_XDFFQ_M r0 *1 0,0
Ccc_DIVOUT_XD0_XDFFQ_M DIVOUT XD0.XDFFQ.M 2.4201e-17
* device instance cc_DIVOUT_XD0_XDFFQ_MB r0 *1 0,0
Ccc_DIVOUT_XD0_XDFFQ_MB DIVOUT XD0.XDFFQ.MB 1.21e-17
* device instance cc_DIVOUT_XD0_XDFFQ_S r0 *1 0,0
Ccc_DIVOUT_XD0_XDFFQ_S DIVOUT XD0.XDFFQ.S 1.8151e-17
* device instance cc_DIVOUT_XD0_XDFFQ_SB r0 *1 0,0
Ccc_DIVOUT_XD0_XDFFQ_SB DIVOUT XD0.XDFFQ.SB 1.8151e-17
* device instance cc_DIVOUT_XD0_XNOR_midp r0 *1 0,0
Ccc_DIVOUT_XD0_XNOR_midp DIVOUT XD0.XNOR.midp 1.21e-17
* device instance cc_DIVOUT_XD0_dmodout r0 *1 0,0
Ccc_DIVOUT_XD0_dmodout DIVOUT XD0.dmodout 1.21e-17
* device instance cc_DIVOUT_XD0_dq r0 *1 0,0
Ccc_DIVOUT_XD0_dq DIVOUT XD0.dq 1.21e-17
* device instance cc_DIVOUT_XD0_nm r0 *1 0,0
Ccc_DIVOUT_XD0_nm DIVOUT XD0.nm 1.8151e-17
* device instance cc_DIVOUT_XD0_nt r0 *1 0,0
Ccc_DIVOUT_XD0_nt DIVOUT XD0.nt 2.4201e-17
* device instance cc_DIVOUT_XD0_t1 r0 *1 0,0
Ccc_DIVOUT_XD0_t1 DIVOUT XD0.t1 1.21e-17
* device instance cc_DIVOUT_XD1_XDFFM_CLKB r0 *1 0,0
Ccc_DIVOUT_XD1_XDFFM_CLKB DIVOUT XD1.XDFFM.CLKB 1.8151e-17
* device instance cc_DIVOUT_XD1_XDFFM_M r0 *1 0,0
Ccc_DIVOUT_XD1_XDFFM_M DIVOUT XD1.XDFFM.M 2.4201e-17
* device instance cc_DIVOUT_XD1_XDFFM_MB r0 *1 0,0
Ccc_DIVOUT_XD1_XDFFM_MB DIVOUT XD1.XDFFM.MB 1.21e-17
* device instance cc_DIVOUT_XD1_XDFFM_S r0 *1 0,0
Ccc_DIVOUT_XD1_XDFFM_S DIVOUT XD1.XDFFM.S 1.8151e-17
* device instance cc_DIVOUT_XD1_XDFFM_SB r0 *1 0,0
Ccc_DIVOUT_XD1_XDFFM_SB DIVOUT XD1.XDFFM.SB 1.8151e-17
* device instance cc_DIVOUT_XD1_XDFFQ_CLKB r0 *1 0,0
Ccc_DIVOUT_XD1_XDFFQ_CLKB DIVOUT XD1.XDFFQ.CLKB 1.8151e-17
* device instance cc_DIVOUT_XD1_XDFFQ_M r0 *1 0,0
Ccc_DIVOUT_XD1_XDFFQ_M DIVOUT XD1.XDFFQ.M 2.4201e-17
* device instance cc_DIVOUT_XD1_XDFFQ_MB r0 *1 0,0
Ccc_DIVOUT_XD1_XDFFQ_MB DIVOUT XD1.XDFFQ.MB 1.21e-17
* device instance cc_DIVOUT_XD1_XDFFQ_S r0 *1 0,0
Ccc_DIVOUT_XD1_XDFFQ_S DIVOUT XD1.XDFFQ.S 1.8151e-17
* device instance cc_DIVOUT_XD1_XDFFQ_SB r0 *1 0,0
Ccc_DIVOUT_XD1_XDFFQ_SB DIVOUT XD1.XDFFQ.SB 1.8151e-17
* device instance cc_DIVOUT_XD1_XNOR_midp r0 *1 0,0
Ccc_DIVOUT_XD1_XNOR_midp DIVOUT XD1.XNOR.midp 1.21e-17
* device instance cc_DIVOUT_XD1_dmodout r0 *1 0,0
Ccc_DIVOUT_XD1_dmodout DIVOUT XD1.dmodout 1.21e-17
* device instance cc_DIVOUT_XD1_dq r0 *1 0,0
Ccc_DIVOUT_XD1_dq DIVOUT XD1.dq 1.21e-17
* device instance cc_DIVOUT_XD1_nm r0 *1 0,0
Ccc_DIVOUT_XD1_nm DIVOUT XD1.nm 1.8151e-17
* device instance cc_DIVOUT_XD1_nt r0 *1 0,0
Ccc_DIVOUT_XD1_nt DIVOUT XD1.nt 2.4201e-17
* device instance cc_DIVOUT_XD1_t1 r0 *1 0,0
Ccc_DIVOUT_XD1_t1 DIVOUT XD1.t1 1.21e-17
* device instance cc_DIVOUT_XD2_XDFFM_CLKB r0 *1 0,0
Ccc_DIVOUT_XD2_XDFFM_CLKB DIVOUT XD2.XDFFM.CLKB 1.8151e-17
* device instance cc_DIVOUT_XD2_XDFFM_M r0 *1 0,0
Ccc_DIVOUT_XD2_XDFFM_M DIVOUT XD2.XDFFM.M 2.4201e-17
* device instance cc_DIVOUT_XD2_XDFFM_MB r0 *1 0,0
Ccc_DIVOUT_XD2_XDFFM_MB DIVOUT XD2.XDFFM.MB 1.21e-17
* device instance cc_DIVOUT_XD2_XDFFM_S r0 *1 0,0
Ccc_DIVOUT_XD2_XDFFM_S DIVOUT XD2.XDFFM.S 1.8151e-17
* device instance cc_DIVOUT_XD2_XDFFM_SB r0 *1 0,0
Ccc_DIVOUT_XD2_XDFFM_SB DIVOUT XD2.XDFFM.SB 1.8151e-17
* device instance cc_DIVOUT_XD2_XDFFQ_CLKB r0 *1 0,0
Ccc_DIVOUT_XD2_XDFFQ_CLKB DIVOUT XD2.XDFFQ.CLKB 1.8151e-17
* device instance cc_DIVOUT_XD2_XDFFQ_M r0 *1 0,0
Ccc_DIVOUT_XD2_XDFFQ_M DIVOUT XD2.XDFFQ.M 2.4201e-17
* device instance cc_DIVOUT_XD2_XDFFQ_MB r0 *1 0,0
Ccc_DIVOUT_XD2_XDFFQ_MB DIVOUT XD2.XDFFQ.MB 1.21e-17
* device instance cc_DIVOUT_XD2_XDFFQ_S r0 *1 0,0
Ccc_DIVOUT_XD2_XDFFQ_S DIVOUT XD2.XDFFQ.S 1.8151e-17
* device instance cc_DIVOUT_XD2_XDFFQ_SB r0 *1 0,0
Ccc_DIVOUT_XD2_XDFFQ_SB DIVOUT XD2.XDFFQ.SB 1.8151e-17
* device instance cc_DIVOUT_XD2_XNOR_midp r0 *1 0,0
Ccc_DIVOUT_XD2_XNOR_midp DIVOUT XD2.XNOR.midp 1.21e-17
* device instance cc_DIVOUT_XD2_dmodout r0 *1 0,0
Ccc_DIVOUT_XD2_dmodout DIVOUT XD2.dmodout 1.21e-17
* device instance cc_DIVOUT_XD2_dq r0 *1 0,0
Ccc_DIVOUT_XD2_dq DIVOUT XD2.dq 1.21e-17
* device instance cc_DIVOUT_XD2_nm r0 *1 0,0
Ccc_DIVOUT_XD2_nm DIVOUT XD2.nm 1.8151e-17
* device instance cc_DIVOUT_XD2_nt r0 *1 0,0
Ccc_DIVOUT_XD2_nt DIVOUT XD2.nt 2.4201e-17
* device instance cc_DIVOUT_XD2_t1 r0 *1 0,0
Ccc_DIVOUT_XD2_t1 DIVOUT XD2.t1 1.21e-17
* device instance cc_DIVOUT_XD3_XDFFM_CLKB r0 *1 0,0
Ccc_DIVOUT_XD3_XDFFM_CLKB DIVOUT XD3.XDFFM.CLKB 1.8151e-17
* device instance cc_DIVOUT_XD3_XDFFM_M r0 *1 0,0
Ccc_DIVOUT_XD3_XDFFM_M DIVOUT XD3.XDFFM.M 2.4201e-17
* device instance cc_DIVOUT_XD3_XDFFM_MB r0 *1 0,0
Ccc_DIVOUT_XD3_XDFFM_MB DIVOUT XD3.XDFFM.MB 1.21e-17
* device instance cc_DIVOUT_XD3_XDFFM_S r0 *1 0,0
Ccc_DIVOUT_XD3_XDFFM_S DIVOUT XD3.XDFFM.S 1.8151e-17
* device instance cc_DIVOUT_XD3_XDFFM_SB r0 *1 0,0
Ccc_DIVOUT_XD3_XDFFM_SB DIVOUT XD3.XDFFM.SB 1.8151e-17
* device instance cc_DIVOUT_XD3_XDFFQ_CLKB r0 *1 0,0
Ccc_DIVOUT_XD3_XDFFQ_CLKB DIVOUT XD3.XDFFQ.CLKB 1.8151e-17
* device instance cc_DIVOUT_XD3_XDFFQ_M r0 *1 0,0
Ccc_DIVOUT_XD3_XDFFQ_M DIVOUT XD3.XDFFQ.M 2.4201e-17
* device instance cc_DIVOUT_XD3_XDFFQ_MB r0 *1 0,0
Ccc_DIVOUT_XD3_XDFFQ_MB DIVOUT XD3.XDFFQ.MB 1.21e-17
* device instance cc_DIVOUT_XD3_XDFFQ_S r0 *1 0,0
Ccc_DIVOUT_XD3_XDFFQ_S DIVOUT XD3.XDFFQ.S 1.8151e-17
* device instance cc_DIVOUT_XD3_XDFFQ_SB r0 *1 0,0
Ccc_DIVOUT_XD3_XDFFQ_SB DIVOUT XD3.XDFFQ.SB 1.8151e-17
* device instance cc_DIVOUT_XD3_XNOR_midp r0 *1 0,0
Ccc_DIVOUT_XD3_XNOR_midp DIVOUT XD3.XNOR.midp 1.21e-17
* device instance cc_DIVOUT_XD3_dmodout r0 *1 0,0
Ccc_DIVOUT_XD3_dmodout DIVOUT XD3.dmodout 1.21e-17
* device instance cc_DIVOUT_XD3_dq r0 *1 0,0
Ccc_DIVOUT_XD3_dq DIVOUT XD3.dq 1.21e-17
* device instance cc_DIVOUT_XD3_nm r0 *1 0,0
Ccc_DIVOUT_XD3_nm DIVOUT XD3.nm 1.8151e-17
* device instance cc_DIVOUT_XD3_nt r0 *1 0,0
Ccc_DIVOUT_XD3_nt DIVOUT XD3.nt 2.4201e-17
* device instance cc_DIVOUT_XD3_t1 r0 *1 0,0
Ccc_DIVOUT_XD3_t1 DIVOUT XD3.t1 1.21e-17
* device instance cc_DIVOUT_XD4_XDFFM_CLKB r0 *1 0,0
Ccc_DIVOUT_XD4_XDFFM_CLKB DIVOUT XD4.XDFFM.CLKB 1.8151e-17
* device instance cc_DIVOUT_XD4_XDFFM_M r0 *1 0,0
Ccc_DIVOUT_XD4_XDFFM_M DIVOUT XD4.XDFFM.M 2.4201e-17
* device instance cc_DIVOUT_XD4_XDFFM_MB r0 *1 0,0
Ccc_DIVOUT_XD4_XDFFM_MB DIVOUT XD4.XDFFM.MB 1.21e-17
* device instance cc_DIVOUT_XD4_XDFFM_S r0 *1 0,0
Ccc_DIVOUT_XD4_XDFFM_S DIVOUT XD4.XDFFM.S 1.8151e-17
* device instance cc_DIVOUT_XD4_XDFFM_SB r0 *1 0,0
Ccc_DIVOUT_XD4_XDFFM_SB DIVOUT XD4.XDFFM.SB 1.8151e-17
* device instance cc_DIVOUT_XD4_XDFFQ_CLKB r0 *1 0,0
Ccc_DIVOUT_XD4_XDFFQ_CLKB DIVOUT XD4.XDFFQ.CLKB 1.8151e-17
* device instance cc_DIVOUT_XD4_XDFFQ_M r0 *1 0,0
Ccc_DIVOUT_XD4_XDFFQ_M DIVOUT XD4.XDFFQ.M 2.4201e-17
* device instance cc_DIVOUT_XD4_XDFFQ_MB r0 *1 0,0
Ccc_DIVOUT_XD4_XDFFQ_MB DIVOUT XD4.XDFFQ.MB 1.21e-17
* device instance cc_DIVOUT_XD4_XDFFQ_S r0 *1 0,0
Ccc_DIVOUT_XD4_XDFFQ_S DIVOUT XD4.XDFFQ.S 1.8151e-17
* device instance cc_DIVOUT_XD4_XDFFQ_SB r0 *1 0,0
Ccc_DIVOUT_XD4_XDFFQ_SB DIVOUT XD4.XDFFQ.SB 1.8151e-17
* device instance cc_DIVOUT_XD4_XNOR_midp r0 *1 0,0
Ccc_DIVOUT_XD4_XNOR_midp DIVOUT XD4.XNOR.midp 1.21e-17
* device instance cc_DIVOUT_XD4_dmodout r0 *1 0,0
Ccc_DIVOUT_XD4_dmodout DIVOUT XD4.dmodout 1.21e-17
* device instance cc_DIVOUT_XD4_dq r0 *1 0,0
Ccc_DIVOUT_XD4_dq DIVOUT XD4.dq 1.21e-17
* device instance cc_DIVOUT_XD4_nm r0 *1 0,0
Ccc_DIVOUT_XD4_nm DIVOUT XD4.nm 1.8151e-17
* device instance cc_DIVOUT_XD4_nt r0 *1 0,0
Ccc_DIVOUT_XD4_nt DIVOUT XD4.nt 2.4201e-17
* device instance cc_DIVOUT_XD4_t1 r0 *1 0,0
Ccc_DIVOUT_XD4_t1 DIVOUT XD4.t1 1.21e-17
* device instance cc_DIVOUT_XD5_XDFFM_CLKB r0 *1 0,0
Ccc_DIVOUT_XD5_XDFFM_CLKB DIVOUT XD5.XDFFM.CLKB 3.6302e-17
* device instance cc_DIVOUT_XD5_XDFFM_M r0 *1 0,0
Ccc_DIVOUT_XD5_XDFFM_M DIVOUT XD5.XDFFM.M 4.8402e-17
* device instance cc_DIVOUT_XD5_XDFFM_MB r0 *1 0,0
Ccc_DIVOUT_XD5_XDFFM_MB DIVOUT XD5.XDFFM.MB 2.4201e-17
* device instance cc_DIVOUT_XD5_XDFFM_S r0 *1 0,0
Ccc_DIVOUT_XD5_XDFFM_S DIVOUT XD5.XDFFM.S 3.6302e-17
* device instance cc_DIVOUT_XD5_XDFFM_SB r0 *1 0,0
Ccc_DIVOUT_XD5_XDFFM_SB DIVOUT XD5.XDFFM.SB 3.6302e-17
* device instance cc_DIVOUT_XD5_XDFFQ_CLKB r0 *1 0,0
Ccc_DIVOUT_XD5_XDFFQ_CLKB DIVOUT XD5.XDFFQ.CLKB 3.6302e-17
* device instance cc_DIVOUT_XD5_XDFFQ_M r0 *1 0,0
Ccc_DIVOUT_XD5_XDFFQ_M DIVOUT XD5.XDFFQ.M 4.8402e-17
* device instance cc_DIVOUT_XD5_XDFFQ_MB r0 *1 0,0
Ccc_DIVOUT_XD5_XDFFQ_MB DIVOUT XD5.XDFFQ.MB 2.4201e-17
* device instance cc_DIVOUT_XD5_XDFFQ_S r0 *1 0,0
Ccc_DIVOUT_XD5_XDFFQ_S DIVOUT XD5.XDFFQ.S 3.6302e-17
* device instance cc_DIVOUT_XD5_XDFFQ_SB r0 *1 0,0
Ccc_DIVOUT_XD5_XDFFQ_SB DIVOUT XD5.XDFFQ.SB 3.6302e-17
* device instance cc_DIVOUT_XD5_XN2_mid1 r0 *1 0,0
Ccc_DIVOUT_XD5_XN2_mid1 DIVOUT XD5.XN2.mid1 1.21e-17
* device instance cc_DIVOUT_XD5_XNOR_midp r0 *1 0,0
Ccc_DIVOUT_XD5_XNOR_midp DIVOUT XD5.XNOR.midp 1.21e-17
* device instance cc_DIVOUT_XD5_dmodout r0 *1 0,0
Ccc_DIVOUT_XD5_dmodout DIVOUT XD5.dmodout 2.4201e-17
* device instance cc_DIVOUT_XD5_dq r0 *1 0,0
Ccc_DIVOUT_XD5_dq DIVOUT XD5.dq 3.0251e-17
* device instance cc_DIVOUT_XD5_nm r0 *1 0,0
Ccc_DIVOUT_XD5_nm DIVOUT XD5.nm 3.0251e-17
* device instance cc_DIVOUT_XD5_nt r0 *1 0,0
Ccc_DIVOUT_XD5_nt DIVOUT XD5.nt 2.4201e-17
* device instance cc_DIVOUT_XD5_t1 r0 *1 0,0
Ccc_DIVOUT_XD5_t1 DIVOUT XD5.t1 1.8151e-17
* device instance cc_DIVOUT_XFRT_CLKB r0 *1 0,0
Ccc_DIVOUT_XFRT_CLKB DIVOUT XFRT.CLKB 2.4201e-17
* device instance cc_DIVOUT_XFRT_M r0 *1 0,0
Ccc_DIVOUT_XFRT_M DIVOUT XFRT.M 3.4688e-17
* device instance cc_DIVOUT_XFRT_MB r0 *1 0,0
Ccc_DIVOUT_XFRT_MB DIVOUT XFRT.MB 1.21e-17
* device instance cc_DIVOUT_XFRT_S r0 *1 0,0
Ccc_DIVOUT_XFRT_S DIVOUT XFRT.S 1.8151e-17
* device instance cc_DIVOUT_XFRT_SB r0 *1 0,0
Ccc_DIVOUT_XFRT_SB DIVOUT XFRT.SB 1.8151e-17
* device instance cc_DIVOUT_ck1 r0 *1 0,0
Ccc_DIVOUT_ck1 DIVOUT ck1 5.4452e-17
* device instance cc_DIVOUT_ck2 r0 *1 0,0
Ccc_DIVOUT_ck2 DIVOUT ck2 5.4452e-17
* device instance cc_DIVOUT_ck3 r0 *1 0,0
Ccc_DIVOUT_ck3 DIVOUT ck3 5.4452e-17
* device instance cc_DIVOUT_ck4 r0 *1 0,0
Ccc_DIVOUT_ck4 DIVOUT ck4 5.4452e-17
* device instance cc_DIVOUT_ck5 r0 *1 0,0
Ccc_DIVOUT_ck5 DIVOUT ck5 9.0754e-17
* device instance cc_DIVOUT_mod0 r0 *1 0,0
Ccc_DIVOUT_mod0 DIVOUT mod0 2.4201e-17
* device instance cc_DIVOUT_mod1 r0 *1 0,0
Ccc_DIVOUT_mod1 DIVOUT mod1 2.4201e-17
* device instance cc_DIVOUT_mod2 r0 *1 0,0
Ccc_DIVOUT_mod2 DIVOUT mod2 2.4201e-17
* device instance cc_DIVOUT_mod3 r0 *1 0,0
Ccc_DIVOUT_mod3 DIVOUT mod3 2.4201e-17
* device instance cc_DIVOUT_mod4 r0 *1 0,0
Ccc_DIVOUT_mod4 DIVOUT mod4 3.0251e-17
* device instance cc_DIVOUT_net1 r0 *1 0,0
Ccc_DIVOUT_net1 DIVOUT net1 1.21e-17
* device instance cc_FB_P0 r0 *1 0,0
Ccc_FB_P0 FB P0 6.05e-18
* device instance cc_FB_P1 r0 *1 0,0
Ccc_FB_P1 FB P1 6.05e-18
* device instance cc_FB_P2 r0 *1 0,0
Ccc_FB_P2 FB P2 6.05e-18
* device instance cc_FB_P3 r0 *1 0,0
Ccc_FB_P3 FB P3 6.05e-18
* device instance cc_FB_P4 r0 *1 0,0
Ccc_FB_P4 FB P4 6.05e-18
* device instance cc_FB_P5 r0 *1 0,0
Ccc_FB_P5 FB P5 6.05e-18
* device instance cc_FB_VDD_DIV r0 *1 0,0
Ccc_FB_VDD_DIV FB VDD_DIV 6.28419e-16
* device instance cc_FB_VSS r0 *1 0,0
Ccc_FB_VSS FB VSS 5.244e-18
* device instance cc_FB_XD0_XDFFM_CLKB r0 *1 0,0
Ccc_FB_XD0_XDFFM_CLKB FB XD0.XDFFM.CLKB 1.8151e-17
* device instance cc_FB_XD0_XDFFM_M r0 *1 0,0
Ccc_FB_XD0_XDFFM_M FB XD0.XDFFM.M 2.4201e-17
* device instance cc_FB_XD0_XDFFM_MB r0 *1 0,0
Ccc_FB_XD0_XDFFM_MB FB XD0.XDFFM.MB 1.21e-17
* device instance cc_FB_XD0_XDFFM_S r0 *1 0,0
Ccc_FB_XD0_XDFFM_S FB XD0.XDFFM.S 1.8151e-17
* device instance cc_FB_XD0_XDFFM_SB r0 *1 0,0
Ccc_FB_XD0_XDFFM_SB FB XD0.XDFFM.SB 1.8151e-17
* device instance cc_FB_XD0_XDFFQ_CLKB r0 *1 0,0
Ccc_FB_XD0_XDFFQ_CLKB FB XD0.XDFFQ.CLKB 1.8151e-17
* device instance cc_FB_XD0_XDFFQ_M r0 *1 0,0
Ccc_FB_XD0_XDFFQ_M FB XD0.XDFFQ.M 2.4201e-17
* device instance cc_FB_XD0_XDFFQ_MB r0 *1 0,0
Ccc_FB_XD0_XDFFQ_MB FB XD0.XDFFQ.MB 1.21e-17
* device instance cc_FB_XD0_XDFFQ_S r0 *1 0,0
Ccc_FB_XD0_XDFFQ_S FB XD0.XDFFQ.S 1.8151e-17
* device instance cc_FB_XD0_XDFFQ_SB r0 *1 0,0
Ccc_FB_XD0_XDFFQ_SB FB XD0.XDFFQ.SB 1.8151e-17
* device instance cc_FB_XD0_XNOR_midp r0 *1 0,0
Ccc_FB_XD0_XNOR_midp FB XD0.XNOR.midp 1.21e-17
* device instance cc_FB_XD0_dmodout r0 *1 0,0
Ccc_FB_XD0_dmodout FB XD0.dmodout 1.21e-17
* device instance cc_FB_XD0_dq r0 *1 0,0
Ccc_FB_XD0_dq FB XD0.dq 1.21e-17
* device instance cc_FB_XD0_nm r0 *1 0,0
Ccc_FB_XD0_nm FB XD0.nm 1.8151e-17
* device instance cc_FB_XD0_nt r0 *1 0,0
Ccc_FB_XD0_nt FB XD0.nt 2.4201e-17
* device instance cc_FB_XD0_t1 r0 *1 0,0
Ccc_FB_XD0_t1 FB XD0.t1 1.21e-17
* device instance cc_FB_XD1_XDFFM_CLKB r0 *1 0,0
Ccc_FB_XD1_XDFFM_CLKB FB XD1.XDFFM.CLKB 1.8151e-17
* device instance cc_FB_XD1_XDFFM_M r0 *1 0,0
Ccc_FB_XD1_XDFFM_M FB XD1.XDFFM.M 2.4201e-17
* device instance cc_FB_XD1_XDFFM_MB r0 *1 0,0
Ccc_FB_XD1_XDFFM_MB FB XD1.XDFFM.MB 1.21e-17
* device instance cc_FB_XD1_XDFFM_S r0 *1 0,0
Ccc_FB_XD1_XDFFM_S FB XD1.XDFFM.S 1.8151e-17
* device instance cc_FB_XD1_XDFFM_SB r0 *1 0,0
Ccc_FB_XD1_XDFFM_SB FB XD1.XDFFM.SB 1.8151e-17
* device instance cc_FB_XD1_XDFFQ_CLKB r0 *1 0,0
Ccc_FB_XD1_XDFFQ_CLKB FB XD1.XDFFQ.CLKB 1.8151e-17
* device instance cc_FB_XD1_XDFFQ_M r0 *1 0,0
Ccc_FB_XD1_XDFFQ_M FB XD1.XDFFQ.M 2.4201e-17
* device instance cc_FB_XD1_XDFFQ_MB r0 *1 0,0
Ccc_FB_XD1_XDFFQ_MB FB XD1.XDFFQ.MB 1.21e-17
* device instance cc_FB_XD1_XDFFQ_S r0 *1 0,0
Ccc_FB_XD1_XDFFQ_S FB XD1.XDFFQ.S 1.8151e-17
* device instance cc_FB_XD1_XDFFQ_SB r0 *1 0,0
Ccc_FB_XD1_XDFFQ_SB FB XD1.XDFFQ.SB 1.8151e-17
* device instance cc_FB_XD1_XNOR_midp r0 *1 0,0
Ccc_FB_XD1_XNOR_midp FB XD1.XNOR.midp 1.21e-17
* device instance cc_FB_XD1_dmodout r0 *1 0,0
Ccc_FB_XD1_dmodout FB XD1.dmodout 1.21e-17
* device instance cc_FB_XD1_dq r0 *1 0,0
Ccc_FB_XD1_dq FB XD1.dq 1.21e-17
* device instance cc_FB_XD1_nm r0 *1 0,0
Ccc_FB_XD1_nm FB XD1.nm 1.8151e-17
* device instance cc_FB_XD1_nt r0 *1 0,0
Ccc_FB_XD1_nt FB XD1.nt 2.4201e-17
* device instance cc_FB_XD1_t1 r0 *1 0,0
Ccc_FB_XD1_t1 FB XD1.t1 1.21e-17
* device instance cc_FB_XD2_XDFFM_CLKB r0 *1 0,0
Ccc_FB_XD2_XDFFM_CLKB FB XD2.XDFFM.CLKB 1.8151e-17
* device instance cc_FB_XD2_XDFFM_M r0 *1 0,0
Ccc_FB_XD2_XDFFM_M FB XD2.XDFFM.M 2.4201e-17
* device instance cc_FB_XD2_XDFFM_MB r0 *1 0,0
Ccc_FB_XD2_XDFFM_MB FB XD2.XDFFM.MB 1.21e-17
* device instance cc_FB_XD2_XDFFM_S r0 *1 0,0
Ccc_FB_XD2_XDFFM_S FB XD2.XDFFM.S 1.8151e-17
* device instance cc_FB_XD2_XDFFM_SB r0 *1 0,0
Ccc_FB_XD2_XDFFM_SB FB XD2.XDFFM.SB 1.8151e-17
* device instance cc_FB_XD2_XDFFQ_CLKB r0 *1 0,0
Ccc_FB_XD2_XDFFQ_CLKB FB XD2.XDFFQ.CLKB 1.8151e-17
* device instance cc_FB_XD2_XDFFQ_M r0 *1 0,0
Ccc_FB_XD2_XDFFQ_M FB XD2.XDFFQ.M 2.4201e-17
* device instance cc_FB_XD2_XDFFQ_MB r0 *1 0,0
Ccc_FB_XD2_XDFFQ_MB FB XD2.XDFFQ.MB 1.21e-17
* device instance cc_FB_XD2_XDFFQ_S r0 *1 0,0
Ccc_FB_XD2_XDFFQ_S FB XD2.XDFFQ.S 1.8151e-17
* device instance cc_FB_XD2_XDFFQ_SB r0 *1 0,0
Ccc_FB_XD2_XDFFQ_SB FB XD2.XDFFQ.SB 1.8151e-17
* device instance cc_FB_XD2_XNOR_midp r0 *1 0,0
Ccc_FB_XD2_XNOR_midp FB XD2.XNOR.midp 1.21e-17
* device instance cc_FB_XD2_dmodout r0 *1 0,0
Ccc_FB_XD2_dmodout FB XD2.dmodout 1.21e-17
* device instance cc_FB_XD2_dq r0 *1 0,0
Ccc_FB_XD2_dq FB XD2.dq 1.21e-17
* device instance cc_FB_XD2_nm r0 *1 0,0
Ccc_FB_XD2_nm FB XD2.nm 1.8151e-17
* device instance cc_FB_XD2_nt r0 *1 0,0
Ccc_FB_XD2_nt FB XD2.nt 2.4201e-17
* device instance cc_FB_XD2_t1 r0 *1 0,0
Ccc_FB_XD2_t1 FB XD2.t1 1.21e-17
* device instance cc_FB_XD3_XDFFM_CLKB r0 *1 0,0
Ccc_FB_XD3_XDFFM_CLKB FB XD3.XDFFM.CLKB 1.8151e-17
* device instance cc_FB_XD3_XDFFM_M r0 *1 0,0
Ccc_FB_XD3_XDFFM_M FB XD3.XDFFM.M 2.4201e-17
* device instance cc_FB_XD3_XDFFM_MB r0 *1 0,0
Ccc_FB_XD3_XDFFM_MB FB XD3.XDFFM.MB 1.21e-17
* device instance cc_FB_XD3_XDFFM_S r0 *1 0,0
Ccc_FB_XD3_XDFFM_S FB XD3.XDFFM.S 1.8151e-17
* device instance cc_FB_XD3_XDFFM_SB r0 *1 0,0
Ccc_FB_XD3_XDFFM_SB FB XD3.XDFFM.SB 1.8151e-17
* device instance cc_FB_XD3_XDFFQ_CLKB r0 *1 0,0
Ccc_FB_XD3_XDFFQ_CLKB FB XD3.XDFFQ.CLKB 1.8151e-17
* device instance cc_FB_XD3_XDFFQ_M r0 *1 0,0
Ccc_FB_XD3_XDFFQ_M FB XD3.XDFFQ.M 2.4201e-17
* device instance cc_FB_XD3_XDFFQ_MB r0 *1 0,0
Ccc_FB_XD3_XDFFQ_MB FB XD3.XDFFQ.MB 1.21e-17
* device instance cc_FB_XD3_XDFFQ_S r0 *1 0,0
Ccc_FB_XD3_XDFFQ_S FB XD3.XDFFQ.S 1.8151e-17
* device instance cc_FB_XD3_XDFFQ_SB r0 *1 0,0
Ccc_FB_XD3_XDFFQ_SB FB XD3.XDFFQ.SB 1.8151e-17
* device instance cc_FB_XD3_XNOR_midp r0 *1 0,0
Ccc_FB_XD3_XNOR_midp FB XD3.XNOR.midp 1.21e-17
* device instance cc_FB_XD3_dmodout r0 *1 0,0
Ccc_FB_XD3_dmodout FB XD3.dmodout 1.21e-17
* device instance cc_FB_XD3_dq r0 *1 0,0
Ccc_FB_XD3_dq FB XD3.dq 1.21e-17
* device instance cc_FB_XD3_nm r0 *1 0,0
Ccc_FB_XD3_nm FB XD3.nm 1.8151e-17
* device instance cc_FB_XD3_nt r0 *1 0,0
Ccc_FB_XD3_nt FB XD3.nt 2.4201e-17
* device instance cc_FB_XD3_t1 r0 *1 0,0
Ccc_FB_XD3_t1 FB XD3.t1 1.21e-17
* device instance cc_FB_XD4_XDFFM_CLKB r0 *1 0,0
Ccc_FB_XD4_XDFFM_CLKB FB XD4.XDFFM.CLKB 1.8151e-17
* device instance cc_FB_XD4_XDFFM_M r0 *1 0,0
Ccc_FB_XD4_XDFFM_M FB XD4.XDFFM.M 2.4201e-17
* device instance cc_FB_XD4_XDFFM_MB r0 *1 0,0
Ccc_FB_XD4_XDFFM_MB FB XD4.XDFFM.MB 1.21e-17
* device instance cc_FB_XD4_XDFFM_S r0 *1 0,0
Ccc_FB_XD4_XDFFM_S FB XD4.XDFFM.S 1.8151e-17
* device instance cc_FB_XD4_XDFFM_SB r0 *1 0,0
Ccc_FB_XD4_XDFFM_SB FB XD4.XDFFM.SB 1.8151e-17
* device instance cc_FB_XD4_XDFFQ_CLKB r0 *1 0,0
Ccc_FB_XD4_XDFFQ_CLKB FB XD4.XDFFQ.CLKB 1.8151e-17
* device instance cc_FB_XD4_XDFFQ_M r0 *1 0,0
Ccc_FB_XD4_XDFFQ_M FB XD4.XDFFQ.M 2.4201e-17
* device instance cc_FB_XD4_XDFFQ_MB r0 *1 0,0
Ccc_FB_XD4_XDFFQ_MB FB XD4.XDFFQ.MB 1.21e-17
* device instance cc_FB_XD4_XDFFQ_S r0 *1 0,0
Ccc_FB_XD4_XDFFQ_S FB XD4.XDFFQ.S 1.8151e-17
* device instance cc_FB_XD4_XDFFQ_SB r0 *1 0,0
Ccc_FB_XD4_XDFFQ_SB FB XD4.XDFFQ.SB 1.8151e-17
* device instance cc_FB_XD4_XNOR_midp r0 *1 0,0
Ccc_FB_XD4_XNOR_midp FB XD4.XNOR.midp 1.21e-17
* device instance cc_FB_XD4_dmodout r0 *1 0,0
Ccc_FB_XD4_dmodout FB XD4.dmodout 1.21e-17
* device instance cc_FB_XD4_dq r0 *1 0,0
Ccc_FB_XD4_dq FB XD4.dq 1.21e-17
* device instance cc_FB_XD4_nm r0 *1 0,0
Ccc_FB_XD4_nm FB XD4.nm 1.8151e-17
* device instance cc_FB_XD4_nt r0 *1 0,0
Ccc_FB_XD4_nt FB XD4.nt 2.4201e-17
* device instance cc_FB_XD4_t1 r0 *1 0,0
Ccc_FB_XD4_t1 FB XD4.t1 1.21e-17
* device instance cc_FB_XD5_XDFFM_CLKB r0 *1 0,0
Ccc_FB_XD5_XDFFM_CLKB FB XD5.XDFFM.CLKB 1.8151e-17
* device instance cc_FB_XD5_XDFFM_M r0 *1 0,0
Ccc_FB_XD5_XDFFM_M FB XD5.XDFFM.M 2.4201e-17
* device instance cc_FB_XD5_XDFFM_MB r0 *1 0,0
Ccc_FB_XD5_XDFFM_MB FB XD5.XDFFM.MB 1.21e-17
* device instance cc_FB_XD5_XDFFM_S r0 *1 0,0
Ccc_FB_XD5_XDFFM_S FB XD5.XDFFM.S 1.8151e-17
* device instance cc_FB_XD5_XDFFM_SB r0 *1 0,0
Ccc_FB_XD5_XDFFM_SB FB XD5.XDFFM.SB 1.8151e-17
* device instance cc_FB_XD5_XDFFQ_CLKB r0 *1 0,0
Ccc_FB_XD5_XDFFQ_CLKB FB XD5.XDFFQ.CLKB 1.8151e-17
* device instance cc_FB_XD5_XDFFQ_M r0 *1 0,0
Ccc_FB_XD5_XDFFQ_M FB XD5.XDFFQ.M 2.4201e-17
* device instance cc_FB_XD5_XDFFQ_MB r0 *1 0,0
Ccc_FB_XD5_XDFFQ_MB FB XD5.XDFFQ.MB 1.21e-17
* device instance cc_FB_XD5_XDFFQ_S r0 *1 0,0
Ccc_FB_XD5_XDFFQ_S FB XD5.XDFFQ.S 1.8151e-17
* device instance cc_FB_XD5_XDFFQ_SB r0 *1 0,0
Ccc_FB_XD5_XDFFQ_SB FB XD5.XDFFQ.SB 1.8151e-17
* device instance cc_FB_XD5_XNOR_midp r0 *1 0,0
Ccc_FB_XD5_XNOR_midp FB XD5.XNOR.midp 1.21e-17
* device instance cc_FB_XD5_dmodout r0 *1 0,0
Ccc_FB_XD5_dmodout FB XD5.dmodout 1.21e-17
* device instance cc_FB_XD5_dq r0 *1 0,0
Ccc_FB_XD5_dq FB XD5.dq 1.21e-17
* device instance cc_FB_XD5_nm r0 *1 0,0
Ccc_FB_XD5_nm FB XD5.nm 1.8151e-17
* device instance cc_FB_XD5_nt r0 *1 0,0
Ccc_FB_XD5_nt FB XD5.nt 2.4201e-17
* device instance cc_FB_XD5_t1 r0 *1 0,0
Ccc_FB_XD5_t1 FB XD5.t1 1.21e-17
* device instance cc_FB_XFRT_CLKB r0 *1 0,0
Ccc_FB_XFRT_CLKB FB XFRT.CLKB 1.8151e-17
* device instance cc_FB_XFRT_M r0 *1 0,0
Ccc_FB_XFRT_M FB XFRT.M 2.4201e-17
* device instance cc_FB_XFRT_MB r0 *1 0,0
Ccc_FB_XFRT_MB FB XFRT.MB 1.21e-17
* device instance cc_FB_XFRT_S r0 *1 0,0
Ccc_FB_XFRT_S FB XFRT.S 1.8151e-17
* device instance cc_FB_XFRT_SB r0 *1 0,0
Ccc_FB_XFRT_SB FB XFRT.SB 1.8151e-17
* device instance cc_FB_ck1 r0 *1 0,0
Ccc_FB_ck1 FB ck1 5.4452e-17
* device instance cc_FB_ck2 r0 *1 0,0
Ccc_FB_ck2 FB ck2 5.4452e-17
* device instance cc_FB_ck3 r0 *1 0,0
Ccc_FB_ck3 FB ck3 5.4452e-17
* device instance cc_FB_ck4 r0 *1 0,0
Ccc_FB_ck4 FB ck4 5.4452e-17
* device instance cc_FB_ck5 r0 *1 0,0
Ccc_FB_ck5 FB ck5 5.4452e-17
* device instance cc_FB_mod0 r0 *1 0,0
Ccc_FB_mod0 FB mod0 2.4201e-17
* device instance cc_FB_mod1 r0 *1 0,0
Ccc_FB_mod1 FB mod1 2.4201e-17
* device instance cc_FB_mod2 r0 *1 0,0
Ccc_FB_mod2 FB mod2 2.4201e-17
* device instance cc_FB_mod3 r0 *1 0,0
Ccc_FB_mod3 FB mod3 2.4201e-17
* device instance cc_FB_mod4 r0 *1 0,0
Ccc_FB_mod4 FB mod4 2.4201e-17
* device instance cc_FB_net1 r0 *1 0,0
Ccc_FB_net1 FB net1 1.21e-17
* device instance cc_P0_P1 r0 *1 0,0
Ccc_P0_P1 P0 P1 6.05e-18
* device instance cc_P0_P2 r0 *1 0,0
Ccc_P0_P2 P0 P2 6.05e-18
* device instance cc_P0_P3 r0 *1 0,0
Ccc_P0_P3 P0 P3 6.05e-18
* device instance cc_P0_P4 r0 *1 0,0
Ccc_P0_P4 P0 P4 6.05e-18
* device instance cc_P0_P5 r0 *1 0,0
Ccc_P0_P5 P0 P5 6.05e-18
* device instance cc_P0_VDD_DIV r0 *1 0,0
Ccc_P0_VDD_DIV P0 VDD_DIV 2.4201e-17
* device instance cc_P0_VSS r0 *1 0,0
Ccc_P0_VSS P0 VSS 5.32422e-16
* device instance cc_P0_XD0_XDFFM_CLKB r0 *1 0,0
Ccc_P0_XD0_XDFFM_CLKB P0 XD0.XDFFM.CLKB 1.8151e-17
* device instance cc_P0_XD0_XDFFM_M r0 *1 0,0
Ccc_P0_XD0_XDFFM_M P0 XD0.XDFFM.M 2.4201e-17
* device instance cc_P0_XD0_XDFFM_MB r0 *1 0,0
Ccc_P0_XD0_XDFFM_MB P0 XD0.XDFFM.MB 1.21e-17
* device instance cc_P0_XD0_XDFFM_S r0 *1 0,0
Ccc_P0_XD0_XDFFM_S P0 XD0.XDFFM.S 1.8151e-17
* device instance cc_P0_XD0_XDFFM_SB r0 *1 0,0
Ccc_P0_XD0_XDFFM_SB P0 XD0.XDFFM.SB 1.8151e-17
* device instance cc_P0_XD0_XDFFQ_CLKB r0 *1 0,0
Ccc_P0_XD0_XDFFQ_CLKB P0 XD0.XDFFQ.CLKB 1.8151e-17
* device instance cc_P0_XD0_XDFFQ_M r0 *1 0,0
Ccc_P0_XD0_XDFFQ_M P0 XD0.XDFFQ.M 2.4201e-17
* device instance cc_P0_XD0_XDFFQ_MB r0 *1 0,0
Ccc_P0_XD0_XDFFQ_MB P0 XD0.XDFFQ.MB 1.21e-17
* device instance cc_P0_XD0_XDFFQ_S r0 *1 0,0
Ccc_P0_XD0_XDFFQ_S P0 XD0.XDFFQ.S 1.8151e-17
* device instance cc_P0_XD0_XDFFQ_SB r0 *1 0,0
Ccc_P0_XD0_XDFFQ_SB P0 XD0.XDFFQ.SB 1.8151e-17
* device instance cc_P0_XD0_XN2_mid1 r0 *1 0,0
Ccc_P0_XD0_XN2_mid1 P0 XD0.XN2.mid1 1.21e-17
* device instance cc_P0_XD0_XN3_mid1 r0 *1 0,0
Ccc_P0_XD0_XN3_mid1 P0 XD0.XN3.mid1 6.05e-18
* device instance cc_P0_XD0_XN3_mid2 r0 *1 0,0
Ccc_P0_XD0_XN3_mid2 P0 XD0.XN3.mid2 1.21e-17
* device instance cc_P0_XD0_dmodout r0 *1 0,0
Ccc_P0_XD0_dmodout P0 XD0.dmodout 1.21e-17
* device instance cc_P0_XD0_dq r0 *1 0,0
Ccc_P0_XD0_dq P0 XD0.dq 1.8151e-17
* device instance cc_P0_XD0_nm r0 *1 0,0
Ccc_P0_XD0_nm P0 XD0.nm 1.21e-17
* device instance cc_P0_XD0_nt r0 *1 0,0
Ccc_P0_XD0_nt P0 XD0.nt 1.21e-17
* device instance cc_P0_XD0_t1 r0 *1 0,0
Ccc_P0_XD0_t1 P0 XD0.t1 1.21e-17
* device instance cc_P0_XD1_XDFFM_CLKB r0 *1 0,0
Ccc_P0_XD1_XDFFM_CLKB P0 XD1.XDFFM.CLKB 1.8151e-17
* device instance cc_P0_XD1_XDFFM_M r0 *1 0,0
Ccc_P0_XD1_XDFFM_M P0 XD1.XDFFM.M 2.4201e-17
* device instance cc_P0_XD1_XDFFM_MB r0 *1 0,0
Ccc_P0_XD1_XDFFM_MB P0 XD1.XDFFM.MB 1.21e-17
* device instance cc_P0_XD1_XDFFM_S r0 *1 0,0
Ccc_P0_XD1_XDFFM_S P0 XD1.XDFFM.S 1.8151e-17
* device instance cc_P0_XD1_XDFFM_SB r0 *1 0,0
Ccc_P0_XD1_XDFFM_SB P0 XD1.XDFFM.SB 1.8151e-17
* device instance cc_P0_XD1_XDFFQ_CLKB r0 *1 0,0
Ccc_P0_XD1_XDFFQ_CLKB P0 XD1.XDFFQ.CLKB 1.8151e-17
* device instance cc_P0_XD1_XDFFQ_M r0 *1 0,0
Ccc_P0_XD1_XDFFQ_M P0 XD1.XDFFQ.M 2.4201e-17
* device instance cc_P0_XD1_XDFFQ_MB r0 *1 0,0
Ccc_P0_XD1_XDFFQ_MB P0 XD1.XDFFQ.MB 1.21e-17
* device instance cc_P0_XD1_XDFFQ_S r0 *1 0,0
Ccc_P0_XD1_XDFFQ_S P0 XD1.XDFFQ.S 1.8151e-17
* device instance cc_P0_XD1_XDFFQ_SB r0 *1 0,0
Ccc_P0_XD1_XDFFQ_SB P0 XD1.XDFFQ.SB 1.8151e-17
* device instance cc_P0_XD1_XN2_mid1 r0 *1 0,0
Ccc_P0_XD1_XN2_mid1 P0 XD1.XN2.mid1 1.21e-17
* device instance cc_P0_XD1_XN3_mid1 r0 *1 0,0
Ccc_P0_XD1_XN3_mid1 P0 XD1.XN3.mid1 1.21e-17
* device instance cc_P0_XD1_XN3_mid2 r0 *1 0,0
Ccc_P0_XD1_XN3_mid2 P0 XD1.XN3.mid2 1.21e-17
* device instance cc_P0_XD1_dmodout r0 *1 0,0
Ccc_P0_XD1_dmodout P0 XD1.dmodout 1.21e-17
* device instance cc_P0_XD1_dq r0 *1 0,0
Ccc_P0_XD1_dq P0 XD1.dq 1.8151e-17
* device instance cc_P0_XD1_nm r0 *1 0,0
Ccc_P0_XD1_nm P0 XD1.nm 1.21e-17
* device instance cc_P0_XD1_nt r0 *1 0,0
Ccc_P0_XD1_nt P0 XD1.nt 1.21e-17
* device instance cc_P0_XD1_t1 r0 *1 0,0
Ccc_P0_XD1_t1 P0 XD1.t1 1.21e-17
* device instance cc_P0_XD2_XDFFM_CLKB r0 *1 0,0
Ccc_P0_XD2_XDFFM_CLKB P0 XD2.XDFFM.CLKB 1.8151e-17
* device instance cc_P0_XD2_XDFFM_M r0 *1 0,0
Ccc_P0_XD2_XDFFM_M P0 XD2.XDFFM.M 2.4201e-17
* device instance cc_P0_XD2_XDFFM_MB r0 *1 0,0
Ccc_P0_XD2_XDFFM_MB P0 XD2.XDFFM.MB 1.21e-17
* device instance cc_P0_XD2_XDFFM_S r0 *1 0,0
Ccc_P0_XD2_XDFFM_S P0 XD2.XDFFM.S 1.8151e-17
* device instance cc_P0_XD2_XDFFM_SB r0 *1 0,0
Ccc_P0_XD2_XDFFM_SB P0 XD2.XDFFM.SB 1.8151e-17
* device instance cc_P0_XD2_XDFFQ_CLKB r0 *1 0,0
Ccc_P0_XD2_XDFFQ_CLKB P0 XD2.XDFFQ.CLKB 1.8151e-17
* device instance cc_P0_XD2_XDFFQ_M r0 *1 0,0
Ccc_P0_XD2_XDFFQ_M P0 XD2.XDFFQ.M 2.4201e-17
* device instance cc_P0_XD2_XDFFQ_MB r0 *1 0,0
Ccc_P0_XD2_XDFFQ_MB P0 XD2.XDFFQ.MB 1.21e-17
* device instance cc_P0_XD2_XDFFQ_S r0 *1 0,0
Ccc_P0_XD2_XDFFQ_S P0 XD2.XDFFQ.S 1.8151e-17
* device instance cc_P0_XD2_XDFFQ_SB r0 *1 0,0
Ccc_P0_XD2_XDFFQ_SB P0 XD2.XDFFQ.SB 1.8151e-17
* device instance cc_P0_XD2_XN2_mid1 r0 *1 0,0
Ccc_P0_XD2_XN2_mid1 P0 XD2.XN2.mid1 1.21e-17
* device instance cc_P0_XD2_XN3_mid1 r0 *1 0,0
Ccc_P0_XD2_XN3_mid1 P0 XD2.XN3.mid1 1.21e-17
* device instance cc_P0_XD2_XN3_mid2 r0 *1 0,0
Ccc_P0_XD2_XN3_mid2 P0 XD2.XN3.mid2 1.21e-17
* device instance cc_P0_XD2_dmodout r0 *1 0,0
Ccc_P0_XD2_dmodout P0 XD2.dmodout 1.21e-17
* device instance cc_P0_XD2_dq r0 *1 0,0
Ccc_P0_XD2_dq P0 XD2.dq 1.8151e-17
* device instance cc_P0_XD2_nm r0 *1 0,0
Ccc_P0_XD2_nm P0 XD2.nm 1.21e-17
* device instance cc_P0_XD2_nt r0 *1 0,0
Ccc_P0_XD2_nt P0 XD2.nt 1.21e-17
* device instance cc_P0_XD2_t1 r0 *1 0,0
Ccc_P0_XD2_t1 P0 XD2.t1 1.21e-17
* device instance cc_P0_XD3_XDFFM_CLKB r0 *1 0,0
Ccc_P0_XD3_XDFFM_CLKB P0 XD3.XDFFM.CLKB 1.8151e-17
* device instance cc_P0_XD3_XDFFM_M r0 *1 0,0
Ccc_P0_XD3_XDFFM_M P0 XD3.XDFFM.M 2.4201e-17
* device instance cc_P0_XD3_XDFFM_MB r0 *1 0,0
Ccc_P0_XD3_XDFFM_MB P0 XD3.XDFFM.MB 1.21e-17
* device instance cc_P0_XD3_XDFFM_S r0 *1 0,0
Ccc_P0_XD3_XDFFM_S P0 XD3.XDFFM.S 1.8151e-17
* device instance cc_P0_XD3_XDFFM_SB r0 *1 0,0
Ccc_P0_XD3_XDFFM_SB P0 XD3.XDFFM.SB 1.8151e-17
* device instance cc_P0_XD3_XDFFQ_CLKB r0 *1 0,0
Ccc_P0_XD3_XDFFQ_CLKB P0 XD3.XDFFQ.CLKB 1.8151e-17
* device instance cc_P0_XD3_XDFFQ_M r0 *1 0,0
Ccc_P0_XD3_XDFFQ_M P0 XD3.XDFFQ.M 2.4201e-17
* device instance cc_P0_XD3_XDFFQ_MB r0 *1 0,0
Ccc_P0_XD3_XDFFQ_MB P0 XD3.XDFFQ.MB 1.21e-17
* device instance cc_P0_XD3_XDFFQ_S r0 *1 0,0
Ccc_P0_XD3_XDFFQ_S P0 XD3.XDFFQ.S 1.8151e-17
* device instance cc_P0_XD3_XDFFQ_SB r0 *1 0,0
Ccc_P0_XD3_XDFFQ_SB P0 XD3.XDFFQ.SB 1.8151e-17
* device instance cc_P0_XD3_XN2_mid1 r0 *1 0,0
Ccc_P0_XD3_XN2_mid1 P0 XD3.XN2.mid1 1.21e-17
* device instance cc_P0_XD3_XN3_mid1 r0 *1 0,0
Ccc_P0_XD3_XN3_mid1 P0 XD3.XN3.mid1 1.21e-17
* device instance cc_P0_XD3_XN3_mid2 r0 *1 0,0
Ccc_P0_XD3_XN3_mid2 P0 XD3.XN3.mid2 1.21e-17
* device instance cc_P0_XD3_dmodout r0 *1 0,0
Ccc_P0_XD3_dmodout P0 XD3.dmodout 1.21e-17
* device instance cc_P0_XD3_dq r0 *1 0,0
Ccc_P0_XD3_dq P0 XD3.dq 1.8151e-17
* device instance cc_P0_XD3_nm r0 *1 0,0
Ccc_P0_XD3_nm P0 XD3.nm 1.21e-17
* device instance cc_P0_XD3_nt r0 *1 0,0
Ccc_P0_XD3_nt P0 XD3.nt 1.21e-17
* device instance cc_P0_XD3_t1 r0 *1 0,0
Ccc_P0_XD3_t1 P0 XD3.t1 1.21e-17
* device instance cc_P0_XD4_XDFFM_CLKB r0 *1 0,0
Ccc_P0_XD4_XDFFM_CLKB P0 XD4.XDFFM.CLKB 1.8151e-17
* device instance cc_P0_XD4_XDFFM_M r0 *1 0,0
Ccc_P0_XD4_XDFFM_M P0 XD4.XDFFM.M 2.4201e-17
* device instance cc_P0_XD4_XDFFM_MB r0 *1 0,0
Ccc_P0_XD4_XDFFM_MB P0 XD4.XDFFM.MB 1.21e-17
* device instance cc_P0_XD4_XDFFM_S r0 *1 0,0
Ccc_P0_XD4_XDFFM_S P0 XD4.XDFFM.S 1.8151e-17
* device instance cc_P0_XD4_XDFFM_SB r0 *1 0,0
Ccc_P0_XD4_XDFFM_SB P0 XD4.XDFFM.SB 1.8151e-17
* device instance cc_P0_XD4_XDFFQ_CLKB r0 *1 0,0
Ccc_P0_XD4_XDFFQ_CLKB P0 XD4.XDFFQ.CLKB 1.8151e-17
* device instance cc_P0_XD4_XDFFQ_M r0 *1 0,0
Ccc_P0_XD4_XDFFQ_M P0 XD4.XDFFQ.M 2.4201e-17
* device instance cc_P0_XD4_XDFFQ_MB r0 *1 0,0
Ccc_P0_XD4_XDFFQ_MB P0 XD4.XDFFQ.MB 1.21e-17
* device instance cc_P0_XD4_XDFFQ_S r0 *1 0,0
Ccc_P0_XD4_XDFFQ_S P0 XD4.XDFFQ.S 1.8151e-17
* device instance cc_P0_XD4_XDFFQ_SB r0 *1 0,0
Ccc_P0_XD4_XDFFQ_SB P0 XD4.XDFFQ.SB 1.8151e-17
* device instance cc_P0_XD4_XN2_mid1 r0 *1 0,0
Ccc_P0_XD4_XN2_mid1 P0 XD4.XN2.mid1 1.21e-17
* device instance cc_P0_XD4_XN3_mid1 r0 *1 0,0
Ccc_P0_XD4_XN3_mid1 P0 XD4.XN3.mid1 1.21e-17
* device instance cc_P0_XD4_XN3_mid2 r0 *1 0,0
Ccc_P0_XD4_XN3_mid2 P0 XD4.XN3.mid2 1.21e-17
* device instance cc_P0_XD4_dmodout r0 *1 0,0
Ccc_P0_XD4_dmodout P0 XD4.dmodout 1.21e-17
* device instance cc_P0_XD4_dq r0 *1 0,0
Ccc_P0_XD4_dq P0 XD4.dq 1.8151e-17
* device instance cc_P0_XD4_nm r0 *1 0,0
Ccc_P0_XD4_nm P0 XD4.nm 1.21e-17
* device instance cc_P0_XD4_nt r0 *1 0,0
Ccc_P0_XD4_nt P0 XD4.nt 1.21e-17
* device instance cc_P0_XD4_t1 r0 *1 0,0
Ccc_P0_XD4_t1 P0 XD4.t1 1.21e-17
* device instance cc_P0_XD5_XDFFM_CLKB r0 *1 0,0
Ccc_P0_XD5_XDFFM_CLKB P0 XD5.XDFFM.CLKB 1.8151e-17
* device instance cc_P0_XD5_XDFFM_M r0 *1 0,0
Ccc_P0_XD5_XDFFM_M P0 XD5.XDFFM.M 2.4201e-17
* device instance cc_P0_XD5_XDFFM_MB r0 *1 0,0
Ccc_P0_XD5_XDFFM_MB P0 XD5.XDFFM.MB 1.21e-17
* device instance cc_P0_XD5_XDFFM_S r0 *1 0,0
Ccc_P0_XD5_XDFFM_S P0 XD5.XDFFM.S 1.8151e-17
* device instance cc_P0_XD5_XDFFM_SB r0 *1 0,0
Ccc_P0_XD5_XDFFM_SB P0 XD5.XDFFM.SB 1.8151e-17
* device instance cc_P0_XD5_XDFFQ_CLKB r0 *1 0,0
Ccc_P0_XD5_XDFFQ_CLKB P0 XD5.XDFFQ.CLKB 1.8151e-17
* device instance cc_P0_XD5_XDFFQ_M r0 *1 0,0
Ccc_P0_XD5_XDFFQ_M P0 XD5.XDFFQ.M 2.4201e-17
* device instance cc_P0_XD5_XDFFQ_MB r0 *1 0,0
Ccc_P0_XD5_XDFFQ_MB P0 XD5.XDFFQ.MB 1.21e-17
* device instance cc_P0_XD5_XDFFQ_S r0 *1 0,0
Ccc_P0_XD5_XDFFQ_S P0 XD5.XDFFQ.S 1.8151e-17
* device instance cc_P0_XD5_XDFFQ_SB r0 *1 0,0
Ccc_P0_XD5_XDFFQ_SB P0 XD5.XDFFQ.SB 1.8151e-17
* device instance cc_P0_XD5_XN2_mid1 r0 *1 0,0
Ccc_P0_XD5_XN2_mid1 P0 XD5.XN2.mid1 1.21e-17
* device instance cc_P0_XD5_XN3_mid1 r0 *1 0,0
Ccc_P0_XD5_XN3_mid1 P0 XD5.XN3.mid1 1.21e-17
* device instance cc_P0_XD5_XN3_mid2 r0 *1 0,0
Ccc_P0_XD5_XN3_mid2 P0 XD5.XN3.mid2 1.21e-17
* device instance cc_P0_XD5_dmodout r0 *1 0,0
Ccc_P0_XD5_dmodout P0 XD5.dmodout 1.21e-17
* device instance cc_P0_XD5_dq r0 *1 0,0
Ccc_P0_XD5_dq P0 XD5.dq 1.8151e-17
* device instance cc_P0_XD5_nm r0 *1 0,0
Ccc_P0_XD5_nm P0 XD5.nm 1.21e-17
* device instance cc_P0_XD5_nt r0 *1 0,0
Ccc_P0_XD5_nt P0 XD5.nt 1.21e-17
* device instance cc_P0_XD5_t1 r0 *1 0,0
Ccc_P0_XD5_t1 P0 XD5.t1 1.21e-17
* device instance cc_P0_XFRT_CLKB r0 *1 0,0
Ccc_P0_XFRT_CLKB P0 XFRT.CLKB 1.8151e-17
* device instance cc_P0_XFRT_M r0 *1 0,0
Ccc_P0_XFRT_M P0 XFRT.M 2.4201e-17
* device instance cc_P0_XFRT_MB r0 *1 0,0
Ccc_P0_XFRT_MB P0 XFRT.MB 1.21e-17
* device instance cc_P0_XFRT_S r0 *1 0,0
Ccc_P0_XFRT_S P0 XFRT.S 1.8151e-17
* device instance cc_P0_XFRT_SB r0 *1 0,0
Ccc_P0_XFRT_SB P0 XFRT.SB 1.8151e-17
* device instance cc_P0_ck1 r0 *1 0,0
Ccc_P0_ck1 P0 ck1 5.4452e-17
* device instance cc_P0_ck2 r0 *1 0,0
Ccc_P0_ck2 P0 ck2 5.4452e-17
* device instance cc_P0_ck3 r0 *1 0,0
Ccc_P0_ck3 P0 ck3 5.4452e-17
* device instance cc_P0_ck4 r0 *1 0,0
Ccc_P0_ck4 P0 ck4 5.4452e-17
* device instance cc_P0_ck5 r0 *1 0,0
Ccc_P0_ck5 P0 ck5 5.4452e-17
* device instance cc_P0_mod0 r0 *1 0,0
Ccc_P0_mod0 P0 mod0 2.4201e-17
* device instance cc_P0_mod1 r0 *1 0,0
Ccc_P0_mod1 P0 mod1 2.4201e-17
* device instance cc_P0_mod2 r0 *1 0,0
Ccc_P0_mod2 P0 mod2 2.4201e-17
* device instance cc_P0_mod3 r0 *1 0,0
Ccc_P0_mod3 P0 mod3 2.4201e-17
* device instance cc_P0_mod4 r0 *1 0,0
Ccc_P0_mod4 P0 mod4 2.4201e-17
* device instance cc_P0_net1 r0 *1 0,0
Ccc_P0_net1 P0 net1 1.21e-17
* device instance cc_P1_P2 r0 *1 0,0
Ccc_P1_P2 P1 P2 6.05e-18
* device instance cc_P1_P3 r0 *1 0,0
Ccc_P1_P3 P1 P3 6.05e-18
* device instance cc_P1_P4 r0 *1 0,0
Ccc_P1_P4 P1 P4 6.05e-18
* device instance cc_P1_P5 r0 *1 0,0
Ccc_P1_P5 P1 P5 6.05e-18
* device instance cc_P1_VDD_DIV r0 *1 0,0
Ccc_P1_VDD_DIV P1 VDD_DIV 1.21005e-16
* device instance cc_P1_VSS r0 *1 0,0
Ccc_P1_VSS P1 VSS 4.47718e-16
* device instance cc_P1_XD0_XDFFM_CLKB r0 *1 0,0
Ccc_P1_XD0_XDFFM_CLKB P1 XD0.XDFFM.CLKB 1.8151e-17
* device instance cc_P1_XD0_XDFFM_M r0 *1 0,0
Ccc_P1_XD0_XDFFM_M P1 XD0.XDFFM.M 2.4201e-17
* device instance cc_P1_XD0_XDFFM_MB r0 *1 0,0
Ccc_P1_XD0_XDFFM_MB P1 XD0.XDFFM.MB 1.21e-17
* device instance cc_P1_XD0_XDFFM_S r0 *1 0,0
Ccc_P1_XD0_XDFFM_S P1 XD0.XDFFM.S 1.8151e-17
* device instance cc_P1_XD0_XDFFM_SB r0 *1 0,0
Ccc_P1_XD0_XDFFM_SB P1 XD0.XDFFM.SB 1.8151e-17
* device instance cc_P1_XD0_XDFFQ_CLKB r0 *1 0,0
Ccc_P1_XD0_XDFFQ_CLKB P1 XD0.XDFFQ.CLKB 1.8151e-17
* device instance cc_P1_XD0_XDFFQ_M r0 *1 0,0
Ccc_P1_XD0_XDFFQ_M P1 XD0.XDFFQ.M 2.4201e-17
* device instance cc_P1_XD0_XDFFQ_MB r0 *1 0,0
Ccc_P1_XD0_XDFFQ_MB P1 XD0.XDFFQ.MB 1.21e-17
* device instance cc_P1_XD0_XDFFQ_S r0 *1 0,0
Ccc_P1_XD0_XDFFQ_S P1 XD0.XDFFQ.S 1.8151e-17
* device instance cc_P1_XD0_XDFFQ_SB r0 *1 0,0
Ccc_P1_XD0_XDFFQ_SB P1 XD0.XDFFQ.SB 1.8151e-17
* device instance cc_P1_XD0_XNOR_midp r0 *1 0,0
Ccc_P1_XD0_XNOR_midp P1 XD0.XNOR.midp 1.21e-17
* device instance cc_P1_XD0_dmodout r0 *1 0,0
Ccc_P1_XD0_dmodout P1 XD0.dmodout 1.21e-17
* device instance cc_P1_XD0_dq r0 *1 0,0
Ccc_P1_XD0_dq P1 XD0.dq 1.21e-17
* device instance cc_P1_XD0_nm r0 *1 0,0
Ccc_P1_XD0_nm P1 XD0.nm 1.8151e-17
* device instance cc_P1_XD0_nt r0 *1 0,0
Ccc_P1_XD0_nt P1 XD0.nt 2.4201e-17
* device instance cc_P1_XD0_t1 r0 *1 0,0
Ccc_P1_XD0_t1 P1 XD0.t1 1.21e-17
* device instance cc_P1_XD1_XDFFM_CLKB r0 *1 0,0
Ccc_P1_XD1_XDFFM_CLKB P1 XD1.XDFFM.CLKB 1.8151e-17
* device instance cc_P1_XD1_XDFFM_M r0 *1 0,0
Ccc_P1_XD1_XDFFM_M P1 XD1.XDFFM.M 2.4201e-17
* device instance cc_P1_XD1_XDFFM_MB r0 *1 0,0
Ccc_P1_XD1_XDFFM_MB P1 XD1.XDFFM.MB 1.21e-17
* device instance cc_P1_XD1_XDFFM_S r0 *1 0,0
Ccc_P1_XD1_XDFFM_S P1 XD1.XDFFM.S 1.8151e-17
* device instance cc_P1_XD1_XDFFM_SB r0 *1 0,0
Ccc_P1_XD1_XDFFM_SB P1 XD1.XDFFM.SB 1.8151e-17
* device instance cc_P1_XD1_XDFFQ_CLKB r0 *1 0,0
Ccc_P1_XD1_XDFFQ_CLKB P1 XD1.XDFFQ.CLKB 1.8151e-17
* device instance cc_P1_XD1_XDFFQ_M r0 *1 0,0
Ccc_P1_XD1_XDFFQ_M P1 XD1.XDFFQ.M 2.4201e-17
* device instance cc_P1_XD1_XDFFQ_MB r0 *1 0,0
Ccc_P1_XD1_XDFFQ_MB P1 XD1.XDFFQ.MB 1.21e-17
* device instance cc_P1_XD1_XDFFQ_S r0 *1 0,0
Ccc_P1_XD1_XDFFQ_S P1 XD1.XDFFQ.S 1.8151e-17
* device instance cc_P1_XD1_XDFFQ_SB r0 *1 0,0
Ccc_P1_XD1_XDFFQ_SB P1 XD1.XDFFQ.SB 1.8151e-17
* device instance cc_P1_XD1_XN2_mid1 r0 *1 0,0
Ccc_P1_XD1_XN2_mid1 P1 XD1.XN2.mid1 1.21e-17
* device instance cc_P1_XD1_XN3_mid1 r0 *1 0,0
Ccc_P1_XD1_XN3_mid1 P1 XD1.XN3.mid1 6.05e-18
* device instance cc_P1_XD1_XN3_mid2 r0 *1 0,0
Ccc_P1_XD1_XN3_mid2 P1 XD1.XN3.mid2 1.21e-17
* device instance cc_P1_XD1_dmodout r0 *1 0,0
Ccc_P1_XD1_dmodout P1 XD1.dmodout 1.21e-17
* device instance cc_P1_XD1_dq r0 *1 0,0
Ccc_P1_XD1_dq P1 XD1.dq 1.8151e-17
* device instance cc_P1_XD1_nm r0 *1 0,0
Ccc_P1_XD1_nm P1 XD1.nm 1.21e-17
* device instance cc_P1_XD1_nt r0 *1 0,0
Ccc_P1_XD1_nt P1 XD1.nt 1.21e-17
* device instance cc_P1_XD1_t1 r0 *1 0,0
Ccc_P1_XD1_t1 P1 XD1.t1 1.21e-17
* device instance cc_P1_XD2_XDFFM_CLKB r0 *1 0,0
Ccc_P1_XD2_XDFFM_CLKB P1 XD2.XDFFM.CLKB 1.8151e-17
* device instance cc_P1_XD2_XDFFM_M r0 *1 0,0
Ccc_P1_XD2_XDFFM_M P1 XD2.XDFFM.M 2.4201e-17
* device instance cc_P1_XD2_XDFFM_MB r0 *1 0,0
Ccc_P1_XD2_XDFFM_MB P1 XD2.XDFFM.MB 1.21e-17
* device instance cc_P1_XD2_XDFFM_S r0 *1 0,0
Ccc_P1_XD2_XDFFM_S P1 XD2.XDFFM.S 1.8151e-17
* device instance cc_P1_XD2_XDFFM_SB r0 *1 0,0
Ccc_P1_XD2_XDFFM_SB P1 XD2.XDFFM.SB 1.8151e-17
* device instance cc_P1_XD2_XDFFQ_CLKB r0 *1 0,0
Ccc_P1_XD2_XDFFQ_CLKB P1 XD2.XDFFQ.CLKB 1.8151e-17
* device instance cc_P1_XD2_XDFFQ_M r0 *1 0,0
Ccc_P1_XD2_XDFFQ_M P1 XD2.XDFFQ.M 2.4201e-17
* device instance cc_P1_XD2_XDFFQ_MB r0 *1 0,0
Ccc_P1_XD2_XDFFQ_MB P1 XD2.XDFFQ.MB 1.21e-17
* device instance cc_P1_XD2_XDFFQ_S r0 *1 0,0
Ccc_P1_XD2_XDFFQ_S P1 XD2.XDFFQ.S 1.8151e-17
* device instance cc_P1_XD2_XDFFQ_SB r0 *1 0,0
Ccc_P1_XD2_XDFFQ_SB P1 XD2.XDFFQ.SB 1.8151e-17
* device instance cc_P1_XD2_XN2_mid1 r0 *1 0,0
Ccc_P1_XD2_XN2_mid1 P1 XD2.XN2.mid1 1.21e-17
* device instance cc_P1_XD2_XN3_mid1 r0 *1 0,0
Ccc_P1_XD2_XN3_mid1 P1 XD2.XN3.mid1 1.21e-17
* device instance cc_P1_XD2_XN3_mid2 r0 *1 0,0
Ccc_P1_XD2_XN3_mid2 P1 XD2.XN3.mid2 1.21e-17
* device instance cc_P1_XD2_dmodout r0 *1 0,0
Ccc_P1_XD2_dmodout P1 XD2.dmodout 1.21e-17
* device instance cc_P1_XD2_dq r0 *1 0,0
Ccc_P1_XD2_dq P1 XD2.dq 1.8151e-17
* device instance cc_P1_XD2_nm r0 *1 0,0
Ccc_P1_XD2_nm P1 XD2.nm 1.21e-17
* device instance cc_P1_XD2_nt r0 *1 0,0
Ccc_P1_XD2_nt P1 XD2.nt 1.21e-17
* device instance cc_P1_XD2_t1 r0 *1 0,0
Ccc_P1_XD2_t1 P1 XD2.t1 1.21e-17
* device instance cc_P1_XD3_XDFFM_CLKB r0 *1 0,0
Ccc_P1_XD3_XDFFM_CLKB P1 XD3.XDFFM.CLKB 1.8151e-17
* device instance cc_P1_XD3_XDFFM_M r0 *1 0,0
Ccc_P1_XD3_XDFFM_M P1 XD3.XDFFM.M 2.4201e-17
* device instance cc_P1_XD3_XDFFM_MB r0 *1 0,0
Ccc_P1_XD3_XDFFM_MB P1 XD3.XDFFM.MB 1.21e-17
* device instance cc_P1_XD3_XDFFM_S r0 *1 0,0
Ccc_P1_XD3_XDFFM_S P1 XD3.XDFFM.S 1.8151e-17
* device instance cc_P1_XD3_XDFFM_SB r0 *1 0,0
Ccc_P1_XD3_XDFFM_SB P1 XD3.XDFFM.SB 1.8151e-17
* device instance cc_P1_XD3_XDFFQ_CLKB r0 *1 0,0
Ccc_P1_XD3_XDFFQ_CLKB P1 XD3.XDFFQ.CLKB 1.8151e-17
* device instance cc_P1_XD3_XDFFQ_M r0 *1 0,0
Ccc_P1_XD3_XDFFQ_M P1 XD3.XDFFQ.M 2.4201e-17
* device instance cc_P1_XD3_XDFFQ_MB r0 *1 0,0
Ccc_P1_XD3_XDFFQ_MB P1 XD3.XDFFQ.MB 1.21e-17
* device instance cc_P1_XD3_XDFFQ_S r0 *1 0,0
Ccc_P1_XD3_XDFFQ_S P1 XD3.XDFFQ.S 1.8151e-17
* device instance cc_P1_XD3_XDFFQ_SB r0 *1 0,0
Ccc_P1_XD3_XDFFQ_SB P1 XD3.XDFFQ.SB 1.8151e-17
* device instance cc_P1_XD3_XN2_mid1 r0 *1 0,0
Ccc_P1_XD3_XN2_mid1 P1 XD3.XN2.mid1 1.21e-17
* device instance cc_P1_XD3_XN3_mid1 r0 *1 0,0
Ccc_P1_XD3_XN3_mid1 P1 XD3.XN3.mid1 1.21e-17
* device instance cc_P1_XD3_XN3_mid2 r0 *1 0,0
Ccc_P1_XD3_XN3_mid2 P1 XD3.XN3.mid2 1.21e-17
* device instance cc_P1_XD3_dmodout r0 *1 0,0
Ccc_P1_XD3_dmodout P1 XD3.dmodout 1.21e-17
* device instance cc_P1_XD3_dq r0 *1 0,0
Ccc_P1_XD3_dq P1 XD3.dq 1.8151e-17
* device instance cc_P1_XD3_nm r0 *1 0,0
Ccc_P1_XD3_nm P1 XD3.nm 1.21e-17
* device instance cc_P1_XD3_nt r0 *1 0,0
Ccc_P1_XD3_nt P1 XD3.nt 1.21e-17
* device instance cc_P1_XD3_t1 r0 *1 0,0
Ccc_P1_XD3_t1 P1 XD3.t1 1.21e-17
* device instance cc_P1_XD4_XDFFM_CLKB r0 *1 0,0
Ccc_P1_XD4_XDFFM_CLKB P1 XD4.XDFFM.CLKB 1.8151e-17
* device instance cc_P1_XD4_XDFFM_M r0 *1 0,0
Ccc_P1_XD4_XDFFM_M P1 XD4.XDFFM.M 2.4201e-17
* device instance cc_P1_XD4_XDFFM_MB r0 *1 0,0
Ccc_P1_XD4_XDFFM_MB P1 XD4.XDFFM.MB 1.21e-17
* device instance cc_P1_XD4_XDFFM_S r0 *1 0,0
Ccc_P1_XD4_XDFFM_S P1 XD4.XDFFM.S 1.8151e-17
* device instance cc_P1_XD4_XDFFM_SB r0 *1 0,0
Ccc_P1_XD4_XDFFM_SB P1 XD4.XDFFM.SB 1.8151e-17
* device instance cc_P1_XD4_XDFFQ_CLKB r0 *1 0,0
Ccc_P1_XD4_XDFFQ_CLKB P1 XD4.XDFFQ.CLKB 1.8151e-17
* device instance cc_P1_XD4_XDFFQ_M r0 *1 0,0
Ccc_P1_XD4_XDFFQ_M P1 XD4.XDFFQ.M 2.4201e-17
* device instance cc_P1_XD4_XDFFQ_MB r0 *1 0,0
Ccc_P1_XD4_XDFFQ_MB P1 XD4.XDFFQ.MB 1.21e-17
* device instance cc_P1_XD4_XDFFQ_S r0 *1 0,0
Ccc_P1_XD4_XDFFQ_S P1 XD4.XDFFQ.S 1.8151e-17
* device instance cc_P1_XD4_XDFFQ_SB r0 *1 0,0
Ccc_P1_XD4_XDFFQ_SB P1 XD4.XDFFQ.SB 1.8151e-17
* device instance cc_P1_XD4_XN2_mid1 r0 *1 0,0
Ccc_P1_XD4_XN2_mid1 P1 XD4.XN2.mid1 1.21e-17
* device instance cc_P1_XD4_XN3_mid1 r0 *1 0,0
Ccc_P1_XD4_XN3_mid1 P1 XD4.XN3.mid1 1.21e-17
* device instance cc_P1_XD4_XN3_mid2 r0 *1 0,0
Ccc_P1_XD4_XN3_mid2 P1 XD4.XN3.mid2 1.21e-17
* device instance cc_P1_XD4_dmodout r0 *1 0,0
Ccc_P1_XD4_dmodout P1 XD4.dmodout 1.21e-17
* device instance cc_P1_XD4_dq r0 *1 0,0
Ccc_P1_XD4_dq P1 XD4.dq 1.8151e-17
* device instance cc_P1_XD4_nm r0 *1 0,0
Ccc_P1_XD4_nm P1 XD4.nm 1.21e-17
* device instance cc_P1_XD4_nt r0 *1 0,0
Ccc_P1_XD4_nt P1 XD4.nt 1.21e-17
* device instance cc_P1_XD4_t1 r0 *1 0,0
Ccc_P1_XD4_t1 P1 XD4.t1 1.21e-17
* device instance cc_P1_XD5_XDFFM_CLKB r0 *1 0,0
Ccc_P1_XD5_XDFFM_CLKB P1 XD5.XDFFM.CLKB 1.8151e-17
* device instance cc_P1_XD5_XDFFM_M r0 *1 0,0
Ccc_P1_XD5_XDFFM_M P1 XD5.XDFFM.M 2.4201e-17
* device instance cc_P1_XD5_XDFFM_MB r0 *1 0,0
Ccc_P1_XD5_XDFFM_MB P1 XD5.XDFFM.MB 1.21e-17
* device instance cc_P1_XD5_XDFFM_S r0 *1 0,0
Ccc_P1_XD5_XDFFM_S P1 XD5.XDFFM.S 1.8151e-17
* device instance cc_P1_XD5_XDFFM_SB r0 *1 0,0
Ccc_P1_XD5_XDFFM_SB P1 XD5.XDFFM.SB 1.8151e-17
* device instance cc_P1_XD5_XDFFQ_CLKB r0 *1 0,0
Ccc_P1_XD5_XDFFQ_CLKB P1 XD5.XDFFQ.CLKB 1.8151e-17
* device instance cc_P1_XD5_XDFFQ_M r0 *1 0,0
Ccc_P1_XD5_XDFFQ_M P1 XD5.XDFFQ.M 2.4201e-17
* device instance cc_P1_XD5_XDFFQ_MB r0 *1 0,0
Ccc_P1_XD5_XDFFQ_MB P1 XD5.XDFFQ.MB 1.21e-17
* device instance cc_P1_XD5_XDFFQ_S r0 *1 0,0
Ccc_P1_XD5_XDFFQ_S P1 XD5.XDFFQ.S 1.8151e-17
* device instance cc_P1_XD5_XDFFQ_SB r0 *1 0,0
Ccc_P1_XD5_XDFFQ_SB P1 XD5.XDFFQ.SB 1.8151e-17
* device instance cc_P1_XD5_XN2_mid1 r0 *1 0,0
Ccc_P1_XD5_XN2_mid1 P1 XD5.XN2.mid1 1.21e-17
* device instance cc_P1_XD5_XN3_mid1 r0 *1 0,0
Ccc_P1_XD5_XN3_mid1 P1 XD5.XN3.mid1 1.21e-17
* device instance cc_P1_XD5_XN3_mid2 r0 *1 0,0
Ccc_P1_XD5_XN3_mid2 P1 XD5.XN3.mid2 1.21e-17
* device instance cc_P1_XD5_dmodout r0 *1 0,0
Ccc_P1_XD5_dmodout P1 XD5.dmodout 1.21e-17
* device instance cc_P1_XD5_dq r0 *1 0,0
Ccc_P1_XD5_dq P1 XD5.dq 1.8151e-17
* device instance cc_P1_XD5_nm r0 *1 0,0
Ccc_P1_XD5_nm P1 XD5.nm 1.21e-17
* device instance cc_P1_XD5_nt r0 *1 0,0
Ccc_P1_XD5_nt P1 XD5.nt 1.21e-17
* device instance cc_P1_XD5_t1 r0 *1 0,0
Ccc_P1_XD5_t1 P1 XD5.t1 1.21e-17
* device instance cc_P1_XFRT_CLKB r0 *1 0,0
Ccc_P1_XFRT_CLKB P1 XFRT.CLKB 1.8151e-17
* device instance cc_P1_XFRT_M r0 *1 0,0
Ccc_P1_XFRT_M P1 XFRT.M 2.4201e-17
* device instance cc_P1_XFRT_MB r0 *1 0,0
Ccc_P1_XFRT_MB P1 XFRT.MB 1.21e-17
* device instance cc_P1_XFRT_S r0 *1 0,0
Ccc_P1_XFRT_S P1 XFRT.S 1.8151e-17
* device instance cc_P1_XFRT_SB r0 *1 0,0
Ccc_P1_XFRT_SB P1 XFRT.SB 1.8151e-17
* device instance cc_P1_ck1 r0 *1 0,0
Ccc_P1_ck1 P1 ck1 5.4452e-17
* device instance cc_P1_ck2 r0 *1 0,0
Ccc_P1_ck2 P1 ck2 5.4452e-17
* device instance cc_P1_ck3 r0 *1 0,0
Ccc_P1_ck3 P1 ck3 5.4452e-17
* device instance cc_P1_ck4 r0 *1 0,0
Ccc_P1_ck4 P1 ck4 5.4452e-17
* device instance cc_P1_ck5 r0 *1 0,0
Ccc_P1_ck5 P1 ck5 5.4452e-17
* device instance cc_P1_mod0 r0 *1 0,0
Ccc_P1_mod0 P1 mod0 2.4201e-17
* device instance cc_P1_mod1 r0 *1 0,0
Ccc_P1_mod1 P1 mod1 2.4201e-17
* device instance cc_P1_mod2 r0 *1 0,0
Ccc_P1_mod2 P1 mod2 2.4201e-17
* device instance cc_P1_mod3 r0 *1 0,0
Ccc_P1_mod3 P1 mod3 2.4201e-17
* device instance cc_P1_mod4 r0 *1 0,0
Ccc_P1_mod4 P1 mod4 2.4201e-17
* device instance cc_P1_net1 r0 *1 0,0
Ccc_P1_net1 P1 net1 1.21e-17
* device instance cc_P2_P3 r0 *1 0,0
Ccc_P2_P3 P2 P3 6.05e-18
* device instance cc_P2_P4 r0 *1 0,0
Ccc_P2_P4 P2 P4 6.05e-18
* device instance cc_P2_P5 r0 *1 0,0
Ccc_P2_P5 P2 P5 6.05e-18
* device instance cc_P2_VDD_DIV r0 *1 0,0
Ccc_P2_VDD_DIV P2 VDD_DIV 2.17809e-16
* device instance cc_P2_VSS r0 *1 0,0
Ccc_P2_VSS P2 VSS 3.63015e-16
* device instance cc_P2_XD0_XDFFM_CLKB r0 *1 0,0
Ccc_P2_XD0_XDFFM_CLKB P2 XD0.XDFFM.CLKB 1.8151e-17
* device instance cc_P2_XD0_XDFFM_M r0 *1 0,0
Ccc_P2_XD0_XDFFM_M P2 XD0.XDFFM.M 2.4201e-17
* device instance cc_P2_XD0_XDFFM_MB r0 *1 0,0
Ccc_P2_XD0_XDFFM_MB P2 XD0.XDFFM.MB 1.21e-17
* device instance cc_P2_XD0_XDFFM_S r0 *1 0,0
Ccc_P2_XD0_XDFFM_S P2 XD0.XDFFM.S 1.8151e-17
* device instance cc_P2_XD0_XDFFM_SB r0 *1 0,0
Ccc_P2_XD0_XDFFM_SB P2 XD0.XDFFM.SB 1.8151e-17
* device instance cc_P2_XD0_XDFFQ_CLKB r0 *1 0,0
Ccc_P2_XD0_XDFFQ_CLKB P2 XD0.XDFFQ.CLKB 1.8151e-17
* device instance cc_P2_XD0_XDFFQ_M r0 *1 0,0
Ccc_P2_XD0_XDFFQ_M P2 XD0.XDFFQ.M 2.4201e-17
* device instance cc_P2_XD0_XDFFQ_MB r0 *1 0,0
Ccc_P2_XD0_XDFFQ_MB P2 XD0.XDFFQ.MB 1.21e-17
* device instance cc_P2_XD0_XDFFQ_S r0 *1 0,0
Ccc_P2_XD0_XDFFQ_S P2 XD0.XDFFQ.S 1.8151e-17
* device instance cc_P2_XD0_XDFFQ_SB r0 *1 0,0
Ccc_P2_XD0_XDFFQ_SB P2 XD0.XDFFQ.SB 1.8151e-17
* device instance cc_P2_XD0_XNOR_midp r0 *1 0,0
Ccc_P2_XD0_XNOR_midp P2 XD0.XNOR.midp 1.21e-17
* device instance cc_P2_XD0_dmodout r0 *1 0,0
Ccc_P2_XD0_dmodout P2 XD0.dmodout 1.21e-17
* device instance cc_P2_XD0_dq r0 *1 0,0
Ccc_P2_XD0_dq P2 XD0.dq 1.21e-17
* device instance cc_P2_XD0_nm r0 *1 0,0
Ccc_P2_XD0_nm P2 XD0.nm 1.8151e-17
* device instance cc_P2_XD0_nt r0 *1 0,0
Ccc_P2_XD0_nt P2 XD0.nt 2.4201e-17
* device instance cc_P2_XD0_t1 r0 *1 0,0
Ccc_P2_XD0_t1 P2 XD0.t1 1.21e-17
* device instance cc_P2_XD1_XDFFM_CLKB r0 *1 0,0
Ccc_P2_XD1_XDFFM_CLKB P2 XD1.XDFFM.CLKB 1.8151e-17
* device instance cc_P2_XD1_XDFFM_M r0 *1 0,0
Ccc_P2_XD1_XDFFM_M P2 XD1.XDFFM.M 2.4201e-17
* device instance cc_P2_XD1_XDFFM_MB r0 *1 0,0
Ccc_P2_XD1_XDFFM_MB P2 XD1.XDFFM.MB 1.21e-17
* device instance cc_P2_XD1_XDFFM_S r0 *1 0,0
Ccc_P2_XD1_XDFFM_S P2 XD1.XDFFM.S 1.8151e-17
* device instance cc_P2_XD1_XDFFM_SB r0 *1 0,0
Ccc_P2_XD1_XDFFM_SB P2 XD1.XDFFM.SB 1.8151e-17
* device instance cc_P2_XD1_XDFFQ_CLKB r0 *1 0,0
Ccc_P2_XD1_XDFFQ_CLKB P2 XD1.XDFFQ.CLKB 1.8151e-17
* device instance cc_P2_XD1_XDFFQ_M r0 *1 0,0
Ccc_P2_XD1_XDFFQ_M P2 XD1.XDFFQ.M 2.4201e-17
* device instance cc_P2_XD1_XDFFQ_MB r0 *1 0,0
Ccc_P2_XD1_XDFFQ_MB P2 XD1.XDFFQ.MB 1.21e-17
* device instance cc_P2_XD1_XDFFQ_S r0 *1 0,0
Ccc_P2_XD1_XDFFQ_S P2 XD1.XDFFQ.S 1.8151e-17
* device instance cc_P2_XD1_XDFFQ_SB r0 *1 0,0
Ccc_P2_XD1_XDFFQ_SB P2 XD1.XDFFQ.SB 1.8151e-17
* device instance cc_P2_XD1_XNOR_midp r0 *1 0,0
Ccc_P2_XD1_XNOR_midp P2 XD1.XNOR.midp 1.21e-17
* device instance cc_P2_XD1_dmodout r0 *1 0,0
Ccc_P2_XD1_dmodout P2 XD1.dmodout 1.21e-17
* device instance cc_P2_XD1_dq r0 *1 0,0
Ccc_P2_XD1_dq P2 XD1.dq 1.21e-17
* device instance cc_P2_XD1_nm r0 *1 0,0
Ccc_P2_XD1_nm P2 XD1.nm 1.8151e-17
* device instance cc_P2_XD1_nt r0 *1 0,0
Ccc_P2_XD1_nt P2 XD1.nt 2.4201e-17
* device instance cc_P2_XD1_t1 r0 *1 0,0
Ccc_P2_XD1_t1 P2 XD1.t1 1.21e-17
* device instance cc_P2_XD2_XDFFM_CLKB r0 *1 0,0
Ccc_P2_XD2_XDFFM_CLKB P2 XD2.XDFFM.CLKB 1.8151e-17
* device instance cc_P2_XD2_XDFFM_M r0 *1 0,0
Ccc_P2_XD2_XDFFM_M P2 XD2.XDFFM.M 2.4201e-17
* device instance cc_P2_XD2_XDFFM_MB r0 *1 0,0
Ccc_P2_XD2_XDFFM_MB P2 XD2.XDFFM.MB 1.21e-17
* device instance cc_P2_XD2_XDFFM_S r0 *1 0,0
Ccc_P2_XD2_XDFFM_S P2 XD2.XDFFM.S 1.8151e-17
* device instance cc_P2_XD2_XDFFM_SB r0 *1 0,0
Ccc_P2_XD2_XDFFM_SB P2 XD2.XDFFM.SB 1.8151e-17
* device instance cc_P2_XD2_XDFFQ_CLKB r0 *1 0,0
Ccc_P2_XD2_XDFFQ_CLKB P2 XD2.XDFFQ.CLKB 1.8151e-17
* device instance cc_P2_XD2_XDFFQ_M r0 *1 0,0
Ccc_P2_XD2_XDFFQ_M P2 XD2.XDFFQ.M 2.4201e-17
* device instance cc_P2_XD2_XDFFQ_MB r0 *1 0,0
Ccc_P2_XD2_XDFFQ_MB P2 XD2.XDFFQ.MB 1.21e-17
* device instance cc_P2_XD2_XDFFQ_S r0 *1 0,0
Ccc_P2_XD2_XDFFQ_S P2 XD2.XDFFQ.S 1.8151e-17
* device instance cc_P2_XD2_XDFFQ_SB r0 *1 0,0
Ccc_P2_XD2_XDFFQ_SB P2 XD2.XDFFQ.SB 1.8151e-17
* device instance cc_P2_XD2_XN2_mid1 r0 *1 0,0
Ccc_P2_XD2_XN2_mid1 P2 XD2.XN2.mid1 1.21e-17
* device instance cc_P2_XD2_XN3_mid1 r0 *1 0,0
Ccc_P2_XD2_XN3_mid1 P2 XD2.XN3.mid1 6.05e-18
* device instance cc_P2_XD2_XN3_mid2 r0 *1 0,0
Ccc_P2_XD2_XN3_mid2 P2 XD2.XN3.mid2 1.21e-17
* device instance cc_P2_XD2_dmodout r0 *1 0,0
Ccc_P2_XD2_dmodout P2 XD2.dmodout 1.21e-17
* device instance cc_P2_XD2_dq r0 *1 0,0
Ccc_P2_XD2_dq P2 XD2.dq 1.8151e-17
* device instance cc_P2_XD2_nm r0 *1 0,0
Ccc_P2_XD2_nm P2 XD2.nm 1.21e-17
* device instance cc_P2_XD2_nt r0 *1 0,0
Ccc_P2_XD2_nt P2 XD2.nt 1.21e-17
* device instance cc_P2_XD2_t1 r0 *1 0,0
Ccc_P2_XD2_t1 P2 XD2.t1 1.21e-17
* device instance cc_P2_XD3_XDFFM_CLKB r0 *1 0,0
Ccc_P2_XD3_XDFFM_CLKB P2 XD3.XDFFM.CLKB 1.8151e-17
* device instance cc_P2_XD3_XDFFM_M r0 *1 0,0
Ccc_P2_XD3_XDFFM_M P2 XD3.XDFFM.M 2.4201e-17
* device instance cc_P2_XD3_XDFFM_MB r0 *1 0,0
Ccc_P2_XD3_XDFFM_MB P2 XD3.XDFFM.MB 1.21e-17
* device instance cc_P2_XD3_XDFFM_S r0 *1 0,0
Ccc_P2_XD3_XDFFM_S P2 XD3.XDFFM.S 1.8151e-17
* device instance cc_P2_XD3_XDFFM_SB r0 *1 0,0
Ccc_P2_XD3_XDFFM_SB P2 XD3.XDFFM.SB 1.8151e-17
* device instance cc_P2_XD3_XDFFQ_CLKB r0 *1 0,0
Ccc_P2_XD3_XDFFQ_CLKB P2 XD3.XDFFQ.CLKB 1.8151e-17
* device instance cc_P2_XD3_XDFFQ_M r0 *1 0,0
Ccc_P2_XD3_XDFFQ_M P2 XD3.XDFFQ.M 2.4201e-17
* device instance cc_P2_XD3_XDFFQ_MB r0 *1 0,0
Ccc_P2_XD3_XDFFQ_MB P2 XD3.XDFFQ.MB 1.21e-17
* device instance cc_P2_XD3_XDFFQ_S r0 *1 0,0
Ccc_P2_XD3_XDFFQ_S P2 XD3.XDFFQ.S 1.8151e-17
* device instance cc_P2_XD3_XDFFQ_SB r0 *1 0,0
Ccc_P2_XD3_XDFFQ_SB P2 XD3.XDFFQ.SB 1.8151e-17
* device instance cc_P2_XD3_XN2_mid1 r0 *1 0,0
Ccc_P2_XD3_XN2_mid1 P2 XD3.XN2.mid1 1.21e-17
* device instance cc_P2_XD3_XN3_mid1 r0 *1 0,0
Ccc_P2_XD3_XN3_mid1 P2 XD3.XN3.mid1 1.21e-17
* device instance cc_P2_XD3_XN3_mid2 r0 *1 0,0
Ccc_P2_XD3_XN3_mid2 P2 XD3.XN3.mid2 1.21e-17
* device instance cc_P2_XD3_dmodout r0 *1 0,0
Ccc_P2_XD3_dmodout P2 XD3.dmodout 1.21e-17
* device instance cc_P2_XD3_dq r0 *1 0,0
Ccc_P2_XD3_dq P2 XD3.dq 1.8151e-17
* device instance cc_P2_XD3_nm r0 *1 0,0
Ccc_P2_XD3_nm P2 XD3.nm 1.21e-17
* device instance cc_P2_XD3_nt r0 *1 0,0
Ccc_P2_XD3_nt P2 XD3.nt 1.21e-17
* device instance cc_P2_XD3_t1 r0 *1 0,0
Ccc_P2_XD3_t1 P2 XD3.t1 1.21e-17
* device instance cc_P2_XD4_XDFFM_CLKB r0 *1 0,0
Ccc_P2_XD4_XDFFM_CLKB P2 XD4.XDFFM.CLKB 1.8151e-17
* device instance cc_P2_XD4_XDFFM_M r0 *1 0,0
Ccc_P2_XD4_XDFFM_M P2 XD4.XDFFM.M 2.4201e-17
* device instance cc_P2_XD4_XDFFM_MB r0 *1 0,0
Ccc_P2_XD4_XDFFM_MB P2 XD4.XDFFM.MB 1.21e-17
* device instance cc_P2_XD4_XDFFM_S r0 *1 0,0
Ccc_P2_XD4_XDFFM_S P2 XD4.XDFFM.S 1.8151e-17
* device instance cc_P2_XD4_XDFFM_SB r0 *1 0,0
Ccc_P2_XD4_XDFFM_SB P2 XD4.XDFFM.SB 1.8151e-17
* device instance cc_P2_XD4_XDFFQ_CLKB r0 *1 0,0
Ccc_P2_XD4_XDFFQ_CLKB P2 XD4.XDFFQ.CLKB 1.8151e-17
* device instance cc_P2_XD4_XDFFQ_M r0 *1 0,0
Ccc_P2_XD4_XDFFQ_M P2 XD4.XDFFQ.M 2.4201e-17
* device instance cc_P2_XD4_XDFFQ_MB r0 *1 0,0
Ccc_P2_XD4_XDFFQ_MB P2 XD4.XDFFQ.MB 1.21e-17
* device instance cc_P2_XD4_XDFFQ_S r0 *1 0,0
Ccc_P2_XD4_XDFFQ_S P2 XD4.XDFFQ.S 1.8151e-17
* device instance cc_P2_XD4_XDFFQ_SB r0 *1 0,0
Ccc_P2_XD4_XDFFQ_SB P2 XD4.XDFFQ.SB 1.8151e-17
* device instance cc_P2_XD4_XN2_mid1 r0 *1 0,0
Ccc_P2_XD4_XN2_mid1 P2 XD4.XN2.mid1 1.21e-17
* device instance cc_P2_XD4_XN3_mid1 r0 *1 0,0
Ccc_P2_XD4_XN3_mid1 P2 XD4.XN3.mid1 1.21e-17
* device instance cc_P2_XD4_XN3_mid2 r0 *1 0,0
Ccc_P2_XD4_XN3_mid2 P2 XD4.XN3.mid2 1.21e-17
* device instance cc_P2_XD4_dmodout r0 *1 0,0
Ccc_P2_XD4_dmodout P2 XD4.dmodout 1.21e-17
* device instance cc_P2_XD4_dq r0 *1 0,0
Ccc_P2_XD4_dq P2 XD4.dq 1.8151e-17
* device instance cc_P2_XD4_nm r0 *1 0,0
Ccc_P2_XD4_nm P2 XD4.nm 1.21e-17
* device instance cc_P2_XD4_nt r0 *1 0,0
Ccc_P2_XD4_nt P2 XD4.nt 1.21e-17
* device instance cc_P2_XD4_t1 r0 *1 0,0
Ccc_P2_XD4_t1 P2 XD4.t1 1.21e-17
* device instance cc_P2_XD5_XDFFM_CLKB r0 *1 0,0
Ccc_P2_XD5_XDFFM_CLKB P2 XD5.XDFFM.CLKB 1.8151e-17
* device instance cc_P2_XD5_XDFFM_M r0 *1 0,0
Ccc_P2_XD5_XDFFM_M P2 XD5.XDFFM.M 2.4201e-17
* device instance cc_P2_XD5_XDFFM_MB r0 *1 0,0
Ccc_P2_XD5_XDFFM_MB P2 XD5.XDFFM.MB 1.21e-17
* device instance cc_P2_XD5_XDFFM_S r0 *1 0,0
Ccc_P2_XD5_XDFFM_S P2 XD5.XDFFM.S 1.8151e-17
* device instance cc_P2_XD5_XDFFM_SB r0 *1 0,0
Ccc_P2_XD5_XDFFM_SB P2 XD5.XDFFM.SB 1.8151e-17
* device instance cc_P2_XD5_XDFFQ_CLKB r0 *1 0,0
Ccc_P2_XD5_XDFFQ_CLKB P2 XD5.XDFFQ.CLKB 1.8151e-17
* device instance cc_P2_XD5_XDFFQ_M r0 *1 0,0
Ccc_P2_XD5_XDFFQ_M P2 XD5.XDFFQ.M 2.4201e-17
* device instance cc_P2_XD5_XDFFQ_MB r0 *1 0,0
Ccc_P2_XD5_XDFFQ_MB P2 XD5.XDFFQ.MB 1.21e-17
* device instance cc_P2_XD5_XDFFQ_S r0 *1 0,0
Ccc_P2_XD5_XDFFQ_S P2 XD5.XDFFQ.S 1.8151e-17
* device instance cc_P2_XD5_XDFFQ_SB r0 *1 0,0
Ccc_P2_XD5_XDFFQ_SB P2 XD5.XDFFQ.SB 1.8151e-17
* device instance cc_P2_XD5_XN2_mid1 r0 *1 0,0
Ccc_P2_XD5_XN2_mid1 P2 XD5.XN2.mid1 1.21e-17
* device instance cc_P2_XD5_XN3_mid1 r0 *1 0,0
Ccc_P2_XD5_XN3_mid1 P2 XD5.XN3.mid1 1.21e-17
* device instance cc_P2_XD5_XN3_mid2 r0 *1 0,0
Ccc_P2_XD5_XN3_mid2 P2 XD5.XN3.mid2 1.21e-17
* device instance cc_P2_XD5_dmodout r0 *1 0,0
Ccc_P2_XD5_dmodout P2 XD5.dmodout 1.21e-17
* device instance cc_P2_XD5_dq r0 *1 0,0
Ccc_P2_XD5_dq P2 XD5.dq 1.8151e-17
* device instance cc_P2_XD5_nm r0 *1 0,0
Ccc_P2_XD5_nm P2 XD5.nm 1.21e-17
* device instance cc_P2_XD5_nt r0 *1 0,0
Ccc_P2_XD5_nt P2 XD5.nt 1.21e-17
* device instance cc_P2_XD5_t1 r0 *1 0,0
Ccc_P2_XD5_t1 P2 XD5.t1 1.21e-17
* device instance cc_P2_XFRT_CLKB r0 *1 0,0
Ccc_P2_XFRT_CLKB P2 XFRT.CLKB 1.8151e-17
* device instance cc_P2_XFRT_M r0 *1 0,0
Ccc_P2_XFRT_M P2 XFRT.M 2.4201e-17
* device instance cc_P2_XFRT_MB r0 *1 0,0
Ccc_P2_XFRT_MB P2 XFRT.MB 1.21e-17
* device instance cc_P2_XFRT_S r0 *1 0,0
Ccc_P2_XFRT_S P2 XFRT.S 1.8151e-17
* device instance cc_P2_XFRT_SB r0 *1 0,0
Ccc_P2_XFRT_SB P2 XFRT.SB 1.8151e-17
* device instance cc_P2_ck1 r0 *1 0,0
Ccc_P2_ck1 P2 ck1 5.4452e-17
* device instance cc_P2_ck2 r0 *1 0,0
Ccc_P2_ck2 P2 ck2 5.4452e-17
* device instance cc_P2_ck3 r0 *1 0,0
Ccc_P2_ck3 P2 ck3 5.4452e-17
* device instance cc_P2_ck4 r0 *1 0,0
Ccc_P2_ck4 P2 ck4 5.4452e-17
* device instance cc_P2_ck5 r0 *1 0,0
Ccc_P2_ck5 P2 ck5 5.4452e-17
* device instance cc_P2_mod0 r0 *1 0,0
Ccc_P2_mod0 P2 mod0 2.4201e-17
* device instance cc_P2_mod1 r0 *1 0,0
Ccc_P2_mod1 P2 mod1 2.4201e-17
* device instance cc_P2_mod2 r0 *1 0,0
Ccc_P2_mod2 P2 mod2 2.4201e-17
* device instance cc_P2_mod3 r0 *1 0,0
Ccc_P2_mod3 P2 mod3 2.4201e-17
* device instance cc_P2_mod4 r0 *1 0,0
Ccc_P2_mod4 P2 mod4 2.4201e-17
* device instance cc_P2_net1 r0 *1 0,0
Ccc_P2_net1 P2 net1 1.21e-17
* device instance cc_P3_P4 r0 *1 0,0
Ccc_P3_P4 P3 P4 6.05e-18
* device instance cc_P3_P5 r0 *1 0,0
Ccc_P3_P5 P3 P5 6.05e-18
* device instance cc_P3_VDD_DIV r0 *1 0,0
Ccc_P3_VDD_DIV P3 VDD_DIV 3.14613e-16
* device instance cc_P3_VSS r0 *1 0,0
Ccc_P3_VSS P3 VSS 2.78311e-16
* device instance cc_P3_XD0_XDFFM_CLKB r0 *1 0,0
Ccc_P3_XD0_XDFFM_CLKB P3 XD0.XDFFM.CLKB 1.8151e-17
* device instance cc_P3_XD0_XDFFM_M r0 *1 0,0
Ccc_P3_XD0_XDFFM_M P3 XD0.XDFFM.M 2.4201e-17
* device instance cc_P3_XD0_XDFFM_MB r0 *1 0,0
Ccc_P3_XD0_XDFFM_MB P3 XD0.XDFFM.MB 1.21e-17
* device instance cc_P3_XD0_XDFFM_S r0 *1 0,0
Ccc_P3_XD0_XDFFM_S P3 XD0.XDFFM.S 1.8151e-17
* device instance cc_P3_XD0_XDFFM_SB r0 *1 0,0
Ccc_P3_XD0_XDFFM_SB P3 XD0.XDFFM.SB 1.8151e-17
* device instance cc_P3_XD0_XDFFQ_CLKB r0 *1 0,0
Ccc_P3_XD0_XDFFQ_CLKB P3 XD0.XDFFQ.CLKB 1.8151e-17
* device instance cc_P3_XD0_XDFFQ_M r0 *1 0,0
Ccc_P3_XD0_XDFFQ_M P3 XD0.XDFFQ.M 2.4201e-17
* device instance cc_P3_XD0_XDFFQ_MB r0 *1 0,0
Ccc_P3_XD0_XDFFQ_MB P3 XD0.XDFFQ.MB 1.21e-17
* device instance cc_P3_XD0_XDFFQ_S r0 *1 0,0
Ccc_P3_XD0_XDFFQ_S P3 XD0.XDFFQ.S 1.8151e-17
* device instance cc_P3_XD0_XDFFQ_SB r0 *1 0,0
Ccc_P3_XD0_XDFFQ_SB P3 XD0.XDFFQ.SB 1.8151e-17
* device instance cc_P3_XD0_XNOR_midp r0 *1 0,0
Ccc_P3_XD0_XNOR_midp P3 XD0.XNOR.midp 1.21e-17
* device instance cc_P3_XD0_dmodout r0 *1 0,0
Ccc_P3_XD0_dmodout P3 XD0.dmodout 1.21e-17
* device instance cc_P3_XD0_dq r0 *1 0,0
Ccc_P3_XD0_dq P3 XD0.dq 1.21e-17
* device instance cc_P3_XD0_nm r0 *1 0,0
Ccc_P3_XD0_nm P3 XD0.nm 1.8151e-17
* device instance cc_P3_XD0_nt r0 *1 0,0
Ccc_P3_XD0_nt P3 XD0.nt 2.4201e-17
* device instance cc_P3_XD0_t1 r0 *1 0,0
Ccc_P3_XD0_t1 P3 XD0.t1 1.21e-17
* device instance cc_P3_XD1_XDFFM_CLKB r0 *1 0,0
Ccc_P3_XD1_XDFFM_CLKB P3 XD1.XDFFM.CLKB 1.8151e-17
* device instance cc_P3_XD1_XDFFM_M r0 *1 0,0
Ccc_P3_XD1_XDFFM_M P3 XD1.XDFFM.M 2.4201e-17
* device instance cc_P3_XD1_XDFFM_MB r0 *1 0,0
Ccc_P3_XD1_XDFFM_MB P3 XD1.XDFFM.MB 1.21e-17
* device instance cc_P3_XD1_XDFFM_S r0 *1 0,0
Ccc_P3_XD1_XDFFM_S P3 XD1.XDFFM.S 1.8151e-17
* device instance cc_P3_XD1_XDFFM_SB r0 *1 0,0
Ccc_P3_XD1_XDFFM_SB P3 XD1.XDFFM.SB 1.8151e-17
* device instance cc_P3_XD1_XDFFQ_CLKB r0 *1 0,0
Ccc_P3_XD1_XDFFQ_CLKB P3 XD1.XDFFQ.CLKB 1.8151e-17
* device instance cc_P3_XD1_XDFFQ_M r0 *1 0,0
Ccc_P3_XD1_XDFFQ_M P3 XD1.XDFFQ.M 2.4201e-17
* device instance cc_P3_XD1_XDFFQ_MB r0 *1 0,0
Ccc_P3_XD1_XDFFQ_MB P3 XD1.XDFFQ.MB 1.21e-17
* device instance cc_P3_XD1_XDFFQ_S r0 *1 0,0
Ccc_P3_XD1_XDFFQ_S P3 XD1.XDFFQ.S 1.8151e-17
* device instance cc_P3_XD1_XDFFQ_SB r0 *1 0,0
Ccc_P3_XD1_XDFFQ_SB P3 XD1.XDFFQ.SB 1.8151e-17
* device instance cc_P3_XD1_XNOR_midp r0 *1 0,0
Ccc_P3_XD1_XNOR_midp P3 XD1.XNOR.midp 1.21e-17
* device instance cc_P3_XD1_dmodout r0 *1 0,0
Ccc_P3_XD1_dmodout P3 XD1.dmodout 1.21e-17
* device instance cc_P3_XD1_dq r0 *1 0,0
Ccc_P3_XD1_dq P3 XD1.dq 1.21e-17
* device instance cc_P3_XD1_nm r0 *1 0,0
Ccc_P3_XD1_nm P3 XD1.nm 1.8151e-17
* device instance cc_P3_XD1_nt r0 *1 0,0
Ccc_P3_XD1_nt P3 XD1.nt 2.4201e-17
* device instance cc_P3_XD1_t1 r0 *1 0,0
Ccc_P3_XD1_t1 P3 XD1.t1 1.21e-17
* device instance cc_P3_XD2_XDFFM_CLKB r0 *1 0,0
Ccc_P3_XD2_XDFFM_CLKB P3 XD2.XDFFM.CLKB 1.8151e-17
* device instance cc_P3_XD2_XDFFM_M r0 *1 0,0
Ccc_P3_XD2_XDFFM_M P3 XD2.XDFFM.M 2.4201e-17
* device instance cc_P3_XD2_XDFFM_MB r0 *1 0,0
Ccc_P3_XD2_XDFFM_MB P3 XD2.XDFFM.MB 1.21e-17
* device instance cc_P3_XD2_XDFFM_S r0 *1 0,0
Ccc_P3_XD2_XDFFM_S P3 XD2.XDFFM.S 1.8151e-17
* device instance cc_P3_XD2_XDFFM_SB r0 *1 0,0
Ccc_P3_XD2_XDFFM_SB P3 XD2.XDFFM.SB 1.8151e-17
* device instance cc_P3_XD2_XDFFQ_CLKB r0 *1 0,0
Ccc_P3_XD2_XDFFQ_CLKB P3 XD2.XDFFQ.CLKB 1.8151e-17
* device instance cc_P3_XD2_XDFFQ_M r0 *1 0,0
Ccc_P3_XD2_XDFFQ_M P3 XD2.XDFFQ.M 2.4201e-17
* device instance cc_P3_XD2_XDFFQ_MB r0 *1 0,0
Ccc_P3_XD2_XDFFQ_MB P3 XD2.XDFFQ.MB 1.21e-17
* device instance cc_P3_XD2_XDFFQ_S r0 *1 0,0
Ccc_P3_XD2_XDFFQ_S P3 XD2.XDFFQ.S 1.8151e-17
* device instance cc_P3_XD2_XDFFQ_SB r0 *1 0,0
Ccc_P3_XD2_XDFFQ_SB P3 XD2.XDFFQ.SB 1.8151e-17
* device instance cc_P3_XD2_XNOR_midp r0 *1 0,0
Ccc_P3_XD2_XNOR_midp P3 XD2.XNOR.midp 1.21e-17
* device instance cc_P3_XD2_dmodout r0 *1 0,0
Ccc_P3_XD2_dmodout P3 XD2.dmodout 1.21e-17
* device instance cc_P3_XD2_dq r0 *1 0,0
Ccc_P3_XD2_dq P3 XD2.dq 1.21e-17
* device instance cc_P3_XD2_nm r0 *1 0,0
Ccc_P3_XD2_nm P3 XD2.nm 1.8151e-17
* device instance cc_P3_XD2_nt r0 *1 0,0
Ccc_P3_XD2_nt P3 XD2.nt 2.4201e-17
* device instance cc_P3_XD2_t1 r0 *1 0,0
Ccc_P3_XD2_t1 P3 XD2.t1 1.21e-17
* device instance cc_P3_XD3_XDFFM_CLKB r0 *1 0,0
Ccc_P3_XD3_XDFFM_CLKB P3 XD3.XDFFM.CLKB 1.8151e-17
* device instance cc_P3_XD3_XDFFM_M r0 *1 0,0
Ccc_P3_XD3_XDFFM_M P3 XD3.XDFFM.M 2.4201e-17
* device instance cc_P3_XD3_XDFFM_MB r0 *1 0,0
Ccc_P3_XD3_XDFFM_MB P3 XD3.XDFFM.MB 1.21e-17
* device instance cc_P3_XD3_XDFFM_S r0 *1 0,0
Ccc_P3_XD3_XDFFM_S P3 XD3.XDFFM.S 1.8151e-17
* device instance cc_P3_XD3_XDFFM_SB r0 *1 0,0
Ccc_P3_XD3_XDFFM_SB P3 XD3.XDFFM.SB 1.8151e-17
* device instance cc_P3_XD3_XDFFQ_CLKB r0 *1 0,0
Ccc_P3_XD3_XDFFQ_CLKB P3 XD3.XDFFQ.CLKB 1.8151e-17
* device instance cc_P3_XD3_XDFFQ_M r0 *1 0,0
Ccc_P3_XD3_XDFFQ_M P3 XD3.XDFFQ.M 2.4201e-17
* device instance cc_P3_XD3_XDFFQ_MB r0 *1 0,0
Ccc_P3_XD3_XDFFQ_MB P3 XD3.XDFFQ.MB 1.21e-17
* device instance cc_P3_XD3_XDFFQ_S r0 *1 0,0
Ccc_P3_XD3_XDFFQ_S P3 XD3.XDFFQ.S 1.8151e-17
* device instance cc_P3_XD3_XDFFQ_SB r0 *1 0,0
Ccc_P3_XD3_XDFFQ_SB P3 XD3.XDFFQ.SB 1.8151e-17
* device instance cc_P3_XD3_XN2_mid1 r0 *1 0,0
Ccc_P3_XD3_XN2_mid1 P3 XD3.XN2.mid1 1.21e-17
* device instance cc_P3_XD3_XN3_mid1 r0 *1 0,0
Ccc_P3_XD3_XN3_mid1 P3 XD3.XN3.mid1 6.05e-18
* device instance cc_P3_XD3_XN3_mid2 r0 *1 0,0
Ccc_P3_XD3_XN3_mid2 P3 XD3.XN3.mid2 1.21e-17
* device instance cc_P3_XD3_dmodout r0 *1 0,0
Ccc_P3_XD3_dmodout P3 XD3.dmodout 1.21e-17
* device instance cc_P3_XD3_dq r0 *1 0,0
Ccc_P3_XD3_dq P3 XD3.dq 1.8151e-17
* device instance cc_P3_XD3_nm r0 *1 0,0
Ccc_P3_XD3_nm P3 XD3.nm 1.21e-17
* device instance cc_P3_XD3_nt r0 *1 0,0
Ccc_P3_XD3_nt P3 XD3.nt 1.21e-17
* device instance cc_P3_XD3_t1 r0 *1 0,0
Ccc_P3_XD3_t1 P3 XD3.t1 1.21e-17
* device instance cc_P3_XD4_XDFFM_CLKB r0 *1 0,0
Ccc_P3_XD4_XDFFM_CLKB P3 XD4.XDFFM.CLKB 1.8151e-17
* device instance cc_P3_XD4_XDFFM_M r0 *1 0,0
Ccc_P3_XD4_XDFFM_M P3 XD4.XDFFM.M 2.4201e-17
* device instance cc_P3_XD4_XDFFM_MB r0 *1 0,0
Ccc_P3_XD4_XDFFM_MB P3 XD4.XDFFM.MB 1.21e-17
* device instance cc_P3_XD4_XDFFM_S r0 *1 0,0
Ccc_P3_XD4_XDFFM_S P3 XD4.XDFFM.S 1.8151e-17
* device instance cc_P3_XD4_XDFFM_SB r0 *1 0,0
Ccc_P3_XD4_XDFFM_SB P3 XD4.XDFFM.SB 1.8151e-17
* device instance cc_P3_XD4_XDFFQ_CLKB r0 *1 0,0
Ccc_P3_XD4_XDFFQ_CLKB P3 XD4.XDFFQ.CLKB 1.8151e-17
* device instance cc_P3_XD4_XDFFQ_M r0 *1 0,0
Ccc_P3_XD4_XDFFQ_M P3 XD4.XDFFQ.M 2.4201e-17
* device instance cc_P3_XD4_XDFFQ_MB r0 *1 0,0
Ccc_P3_XD4_XDFFQ_MB P3 XD4.XDFFQ.MB 1.21e-17
* device instance cc_P3_XD4_XDFFQ_S r0 *1 0,0
Ccc_P3_XD4_XDFFQ_S P3 XD4.XDFFQ.S 1.8151e-17
* device instance cc_P3_XD4_XDFFQ_SB r0 *1 0,0
Ccc_P3_XD4_XDFFQ_SB P3 XD4.XDFFQ.SB 1.8151e-17
* device instance cc_P3_XD4_XN2_mid1 r0 *1 0,0
Ccc_P3_XD4_XN2_mid1 P3 XD4.XN2.mid1 1.21e-17
* device instance cc_P3_XD4_XN3_mid1 r0 *1 0,0
Ccc_P3_XD4_XN3_mid1 P3 XD4.XN3.mid1 1.21e-17
* device instance cc_P3_XD4_XN3_mid2 r0 *1 0,0
Ccc_P3_XD4_XN3_mid2 P3 XD4.XN3.mid2 1.21e-17
* device instance cc_P3_XD4_dmodout r0 *1 0,0
Ccc_P3_XD4_dmodout P3 XD4.dmodout 1.21e-17
* device instance cc_P3_XD4_dq r0 *1 0,0
Ccc_P3_XD4_dq P3 XD4.dq 1.8151e-17
* device instance cc_P3_XD4_nm r0 *1 0,0
Ccc_P3_XD4_nm P3 XD4.nm 1.21e-17
* device instance cc_P3_XD4_nt r0 *1 0,0
Ccc_P3_XD4_nt P3 XD4.nt 1.21e-17
* device instance cc_P3_XD4_t1 r0 *1 0,0
Ccc_P3_XD4_t1 P3 XD4.t1 1.21e-17
* device instance cc_P3_XD5_XDFFM_CLKB r0 *1 0,0
Ccc_P3_XD5_XDFFM_CLKB P3 XD5.XDFFM.CLKB 1.8151e-17
* device instance cc_P3_XD5_XDFFM_M r0 *1 0,0
Ccc_P3_XD5_XDFFM_M P3 XD5.XDFFM.M 2.4201e-17
* device instance cc_P3_XD5_XDFFM_MB r0 *1 0,0
Ccc_P3_XD5_XDFFM_MB P3 XD5.XDFFM.MB 1.21e-17
* device instance cc_P3_XD5_XDFFM_S r0 *1 0,0
Ccc_P3_XD5_XDFFM_S P3 XD5.XDFFM.S 1.8151e-17
* device instance cc_P3_XD5_XDFFM_SB r0 *1 0,0
Ccc_P3_XD5_XDFFM_SB P3 XD5.XDFFM.SB 1.8151e-17
* device instance cc_P3_XD5_XDFFQ_CLKB r0 *1 0,0
Ccc_P3_XD5_XDFFQ_CLKB P3 XD5.XDFFQ.CLKB 1.8151e-17
* device instance cc_P3_XD5_XDFFQ_M r0 *1 0,0
Ccc_P3_XD5_XDFFQ_M P3 XD5.XDFFQ.M 2.4201e-17
* device instance cc_P3_XD5_XDFFQ_MB r0 *1 0,0
Ccc_P3_XD5_XDFFQ_MB P3 XD5.XDFFQ.MB 1.21e-17
* device instance cc_P3_XD5_XDFFQ_S r0 *1 0,0
Ccc_P3_XD5_XDFFQ_S P3 XD5.XDFFQ.S 1.8151e-17
* device instance cc_P3_XD5_XDFFQ_SB r0 *1 0,0
Ccc_P3_XD5_XDFFQ_SB P3 XD5.XDFFQ.SB 1.8151e-17
* device instance cc_P3_XD5_XN2_mid1 r0 *1 0,0
Ccc_P3_XD5_XN2_mid1 P3 XD5.XN2.mid1 1.21e-17
* device instance cc_P3_XD5_XN3_mid1 r0 *1 0,0
Ccc_P3_XD5_XN3_mid1 P3 XD5.XN3.mid1 1.21e-17
* device instance cc_P3_XD5_XN3_mid2 r0 *1 0,0
Ccc_P3_XD5_XN3_mid2 P3 XD5.XN3.mid2 1.21e-17
* device instance cc_P3_XD5_dmodout r0 *1 0,0
Ccc_P3_XD5_dmodout P3 XD5.dmodout 1.21e-17
* device instance cc_P3_XD5_dq r0 *1 0,0
Ccc_P3_XD5_dq P3 XD5.dq 1.8151e-17
* device instance cc_P3_XD5_nm r0 *1 0,0
Ccc_P3_XD5_nm P3 XD5.nm 1.21e-17
* device instance cc_P3_XD5_nt r0 *1 0,0
Ccc_P3_XD5_nt P3 XD5.nt 1.21e-17
* device instance cc_P3_XD5_t1 r0 *1 0,0
Ccc_P3_XD5_t1 P3 XD5.t1 1.21e-17
* device instance cc_P3_XFRT_CLKB r0 *1 0,0
Ccc_P3_XFRT_CLKB P3 XFRT.CLKB 1.8151e-17
* device instance cc_P3_XFRT_M r0 *1 0,0
Ccc_P3_XFRT_M P3 XFRT.M 2.4201e-17
* device instance cc_P3_XFRT_MB r0 *1 0,0
Ccc_P3_XFRT_MB P3 XFRT.MB 1.21e-17
* device instance cc_P3_XFRT_S r0 *1 0,0
Ccc_P3_XFRT_S P3 XFRT.S 1.8151e-17
* device instance cc_P3_XFRT_SB r0 *1 0,0
Ccc_P3_XFRT_SB P3 XFRT.SB 1.8151e-17
* device instance cc_P3_ck1 r0 *1 0,0
Ccc_P3_ck1 P3 ck1 5.4452e-17
* device instance cc_P3_ck2 r0 *1 0,0
Ccc_P3_ck2 P3 ck2 5.4452e-17
* device instance cc_P3_ck3 r0 *1 0,0
Ccc_P3_ck3 P3 ck3 5.4452e-17
* device instance cc_P3_ck4 r0 *1 0,0
Ccc_P3_ck4 P3 ck4 5.4452e-17
* device instance cc_P3_ck5 r0 *1 0,0
Ccc_P3_ck5 P3 ck5 5.4452e-17
* device instance cc_P3_mod0 r0 *1 0,0
Ccc_P3_mod0 P3 mod0 2.4201e-17
* device instance cc_P3_mod1 r0 *1 0,0
Ccc_P3_mod1 P3 mod1 2.4201e-17
* device instance cc_P3_mod2 r0 *1 0,0
Ccc_P3_mod2 P3 mod2 2.4201e-17
* device instance cc_P3_mod3 r0 *1 0,0
Ccc_P3_mod3 P3 mod3 2.4201e-17
* device instance cc_P3_mod4 r0 *1 0,0
Ccc_P3_mod4 P3 mod4 2.4201e-17
* device instance cc_P3_net1 r0 *1 0,0
Ccc_P3_net1 P3 net1 1.21e-17
* device instance cc_P4_P5 r0 *1 0,0
Ccc_P4_P5 P4 P5 6.05e-18
* device instance cc_P4_VDD_DIV r0 *1 0,0
Ccc_P4_VDD_DIV P4 VDD_DIV 4.11417e-16
* device instance cc_P4_VSS r0 *1 0,0
Ccc_P4_VSS P4 VSS 1.93608e-16
* device instance cc_P4_XD0_XDFFM_CLKB r0 *1 0,0
Ccc_P4_XD0_XDFFM_CLKB P4 XD0.XDFFM.CLKB 1.8151e-17
* device instance cc_P4_XD0_XDFFM_M r0 *1 0,0
Ccc_P4_XD0_XDFFM_M P4 XD0.XDFFM.M 2.4201e-17
* device instance cc_P4_XD0_XDFFM_MB r0 *1 0,0
Ccc_P4_XD0_XDFFM_MB P4 XD0.XDFFM.MB 1.21e-17
* device instance cc_P4_XD0_XDFFM_S r0 *1 0,0
Ccc_P4_XD0_XDFFM_S P4 XD0.XDFFM.S 1.8151e-17
* device instance cc_P4_XD0_XDFFM_SB r0 *1 0,0
Ccc_P4_XD0_XDFFM_SB P4 XD0.XDFFM.SB 1.8151e-17
* device instance cc_P4_XD0_XDFFQ_CLKB r0 *1 0,0
Ccc_P4_XD0_XDFFQ_CLKB P4 XD0.XDFFQ.CLKB 1.8151e-17
* device instance cc_P4_XD0_XDFFQ_M r0 *1 0,0
Ccc_P4_XD0_XDFFQ_M P4 XD0.XDFFQ.M 2.4201e-17
* device instance cc_P4_XD0_XDFFQ_MB r0 *1 0,0
Ccc_P4_XD0_XDFFQ_MB P4 XD0.XDFFQ.MB 1.21e-17
* device instance cc_P4_XD0_XDFFQ_S r0 *1 0,0
Ccc_P4_XD0_XDFFQ_S P4 XD0.XDFFQ.S 1.8151e-17
* device instance cc_P4_XD0_XDFFQ_SB r0 *1 0,0
Ccc_P4_XD0_XDFFQ_SB P4 XD0.XDFFQ.SB 1.8151e-17
* device instance cc_P4_XD0_XNOR_midp r0 *1 0,0
Ccc_P4_XD0_XNOR_midp P4 XD0.XNOR.midp 1.21e-17
* device instance cc_P4_XD0_dmodout r0 *1 0,0
Ccc_P4_XD0_dmodout P4 XD0.dmodout 1.21e-17
* device instance cc_P4_XD0_dq r0 *1 0,0
Ccc_P4_XD0_dq P4 XD0.dq 1.21e-17
* device instance cc_P4_XD0_nm r0 *1 0,0
Ccc_P4_XD0_nm P4 XD0.nm 1.8151e-17
* device instance cc_P4_XD0_nt r0 *1 0,0
Ccc_P4_XD0_nt P4 XD0.nt 2.4201e-17
* device instance cc_P4_XD0_t1 r0 *1 0,0
Ccc_P4_XD0_t1 P4 XD0.t1 1.21e-17
* device instance cc_P4_XD1_XDFFM_CLKB r0 *1 0,0
Ccc_P4_XD1_XDFFM_CLKB P4 XD1.XDFFM.CLKB 1.8151e-17
* device instance cc_P4_XD1_XDFFM_M r0 *1 0,0
Ccc_P4_XD1_XDFFM_M P4 XD1.XDFFM.M 2.4201e-17
* device instance cc_P4_XD1_XDFFM_MB r0 *1 0,0
Ccc_P4_XD1_XDFFM_MB P4 XD1.XDFFM.MB 1.21e-17
* device instance cc_P4_XD1_XDFFM_S r0 *1 0,0
Ccc_P4_XD1_XDFFM_S P4 XD1.XDFFM.S 1.8151e-17
* device instance cc_P4_XD1_XDFFM_SB r0 *1 0,0
Ccc_P4_XD1_XDFFM_SB P4 XD1.XDFFM.SB 1.8151e-17
* device instance cc_P4_XD1_XDFFQ_CLKB r0 *1 0,0
Ccc_P4_XD1_XDFFQ_CLKB P4 XD1.XDFFQ.CLKB 1.8151e-17
* device instance cc_P4_XD1_XDFFQ_M r0 *1 0,0
Ccc_P4_XD1_XDFFQ_M P4 XD1.XDFFQ.M 2.4201e-17
* device instance cc_P4_XD1_XDFFQ_MB r0 *1 0,0
Ccc_P4_XD1_XDFFQ_MB P4 XD1.XDFFQ.MB 1.21e-17
* device instance cc_P4_XD1_XDFFQ_S r0 *1 0,0
Ccc_P4_XD1_XDFFQ_S P4 XD1.XDFFQ.S 1.8151e-17
* device instance cc_P4_XD1_XDFFQ_SB r0 *1 0,0
Ccc_P4_XD1_XDFFQ_SB P4 XD1.XDFFQ.SB 1.8151e-17
* device instance cc_P4_XD1_XNOR_midp r0 *1 0,0
Ccc_P4_XD1_XNOR_midp P4 XD1.XNOR.midp 1.21e-17
* device instance cc_P4_XD1_dmodout r0 *1 0,0
Ccc_P4_XD1_dmodout P4 XD1.dmodout 1.21e-17
* device instance cc_P4_XD1_dq r0 *1 0,0
Ccc_P4_XD1_dq P4 XD1.dq 1.21e-17
* device instance cc_P4_XD1_nm r0 *1 0,0
Ccc_P4_XD1_nm P4 XD1.nm 1.8151e-17
* device instance cc_P4_XD1_nt r0 *1 0,0
Ccc_P4_XD1_nt P4 XD1.nt 2.4201e-17
* device instance cc_P4_XD1_t1 r0 *1 0,0
Ccc_P4_XD1_t1 P4 XD1.t1 1.21e-17
* device instance cc_P4_XD2_XDFFM_CLKB r0 *1 0,0
Ccc_P4_XD2_XDFFM_CLKB P4 XD2.XDFFM.CLKB 1.8151e-17
* device instance cc_P4_XD2_XDFFM_M r0 *1 0,0
Ccc_P4_XD2_XDFFM_M P4 XD2.XDFFM.M 2.4201e-17
* device instance cc_P4_XD2_XDFFM_MB r0 *1 0,0
Ccc_P4_XD2_XDFFM_MB P4 XD2.XDFFM.MB 1.21e-17
* device instance cc_P4_XD2_XDFFM_S r0 *1 0,0
Ccc_P4_XD2_XDFFM_S P4 XD2.XDFFM.S 1.8151e-17
* device instance cc_P4_XD2_XDFFM_SB r0 *1 0,0
Ccc_P4_XD2_XDFFM_SB P4 XD2.XDFFM.SB 1.8151e-17
* device instance cc_P4_XD2_XDFFQ_CLKB r0 *1 0,0
Ccc_P4_XD2_XDFFQ_CLKB P4 XD2.XDFFQ.CLKB 1.8151e-17
* device instance cc_P4_XD2_XDFFQ_M r0 *1 0,0
Ccc_P4_XD2_XDFFQ_M P4 XD2.XDFFQ.M 2.4201e-17
* device instance cc_P4_XD2_XDFFQ_MB r0 *1 0,0
Ccc_P4_XD2_XDFFQ_MB P4 XD2.XDFFQ.MB 1.21e-17
* device instance cc_P4_XD2_XDFFQ_S r0 *1 0,0
Ccc_P4_XD2_XDFFQ_S P4 XD2.XDFFQ.S 1.8151e-17
* device instance cc_P4_XD2_XDFFQ_SB r0 *1 0,0
Ccc_P4_XD2_XDFFQ_SB P4 XD2.XDFFQ.SB 1.8151e-17
* device instance cc_P4_XD2_XNOR_midp r0 *1 0,0
Ccc_P4_XD2_XNOR_midp P4 XD2.XNOR.midp 1.21e-17
* device instance cc_P4_XD2_dmodout r0 *1 0,0
Ccc_P4_XD2_dmodout P4 XD2.dmodout 1.21e-17
* device instance cc_P4_XD2_dq r0 *1 0,0
Ccc_P4_XD2_dq P4 XD2.dq 1.21e-17
* device instance cc_P4_XD2_nm r0 *1 0,0
Ccc_P4_XD2_nm P4 XD2.nm 1.8151e-17
* device instance cc_P4_XD2_nt r0 *1 0,0
Ccc_P4_XD2_nt P4 XD2.nt 2.4201e-17
* device instance cc_P4_XD2_t1 r0 *1 0,0
Ccc_P4_XD2_t1 P4 XD2.t1 1.21e-17
* device instance cc_P4_XD3_XDFFM_CLKB r0 *1 0,0
Ccc_P4_XD3_XDFFM_CLKB P4 XD3.XDFFM.CLKB 1.8151e-17
* device instance cc_P4_XD3_XDFFM_M r0 *1 0,0
Ccc_P4_XD3_XDFFM_M P4 XD3.XDFFM.M 2.4201e-17
* device instance cc_P4_XD3_XDFFM_MB r0 *1 0,0
Ccc_P4_XD3_XDFFM_MB P4 XD3.XDFFM.MB 1.21e-17
* device instance cc_P4_XD3_XDFFM_S r0 *1 0,0
Ccc_P4_XD3_XDFFM_S P4 XD3.XDFFM.S 1.8151e-17
* device instance cc_P4_XD3_XDFFM_SB r0 *1 0,0
Ccc_P4_XD3_XDFFM_SB P4 XD3.XDFFM.SB 1.8151e-17
* device instance cc_P4_XD3_XDFFQ_CLKB r0 *1 0,0
Ccc_P4_XD3_XDFFQ_CLKB P4 XD3.XDFFQ.CLKB 1.8151e-17
* device instance cc_P4_XD3_XDFFQ_M r0 *1 0,0
Ccc_P4_XD3_XDFFQ_M P4 XD3.XDFFQ.M 2.4201e-17
* device instance cc_P4_XD3_XDFFQ_MB r0 *1 0,0
Ccc_P4_XD3_XDFFQ_MB P4 XD3.XDFFQ.MB 1.21e-17
* device instance cc_P4_XD3_XDFFQ_S r0 *1 0,0
Ccc_P4_XD3_XDFFQ_S P4 XD3.XDFFQ.S 1.8151e-17
* device instance cc_P4_XD3_XDFFQ_SB r0 *1 0,0
Ccc_P4_XD3_XDFFQ_SB P4 XD3.XDFFQ.SB 1.8151e-17
* device instance cc_P4_XD3_XNOR_midp r0 *1 0,0
Ccc_P4_XD3_XNOR_midp P4 XD3.XNOR.midp 1.21e-17
* device instance cc_P4_XD3_dmodout r0 *1 0,0
Ccc_P4_XD3_dmodout P4 XD3.dmodout 1.21e-17
* device instance cc_P4_XD3_dq r0 *1 0,0
Ccc_P4_XD3_dq P4 XD3.dq 1.21e-17
* device instance cc_P4_XD3_nm r0 *1 0,0
Ccc_P4_XD3_nm P4 XD3.nm 1.8151e-17
* device instance cc_P4_XD3_nt r0 *1 0,0
Ccc_P4_XD3_nt P4 XD3.nt 2.4201e-17
* device instance cc_P4_XD3_t1 r0 *1 0,0
Ccc_P4_XD3_t1 P4 XD3.t1 1.21e-17
* device instance cc_P4_XD4_XDFFM_CLKB r0 *1 0,0
Ccc_P4_XD4_XDFFM_CLKB P4 XD4.XDFFM.CLKB 1.8151e-17
* device instance cc_P4_XD4_XDFFM_M r0 *1 0,0
Ccc_P4_XD4_XDFFM_M P4 XD4.XDFFM.M 2.4201e-17
* device instance cc_P4_XD4_XDFFM_MB r0 *1 0,0
Ccc_P4_XD4_XDFFM_MB P4 XD4.XDFFM.MB 1.21e-17
* device instance cc_P4_XD4_XDFFM_S r0 *1 0,0
Ccc_P4_XD4_XDFFM_S P4 XD4.XDFFM.S 1.8151e-17
* device instance cc_P4_XD4_XDFFM_SB r0 *1 0,0
Ccc_P4_XD4_XDFFM_SB P4 XD4.XDFFM.SB 1.8151e-17
* device instance cc_P4_XD4_XDFFQ_CLKB r0 *1 0,0
Ccc_P4_XD4_XDFFQ_CLKB P4 XD4.XDFFQ.CLKB 1.8151e-17
* device instance cc_P4_XD4_XDFFQ_M r0 *1 0,0
Ccc_P4_XD4_XDFFQ_M P4 XD4.XDFFQ.M 2.4201e-17
* device instance cc_P4_XD4_XDFFQ_MB r0 *1 0,0
Ccc_P4_XD4_XDFFQ_MB P4 XD4.XDFFQ.MB 1.21e-17
* device instance cc_P4_XD4_XDFFQ_S r0 *1 0,0
Ccc_P4_XD4_XDFFQ_S P4 XD4.XDFFQ.S 1.8151e-17
* device instance cc_P4_XD4_XDFFQ_SB r0 *1 0,0
Ccc_P4_XD4_XDFFQ_SB P4 XD4.XDFFQ.SB 1.8151e-17
* device instance cc_P4_XD4_XN2_mid1 r0 *1 0,0
Ccc_P4_XD4_XN2_mid1 P4 XD4.XN2.mid1 1.21e-17
* device instance cc_P4_XD4_XN3_mid1 r0 *1 0,0
Ccc_P4_XD4_XN3_mid1 P4 XD4.XN3.mid1 6.05e-18
* device instance cc_P4_XD4_XN3_mid2 r0 *1 0,0
Ccc_P4_XD4_XN3_mid2 P4 XD4.XN3.mid2 1.21e-17
* device instance cc_P4_XD4_dmodout r0 *1 0,0
Ccc_P4_XD4_dmodout P4 XD4.dmodout 1.21e-17
* device instance cc_P4_XD4_dq r0 *1 0,0
Ccc_P4_XD4_dq P4 XD4.dq 1.8151e-17
* device instance cc_P4_XD4_nm r0 *1 0,0
Ccc_P4_XD4_nm P4 XD4.nm 1.21e-17
* device instance cc_P4_XD4_nt r0 *1 0,0
Ccc_P4_XD4_nt P4 XD4.nt 1.21e-17
* device instance cc_P4_XD4_t1 r0 *1 0,0
Ccc_P4_XD4_t1 P4 XD4.t1 1.21e-17
* device instance cc_P4_XD5_XDFFM_CLKB r0 *1 0,0
Ccc_P4_XD5_XDFFM_CLKB P4 XD5.XDFFM.CLKB 1.8151e-17
* device instance cc_P4_XD5_XDFFM_M r0 *1 0,0
Ccc_P4_XD5_XDFFM_M P4 XD5.XDFFM.M 2.4201e-17
* device instance cc_P4_XD5_XDFFM_MB r0 *1 0,0
Ccc_P4_XD5_XDFFM_MB P4 XD5.XDFFM.MB 1.21e-17
* device instance cc_P4_XD5_XDFFM_S r0 *1 0,0
Ccc_P4_XD5_XDFFM_S P4 XD5.XDFFM.S 1.8151e-17
* device instance cc_P4_XD5_XDFFM_SB r0 *1 0,0
Ccc_P4_XD5_XDFFM_SB P4 XD5.XDFFM.SB 1.8151e-17
* device instance cc_P4_XD5_XDFFQ_CLKB r0 *1 0,0
Ccc_P4_XD5_XDFFQ_CLKB P4 XD5.XDFFQ.CLKB 1.8151e-17
* device instance cc_P4_XD5_XDFFQ_M r0 *1 0,0
Ccc_P4_XD5_XDFFQ_M P4 XD5.XDFFQ.M 2.4201e-17
* device instance cc_P4_XD5_XDFFQ_MB r0 *1 0,0
Ccc_P4_XD5_XDFFQ_MB P4 XD5.XDFFQ.MB 1.21e-17
* device instance cc_P4_XD5_XDFFQ_S r0 *1 0,0
Ccc_P4_XD5_XDFFQ_S P4 XD5.XDFFQ.S 1.8151e-17
* device instance cc_P4_XD5_XDFFQ_SB r0 *1 0,0
Ccc_P4_XD5_XDFFQ_SB P4 XD5.XDFFQ.SB 1.8151e-17
* device instance cc_P4_XD5_XN2_mid1 r0 *1 0,0
Ccc_P4_XD5_XN2_mid1 P4 XD5.XN2.mid1 1.21e-17
* device instance cc_P4_XD5_XN3_mid1 r0 *1 0,0
Ccc_P4_XD5_XN3_mid1 P4 XD5.XN3.mid1 1.21e-17
* device instance cc_P4_XD5_XN3_mid2 r0 *1 0,0
Ccc_P4_XD5_XN3_mid2 P4 XD5.XN3.mid2 1.21e-17
* device instance cc_P4_XD5_dmodout r0 *1 0,0
Ccc_P4_XD5_dmodout P4 XD5.dmodout 1.21e-17
* device instance cc_P4_XD5_dq r0 *1 0,0
Ccc_P4_XD5_dq P4 XD5.dq 1.8151e-17
* device instance cc_P4_XD5_nm r0 *1 0,0
Ccc_P4_XD5_nm P4 XD5.nm 1.21e-17
* device instance cc_P4_XD5_nt r0 *1 0,0
Ccc_P4_XD5_nt P4 XD5.nt 1.21e-17
* device instance cc_P4_XD5_t1 r0 *1 0,0
Ccc_P4_XD5_t1 P4 XD5.t1 1.21e-17
* device instance cc_P4_XFRT_CLKB r0 *1 0,0
Ccc_P4_XFRT_CLKB P4 XFRT.CLKB 1.8151e-17
* device instance cc_P4_XFRT_M r0 *1 0,0
Ccc_P4_XFRT_M P4 XFRT.M 2.4201e-17
* device instance cc_P4_XFRT_MB r0 *1 0,0
Ccc_P4_XFRT_MB P4 XFRT.MB 1.21e-17
* device instance cc_P4_XFRT_S r0 *1 0,0
Ccc_P4_XFRT_S P4 XFRT.S 1.8151e-17
* device instance cc_P4_XFRT_SB r0 *1 0,0
Ccc_P4_XFRT_SB P4 XFRT.SB 1.8151e-17
* device instance cc_P4_ck1 r0 *1 0,0
Ccc_P4_ck1 P4 ck1 5.4452e-17
* device instance cc_P4_ck2 r0 *1 0,0
Ccc_P4_ck2 P4 ck2 5.4452e-17
* device instance cc_P4_ck3 r0 *1 0,0
Ccc_P4_ck3 P4 ck3 5.4452e-17
* device instance cc_P4_ck4 r0 *1 0,0
Ccc_P4_ck4 P4 ck4 5.4452e-17
* device instance cc_P4_ck5 r0 *1 0,0
Ccc_P4_ck5 P4 ck5 5.4452e-17
* device instance cc_P4_mod0 r0 *1 0,0
Ccc_P4_mod0 P4 mod0 2.4201e-17
* device instance cc_P4_mod1 r0 *1 0,0
Ccc_P4_mod1 P4 mod1 2.4201e-17
* device instance cc_P4_mod2 r0 *1 0,0
Ccc_P4_mod2 P4 mod2 2.4201e-17
* device instance cc_P4_mod3 r0 *1 0,0
Ccc_P4_mod3 P4 mod3 2.4201e-17
* device instance cc_P4_mod4 r0 *1 0,0
Ccc_P4_mod4 P4 mod4 2.4201e-17
* device instance cc_P4_net1 r0 *1 0,0
Ccc_P4_net1 P4 net1 1.21e-17
* device instance cc_P5_VDD_DIV r0 *1 0,0
Ccc_P5_VDD_DIV P5 VDD_DIV 5.08221e-16
* device instance cc_P5_VSS r0 *1 0,0
Ccc_P5_VSS P5 VSS 1.08905e-16
* device instance cc_P5_XD0_XDFFM_CLKB r0 *1 0,0
Ccc_P5_XD0_XDFFM_CLKB P5 XD0.XDFFM.CLKB 1.8151e-17
* device instance cc_P5_XD0_XDFFM_M r0 *1 0,0
Ccc_P5_XD0_XDFFM_M P5 XD0.XDFFM.M 2.4201e-17
* device instance cc_P5_XD0_XDFFM_MB r0 *1 0,0
Ccc_P5_XD0_XDFFM_MB P5 XD0.XDFFM.MB 1.21e-17
* device instance cc_P5_XD0_XDFFM_S r0 *1 0,0
Ccc_P5_XD0_XDFFM_S P5 XD0.XDFFM.S 1.8151e-17
* device instance cc_P5_XD0_XDFFM_SB r0 *1 0,0
Ccc_P5_XD0_XDFFM_SB P5 XD0.XDFFM.SB 1.8151e-17
* device instance cc_P5_XD0_XDFFQ_CLKB r0 *1 0,0
Ccc_P5_XD0_XDFFQ_CLKB P5 XD0.XDFFQ.CLKB 1.8151e-17
* device instance cc_P5_XD0_XDFFQ_M r0 *1 0,0
Ccc_P5_XD0_XDFFQ_M P5 XD0.XDFFQ.M 2.4201e-17
* device instance cc_P5_XD0_XDFFQ_MB r0 *1 0,0
Ccc_P5_XD0_XDFFQ_MB P5 XD0.XDFFQ.MB 1.21e-17
* device instance cc_P5_XD0_XDFFQ_S r0 *1 0,0
Ccc_P5_XD0_XDFFQ_S P5 XD0.XDFFQ.S 1.8151e-17
* device instance cc_P5_XD0_XDFFQ_SB r0 *1 0,0
Ccc_P5_XD0_XDFFQ_SB P5 XD0.XDFFQ.SB 1.8151e-17
* device instance cc_P5_XD0_XNOR_midp r0 *1 0,0
Ccc_P5_XD0_XNOR_midp P5 XD0.XNOR.midp 1.21e-17
* device instance cc_P5_XD0_dmodout r0 *1 0,0
Ccc_P5_XD0_dmodout P5 XD0.dmodout 1.21e-17
* device instance cc_P5_XD0_dq r0 *1 0,0
Ccc_P5_XD0_dq P5 XD0.dq 1.21e-17
* device instance cc_P5_XD0_nm r0 *1 0,0
Ccc_P5_XD0_nm P5 XD0.nm 1.8151e-17
* device instance cc_P5_XD0_nt r0 *1 0,0
Ccc_P5_XD0_nt P5 XD0.nt 2.4201e-17
* device instance cc_P5_XD0_t1 r0 *1 0,0
Ccc_P5_XD0_t1 P5 XD0.t1 1.21e-17
* device instance cc_P5_XD1_XDFFM_CLKB r0 *1 0,0
Ccc_P5_XD1_XDFFM_CLKB P5 XD1.XDFFM.CLKB 1.8151e-17
* device instance cc_P5_XD1_XDFFM_M r0 *1 0,0
Ccc_P5_XD1_XDFFM_M P5 XD1.XDFFM.M 2.4201e-17
* device instance cc_P5_XD1_XDFFM_MB r0 *1 0,0
Ccc_P5_XD1_XDFFM_MB P5 XD1.XDFFM.MB 1.21e-17
* device instance cc_P5_XD1_XDFFM_S r0 *1 0,0
Ccc_P5_XD1_XDFFM_S P5 XD1.XDFFM.S 1.8151e-17
* device instance cc_P5_XD1_XDFFM_SB r0 *1 0,0
Ccc_P5_XD1_XDFFM_SB P5 XD1.XDFFM.SB 1.8151e-17
* device instance cc_P5_XD1_XDFFQ_CLKB r0 *1 0,0
Ccc_P5_XD1_XDFFQ_CLKB P5 XD1.XDFFQ.CLKB 1.8151e-17
* device instance cc_P5_XD1_XDFFQ_M r0 *1 0,0
Ccc_P5_XD1_XDFFQ_M P5 XD1.XDFFQ.M 2.4201e-17
* device instance cc_P5_XD1_XDFFQ_MB r0 *1 0,0
Ccc_P5_XD1_XDFFQ_MB P5 XD1.XDFFQ.MB 1.21e-17
* device instance cc_P5_XD1_XDFFQ_S r0 *1 0,0
Ccc_P5_XD1_XDFFQ_S P5 XD1.XDFFQ.S 1.8151e-17
* device instance cc_P5_XD1_XDFFQ_SB r0 *1 0,0
Ccc_P5_XD1_XDFFQ_SB P5 XD1.XDFFQ.SB 1.8151e-17
* device instance cc_P5_XD1_XNOR_midp r0 *1 0,0
Ccc_P5_XD1_XNOR_midp P5 XD1.XNOR.midp 1.21e-17
* device instance cc_P5_XD1_dmodout r0 *1 0,0
Ccc_P5_XD1_dmodout P5 XD1.dmodout 1.21e-17
* device instance cc_P5_XD1_dq r0 *1 0,0
Ccc_P5_XD1_dq P5 XD1.dq 1.21e-17
* device instance cc_P5_XD1_nm r0 *1 0,0
Ccc_P5_XD1_nm P5 XD1.nm 1.8151e-17
* device instance cc_P5_XD1_nt r0 *1 0,0
Ccc_P5_XD1_nt P5 XD1.nt 2.4201e-17
* device instance cc_P5_XD1_t1 r0 *1 0,0
Ccc_P5_XD1_t1 P5 XD1.t1 1.21e-17
* device instance cc_P5_XD2_XDFFM_CLKB r0 *1 0,0
Ccc_P5_XD2_XDFFM_CLKB P5 XD2.XDFFM.CLKB 1.8151e-17
* device instance cc_P5_XD2_XDFFM_M r0 *1 0,0
Ccc_P5_XD2_XDFFM_M P5 XD2.XDFFM.M 2.4201e-17
* device instance cc_P5_XD2_XDFFM_MB r0 *1 0,0
Ccc_P5_XD2_XDFFM_MB P5 XD2.XDFFM.MB 1.21e-17
* device instance cc_P5_XD2_XDFFM_S r0 *1 0,0
Ccc_P5_XD2_XDFFM_S P5 XD2.XDFFM.S 1.8151e-17
* device instance cc_P5_XD2_XDFFM_SB r0 *1 0,0
Ccc_P5_XD2_XDFFM_SB P5 XD2.XDFFM.SB 1.8151e-17
* device instance cc_P5_XD2_XDFFQ_CLKB r0 *1 0,0
Ccc_P5_XD2_XDFFQ_CLKB P5 XD2.XDFFQ.CLKB 1.8151e-17
* device instance cc_P5_XD2_XDFFQ_M r0 *1 0,0
Ccc_P5_XD2_XDFFQ_M P5 XD2.XDFFQ.M 2.4201e-17
* device instance cc_P5_XD2_XDFFQ_MB r0 *1 0,0
Ccc_P5_XD2_XDFFQ_MB P5 XD2.XDFFQ.MB 1.21e-17
* device instance cc_P5_XD2_XDFFQ_S r0 *1 0,0
Ccc_P5_XD2_XDFFQ_S P5 XD2.XDFFQ.S 1.8151e-17
* device instance cc_P5_XD2_XDFFQ_SB r0 *1 0,0
Ccc_P5_XD2_XDFFQ_SB P5 XD2.XDFFQ.SB 1.8151e-17
* device instance cc_P5_XD2_XNOR_midp r0 *1 0,0
Ccc_P5_XD2_XNOR_midp P5 XD2.XNOR.midp 1.21e-17
* device instance cc_P5_XD2_dmodout r0 *1 0,0
Ccc_P5_XD2_dmodout P5 XD2.dmodout 1.21e-17
* device instance cc_P5_XD2_dq r0 *1 0,0
Ccc_P5_XD2_dq P5 XD2.dq 1.21e-17
* device instance cc_P5_XD2_nm r0 *1 0,0
Ccc_P5_XD2_nm P5 XD2.nm 1.8151e-17
* device instance cc_P5_XD2_nt r0 *1 0,0
Ccc_P5_XD2_nt P5 XD2.nt 2.4201e-17
* device instance cc_P5_XD2_t1 r0 *1 0,0
Ccc_P5_XD2_t1 P5 XD2.t1 1.21e-17
* device instance cc_P5_XD3_XDFFM_CLKB r0 *1 0,0
Ccc_P5_XD3_XDFFM_CLKB P5 XD3.XDFFM.CLKB 1.8151e-17
* device instance cc_P5_XD3_XDFFM_M r0 *1 0,0
Ccc_P5_XD3_XDFFM_M P5 XD3.XDFFM.M 2.4201e-17
* device instance cc_P5_XD3_XDFFM_MB r0 *1 0,0
Ccc_P5_XD3_XDFFM_MB P5 XD3.XDFFM.MB 1.21e-17
* device instance cc_P5_XD3_XDFFM_S r0 *1 0,0
Ccc_P5_XD3_XDFFM_S P5 XD3.XDFFM.S 1.8151e-17
* device instance cc_P5_XD3_XDFFM_SB r0 *1 0,0
Ccc_P5_XD3_XDFFM_SB P5 XD3.XDFFM.SB 1.8151e-17
* device instance cc_P5_XD3_XDFFQ_CLKB r0 *1 0,0
Ccc_P5_XD3_XDFFQ_CLKB P5 XD3.XDFFQ.CLKB 1.8151e-17
* device instance cc_P5_XD3_XDFFQ_M r0 *1 0,0
Ccc_P5_XD3_XDFFQ_M P5 XD3.XDFFQ.M 2.4201e-17
* device instance cc_P5_XD3_XDFFQ_MB r0 *1 0,0
Ccc_P5_XD3_XDFFQ_MB P5 XD3.XDFFQ.MB 1.21e-17
* device instance cc_P5_XD3_XDFFQ_S r0 *1 0,0
Ccc_P5_XD3_XDFFQ_S P5 XD3.XDFFQ.S 1.8151e-17
* device instance cc_P5_XD3_XDFFQ_SB r0 *1 0,0
Ccc_P5_XD3_XDFFQ_SB P5 XD3.XDFFQ.SB 1.8151e-17
* device instance cc_P5_XD3_XNOR_midp r0 *1 0,0
Ccc_P5_XD3_XNOR_midp P5 XD3.XNOR.midp 1.21e-17
* device instance cc_P5_XD3_dmodout r0 *1 0,0
Ccc_P5_XD3_dmodout P5 XD3.dmodout 1.21e-17
* device instance cc_P5_XD3_dq r0 *1 0,0
Ccc_P5_XD3_dq P5 XD3.dq 1.21e-17
* device instance cc_P5_XD3_nm r0 *1 0,0
Ccc_P5_XD3_nm P5 XD3.nm 1.8151e-17
* device instance cc_P5_XD3_nt r0 *1 0,0
Ccc_P5_XD3_nt P5 XD3.nt 2.4201e-17
* device instance cc_P5_XD3_t1 r0 *1 0,0
Ccc_P5_XD3_t1 P5 XD3.t1 1.21e-17
* device instance cc_P5_XD4_XDFFM_CLKB r0 *1 0,0
Ccc_P5_XD4_XDFFM_CLKB P5 XD4.XDFFM.CLKB 1.8151e-17
* device instance cc_P5_XD4_XDFFM_M r0 *1 0,0
Ccc_P5_XD4_XDFFM_M P5 XD4.XDFFM.M 2.4201e-17
* device instance cc_P5_XD4_XDFFM_MB r0 *1 0,0
Ccc_P5_XD4_XDFFM_MB P5 XD4.XDFFM.MB 1.21e-17
* device instance cc_P5_XD4_XDFFM_S r0 *1 0,0
Ccc_P5_XD4_XDFFM_S P5 XD4.XDFFM.S 1.8151e-17
* device instance cc_P5_XD4_XDFFM_SB r0 *1 0,0
Ccc_P5_XD4_XDFFM_SB P5 XD4.XDFFM.SB 1.8151e-17
* device instance cc_P5_XD4_XDFFQ_CLKB r0 *1 0,0
Ccc_P5_XD4_XDFFQ_CLKB P5 XD4.XDFFQ.CLKB 1.8151e-17
* device instance cc_P5_XD4_XDFFQ_M r0 *1 0,0
Ccc_P5_XD4_XDFFQ_M P5 XD4.XDFFQ.M 2.4201e-17
* device instance cc_P5_XD4_XDFFQ_MB r0 *1 0,0
Ccc_P5_XD4_XDFFQ_MB P5 XD4.XDFFQ.MB 1.21e-17
* device instance cc_P5_XD4_XDFFQ_S r0 *1 0,0
Ccc_P5_XD4_XDFFQ_S P5 XD4.XDFFQ.S 1.8151e-17
* device instance cc_P5_XD4_XDFFQ_SB r0 *1 0,0
Ccc_P5_XD4_XDFFQ_SB P5 XD4.XDFFQ.SB 1.8151e-17
* device instance cc_P5_XD4_XNOR_midp r0 *1 0,0
Ccc_P5_XD4_XNOR_midp P5 XD4.XNOR.midp 1.21e-17
* device instance cc_P5_XD4_dmodout r0 *1 0,0
Ccc_P5_XD4_dmodout P5 XD4.dmodout 1.21e-17
* device instance cc_P5_XD4_dq r0 *1 0,0
Ccc_P5_XD4_dq P5 XD4.dq 1.21e-17
* device instance cc_P5_XD4_nm r0 *1 0,0
Ccc_P5_XD4_nm P5 XD4.nm 1.8151e-17
* device instance cc_P5_XD4_nt r0 *1 0,0
Ccc_P5_XD4_nt P5 XD4.nt 2.4201e-17
* device instance cc_P5_XD4_t1 r0 *1 0,0
Ccc_P5_XD4_t1 P5 XD4.t1 1.21e-17
* device instance cc_P5_XD5_XDFFM_CLKB r0 *1 0,0
Ccc_P5_XD5_XDFFM_CLKB P5 XD5.XDFFM.CLKB 1.8151e-17
* device instance cc_P5_XD5_XDFFM_M r0 *1 0,0
Ccc_P5_XD5_XDFFM_M P5 XD5.XDFFM.M 2.4201e-17
* device instance cc_P5_XD5_XDFFM_MB r0 *1 0,0
Ccc_P5_XD5_XDFFM_MB P5 XD5.XDFFM.MB 1.21e-17
* device instance cc_P5_XD5_XDFFM_S r0 *1 0,0
Ccc_P5_XD5_XDFFM_S P5 XD5.XDFFM.S 1.8151e-17
* device instance cc_P5_XD5_XDFFM_SB r0 *1 0,0
Ccc_P5_XD5_XDFFM_SB P5 XD5.XDFFM.SB 1.8151e-17
* device instance cc_P5_XD5_XDFFQ_CLKB r0 *1 0,0
Ccc_P5_XD5_XDFFQ_CLKB P5 XD5.XDFFQ.CLKB 1.8151e-17
* device instance cc_P5_XD5_XDFFQ_M r0 *1 0,0
Ccc_P5_XD5_XDFFQ_M P5 XD5.XDFFQ.M 2.4201e-17
* device instance cc_P5_XD5_XDFFQ_MB r0 *1 0,0
Ccc_P5_XD5_XDFFQ_MB P5 XD5.XDFFQ.MB 1.21e-17
* device instance cc_P5_XD5_XDFFQ_S r0 *1 0,0
Ccc_P5_XD5_XDFFQ_S P5 XD5.XDFFQ.S 1.8151e-17
* device instance cc_P5_XD5_XDFFQ_SB r0 *1 0,0
Ccc_P5_XD5_XDFFQ_SB P5 XD5.XDFFQ.SB 1.8151e-17
* device instance cc_P5_XD5_XN2_mid1 r0 *1 0,0
Ccc_P5_XD5_XN2_mid1 P5 XD5.XN2.mid1 1.21e-17
* device instance cc_P5_XD5_XN3_mid1 r0 *1 0,0
Ccc_P5_XD5_XN3_mid1 P5 XD5.XN3.mid1 6.05e-18
* device instance cc_P5_XD5_XN3_mid2 r0 *1 0,0
Ccc_P5_XD5_XN3_mid2 P5 XD5.XN3.mid2 1.21e-17
* device instance cc_P5_XD5_dmodout r0 *1 0,0
Ccc_P5_XD5_dmodout P5 XD5.dmodout 1.21e-17
* device instance cc_P5_XD5_dq r0 *1 0,0
Ccc_P5_XD5_dq P5 XD5.dq 1.8151e-17
* device instance cc_P5_XD5_nm r0 *1 0,0
Ccc_P5_XD5_nm P5 XD5.nm 1.21e-17
* device instance cc_P5_XD5_nt r0 *1 0,0
Ccc_P5_XD5_nt P5 XD5.nt 1.21e-17
* device instance cc_P5_XD5_t1 r0 *1 0,0
Ccc_P5_XD5_t1 P5 XD5.t1 1.21e-17
* device instance cc_P5_XFRT_CLKB r0 *1 0,0
Ccc_P5_XFRT_CLKB P5 XFRT.CLKB 1.8151e-17
* device instance cc_P5_XFRT_M r0 *1 0,0
Ccc_P5_XFRT_M P5 XFRT.M 2.4201e-17
* device instance cc_P5_XFRT_MB r0 *1 0,0
Ccc_P5_XFRT_MB P5 XFRT.MB 1.21e-17
* device instance cc_P5_XFRT_S r0 *1 0,0
Ccc_P5_XFRT_S P5 XFRT.S 1.8151e-17
* device instance cc_P5_XFRT_SB r0 *1 0,0
Ccc_P5_XFRT_SB P5 XFRT.SB 1.8151e-17
* device instance cc_P5_ck1 r0 *1 0,0
Ccc_P5_ck1 P5 ck1 5.4452e-17
* device instance cc_P5_ck2 r0 *1 0,0
Ccc_P5_ck2 P5 ck2 5.4452e-17
* device instance cc_P5_ck3 r0 *1 0,0
Ccc_P5_ck3 P5 ck3 5.4452e-17
* device instance cc_P5_ck4 r0 *1 0,0
Ccc_P5_ck4 P5 ck4 5.4452e-17
* device instance cc_P5_ck5 r0 *1 0,0
Ccc_P5_ck5 P5 ck5 5.4452e-17
* device instance cc_P5_mod0 r0 *1 0,0
Ccc_P5_mod0 P5 mod0 2.4201e-17
* device instance cc_P5_mod1 r0 *1 0,0
Ccc_P5_mod1 P5 mod1 2.4201e-17
* device instance cc_P5_mod2 r0 *1 0,0
Ccc_P5_mod2 P5 mod2 2.4201e-17
* device instance cc_P5_mod3 r0 *1 0,0
Ccc_P5_mod3 P5 mod3 2.4201e-17
* device instance cc_P5_mod4 r0 *1 0,0
Ccc_P5_mod4 P5 mod4 2.4201e-17
* device instance cc_P5_net1 r0 *1 0,0
Ccc_P5_net1 P5 net1 1.21e-17
* device instance cc_VDD_DIV_VSS r0 *1 0,0
Ccc_VDD_DIV_VSS VDD_DIV VSS 1.08905e-16
* device instance cc_VDD_DIV_XD0_XDFFM_CLKB r0 *1 0,0
Ccc_VDD_DIV_XD0_XDFFM_CLKB VDD_DIV XD0.XDFFM.CLKB 2.3394e-17
* device instance cc_VDD_DIV_XD0_XDFFM_M r0 *1 0,0
Ccc_VDD_DIV_XD0_XDFFM_M VDD_DIV XD0.XDFFM.M 2.4201e-17
* device instance cc_VDD_DIV_XD0_XDFFM_MB r0 *1 0,0
Ccc_VDD_DIV_XD0_XDFFM_MB VDD_DIV XD0.XDFFM.MB 1.7344e-17
* device instance cc_VDD_DIV_XD0_XDFFM_S r0 *1 0,0
Ccc_VDD_DIV_XD0_XDFFM_S VDD_DIV XD0.XDFFM.S 1.8151e-17
* device instance cc_VDD_DIV_XD0_XDFFM_SB r0 *1 0,0
Ccc_VDD_DIV_XD0_XDFFM_SB VDD_DIV XD0.XDFFM.SB 2.3394e-17
* device instance cc_VDD_DIV_XD0_XDFFQ_CLKB r0 *1 0,0
Ccc_VDD_DIV_XD0_XDFFQ_CLKB VDD_DIV XD0.XDFFQ.CLKB 2.3394e-17
* device instance cc_VDD_DIV_XD0_XDFFQ_M r0 *1 0,0
Ccc_VDD_DIV_XD0_XDFFQ_M VDD_DIV XD0.XDFFQ.M 2.4201e-17
* device instance cc_VDD_DIV_XD0_XDFFQ_MB r0 *1 0,0
Ccc_VDD_DIV_XD0_XDFFQ_MB VDD_DIV XD0.XDFFQ.MB 1.7344e-17
* device instance cc_VDD_DIV_XD0_XDFFQ_S r0 *1 0,0
Ccc_VDD_DIV_XD0_XDFFQ_S VDD_DIV XD0.XDFFQ.S 1.8151e-17
* device instance cc_VDD_DIV_XD0_XDFFQ_SB r0 *1 0,0
Ccc_VDD_DIV_XD0_XDFFQ_SB VDD_DIV XD0.XDFFQ.SB 2.3394e-17
* device instance cc_VDD_DIV_XD0_XNOR_midp r0 *1 0,0
Ccc_VDD_DIV_XD0_XNOR_midp VDD_DIV XD0.XNOR.midp 1.7344e-17
* device instance cc_VDD_DIV_XD0_dmodout r0 *1 0,0
Ccc_VDD_DIV_XD0_dmodout VDD_DIV XD0.dmodout 1.7344e-17
* device instance cc_VDD_DIV_XD0_dq r0 *1 0,0
Ccc_VDD_DIV_XD0_dq VDD_DIV XD0.dq 1.21e-17
* device instance cc_VDD_DIV_XD0_nm r0 *1 0,0
Ccc_VDD_DIV_XD0_nm VDD_DIV XD0.nm 2.8638e-17
* device instance cc_VDD_DIV_XD0_nt r0 *1 0,0
Ccc_VDD_DIV_XD0_nt VDD_DIV XD0.nt 3.9932e-17
* device instance cc_VDD_DIV_XD0_t1 r0 *1 0,0
Ccc_VDD_DIV_XD0_t1 VDD_DIV XD0.t1 1.7344e-17
* device instance cc_VDD_DIV_XD1_XDFFM_CLKB r0 *1 0,0
Ccc_VDD_DIV_XD1_XDFFM_CLKB VDD_DIV XD1.XDFFM.CLKB 2.3394e-17
* device instance cc_VDD_DIV_XD1_XDFFM_M r0 *1 0,0
Ccc_VDD_DIV_XD1_XDFFM_M VDD_DIV XD1.XDFFM.M 2.4201e-17
* device instance cc_VDD_DIV_XD1_XDFFM_MB r0 *1 0,0
Ccc_VDD_DIV_XD1_XDFFM_MB VDD_DIV XD1.XDFFM.MB 1.7344e-17
* device instance cc_VDD_DIV_XD1_XDFFM_S r0 *1 0,0
Ccc_VDD_DIV_XD1_XDFFM_S VDD_DIV XD1.XDFFM.S 1.8151e-17
* device instance cc_VDD_DIV_XD1_XDFFM_SB r0 *1 0,0
Ccc_VDD_DIV_XD1_XDFFM_SB VDD_DIV XD1.XDFFM.SB 2.3394e-17
* device instance cc_VDD_DIV_XD1_XDFFQ_CLKB r0 *1 0,0
Ccc_VDD_DIV_XD1_XDFFQ_CLKB VDD_DIV XD1.XDFFQ.CLKB 2.3394e-17
* device instance cc_VDD_DIV_XD1_XDFFQ_M r0 *1 0,0
Ccc_VDD_DIV_XD1_XDFFQ_M VDD_DIV XD1.XDFFQ.M 2.4201e-17
* device instance cc_VDD_DIV_XD1_XDFFQ_MB r0 *1 0,0
Ccc_VDD_DIV_XD1_XDFFQ_MB VDD_DIV XD1.XDFFQ.MB 1.7344e-17
* device instance cc_VDD_DIV_XD1_XDFFQ_S r0 *1 0,0
Ccc_VDD_DIV_XD1_XDFFQ_S VDD_DIV XD1.XDFFQ.S 1.8151e-17
* device instance cc_VDD_DIV_XD1_XDFFQ_SB r0 *1 0,0
Ccc_VDD_DIV_XD1_XDFFQ_SB VDD_DIV XD1.XDFFQ.SB 2.3394e-17
* device instance cc_VDD_DIV_XD1_XNOR_midp r0 *1 0,0
Ccc_VDD_DIV_XD1_XNOR_midp VDD_DIV XD1.XNOR.midp 1.7344e-17
* device instance cc_VDD_DIV_XD1_dmodout r0 *1 0,0
Ccc_VDD_DIV_XD1_dmodout VDD_DIV XD1.dmodout 1.7344e-17
* device instance cc_VDD_DIV_XD1_dq r0 *1 0,0
Ccc_VDD_DIV_XD1_dq VDD_DIV XD1.dq 1.21e-17
* device instance cc_VDD_DIV_XD1_nm r0 *1 0,0
Ccc_VDD_DIV_XD1_nm VDD_DIV XD1.nm 2.8638e-17
* device instance cc_VDD_DIV_XD1_nt r0 *1 0,0
Ccc_VDD_DIV_XD1_nt VDD_DIV XD1.nt 3.9932e-17
* device instance cc_VDD_DIV_XD1_t1 r0 *1 0,0
Ccc_VDD_DIV_XD1_t1 VDD_DIV XD1.t1 1.7344e-17
* device instance cc_VDD_DIV_XD2_XDFFM_CLKB r0 *1 0,0
Ccc_VDD_DIV_XD2_XDFFM_CLKB VDD_DIV XD2.XDFFM.CLKB 2.3394e-17
* device instance cc_VDD_DIV_XD2_XDFFM_M r0 *1 0,0
Ccc_VDD_DIV_XD2_XDFFM_M VDD_DIV XD2.XDFFM.M 2.4201e-17
* device instance cc_VDD_DIV_XD2_XDFFM_MB r0 *1 0,0
Ccc_VDD_DIV_XD2_XDFFM_MB VDD_DIV XD2.XDFFM.MB 1.7344e-17
* device instance cc_VDD_DIV_XD2_XDFFM_S r0 *1 0,0
Ccc_VDD_DIV_XD2_XDFFM_S VDD_DIV XD2.XDFFM.S 1.8151e-17
* device instance cc_VDD_DIV_XD2_XDFFM_SB r0 *1 0,0
Ccc_VDD_DIV_XD2_XDFFM_SB VDD_DIV XD2.XDFFM.SB 2.3394e-17
* device instance cc_VDD_DIV_XD2_XDFFQ_CLKB r0 *1 0,0
Ccc_VDD_DIV_XD2_XDFFQ_CLKB VDD_DIV XD2.XDFFQ.CLKB 2.3394e-17
* device instance cc_VDD_DIV_XD2_XDFFQ_M r0 *1 0,0
Ccc_VDD_DIV_XD2_XDFFQ_M VDD_DIV XD2.XDFFQ.M 2.4201e-17
* device instance cc_VDD_DIV_XD2_XDFFQ_MB r0 *1 0,0
Ccc_VDD_DIV_XD2_XDFFQ_MB VDD_DIV XD2.XDFFQ.MB 1.7344e-17
* device instance cc_VDD_DIV_XD2_XDFFQ_S r0 *1 0,0
Ccc_VDD_DIV_XD2_XDFFQ_S VDD_DIV XD2.XDFFQ.S 1.8151e-17
* device instance cc_VDD_DIV_XD2_XDFFQ_SB r0 *1 0,0
Ccc_VDD_DIV_XD2_XDFFQ_SB VDD_DIV XD2.XDFFQ.SB 2.3394e-17
* device instance cc_VDD_DIV_XD2_XNOR_midp r0 *1 0,0
Ccc_VDD_DIV_XD2_XNOR_midp VDD_DIV XD2.XNOR.midp 1.7344e-17
* device instance cc_VDD_DIV_XD2_dmodout r0 *1 0,0
Ccc_VDD_DIV_XD2_dmodout VDD_DIV XD2.dmodout 1.7344e-17
* device instance cc_VDD_DIV_XD2_dq r0 *1 0,0
Ccc_VDD_DIV_XD2_dq VDD_DIV XD2.dq 1.21e-17
* device instance cc_VDD_DIV_XD2_nm r0 *1 0,0
Ccc_VDD_DIV_XD2_nm VDD_DIV XD2.nm 2.8638e-17
* device instance cc_VDD_DIV_XD2_nt r0 *1 0,0
Ccc_VDD_DIV_XD2_nt VDD_DIV XD2.nt 3.9932e-17
* device instance cc_VDD_DIV_XD2_t1 r0 *1 0,0
Ccc_VDD_DIV_XD2_t1 VDD_DIV XD2.t1 1.7344e-17
* device instance cc_VDD_DIV_XD3_XDFFM_CLKB r0 *1 0,0
Ccc_VDD_DIV_XD3_XDFFM_CLKB VDD_DIV XD3.XDFFM.CLKB 2.3394e-17
* device instance cc_VDD_DIV_XD3_XDFFM_M r0 *1 0,0
Ccc_VDD_DIV_XD3_XDFFM_M VDD_DIV XD3.XDFFM.M 2.4201e-17
* device instance cc_VDD_DIV_XD3_XDFFM_MB r0 *1 0,0
Ccc_VDD_DIV_XD3_XDFFM_MB VDD_DIV XD3.XDFFM.MB 1.7344e-17
* device instance cc_VDD_DIV_XD3_XDFFM_S r0 *1 0,0
Ccc_VDD_DIV_XD3_XDFFM_S VDD_DIV XD3.XDFFM.S 1.8151e-17
* device instance cc_VDD_DIV_XD3_XDFFM_SB r0 *1 0,0
Ccc_VDD_DIV_XD3_XDFFM_SB VDD_DIV XD3.XDFFM.SB 2.3394e-17
* device instance cc_VDD_DIV_XD3_XDFFQ_CLKB r0 *1 0,0
Ccc_VDD_DIV_XD3_XDFFQ_CLKB VDD_DIV XD3.XDFFQ.CLKB 2.3394e-17
* device instance cc_VDD_DIV_XD3_XDFFQ_M r0 *1 0,0
Ccc_VDD_DIV_XD3_XDFFQ_M VDD_DIV XD3.XDFFQ.M 2.4201e-17
* device instance cc_VDD_DIV_XD3_XDFFQ_MB r0 *1 0,0
Ccc_VDD_DIV_XD3_XDFFQ_MB VDD_DIV XD3.XDFFQ.MB 1.7344e-17
* device instance cc_VDD_DIV_XD3_XDFFQ_S r0 *1 0,0
Ccc_VDD_DIV_XD3_XDFFQ_S VDD_DIV XD3.XDFFQ.S 1.8151e-17
* device instance cc_VDD_DIV_XD3_XDFFQ_SB r0 *1 0,0
Ccc_VDD_DIV_XD3_XDFFQ_SB VDD_DIV XD3.XDFFQ.SB 2.3394e-17
* device instance cc_VDD_DIV_XD3_XNOR_midp r0 *1 0,0
Ccc_VDD_DIV_XD3_XNOR_midp VDD_DIV XD3.XNOR.midp 1.7344e-17
* device instance cc_VDD_DIV_XD3_dmodout r0 *1 0,0
Ccc_VDD_DIV_XD3_dmodout VDD_DIV XD3.dmodout 1.7344e-17
* device instance cc_VDD_DIV_XD3_dq r0 *1 0,0
Ccc_VDD_DIV_XD3_dq VDD_DIV XD3.dq 1.21e-17
* device instance cc_VDD_DIV_XD3_nm r0 *1 0,0
Ccc_VDD_DIV_XD3_nm VDD_DIV XD3.nm 2.8638e-17
* device instance cc_VDD_DIV_XD3_nt r0 *1 0,0
Ccc_VDD_DIV_XD3_nt VDD_DIV XD3.nt 3.9932e-17
* device instance cc_VDD_DIV_XD3_t1 r0 *1 0,0
Ccc_VDD_DIV_XD3_t1 VDD_DIV XD3.t1 1.7344e-17
* device instance cc_VDD_DIV_XD4_XDFFM_CLKB r0 *1 0,0
Ccc_VDD_DIV_XD4_XDFFM_CLKB VDD_DIV XD4.XDFFM.CLKB 2.3394e-17
* device instance cc_VDD_DIV_XD4_XDFFM_M r0 *1 0,0
Ccc_VDD_DIV_XD4_XDFFM_M VDD_DIV XD4.XDFFM.M 2.4201e-17
* device instance cc_VDD_DIV_XD4_XDFFM_MB r0 *1 0,0
Ccc_VDD_DIV_XD4_XDFFM_MB VDD_DIV XD4.XDFFM.MB 1.7344e-17
* device instance cc_VDD_DIV_XD4_XDFFM_S r0 *1 0,0
Ccc_VDD_DIV_XD4_XDFFM_S VDD_DIV XD4.XDFFM.S 1.8151e-17
* device instance cc_VDD_DIV_XD4_XDFFM_SB r0 *1 0,0
Ccc_VDD_DIV_XD4_XDFFM_SB VDD_DIV XD4.XDFFM.SB 2.3394e-17
* device instance cc_VDD_DIV_XD4_XDFFQ_CLKB r0 *1 0,0
Ccc_VDD_DIV_XD4_XDFFQ_CLKB VDD_DIV XD4.XDFFQ.CLKB 2.3394e-17
* device instance cc_VDD_DIV_XD4_XDFFQ_M r0 *1 0,0
Ccc_VDD_DIV_XD4_XDFFQ_M VDD_DIV XD4.XDFFQ.M 2.4201e-17
* device instance cc_VDD_DIV_XD4_XDFFQ_MB r0 *1 0,0
Ccc_VDD_DIV_XD4_XDFFQ_MB VDD_DIV XD4.XDFFQ.MB 1.7344e-17
* device instance cc_VDD_DIV_XD4_XDFFQ_S r0 *1 0,0
Ccc_VDD_DIV_XD4_XDFFQ_S VDD_DIV XD4.XDFFQ.S 1.8151e-17
* device instance cc_VDD_DIV_XD4_XDFFQ_SB r0 *1 0,0
Ccc_VDD_DIV_XD4_XDFFQ_SB VDD_DIV XD4.XDFFQ.SB 2.3394e-17
* device instance cc_VDD_DIV_XD4_XNOR_midp r0 *1 0,0
Ccc_VDD_DIV_XD4_XNOR_midp VDD_DIV XD4.XNOR.midp 1.7344e-17
* device instance cc_VDD_DIV_XD4_dmodout r0 *1 0,0
Ccc_VDD_DIV_XD4_dmodout VDD_DIV XD4.dmodout 1.7344e-17
* device instance cc_VDD_DIV_XD4_dq r0 *1 0,0
Ccc_VDD_DIV_XD4_dq VDD_DIV XD4.dq 1.21e-17
* device instance cc_VDD_DIV_XD4_nm r0 *1 0,0
Ccc_VDD_DIV_XD4_nm VDD_DIV XD4.nm 2.8638e-17
* device instance cc_VDD_DIV_XD4_nt r0 *1 0,0
Ccc_VDD_DIV_XD4_nt VDD_DIV XD4.nt 3.9932e-17
* device instance cc_VDD_DIV_XD4_t1 r0 *1 0,0
Ccc_VDD_DIV_XD4_t1 VDD_DIV XD4.t1 1.7344e-17
* device instance cc_VDD_DIV_XD5_XDFFM_CLKB r0 *1 0,0
Ccc_VDD_DIV_XD5_XDFFM_CLKB VDD_DIV XD5.XDFFM.CLKB 4.1545e-17
* device instance cc_VDD_DIV_XD5_XDFFM_M r0 *1 0,0
Ccc_VDD_DIV_XD5_XDFFM_M VDD_DIV XD5.XDFFM.M 4.8402e-17
* device instance cc_VDD_DIV_XD5_XDFFM_MB r0 *1 0,0
Ccc_VDD_DIV_XD5_XDFFM_MB VDD_DIV XD5.XDFFM.MB 2.9445e-17
* device instance cc_VDD_DIV_XD5_XDFFM_S r0 *1 0,0
Ccc_VDD_DIV_XD5_XDFFM_S VDD_DIV XD5.XDFFM.S 3.6302e-17
* device instance cc_VDD_DIV_XD5_XDFFM_SB r0 *1 0,0
Ccc_VDD_DIV_XD5_XDFFM_SB VDD_DIV XD5.XDFFM.SB 4.1545e-17
* device instance cc_VDD_DIV_XD5_XDFFQ_CLKB r0 *1 0,0
Ccc_VDD_DIV_XD5_XDFFQ_CLKB VDD_DIV XD5.XDFFQ.CLKB 4.1545e-17
* device instance cc_VDD_DIV_XD5_XDFFQ_M r0 *1 0,0
Ccc_VDD_DIV_XD5_XDFFQ_M VDD_DIV XD5.XDFFQ.M 4.8402e-17
* device instance cc_VDD_DIV_XD5_XDFFQ_MB r0 *1 0,0
Ccc_VDD_DIV_XD5_XDFFQ_MB VDD_DIV XD5.XDFFQ.MB 2.9445e-17
* device instance cc_VDD_DIV_XD5_XDFFQ_S r0 *1 0,0
Ccc_VDD_DIV_XD5_XDFFQ_S VDD_DIV XD5.XDFFQ.S 3.6302e-17
* device instance cc_VDD_DIV_XD5_XDFFQ_SB r0 *1 0,0
Ccc_VDD_DIV_XD5_XDFFQ_SB VDD_DIV XD5.XDFFQ.SB 4.1545e-17
* device instance cc_VDD_DIV_XD5_XN2_mid1 r0 *1 0,0
Ccc_VDD_DIV_XD5_XN2_mid1 VDD_DIV XD5.XN2.mid1 1.21e-17
* device instance cc_VDD_DIV_XD5_XN3_mid1 r0 *1 0,0
Ccc_VDD_DIV_XD5_XN3_mid1 VDD_DIV XD5.XN3.mid1 1.21e-17
* device instance cc_VDD_DIV_XD5_XN3_mid2 r0 *1 0,0
Ccc_VDD_DIV_XD5_XN3_mid2 VDD_DIV XD5.XN3.mid2 1.21e-17
* device instance cc_VDD_DIV_XD5_XNOR_midp r0 *1 0,0
Ccc_VDD_DIV_XD5_XNOR_midp VDD_DIV XD5.XNOR.midp 1.7344e-17
* device instance cc_VDD_DIV_XD5_dmodout r0 *1 0,0
Ccc_VDD_DIV_XD5_dmodout VDD_DIV XD5.dmodout 2.9445e-17
* device instance cc_VDD_DIV_XD5_dq r0 *1 0,0
Ccc_VDD_DIV_XD5_dq VDD_DIV XD5.dq 3.0251e-17
* device instance cc_VDD_DIV_XD5_nm r0 *1 0,0
Ccc_VDD_DIV_XD5_nm VDD_DIV XD5.nm 4.0738e-17
* device instance cc_VDD_DIV_XD5_nt r0 *1 0,0
Ccc_VDD_DIV_XD5_nt VDD_DIV XD5.nt 5.2032e-17
* device instance cc_VDD_DIV_XD5_t1 r0 *1 0,0
Ccc_VDD_DIV_XD5_t1 VDD_DIV XD5.t1 2.9445e-17
* device instance cc_VDD_DIV_XFRT_CLKB r0 *1 0,0
Ccc_VDD_DIV_XFRT_CLKB VDD_DIV XFRT.CLKB 4.1545e-17
* device instance cc_VDD_DIV_XFRT_M r0 *1 0,0
Ccc_VDD_DIV_XFRT_M VDD_DIV XFRT.M 4.8402e-17
* device instance cc_VDD_DIV_XFRT_MB r0 *1 0,0
Ccc_VDD_DIV_XFRT_MB VDD_DIV XFRT.MB 2.9445e-17
* device instance cc_VDD_DIV_XFRT_S r0 *1 0,0
Ccc_VDD_DIV_XFRT_S VDD_DIV XFRT.S 3.6302e-17
* device instance cc_VDD_DIV_XFRT_SB r0 *1 0,0
Ccc_VDD_DIV_XFRT_SB VDD_DIV XFRT.SB 4.1545e-17
* device instance cc_VDD_DIV_ck1 r0 *1 0,0
Ccc_VDD_DIV_ck1 VDD_DIV ck1 5.9696e-17
* device instance cc_VDD_DIV_ck2 r0 *1 0,0
Ccc_VDD_DIV_ck2 VDD_DIV ck2 5.9696e-17
* device instance cc_VDD_DIV_ck3 r0 *1 0,0
Ccc_VDD_DIV_ck3 VDD_DIV ck3 5.9696e-17
* device instance cc_VDD_DIV_ck4 r0 *1 0,0
Ccc_VDD_DIV_ck4 VDD_DIV ck4 5.9696e-17
* device instance cc_VDD_DIV_ck5 r0 *1 0,0
Ccc_VDD_DIV_ck5 VDD_DIV ck5 9.5997e-17
* device instance cc_VDD_DIV_mod0 r0 *1 0,0
Ccc_VDD_DIV_mod0 VDD_DIV mod0 2.9445e-17
* device instance cc_VDD_DIV_mod1 r0 *1 0,0
Ccc_VDD_DIV_mod1 VDD_DIV mod1 2.9445e-17
* device instance cc_VDD_DIV_mod2 r0 *1 0,0
Ccc_VDD_DIV_mod2 VDD_DIV mod2 2.9445e-17
* device instance cc_VDD_DIV_mod3 r0 *1 0,0
Ccc_VDD_DIV_mod3 VDD_DIV mod3 2.9445e-17
* device instance cc_VDD_DIV_mod4 r0 *1 0,0
Ccc_VDD_DIV_mod4 VDD_DIV mod4 4.1545e-17
* device instance cc_VDD_DIV_net1 r0 *1 0,0
Ccc_VDD_DIV_net1 VDD_DIV net1 1.7344e-17
* device instance cc_VSS_XD0_XDFFM_CLKB r0 *1 0,0
Ccc_VSS_XD0_XDFFM_CLKB VSS XD0.XDFFM.CLKB 2.3394e-17
* device instance cc_VSS_XD0_XDFFM_M r0 *1 0,0
Ccc_VSS_XD0_XDFFM_M VSS XD0.XDFFM.M 2.4201e-17
* device instance cc_VSS_XD0_XDFFM_MB r0 *1 0,0
Ccc_VSS_XD0_XDFFM_MB VSS XD0.XDFFM.MB 1.7344e-17
* device instance cc_VSS_XD0_XDFFM_S r0 *1 0,0
Ccc_VSS_XD0_XDFFM_S VSS XD0.XDFFM.S 1.8151e-17
* device instance cc_VSS_XD0_XDFFM_SB r0 *1 0,0
Ccc_VSS_XD0_XDFFM_SB VSS XD0.XDFFM.SB 2.3394e-17
* device instance cc_VSS_XD0_XDFFQ_CLKB r0 *1 0,0
Ccc_VSS_XD0_XDFFQ_CLKB VSS XD0.XDFFQ.CLKB 2.3394e-17
* device instance cc_VSS_XD0_XDFFQ_M r0 *1 0,0
Ccc_VSS_XD0_XDFFQ_M VSS XD0.XDFFQ.M 2.4201e-17
* device instance cc_VSS_XD0_XDFFQ_MB r0 *1 0,0
Ccc_VSS_XD0_XDFFQ_MB VSS XD0.XDFFQ.MB 1.7344e-17
* device instance cc_VSS_XD0_XDFFQ_S r0 *1 0,0
Ccc_VSS_XD0_XDFFQ_S VSS XD0.XDFFQ.S 1.8151e-17
* device instance cc_VSS_XD0_XDFFQ_SB r0 *1 0,0
Ccc_VSS_XD0_XDFFQ_SB VSS XD0.XDFFQ.SB 2.3394e-17
* device instance cc_VSS_XD0_XN2_mid1 r0 *1 0,0
Ccc_VSS_XD0_XN2_mid1 VSS XD0.XN2.mid1 1.7344e-17
* device instance cc_VSS_XD0_XN3_mid1 r0 *1 0,0
Ccc_VSS_XD0_XN3_mid1 VSS XD0.XN3.mid1 1.21e-17
* device instance cc_VSS_XD0_XN3_mid2 r0 *1 0,0
Ccc_VSS_XD0_XN3_mid2 VSS XD0.XN3.mid2 1.7344e-17
* device instance cc_VSS_XD0_dmodout r0 *1 0,0
Ccc_VSS_XD0_dmodout VSS XD0.dmodout 1.7344e-17
* device instance cc_VSS_XD0_dq r0 *1 0,0
Ccc_VSS_XD0_dq VSS XD0.dq 2.8638e-17
* device instance cc_VSS_XD0_nm r0 *1 0,0
Ccc_VSS_XD0_nm VSS XD0.nm 1.21e-17
* device instance cc_VSS_XD0_nt r0 *1 0,0
Ccc_VSS_XD0_nt VSS XD0.nt 1.21e-17
* device instance cc_VSS_XD0_t1 r0 *1 0,0
Ccc_VSS_XD0_t1 VSS XD0.t1 1.7344e-17
* device instance cc_VSS_XD1_XDFFM_CLKB r0 *1 0,0
Ccc_VSS_XD1_XDFFM_CLKB VSS XD1.XDFFM.CLKB 2.3394e-17
* device instance cc_VSS_XD1_XDFFM_M r0 *1 0,0
Ccc_VSS_XD1_XDFFM_M VSS XD1.XDFFM.M 2.4201e-17
* device instance cc_VSS_XD1_XDFFM_MB r0 *1 0,0
Ccc_VSS_XD1_XDFFM_MB VSS XD1.XDFFM.MB 1.7344e-17
* device instance cc_VSS_XD1_XDFFM_S r0 *1 0,0
Ccc_VSS_XD1_XDFFM_S VSS XD1.XDFFM.S 1.8151e-17
* device instance cc_VSS_XD1_XDFFM_SB r0 *1 0,0
Ccc_VSS_XD1_XDFFM_SB VSS XD1.XDFFM.SB 2.3394e-17
* device instance cc_VSS_XD1_XDFFQ_CLKB r0 *1 0,0
Ccc_VSS_XD1_XDFFQ_CLKB VSS XD1.XDFFQ.CLKB 2.3394e-17
* device instance cc_VSS_XD1_XDFFQ_M r0 *1 0,0
Ccc_VSS_XD1_XDFFQ_M VSS XD1.XDFFQ.M 2.4201e-17
* device instance cc_VSS_XD1_XDFFQ_MB r0 *1 0,0
Ccc_VSS_XD1_XDFFQ_MB VSS XD1.XDFFQ.MB 1.7344e-17
* device instance cc_VSS_XD1_XDFFQ_S r0 *1 0,0
Ccc_VSS_XD1_XDFFQ_S VSS XD1.XDFFQ.S 1.8151e-17
* device instance cc_VSS_XD1_XDFFQ_SB r0 *1 0,0
Ccc_VSS_XD1_XDFFQ_SB VSS XD1.XDFFQ.SB 2.3394e-17
* device instance cc_VSS_XD1_XN2_mid1 r0 *1 0,0
Ccc_VSS_XD1_XN2_mid1 VSS XD1.XN2.mid1 1.7344e-17
* device instance cc_VSS_XD1_XN3_mid1 r0 *1 0,0
Ccc_VSS_XD1_XN3_mid1 VSS XD1.XN3.mid1 1.21e-17
* device instance cc_VSS_XD1_XN3_mid2 r0 *1 0,0
Ccc_VSS_XD1_XN3_mid2 VSS XD1.XN3.mid2 1.7344e-17
* device instance cc_VSS_XD1_dmodout r0 *1 0,0
Ccc_VSS_XD1_dmodout VSS XD1.dmodout 1.7344e-17
* device instance cc_VSS_XD1_dq r0 *1 0,0
Ccc_VSS_XD1_dq VSS XD1.dq 2.8638e-17
* device instance cc_VSS_XD1_nm r0 *1 0,0
Ccc_VSS_XD1_nm VSS XD1.nm 1.21e-17
* device instance cc_VSS_XD1_nt r0 *1 0,0
Ccc_VSS_XD1_nt VSS XD1.nt 1.21e-17
* device instance cc_VSS_XD1_t1 r0 *1 0,0
Ccc_VSS_XD1_t1 VSS XD1.t1 1.7344e-17
* device instance cc_VSS_XD2_XDFFM_CLKB r0 *1 0,0
Ccc_VSS_XD2_XDFFM_CLKB VSS XD2.XDFFM.CLKB 2.3394e-17
* device instance cc_VSS_XD2_XDFFM_M r0 *1 0,0
Ccc_VSS_XD2_XDFFM_M VSS XD2.XDFFM.M 2.4201e-17
* device instance cc_VSS_XD2_XDFFM_MB r0 *1 0,0
Ccc_VSS_XD2_XDFFM_MB VSS XD2.XDFFM.MB 1.7344e-17
* device instance cc_VSS_XD2_XDFFM_S r0 *1 0,0
Ccc_VSS_XD2_XDFFM_S VSS XD2.XDFFM.S 1.8151e-17
* device instance cc_VSS_XD2_XDFFM_SB r0 *1 0,0
Ccc_VSS_XD2_XDFFM_SB VSS XD2.XDFFM.SB 2.3394e-17
* device instance cc_VSS_XD2_XDFFQ_CLKB r0 *1 0,0
Ccc_VSS_XD2_XDFFQ_CLKB VSS XD2.XDFFQ.CLKB 2.3394e-17
* device instance cc_VSS_XD2_XDFFQ_M r0 *1 0,0
Ccc_VSS_XD2_XDFFQ_M VSS XD2.XDFFQ.M 2.4201e-17
* device instance cc_VSS_XD2_XDFFQ_MB r0 *1 0,0
Ccc_VSS_XD2_XDFFQ_MB VSS XD2.XDFFQ.MB 1.7344e-17
* device instance cc_VSS_XD2_XDFFQ_S r0 *1 0,0
Ccc_VSS_XD2_XDFFQ_S VSS XD2.XDFFQ.S 1.8151e-17
* device instance cc_VSS_XD2_XDFFQ_SB r0 *1 0,0
Ccc_VSS_XD2_XDFFQ_SB VSS XD2.XDFFQ.SB 2.3394e-17
* device instance cc_VSS_XD2_XN2_mid1 r0 *1 0,0
Ccc_VSS_XD2_XN2_mid1 VSS XD2.XN2.mid1 1.7344e-17
* device instance cc_VSS_XD2_XN3_mid1 r0 *1 0,0
Ccc_VSS_XD2_XN3_mid1 VSS XD2.XN3.mid1 1.21e-17
* device instance cc_VSS_XD2_XN3_mid2 r0 *1 0,0
Ccc_VSS_XD2_XN3_mid2 VSS XD2.XN3.mid2 1.7344e-17
* device instance cc_VSS_XD2_dmodout r0 *1 0,0
Ccc_VSS_XD2_dmodout VSS XD2.dmodout 1.7344e-17
* device instance cc_VSS_XD2_dq r0 *1 0,0
Ccc_VSS_XD2_dq VSS XD2.dq 2.8638e-17
* device instance cc_VSS_XD2_nm r0 *1 0,0
Ccc_VSS_XD2_nm VSS XD2.nm 1.21e-17
* device instance cc_VSS_XD2_nt r0 *1 0,0
Ccc_VSS_XD2_nt VSS XD2.nt 1.21e-17
* device instance cc_VSS_XD2_t1 r0 *1 0,0
Ccc_VSS_XD2_t1 VSS XD2.t1 1.7344e-17
* device instance cc_VSS_XD3_XDFFM_CLKB r0 *1 0,0
Ccc_VSS_XD3_XDFFM_CLKB VSS XD3.XDFFM.CLKB 2.3394e-17
* device instance cc_VSS_XD3_XDFFM_M r0 *1 0,0
Ccc_VSS_XD3_XDFFM_M VSS XD3.XDFFM.M 2.4201e-17
* device instance cc_VSS_XD3_XDFFM_MB r0 *1 0,0
Ccc_VSS_XD3_XDFFM_MB VSS XD3.XDFFM.MB 1.7344e-17
* device instance cc_VSS_XD3_XDFFM_S r0 *1 0,0
Ccc_VSS_XD3_XDFFM_S VSS XD3.XDFFM.S 1.8151e-17
* device instance cc_VSS_XD3_XDFFM_SB r0 *1 0,0
Ccc_VSS_XD3_XDFFM_SB VSS XD3.XDFFM.SB 2.3394e-17
* device instance cc_VSS_XD3_XDFFQ_CLKB r0 *1 0,0
Ccc_VSS_XD3_XDFFQ_CLKB VSS XD3.XDFFQ.CLKB 2.3394e-17
* device instance cc_VSS_XD3_XDFFQ_M r0 *1 0,0
Ccc_VSS_XD3_XDFFQ_M VSS XD3.XDFFQ.M 2.4201e-17
* device instance cc_VSS_XD3_XDFFQ_MB r0 *1 0,0
Ccc_VSS_XD3_XDFFQ_MB VSS XD3.XDFFQ.MB 1.7344e-17
* device instance cc_VSS_XD3_XDFFQ_S r0 *1 0,0
Ccc_VSS_XD3_XDFFQ_S VSS XD3.XDFFQ.S 1.8151e-17
* device instance cc_VSS_XD3_XDFFQ_SB r0 *1 0,0
Ccc_VSS_XD3_XDFFQ_SB VSS XD3.XDFFQ.SB 2.3394e-17
* device instance cc_VSS_XD3_XN2_mid1 r0 *1 0,0
Ccc_VSS_XD3_XN2_mid1 VSS XD3.XN2.mid1 1.7344e-17
* device instance cc_VSS_XD3_XN3_mid1 r0 *1 0,0
Ccc_VSS_XD3_XN3_mid1 VSS XD3.XN3.mid1 1.21e-17
* device instance cc_VSS_XD3_XN3_mid2 r0 *1 0,0
Ccc_VSS_XD3_XN3_mid2 VSS XD3.XN3.mid2 1.7344e-17
* device instance cc_VSS_XD3_dmodout r0 *1 0,0
Ccc_VSS_XD3_dmodout VSS XD3.dmodout 1.7344e-17
* device instance cc_VSS_XD3_dq r0 *1 0,0
Ccc_VSS_XD3_dq VSS XD3.dq 2.8638e-17
* device instance cc_VSS_XD3_nm r0 *1 0,0
Ccc_VSS_XD3_nm VSS XD3.nm 1.21e-17
* device instance cc_VSS_XD3_nt r0 *1 0,0
Ccc_VSS_XD3_nt VSS XD3.nt 1.21e-17
* device instance cc_VSS_XD3_t1 r0 *1 0,0
Ccc_VSS_XD3_t1 VSS XD3.t1 1.7344e-17
* device instance cc_VSS_XD4_XDFFM_CLKB r0 *1 0,0
Ccc_VSS_XD4_XDFFM_CLKB VSS XD4.XDFFM.CLKB 2.3394e-17
* device instance cc_VSS_XD4_XDFFM_M r0 *1 0,0
Ccc_VSS_XD4_XDFFM_M VSS XD4.XDFFM.M 2.4201e-17
* device instance cc_VSS_XD4_XDFFM_MB r0 *1 0,0
Ccc_VSS_XD4_XDFFM_MB VSS XD4.XDFFM.MB 1.7344e-17
* device instance cc_VSS_XD4_XDFFM_S r0 *1 0,0
Ccc_VSS_XD4_XDFFM_S VSS XD4.XDFFM.S 1.8151e-17
* device instance cc_VSS_XD4_XDFFM_SB r0 *1 0,0
Ccc_VSS_XD4_XDFFM_SB VSS XD4.XDFFM.SB 2.3394e-17
* device instance cc_VSS_XD4_XDFFQ_CLKB r0 *1 0,0
Ccc_VSS_XD4_XDFFQ_CLKB VSS XD4.XDFFQ.CLKB 2.3394e-17
* device instance cc_VSS_XD4_XDFFQ_M r0 *1 0,0
Ccc_VSS_XD4_XDFFQ_M VSS XD4.XDFFQ.M 2.4201e-17
* device instance cc_VSS_XD4_XDFFQ_MB r0 *1 0,0
Ccc_VSS_XD4_XDFFQ_MB VSS XD4.XDFFQ.MB 1.7344e-17
* device instance cc_VSS_XD4_XDFFQ_S r0 *1 0,0
Ccc_VSS_XD4_XDFFQ_S VSS XD4.XDFFQ.S 1.8151e-17
* device instance cc_VSS_XD4_XDFFQ_SB r0 *1 0,0
Ccc_VSS_XD4_XDFFQ_SB VSS XD4.XDFFQ.SB 2.3394e-17
* device instance cc_VSS_XD4_XN2_mid1 r0 *1 0,0
Ccc_VSS_XD4_XN2_mid1 VSS XD4.XN2.mid1 1.7344e-17
* device instance cc_VSS_XD4_XN3_mid1 r0 *1 0,0
Ccc_VSS_XD4_XN3_mid1 VSS XD4.XN3.mid1 1.21e-17
* device instance cc_VSS_XD4_XN3_mid2 r0 *1 0,0
Ccc_VSS_XD4_XN3_mid2 VSS XD4.XN3.mid2 1.7344e-17
* device instance cc_VSS_XD4_dmodout r0 *1 0,0
Ccc_VSS_XD4_dmodout VSS XD4.dmodout 1.7344e-17
* device instance cc_VSS_XD4_dq r0 *1 0,0
Ccc_VSS_XD4_dq VSS XD4.dq 2.8638e-17
* device instance cc_VSS_XD4_nm r0 *1 0,0
Ccc_VSS_XD4_nm VSS XD4.nm 1.21e-17
* device instance cc_VSS_XD4_nt r0 *1 0,0
Ccc_VSS_XD4_nt VSS XD4.nt 1.21e-17
* device instance cc_VSS_XD4_t1 r0 *1 0,0
Ccc_VSS_XD4_t1 VSS XD4.t1 1.7344e-17
* device instance cc_VSS_XD5_XDFFM_CLKB r0 *1 0,0
Ccc_VSS_XD5_XDFFM_CLKB VSS XD5.XDFFM.CLKB 2.3394e-17
* device instance cc_VSS_XD5_XDFFM_M r0 *1 0,0
Ccc_VSS_XD5_XDFFM_M VSS XD5.XDFFM.M 2.4201e-17
* device instance cc_VSS_XD5_XDFFM_MB r0 *1 0,0
Ccc_VSS_XD5_XDFFM_MB VSS XD5.XDFFM.MB 1.7344e-17
* device instance cc_VSS_XD5_XDFFM_S r0 *1 0,0
Ccc_VSS_XD5_XDFFM_S VSS XD5.XDFFM.S 1.8151e-17
* device instance cc_VSS_XD5_XDFFM_SB r0 *1 0,0
Ccc_VSS_XD5_XDFFM_SB VSS XD5.XDFFM.SB 2.3394e-17
* device instance cc_VSS_XD5_XDFFQ_CLKB r0 *1 0,0
Ccc_VSS_XD5_XDFFQ_CLKB VSS XD5.XDFFQ.CLKB 2.3394e-17
* device instance cc_VSS_XD5_XDFFQ_M r0 *1 0,0
Ccc_VSS_XD5_XDFFQ_M VSS XD5.XDFFQ.M 2.4201e-17
* device instance cc_VSS_XD5_XDFFQ_MB r0 *1 0,0
Ccc_VSS_XD5_XDFFQ_MB VSS XD5.XDFFQ.MB 1.7344e-17
* device instance cc_VSS_XD5_XDFFQ_S r0 *1 0,0
Ccc_VSS_XD5_XDFFQ_S VSS XD5.XDFFQ.S 1.8151e-17
* device instance cc_VSS_XD5_XDFFQ_SB r0 *1 0,0
Ccc_VSS_XD5_XDFFQ_SB VSS XD5.XDFFQ.SB 2.3394e-17
* device instance cc_VSS_XD5_XN2_mid1 r0 *1 0,0
Ccc_VSS_XD5_XN2_mid1 VSS XD5.XN2.mid1 1.7344e-17
* device instance cc_VSS_XD5_XN3_mid1 r0 *1 0,0
Ccc_VSS_XD5_XN3_mid1 VSS XD5.XN3.mid1 1.21e-17
* device instance cc_VSS_XD5_XN3_mid2 r0 *1 0,0
Ccc_VSS_XD5_XN3_mid2 VSS XD5.XN3.mid2 1.7344e-17
* device instance cc_VSS_XD5_dmodout r0 *1 0,0
Ccc_VSS_XD5_dmodout VSS XD5.dmodout 1.7344e-17
* device instance cc_VSS_XD5_dq r0 *1 0,0
Ccc_VSS_XD5_dq VSS XD5.dq 2.8638e-17
* device instance cc_VSS_XD5_nm r0 *1 0,0
Ccc_VSS_XD5_nm VSS XD5.nm 1.21e-17
* device instance cc_VSS_XD5_nt r0 *1 0,0
Ccc_VSS_XD5_nt VSS XD5.nt 1.21e-17
* device instance cc_VSS_XD5_t1 r0 *1 0,0
Ccc_VSS_XD5_t1 VSS XD5.t1 1.7344e-17
* device instance cc_VSS_XFRT_CLKB r0 *1 0,0
Ccc_VSS_XFRT_CLKB VSS XFRT.CLKB 2.3394e-17
* device instance cc_VSS_XFRT_M r0 *1 0,0
Ccc_VSS_XFRT_M VSS XFRT.M 2.4201e-17
* device instance cc_VSS_XFRT_MB r0 *1 0,0
Ccc_VSS_XFRT_MB VSS XFRT.MB 1.7344e-17
* device instance cc_VSS_XFRT_S r0 *1 0,0
Ccc_VSS_XFRT_S VSS XFRT.S 1.8151e-17
* device instance cc_VSS_XFRT_SB r0 *1 0,0
Ccc_VSS_XFRT_SB VSS XFRT.SB 2.3394e-17
* device instance cc_VSS_ck1 r0 *1 0,0
Ccc_VSS_ck1 VSS ck1 5.9696e-17
* device instance cc_VSS_ck2 r0 *1 0,0
Ccc_VSS_ck2 VSS ck2 5.9696e-17
* device instance cc_VSS_ck3 r0 *1 0,0
Ccc_VSS_ck3 VSS ck3 5.9696e-17
* device instance cc_VSS_ck4 r0 *1 0,0
Ccc_VSS_ck4 VSS ck4 5.9696e-17
* device instance cc_VSS_ck5 r0 *1 0,0
Ccc_VSS_ck5 VSS ck5 5.9696e-17
* device instance cc_VSS_mod0 r0 *1 0,0
Ccc_VSS_mod0 VSS mod0 2.9445e-17
* device instance cc_VSS_mod1 r0 *1 0,0
Ccc_VSS_mod1 VSS mod1 2.9445e-17
* device instance cc_VSS_mod2 r0 *1 0,0
Ccc_VSS_mod2 VSS mod2 2.9445e-17
* device instance cc_VSS_mod3 r0 *1 0,0
Ccc_VSS_mod3 VSS mod3 2.9445e-17
* device instance cc_VSS_mod4 r0 *1 0,0
Ccc_VSS_mod4 VSS mod4 2.9445e-17
* device instance cc_VSS_net1 r0 *1 0,0
Ccc_VSS_net1 VSS net1 1.7344e-17
* device instance cc_XD0_XDFFM_CLKB_XD0_XDFFM_M r0 *1 0,0
Ccc_XD0_XDFFM_CLKB_XD0_XDFFM_M XD0.XDFFM.CLKB XD0.XDFFM.M 4.2352e-17
* device instance cc_XD0_XDFFM_CLKB_XD0_XDFFM_MB r0 *1 0,0
Ccc_XD0_XDFFM_CLKB_XD0_XDFFM_MB XD0.XDFFM.CLKB XD0.XDFFM.MB 2.4201e-17
* device instance cc_XD0_XDFFM_CLKB_XD0_XDFFM_S r0 *1 0,0
Ccc_XD0_XDFFM_CLKB_XD0_XDFFM_S XD0.XDFFM.CLKB XD0.XDFFM.S 1.8151e-17
* device instance cc_XD0_XDFFM_CLKB_XD0_XDFFM_SB r0 *1 0,0
Ccc_XD0_XDFFM_CLKB_XD0_XDFFM_SB XD0.XDFFM.CLKB XD0.XDFFM.SB 1.8151e-17
* device instance cc_XD0_XDFFM_CLKB_XD0_XDFFQ_CLKB r0 *1 0,0
Ccc_XD0_XDFFM_CLKB_XD0_XDFFQ_CLKB XD0.XDFFM.CLKB XD0.XDFFQ.CLKB 1.8151e-17
* device instance cc_XD0_XDFFM_CLKB_XD0_XDFFQ_M r0 *1 0,0
Ccc_XD0_XDFFM_CLKB_XD0_XDFFQ_M XD0.XDFFM.CLKB XD0.XDFFQ.M 2.4201e-17
* device instance cc_XD0_XDFFM_CLKB_XD0_XDFFQ_MB r0 *1 0,0
Ccc_XD0_XDFFM_CLKB_XD0_XDFFQ_MB XD0.XDFFM.CLKB XD0.XDFFQ.MB 1.21e-17
* device instance cc_XD0_XDFFM_CLKB_XD0_XDFFQ_S r0 *1 0,0
Ccc_XD0_XDFFM_CLKB_XD0_XDFFQ_S XD0.XDFFM.CLKB XD0.XDFFQ.S 1.8151e-17
* device instance cc_XD0_XDFFM_CLKB_XD0_XDFFQ_SB r0 *1 0,0
Ccc_XD0_XDFFM_CLKB_XD0_XDFFQ_SB XD0.XDFFM.CLKB XD0.XDFFQ.SB 1.8151e-17
* device instance cc_XD0_XDFFM_CLKB_XD0_XNOR_midp r0 *1 0,0
Ccc_XD0_XDFFM_CLKB_XD0_XNOR_midp XD0.XDFFM.CLKB XD0.XNOR.midp 1.21e-17
* device instance cc_XD0_XDFFM_CLKB_XD0_dmodout r0 *1 0,0
Ccc_XD0_XDFFM_CLKB_XD0_dmodout XD0.XDFFM.CLKB XD0.dmodout 1.8151e-17
* device instance cc_XD0_XDFFM_CLKB_XD0_dq r0 *1 0,0
Ccc_XD0_XDFFM_CLKB_XD0_dq XD0.XDFFM.CLKB XD0.dq 1.21e-17
* device instance cc_XD0_XDFFM_CLKB_XD0_nm r0 *1 0,0
Ccc_XD0_XDFFM_CLKB_XD0_nm XD0.XDFFM.CLKB XD0.nm 1.8151e-17
* device instance cc_XD0_XDFFM_CLKB_XD0_nt r0 *1 0,0
Ccc_XD0_XDFFM_CLKB_XD0_nt XD0.XDFFM.CLKB XD0.nt 2.4201e-17
* device instance cc_XD0_XDFFM_CLKB_XD0_t1 r0 *1 0,0
Ccc_XD0_XDFFM_CLKB_XD0_t1 XD0.XDFFM.CLKB XD0.t1 1.21e-17
* device instance cc_XD0_XDFFM_CLKB_XD1_XDFFM_CLKB r0 *1 0,0
Ccc_XD0_XDFFM_CLKB_XD1_XDFFM_CLKB XD0.XDFFM.CLKB XD1.XDFFM.CLKB 1.8151e-17
* device instance cc_XD0_XDFFM_CLKB_XD1_XDFFM_M r0 *1 0,0
Ccc_XD0_XDFFM_CLKB_XD1_XDFFM_M XD0.XDFFM.CLKB XD1.XDFFM.M 2.4201e-17
* device instance cc_XD0_XDFFM_CLKB_XD1_XDFFM_MB r0 *1 0,0
Ccc_XD0_XDFFM_CLKB_XD1_XDFFM_MB XD0.XDFFM.CLKB XD1.XDFFM.MB 1.21e-17
* device instance cc_XD0_XDFFM_CLKB_XD1_XDFFM_S r0 *1 0,0
Ccc_XD0_XDFFM_CLKB_XD1_XDFFM_S XD0.XDFFM.CLKB XD1.XDFFM.S 1.8151e-17
* device instance cc_XD0_XDFFM_CLKB_XD1_XDFFM_SB r0 *1 0,0
Ccc_XD0_XDFFM_CLKB_XD1_XDFFM_SB XD0.XDFFM.CLKB XD1.XDFFM.SB 1.8151e-17
* device instance cc_XD0_XDFFM_CLKB_XD1_XDFFQ_CLKB r0 *1 0,0
Ccc_XD0_XDFFM_CLKB_XD1_XDFFQ_CLKB XD0.XDFFM.CLKB XD1.XDFFQ.CLKB 1.8151e-17
* device instance cc_XD0_XDFFM_CLKB_XD1_XDFFQ_M r0 *1 0,0
Ccc_XD0_XDFFM_CLKB_XD1_XDFFQ_M XD0.XDFFM.CLKB XD1.XDFFQ.M 2.4201e-17
* device instance cc_XD0_XDFFM_CLKB_XD1_XDFFQ_MB r0 *1 0,0
Ccc_XD0_XDFFM_CLKB_XD1_XDFFQ_MB XD0.XDFFM.CLKB XD1.XDFFQ.MB 1.21e-17
* device instance cc_XD0_XDFFM_CLKB_XD1_XDFFQ_S r0 *1 0,0
Ccc_XD0_XDFFM_CLKB_XD1_XDFFQ_S XD0.XDFFM.CLKB XD1.XDFFQ.S 1.8151e-17
* device instance cc_XD0_XDFFM_CLKB_XD1_XDFFQ_SB r0 *1 0,0
Ccc_XD0_XDFFM_CLKB_XD1_XDFFQ_SB XD0.XDFFM.CLKB XD1.XDFFQ.SB 1.8151e-17
* device instance cc_XD0_XDFFM_CLKB_XD1_XN2_mid1 r0 *1 0,0
Ccc_XD0_XDFFM_CLKB_XD1_XN2_mid1 XD0.XDFFM.CLKB XD1.XN2.mid1 1.21e-17
* device instance cc_XD0_XDFFM_CLKB_XD1_XN3_mid1 r0 *1 0,0
Ccc_XD0_XDFFM_CLKB_XD1_XN3_mid1 XD0.XDFFM.CLKB XD1.XN3.mid1 1.21e-17
* device instance cc_XD0_XDFFM_CLKB_XD1_XN3_mid2 r0 *1 0,0
Ccc_XD0_XDFFM_CLKB_XD1_XN3_mid2 XD0.XDFFM.CLKB XD1.XN3.mid2 1.21e-17
* device instance cc_XD0_XDFFM_CLKB_XD1_dmodout r0 *1 0,0
Ccc_XD0_XDFFM_CLKB_XD1_dmodout XD0.XDFFM.CLKB XD1.dmodout 1.21e-17
* device instance cc_XD0_XDFFM_CLKB_XD1_dq r0 *1 0,0
Ccc_XD0_XDFFM_CLKB_XD1_dq XD0.XDFFM.CLKB XD1.dq 1.8151e-17
* device instance cc_XD0_XDFFM_CLKB_XD1_nm r0 *1 0,0
Ccc_XD0_XDFFM_CLKB_XD1_nm XD0.XDFFM.CLKB XD1.nm 1.21e-17
* device instance cc_XD0_XDFFM_CLKB_XD1_nt r0 *1 0,0
Ccc_XD0_XDFFM_CLKB_XD1_nt XD0.XDFFM.CLKB XD1.nt 1.21e-17
* device instance cc_XD0_XDFFM_CLKB_XD1_t1 r0 *1 0,0
Ccc_XD0_XDFFM_CLKB_XD1_t1 XD0.XDFFM.CLKB XD1.t1 1.21e-17
* device instance cc_XD0_XDFFM_CLKB_XD2_XDFFM_CLKB r0 *1 0,0
Ccc_XD0_XDFFM_CLKB_XD2_XDFFM_CLKB XD0.XDFFM.CLKB XD2.XDFFM.CLKB 1.8151e-17
* device instance cc_XD0_XDFFM_CLKB_XD2_XDFFM_M r0 *1 0,0
Ccc_XD0_XDFFM_CLKB_XD2_XDFFM_M XD0.XDFFM.CLKB XD2.XDFFM.M 2.4201e-17
* device instance cc_XD0_XDFFM_CLKB_XD2_XDFFM_MB r0 *1 0,0
Ccc_XD0_XDFFM_CLKB_XD2_XDFFM_MB XD0.XDFFM.CLKB XD2.XDFFM.MB 1.21e-17
* device instance cc_XD0_XDFFM_CLKB_XD2_XDFFM_S r0 *1 0,0
Ccc_XD0_XDFFM_CLKB_XD2_XDFFM_S XD0.XDFFM.CLKB XD2.XDFFM.S 1.8151e-17
* device instance cc_XD0_XDFFM_CLKB_XD2_XDFFM_SB r0 *1 0,0
Ccc_XD0_XDFFM_CLKB_XD2_XDFFM_SB XD0.XDFFM.CLKB XD2.XDFFM.SB 1.8151e-17
* device instance cc_XD0_XDFFM_CLKB_XD2_XDFFQ_CLKB r0 *1 0,0
Ccc_XD0_XDFFM_CLKB_XD2_XDFFQ_CLKB XD0.XDFFM.CLKB XD2.XDFFQ.CLKB 1.8151e-17
* device instance cc_XD0_XDFFM_CLKB_XD2_XDFFQ_M r0 *1 0,0
Ccc_XD0_XDFFM_CLKB_XD2_XDFFQ_M XD0.XDFFM.CLKB XD2.XDFFQ.M 2.4201e-17
* device instance cc_XD0_XDFFM_CLKB_XD2_XDFFQ_MB r0 *1 0,0
Ccc_XD0_XDFFM_CLKB_XD2_XDFFQ_MB XD0.XDFFM.CLKB XD2.XDFFQ.MB 1.21e-17
* device instance cc_XD0_XDFFM_CLKB_XD2_XDFFQ_S r0 *1 0,0
Ccc_XD0_XDFFM_CLKB_XD2_XDFFQ_S XD0.XDFFM.CLKB XD2.XDFFQ.S 1.8151e-17
* device instance cc_XD0_XDFFM_CLKB_XD2_XDFFQ_SB r0 *1 0,0
Ccc_XD0_XDFFM_CLKB_XD2_XDFFQ_SB XD0.XDFFM.CLKB XD2.XDFFQ.SB 1.8151e-17
* device instance cc_XD0_XDFFM_CLKB_XD2_XN2_mid1 r0 *1 0,0
Ccc_XD0_XDFFM_CLKB_XD2_XN2_mid1 XD0.XDFFM.CLKB XD2.XN2.mid1 1.21e-17
* device instance cc_XD0_XDFFM_CLKB_XD2_XN3_mid1 r0 *1 0,0
Ccc_XD0_XDFFM_CLKB_XD2_XN3_mid1 XD0.XDFFM.CLKB XD2.XN3.mid1 1.21e-17
* device instance cc_XD0_XDFFM_CLKB_XD2_XN3_mid2 r0 *1 0,0
Ccc_XD0_XDFFM_CLKB_XD2_XN3_mid2 XD0.XDFFM.CLKB XD2.XN3.mid2 1.21e-17
* device instance cc_XD0_XDFFM_CLKB_XD2_dmodout r0 *1 0,0
Ccc_XD0_XDFFM_CLKB_XD2_dmodout XD0.XDFFM.CLKB XD2.dmodout 1.21e-17
* device instance cc_XD0_XDFFM_CLKB_XD2_dq r0 *1 0,0
Ccc_XD0_XDFFM_CLKB_XD2_dq XD0.XDFFM.CLKB XD2.dq 1.8151e-17
* device instance cc_XD0_XDFFM_CLKB_XD2_nm r0 *1 0,0
Ccc_XD0_XDFFM_CLKB_XD2_nm XD0.XDFFM.CLKB XD2.nm 1.21e-17
* device instance cc_XD0_XDFFM_CLKB_XD2_nt r0 *1 0,0
Ccc_XD0_XDFFM_CLKB_XD2_nt XD0.XDFFM.CLKB XD2.nt 1.21e-17
* device instance cc_XD0_XDFFM_CLKB_XD2_t1 r0 *1 0,0
Ccc_XD0_XDFFM_CLKB_XD2_t1 XD0.XDFFM.CLKB XD2.t1 1.21e-17
* device instance cc_XD0_XDFFM_CLKB_XD3_XDFFM_CLKB r0 *1 0,0
Ccc_XD0_XDFFM_CLKB_XD3_XDFFM_CLKB XD0.XDFFM.CLKB XD3.XDFFM.CLKB 1.8151e-17
* device instance cc_XD0_XDFFM_CLKB_XD3_XDFFM_M r0 *1 0,0
Ccc_XD0_XDFFM_CLKB_XD3_XDFFM_M XD0.XDFFM.CLKB XD3.XDFFM.M 2.4201e-17
* device instance cc_XD0_XDFFM_CLKB_XD3_XDFFM_MB r0 *1 0,0
Ccc_XD0_XDFFM_CLKB_XD3_XDFFM_MB XD0.XDFFM.CLKB XD3.XDFFM.MB 1.21e-17
* device instance cc_XD0_XDFFM_CLKB_XD3_XDFFM_S r0 *1 0,0
Ccc_XD0_XDFFM_CLKB_XD3_XDFFM_S XD0.XDFFM.CLKB XD3.XDFFM.S 1.8151e-17
* device instance cc_XD0_XDFFM_CLKB_XD3_XDFFM_SB r0 *1 0,0
Ccc_XD0_XDFFM_CLKB_XD3_XDFFM_SB XD0.XDFFM.CLKB XD3.XDFFM.SB 1.8151e-17
* device instance cc_XD0_XDFFM_CLKB_XD3_XDFFQ_CLKB r0 *1 0,0
Ccc_XD0_XDFFM_CLKB_XD3_XDFFQ_CLKB XD0.XDFFM.CLKB XD3.XDFFQ.CLKB 1.8151e-17
* device instance cc_XD0_XDFFM_CLKB_XD3_XDFFQ_M r0 *1 0,0
Ccc_XD0_XDFFM_CLKB_XD3_XDFFQ_M XD0.XDFFM.CLKB XD3.XDFFQ.M 2.4201e-17
* device instance cc_XD0_XDFFM_CLKB_XD3_XDFFQ_MB r0 *1 0,0
Ccc_XD0_XDFFM_CLKB_XD3_XDFFQ_MB XD0.XDFFM.CLKB XD3.XDFFQ.MB 1.21e-17
* device instance cc_XD0_XDFFM_CLKB_XD3_XDFFQ_S r0 *1 0,0
Ccc_XD0_XDFFM_CLKB_XD3_XDFFQ_S XD0.XDFFM.CLKB XD3.XDFFQ.S 1.8151e-17
* device instance cc_XD0_XDFFM_CLKB_XD3_XDFFQ_SB r0 *1 0,0
Ccc_XD0_XDFFM_CLKB_XD3_XDFFQ_SB XD0.XDFFM.CLKB XD3.XDFFQ.SB 1.8151e-17
* device instance cc_XD0_XDFFM_CLKB_XD3_XN2_mid1 r0 *1 0,0
Ccc_XD0_XDFFM_CLKB_XD3_XN2_mid1 XD0.XDFFM.CLKB XD3.XN2.mid1 1.21e-17
* device instance cc_XD0_XDFFM_CLKB_XD3_XN3_mid1 r0 *1 0,0
Ccc_XD0_XDFFM_CLKB_XD3_XN3_mid1 XD0.XDFFM.CLKB XD3.XN3.mid1 1.21e-17
* device instance cc_XD0_XDFFM_CLKB_XD3_XN3_mid2 r0 *1 0,0
Ccc_XD0_XDFFM_CLKB_XD3_XN3_mid2 XD0.XDFFM.CLKB XD3.XN3.mid2 1.21e-17
* device instance cc_XD0_XDFFM_CLKB_XD3_dmodout r0 *1 0,0
Ccc_XD0_XDFFM_CLKB_XD3_dmodout XD0.XDFFM.CLKB XD3.dmodout 1.21e-17
* device instance cc_XD0_XDFFM_CLKB_XD3_dq r0 *1 0,0
Ccc_XD0_XDFFM_CLKB_XD3_dq XD0.XDFFM.CLKB XD3.dq 1.8151e-17
* device instance cc_XD0_XDFFM_CLKB_XD3_nm r0 *1 0,0
Ccc_XD0_XDFFM_CLKB_XD3_nm XD0.XDFFM.CLKB XD3.nm 1.21e-17
* device instance cc_XD0_XDFFM_CLKB_XD3_nt r0 *1 0,0
Ccc_XD0_XDFFM_CLKB_XD3_nt XD0.XDFFM.CLKB XD3.nt 1.21e-17
* device instance cc_XD0_XDFFM_CLKB_XD3_t1 r0 *1 0,0
Ccc_XD0_XDFFM_CLKB_XD3_t1 XD0.XDFFM.CLKB XD3.t1 1.21e-17
* device instance cc_XD0_XDFFM_CLKB_XD4_XDFFM_CLKB r0 *1 0,0
Ccc_XD0_XDFFM_CLKB_XD4_XDFFM_CLKB XD0.XDFFM.CLKB XD4.XDFFM.CLKB 1.8151e-17
* device instance cc_XD0_XDFFM_CLKB_XD4_XDFFM_M r0 *1 0,0
Ccc_XD0_XDFFM_CLKB_XD4_XDFFM_M XD0.XDFFM.CLKB XD4.XDFFM.M 2.4201e-17
* device instance cc_XD0_XDFFM_CLKB_XD4_XDFFM_MB r0 *1 0,0
Ccc_XD0_XDFFM_CLKB_XD4_XDFFM_MB XD0.XDFFM.CLKB XD4.XDFFM.MB 1.21e-17
* device instance cc_XD0_XDFFM_CLKB_XD4_XDFFM_S r0 *1 0,0
Ccc_XD0_XDFFM_CLKB_XD4_XDFFM_S XD0.XDFFM.CLKB XD4.XDFFM.S 1.8151e-17
* device instance cc_XD0_XDFFM_CLKB_XD4_XDFFM_SB r0 *1 0,0
Ccc_XD0_XDFFM_CLKB_XD4_XDFFM_SB XD0.XDFFM.CLKB XD4.XDFFM.SB 1.8151e-17
* device instance cc_XD0_XDFFM_CLKB_XD4_XDFFQ_CLKB r0 *1 0,0
Ccc_XD0_XDFFM_CLKB_XD4_XDFFQ_CLKB XD0.XDFFM.CLKB XD4.XDFFQ.CLKB 1.8151e-17
* device instance cc_XD0_XDFFM_CLKB_XD4_XDFFQ_M r0 *1 0,0
Ccc_XD0_XDFFM_CLKB_XD4_XDFFQ_M XD0.XDFFM.CLKB XD4.XDFFQ.M 2.4201e-17
* device instance cc_XD0_XDFFM_CLKB_XD4_XDFFQ_MB r0 *1 0,0
Ccc_XD0_XDFFM_CLKB_XD4_XDFFQ_MB XD0.XDFFM.CLKB XD4.XDFFQ.MB 1.21e-17
* device instance cc_XD0_XDFFM_CLKB_XD4_XDFFQ_S r0 *1 0,0
Ccc_XD0_XDFFM_CLKB_XD4_XDFFQ_S XD0.XDFFM.CLKB XD4.XDFFQ.S 1.8151e-17
* device instance cc_XD0_XDFFM_CLKB_XD4_XDFFQ_SB r0 *1 0,0
Ccc_XD0_XDFFM_CLKB_XD4_XDFFQ_SB XD0.XDFFM.CLKB XD4.XDFFQ.SB 1.8151e-17
* device instance cc_XD0_XDFFM_CLKB_XD4_XN2_mid1 r0 *1 0,0
Ccc_XD0_XDFFM_CLKB_XD4_XN2_mid1 XD0.XDFFM.CLKB XD4.XN2.mid1 1.21e-17
* device instance cc_XD0_XDFFM_CLKB_XD4_XN3_mid1 r0 *1 0,0
Ccc_XD0_XDFFM_CLKB_XD4_XN3_mid1 XD0.XDFFM.CLKB XD4.XN3.mid1 1.21e-17
* device instance cc_XD0_XDFFM_CLKB_XD4_XN3_mid2 r0 *1 0,0
Ccc_XD0_XDFFM_CLKB_XD4_XN3_mid2 XD0.XDFFM.CLKB XD4.XN3.mid2 1.21e-17
* device instance cc_XD0_XDFFM_CLKB_XD4_dmodout r0 *1 0,0
Ccc_XD0_XDFFM_CLKB_XD4_dmodout XD0.XDFFM.CLKB XD4.dmodout 1.21e-17
* device instance cc_XD0_XDFFM_CLKB_XD4_dq r0 *1 0,0
Ccc_XD0_XDFFM_CLKB_XD4_dq XD0.XDFFM.CLKB XD4.dq 1.8151e-17
* device instance cc_XD0_XDFFM_CLKB_XD4_nm r0 *1 0,0
Ccc_XD0_XDFFM_CLKB_XD4_nm XD0.XDFFM.CLKB XD4.nm 1.21e-17
* device instance cc_XD0_XDFFM_CLKB_XD4_nt r0 *1 0,0
Ccc_XD0_XDFFM_CLKB_XD4_nt XD0.XDFFM.CLKB XD4.nt 1.21e-17
* device instance cc_XD0_XDFFM_CLKB_XD4_t1 r0 *1 0,0
Ccc_XD0_XDFFM_CLKB_XD4_t1 XD0.XDFFM.CLKB XD4.t1 1.21e-17
* device instance cc_XD0_XDFFM_CLKB_XD5_XDFFM_CLKB r0 *1 0,0
Ccc_XD0_XDFFM_CLKB_XD5_XDFFM_CLKB XD0.XDFFM.CLKB XD5.XDFFM.CLKB 1.8151e-17
* device instance cc_XD0_XDFFM_CLKB_XD5_XDFFM_M r0 *1 0,0
Ccc_XD0_XDFFM_CLKB_XD5_XDFFM_M XD0.XDFFM.CLKB XD5.XDFFM.M 2.4201e-17
* device instance cc_XD0_XDFFM_CLKB_XD5_XDFFM_MB r0 *1 0,0
Ccc_XD0_XDFFM_CLKB_XD5_XDFFM_MB XD0.XDFFM.CLKB XD5.XDFFM.MB 1.21e-17
* device instance cc_XD0_XDFFM_CLKB_XD5_XDFFM_S r0 *1 0,0
Ccc_XD0_XDFFM_CLKB_XD5_XDFFM_S XD0.XDFFM.CLKB XD5.XDFFM.S 1.8151e-17
* device instance cc_XD0_XDFFM_CLKB_XD5_XDFFM_SB r0 *1 0,0
Ccc_XD0_XDFFM_CLKB_XD5_XDFFM_SB XD0.XDFFM.CLKB XD5.XDFFM.SB 1.8151e-17
* device instance cc_XD0_XDFFM_CLKB_XD5_XDFFQ_CLKB r0 *1 0,0
Ccc_XD0_XDFFM_CLKB_XD5_XDFFQ_CLKB XD0.XDFFM.CLKB XD5.XDFFQ.CLKB 1.8151e-17
* device instance cc_XD0_XDFFM_CLKB_XD5_XDFFQ_M r0 *1 0,0
Ccc_XD0_XDFFM_CLKB_XD5_XDFFQ_M XD0.XDFFM.CLKB XD5.XDFFQ.M 2.4201e-17
* device instance cc_XD0_XDFFM_CLKB_XD5_XDFFQ_MB r0 *1 0,0
Ccc_XD0_XDFFM_CLKB_XD5_XDFFQ_MB XD0.XDFFM.CLKB XD5.XDFFQ.MB 1.21e-17
* device instance cc_XD0_XDFFM_CLKB_XD5_XDFFQ_S r0 *1 0,0
Ccc_XD0_XDFFM_CLKB_XD5_XDFFQ_S XD0.XDFFM.CLKB XD5.XDFFQ.S 1.8151e-17
* device instance cc_XD0_XDFFM_CLKB_XD5_XDFFQ_SB r0 *1 0,0
Ccc_XD0_XDFFM_CLKB_XD5_XDFFQ_SB XD0.XDFFM.CLKB XD5.XDFFQ.SB 1.8151e-17
* device instance cc_XD0_XDFFM_CLKB_XD5_XN2_mid1 r0 *1 0,0
Ccc_XD0_XDFFM_CLKB_XD5_XN2_mid1 XD0.XDFFM.CLKB XD5.XN2.mid1 1.21e-17
* device instance cc_XD0_XDFFM_CLKB_XD5_XN3_mid1 r0 *1 0,0
Ccc_XD0_XDFFM_CLKB_XD5_XN3_mid1 XD0.XDFFM.CLKB XD5.XN3.mid1 1.21e-17
* device instance cc_XD0_XDFFM_CLKB_XD5_XN3_mid2 r0 *1 0,0
Ccc_XD0_XDFFM_CLKB_XD5_XN3_mid2 XD0.XDFFM.CLKB XD5.XN3.mid2 1.21e-17
* device instance cc_XD0_XDFFM_CLKB_XD5_dmodout r0 *1 0,0
Ccc_XD0_XDFFM_CLKB_XD5_dmodout XD0.XDFFM.CLKB XD5.dmodout 1.21e-17
* device instance cc_XD0_XDFFM_CLKB_XD5_dq r0 *1 0,0
Ccc_XD0_XDFFM_CLKB_XD5_dq XD0.XDFFM.CLKB XD5.dq 1.8151e-17
* device instance cc_XD0_XDFFM_CLKB_XD5_nm r0 *1 0,0
Ccc_XD0_XDFFM_CLKB_XD5_nm XD0.XDFFM.CLKB XD5.nm 1.21e-17
* device instance cc_XD0_XDFFM_CLKB_XD5_nt r0 *1 0,0
Ccc_XD0_XDFFM_CLKB_XD5_nt XD0.XDFFM.CLKB XD5.nt 1.21e-17
* device instance cc_XD0_XDFFM_CLKB_XD5_t1 r0 *1 0,0
Ccc_XD0_XDFFM_CLKB_XD5_t1 XD0.XDFFM.CLKB XD5.t1 1.21e-17
* device instance cc_XD0_XDFFM_CLKB_XFRT_CLKB r0 *1 0,0
Ccc_XD0_XDFFM_CLKB_XFRT_CLKB XD0.XDFFM.CLKB XFRT.CLKB 1.8151e-17
* device instance cc_XD0_XDFFM_CLKB_XFRT_M r0 *1 0,0
Ccc_XD0_XDFFM_CLKB_XFRT_M XD0.XDFFM.CLKB XFRT.M 2.4201e-17
* device instance cc_XD0_XDFFM_CLKB_XFRT_MB r0 *1 0,0
Ccc_XD0_XDFFM_CLKB_XFRT_MB XD0.XDFFM.CLKB XFRT.MB 1.21e-17
* device instance cc_XD0_XDFFM_CLKB_XFRT_S r0 *1 0,0
Ccc_XD0_XDFFM_CLKB_XFRT_S XD0.XDFFM.CLKB XFRT.S 1.8151e-17
* device instance cc_XD0_XDFFM_CLKB_XFRT_SB r0 *1 0,0
Ccc_XD0_XDFFM_CLKB_XFRT_SB XD0.XDFFM.CLKB XFRT.SB 1.8151e-17
* device instance cc_XD0_XDFFM_CLKB_ck1 r0 *1 0,0
Ccc_XD0_XDFFM_CLKB_ck1 XD0.XDFFM.CLKB ck1 5.4452e-17
* device instance cc_XD0_XDFFM_CLKB_ck2 r0 *1 0,0
Ccc_XD0_XDFFM_CLKB_ck2 XD0.XDFFM.CLKB ck2 5.4452e-17
* device instance cc_XD0_XDFFM_CLKB_ck3 r0 *1 0,0
Ccc_XD0_XDFFM_CLKB_ck3 XD0.XDFFM.CLKB ck3 5.4452e-17
* device instance cc_XD0_XDFFM_CLKB_ck4 r0 *1 0,0
Ccc_XD0_XDFFM_CLKB_ck4 XD0.XDFFM.CLKB ck4 5.4452e-17
* device instance cc_XD0_XDFFM_CLKB_ck5 r0 *1 0,0
Ccc_XD0_XDFFM_CLKB_ck5 XD0.XDFFM.CLKB ck5 5.4452e-17
* device instance cc_XD0_XDFFM_CLKB_mod0 r0 *1 0,0
Ccc_XD0_XDFFM_CLKB_mod0 XD0.XDFFM.CLKB mod0 2.4201e-17
* device instance cc_XD0_XDFFM_CLKB_mod1 r0 *1 0,0
Ccc_XD0_XDFFM_CLKB_mod1 XD0.XDFFM.CLKB mod1 2.4201e-17
* device instance cc_XD0_XDFFM_CLKB_mod2 r0 *1 0,0
Ccc_XD0_XDFFM_CLKB_mod2 XD0.XDFFM.CLKB mod2 2.4201e-17
* device instance cc_XD0_XDFFM_CLKB_mod3 r0 *1 0,0
Ccc_XD0_XDFFM_CLKB_mod3 XD0.XDFFM.CLKB mod3 2.4201e-17
* device instance cc_XD0_XDFFM_CLKB_mod4 r0 *1 0,0
Ccc_XD0_XDFFM_CLKB_mod4 XD0.XDFFM.CLKB mod4 2.4201e-17
* device instance cc_XD0_XDFFM_CLKB_net1 r0 *1 0,0
Ccc_XD0_XDFFM_CLKB_net1 XD0.XDFFM.CLKB net1 1.21e-17
* device instance cc_XD0_XDFFM_M_XD0_XDFFM_MB r0 *1 0,0
Ccc_XD0_XDFFM_M_XD0_XDFFM_MB XD0.XDFFM.M XD0.XDFFM.MB 3.4688e-17
* device instance cc_XD0_XDFFM_M_XD0_XDFFM_S r0 *1 0,0
Ccc_XD0_XDFFM_M_XD0_XDFFM_S XD0.XDFFM.M XD0.XDFFM.S 2.8638e-17
* device instance cc_XD0_XDFFM_M_XD0_XDFFM_SB r0 *1 0,0
Ccc_XD0_XDFFM_M_XD0_XDFFM_SB XD0.XDFFM.M XD0.XDFFM.SB 1.8151e-17
* device instance cc_XD0_XDFFM_M_XD0_XDFFQ_CLKB r0 *1 0,0
Ccc_XD0_XDFFM_M_XD0_XDFFQ_CLKB XD0.XDFFM.M XD0.XDFFQ.CLKB 1.8151e-17
* device instance cc_XD0_XDFFM_M_XD0_XDFFQ_M r0 *1 0,0
Ccc_XD0_XDFFM_M_XD0_XDFFQ_M XD0.XDFFM.M XD0.XDFFQ.M 2.4201e-17
* device instance cc_XD0_XDFFM_M_XD0_XDFFQ_MB r0 *1 0,0
Ccc_XD0_XDFFM_M_XD0_XDFFQ_MB XD0.XDFFM.M XD0.XDFFQ.MB 1.21e-17
* device instance cc_XD0_XDFFM_M_XD0_XDFFQ_S r0 *1 0,0
Ccc_XD0_XDFFM_M_XD0_XDFFQ_S XD0.XDFFM.M XD0.XDFFQ.S 1.8151e-17
* device instance cc_XD0_XDFFM_M_XD0_XDFFQ_SB r0 *1 0,0
Ccc_XD0_XDFFM_M_XD0_XDFFQ_SB XD0.XDFFM.M XD0.XDFFQ.SB 1.8151e-17
* device instance cc_XD0_XDFFM_M_XD0_XNOR_midp r0 *1 0,0
Ccc_XD0_XDFFM_M_XD0_XNOR_midp XD0.XDFFM.M XD0.XNOR.midp 1.21e-17
* device instance cc_XD0_XDFFM_M_XD0_dmodout r0 *1 0,0
Ccc_XD0_XDFFM_M_XD0_dmodout XD0.XDFFM.M XD0.dmodout 2.8638e-17
* device instance cc_XD0_XDFFM_M_XD0_dq r0 *1 0,0
Ccc_XD0_XDFFM_M_XD0_dq XD0.XDFFM.M XD0.dq 1.21e-17
* device instance cc_XD0_XDFFM_M_XD0_nm r0 *1 0,0
Ccc_XD0_XDFFM_M_XD0_nm XD0.XDFFM.M XD0.nm 1.8151e-17
* device instance cc_XD0_XDFFM_M_XD0_nt r0 *1 0,0
Ccc_XD0_XDFFM_M_XD0_nt XD0.XDFFM.M XD0.nt 2.4201e-17
* device instance cc_XD0_XDFFM_M_XD0_t1 r0 *1 0,0
Ccc_XD0_XDFFM_M_XD0_t1 XD0.XDFFM.M XD0.t1 1.21e-17
* device instance cc_XD0_XDFFM_M_XD1_XDFFM_CLKB r0 *1 0,0
Ccc_XD0_XDFFM_M_XD1_XDFFM_CLKB XD0.XDFFM.M XD1.XDFFM.CLKB 1.8151e-17
* device instance cc_XD0_XDFFM_M_XD1_XDFFM_M r0 *1 0,0
Ccc_XD0_XDFFM_M_XD1_XDFFM_M XD0.XDFFM.M XD1.XDFFM.M 2.4201e-17
* device instance cc_XD0_XDFFM_M_XD1_XDFFM_MB r0 *1 0,0
Ccc_XD0_XDFFM_M_XD1_XDFFM_MB XD0.XDFFM.M XD1.XDFFM.MB 1.21e-17
* device instance cc_XD0_XDFFM_M_XD1_XDFFM_S r0 *1 0,0
Ccc_XD0_XDFFM_M_XD1_XDFFM_S XD0.XDFFM.M XD1.XDFFM.S 1.8151e-17
* device instance cc_XD0_XDFFM_M_XD1_XDFFM_SB r0 *1 0,0
Ccc_XD0_XDFFM_M_XD1_XDFFM_SB XD0.XDFFM.M XD1.XDFFM.SB 1.8151e-17
* device instance cc_XD0_XDFFM_M_XD1_XDFFQ_CLKB r0 *1 0,0
Ccc_XD0_XDFFM_M_XD1_XDFFQ_CLKB XD0.XDFFM.M XD1.XDFFQ.CLKB 1.8151e-17
* device instance cc_XD0_XDFFM_M_XD1_XDFFQ_M r0 *1 0,0
Ccc_XD0_XDFFM_M_XD1_XDFFQ_M XD0.XDFFM.M XD1.XDFFQ.M 2.4201e-17
* device instance cc_XD0_XDFFM_M_XD1_XDFFQ_MB r0 *1 0,0
Ccc_XD0_XDFFM_M_XD1_XDFFQ_MB XD0.XDFFM.M XD1.XDFFQ.MB 1.21e-17
* device instance cc_XD0_XDFFM_M_XD1_XDFFQ_S r0 *1 0,0
Ccc_XD0_XDFFM_M_XD1_XDFFQ_S XD0.XDFFM.M XD1.XDFFQ.S 1.8151e-17
* device instance cc_XD0_XDFFM_M_XD1_XDFFQ_SB r0 *1 0,0
Ccc_XD0_XDFFM_M_XD1_XDFFQ_SB XD0.XDFFM.M XD1.XDFFQ.SB 1.8151e-17
* device instance cc_XD0_XDFFM_M_XD1_XN2_mid1 r0 *1 0,0
Ccc_XD0_XDFFM_M_XD1_XN2_mid1 XD0.XDFFM.M XD1.XN2.mid1 1.21e-17
* device instance cc_XD0_XDFFM_M_XD1_XN3_mid1 r0 *1 0,0
Ccc_XD0_XDFFM_M_XD1_XN3_mid1 XD0.XDFFM.M XD1.XN3.mid1 1.21e-17
* device instance cc_XD0_XDFFM_M_XD1_XN3_mid2 r0 *1 0,0
Ccc_XD0_XDFFM_M_XD1_XN3_mid2 XD0.XDFFM.M XD1.XN3.mid2 1.21e-17
* device instance cc_XD0_XDFFM_M_XD1_dmodout r0 *1 0,0
Ccc_XD0_XDFFM_M_XD1_dmodout XD0.XDFFM.M XD1.dmodout 1.21e-17
* device instance cc_XD0_XDFFM_M_XD1_dq r0 *1 0,0
Ccc_XD0_XDFFM_M_XD1_dq XD0.XDFFM.M XD1.dq 1.8151e-17
* device instance cc_XD0_XDFFM_M_XD1_nm r0 *1 0,0
Ccc_XD0_XDFFM_M_XD1_nm XD0.XDFFM.M XD1.nm 1.21e-17
* device instance cc_XD0_XDFFM_M_XD1_nt r0 *1 0,0
Ccc_XD0_XDFFM_M_XD1_nt XD0.XDFFM.M XD1.nt 1.21e-17
* device instance cc_XD0_XDFFM_M_XD1_t1 r0 *1 0,0
Ccc_XD0_XDFFM_M_XD1_t1 XD0.XDFFM.M XD1.t1 1.21e-17
* device instance cc_XD0_XDFFM_M_XD2_XDFFM_CLKB r0 *1 0,0
Ccc_XD0_XDFFM_M_XD2_XDFFM_CLKB XD0.XDFFM.M XD2.XDFFM.CLKB 1.8151e-17
* device instance cc_XD0_XDFFM_M_XD2_XDFFM_M r0 *1 0,0
Ccc_XD0_XDFFM_M_XD2_XDFFM_M XD0.XDFFM.M XD2.XDFFM.M 2.4201e-17
* device instance cc_XD0_XDFFM_M_XD2_XDFFM_MB r0 *1 0,0
Ccc_XD0_XDFFM_M_XD2_XDFFM_MB XD0.XDFFM.M XD2.XDFFM.MB 1.21e-17
* device instance cc_XD0_XDFFM_M_XD2_XDFFM_S r0 *1 0,0
Ccc_XD0_XDFFM_M_XD2_XDFFM_S XD0.XDFFM.M XD2.XDFFM.S 1.8151e-17
* device instance cc_XD0_XDFFM_M_XD2_XDFFM_SB r0 *1 0,0
Ccc_XD0_XDFFM_M_XD2_XDFFM_SB XD0.XDFFM.M XD2.XDFFM.SB 1.8151e-17
* device instance cc_XD0_XDFFM_M_XD2_XDFFQ_CLKB r0 *1 0,0
Ccc_XD0_XDFFM_M_XD2_XDFFQ_CLKB XD0.XDFFM.M XD2.XDFFQ.CLKB 1.8151e-17
* device instance cc_XD0_XDFFM_M_XD2_XDFFQ_M r0 *1 0,0
Ccc_XD0_XDFFM_M_XD2_XDFFQ_M XD0.XDFFM.M XD2.XDFFQ.M 2.4201e-17
* device instance cc_XD0_XDFFM_M_XD2_XDFFQ_MB r0 *1 0,0
Ccc_XD0_XDFFM_M_XD2_XDFFQ_MB XD0.XDFFM.M XD2.XDFFQ.MB 1.21e-17
* device instance cc_XD0_XDFFM_M_XD2_XDFFQ_S r0 *1 0,0
Ccc_XD0_XDFFM_M_XD2_XDFFQ_S XD0.XDFFM.M XD2.XDFFQ.S 1.8151e-17
* device instance cc_XD0_XDFFM_M_XD2_XDFFQ_SB r0 *1 0,0
Ccc_XD0_XDFFM_M_XD2_XDFFQ_SB XD0.XDFFM.M XD2.XDFFQ.SB 1.8151e-17
* device instance cc_XD0_XDFFM_M_XD2_XN2_mid1 r0 *1 0,0
Ccc_XD0_XDFFM_M_XD2_XN2_mid1 XD0.XDFFM.M XD2.XN2.mid1 1.21e-17
* device instance cc_XD0_XDFFM_M_XD2_XN3_mid1 r0 *1 0,0
Ccc_XD0_XDFFM_M_XD2_XN3_mid1 XD0.XDFFM.M XD2.XN3.mid1 1.21e-17
* device instance cc_XD0_XDFFM_M_XD2_XN3_mid2 r0 *1 0,0
Ccc_XD0_XDFFM_M_XD2_XN3_mid2 XD0.XDFFM.M XD2.XN3.mid2 1.21e-17
* device instance cc_XD0_XDFFM_M_XD2_dmodout r0 *1 0,0
Ccc_XD0_XDFFM_M_XD2_dmodout XD0.XDFFM.M XD2.dmodout 1.21e-17
* device instance cc_XD0_XDFFM_M_XD2_dq r0 *1 0,0
Ccc_XD0_XDFFM_M_XD2_dq XD0.XDFFM.M XD2.dq 1.8151e-17
* device instance cc_XD0_XDFFM_M_XD2_nm r0 *1 0,0
Ccc_XD0_XDFFM_M_XD2_nm XD0.XDFFM.M XD2.nm 1.21e-17
* device instance cc_XD0_XDFFM_M_XD2_nt r0 *1 0,0
Ccc_XD0_XDFFM_M_XD2_nt XD0.XDFFM.M XD2.nt 1.21e-17
* device instance cc_XD0_XDFFM_M_XD2_t1 r0 *1 0,0
Ccc_XD0_XDFFM_M_XD2_t1 XD0.XDFFM.M XD2.t1 1.21e-17
* device instance cc_XD0_XDFFM_M_XD3_XDFFM_CLKB r0 *1 0,0
Ccc_XD0_XDFFM_M_XD3_XDFFM_CLKB XD0.XDFFM.M XD3.XDFFM.CLKB 1.8151e-17
* device instance cc_XD0_XDFFM_M_XD3_XDFFM_M r0 *1 0,0
Ccc_XD0_XDFFM_M_XD3_XDFFM_M XD0.XDFFM.M XD3.XDFFM.M 2.4201e-17
* device instance cc_XD0_XDFFM_M_XD3_XDFFM_MB r0 *1 0,0
Ccc_XD0_XDFFM_M_XD3_XDFFM_MB XD0.XDFFM.M XD3.XDFFM.MB 1.21e-17
* device instance cc_XD0_XDFFM_M_XD3_XDFFM_S r0 *1 0,0
Ccc_XD0_XDFFM_M_XD3_XDFFM_S XD0.XDFFM.M XD3.XDFFM.S 1.8151e-17
* device instance cc_XD0_XDFFM_M_XD3_XDFFM_SB r0 *1 0,0
Ccc_XD0_XDFFM_M_XD3_XDFFM_SB XD0.XDFFM.M XD3.XDFFM.SB 1.8151e-17
* device instance cc_XD0_XDFFM_M_XD3_XDFFQ_CLKB r0 *1 0,0
Ccc_XD0_XDFFM_M_XD3_XDFFQ_CLKB XD0.XDFFM.M XD3.XDFFQ.CLKB 1.8151e-17
* device instance cc_XD0_XDFFM_M_XD3_XDFFQ_M r0 *1 0,0
Ccc_XD0_XDFFM_M_XD3_XDFFQ_M XD0.XDFFM.M XD3.XDFFQ.M 2.4201e-17
* device instance cc_XD0_XDFFM_M_XD3_XDFFQ_MB r0 *1 0,0
Ccc_XD0_XDFFM_M_XD3_XDFFQ_MB XD0.XDFFM.M XD3.XDFFQ.MB 1.21e-17
* device instance cc_XD0_XDFFM_M_XD3_XDFFQ_S r0 *1 0,0
Ccc_XD0_XDFFM_M_XD3_XDFFQ_S XD0.XDFFM.M XD3.XDFFQ.S 1.8151e-17
* device instance cc_XD0_XDFFM_M_XD3_XDFFQ_SB r0 *1 0,0
Ccc_XD0_XDFFM_M_XD3_XDFFQ_SB XD0.XDFFM.M XD3.XDFFQ.SB 1.8151e-17
* device instance cc_XD0_XDFFM_M_XD3_XN2_mid1 r0 *1 0,0
Ccc_XD0_XDFFM_M_XD3_XN2_mid1 XD0.XDFFM.M XD3.XN2.mid1 1.21e-17
* device instance cc_XD0_XDFFM_M_XD3_XN3_mid1 r0 *1 0,0
Ccc_XD0_XDFFM_M_XD3_XN3_mid1 XD0.XDFFM.M XD3.XN3.mid1 1.21e-17
* device instance cc_XD0_XDFFM_M_XD3_XN3_mid2 r0 *1 0,0
Ccc_XD0_XDFFM_M_XD3_XN3_mid2 XD0.XDFFM.M XD3.XN3.mid2 1.21e-17
* device instance cc_XD0_XDFFM_M_XD3_dmodout r0 *1 0,0
Ccc_XD0_XDFFM_M_XD3_dmodout XD0.XDFFM.M XD3.dmodout 1.21e-17
* device instance cc_XD0_XDFFM_M_XD3_dq r0 *1 0,0
Ccc_XD0_XDFFM_M_XD3_dq XD0.XDFFM.M XD3.dq 1.8151e-17
* device instance cc_XD0_XDFFM_M_XD3_nm r0 *1 0,0
Ccc_XD0_XDFFM_M_XD3_nm XD0.XDFFM.M XD3.nm 1.21e-17
* device instance cc_XD0_XDFFM_M_XD3_nt r0 *1 0,0
Ccc_XD0_XDFFM_M_XD3_nt XD0.XDFFM.M XD3.nt 1.21e-17
* device instance cc_XD0_XDFFM_M_XD3_t1 r0 *1 0,0
Ccc_XD0_XDFFM_M_XD3_t1 XD0.XDFFM.M XD3.t1 1.21e-17
* device instance cc_XD0_XDFFM_M_XD4_XDFFM_CLKB r0 *1 0,0
Ccc_XD0_XDFFM_M_XD4_XDFFM_CLKB XD0.XDFFM.M XD4.XDFFM.CLKB 1.8151e-17
* device instance cc_XD0_XDFFM_M_XD4_XDFFM_M r0 *1 0,0
Ccc_XD0_XDFFM_M_XD4_XDFFM_M XD0.XDFFM.M XD4.XDFFM.M 2.4201e-17
* device instance cc_XD0_XDFFM_M_XD4_XDFFM_MB r0 *1 0,0
Ccc_XD0_XDFFM_M_XD4_XDFFM_MB XD0.XDFFM.M XD4.XDFFM.MB 1.21e-17
* device instance cc_XD0_XDFFM_M_XD4_XDFFM_S r0 *1 0,0
Ccc_XD0_XDFFM_M_XD4_XDFFM_S XD0.XDFFM.M XD4.XDFFM.S 1.8151e-17
* device instance cc_XD0_XDFFM_M_XD4_XDFFM_SB r0 *1 0,0
Ccc_XD0_XDFFM_M_XD4_XDFFM_SB XD0.XDFFM.M XD4.XDFFM.SB 1.8151e-17
* device instance cc_XD0_XDFFM_M_XD4_XDFFQ_CLKB r0 *1 0,0
Ccc_XD0_XDFFM_M_XD4_XDFFQ_CLKB XD0.XDFFM.M XD4.XDFFQ.CLKB 1.8151e-17
* device instance cc_XD0_XDFFM_M_XD4_XDFFQ_M r0 *1 0,0
Ccc_XD0_XDFFM_M_XD4_XDFFQ_M XD0.XDFFM.M XD4.XDFFQ.M 2.4201e-17
* device instance cc_XD0_XDFFM_M_XD4_XDFFQ_MB r0 *1 0,0
Ccc_XD0_XDFFM_M_XD4_XDFFQ_MB XD0.XDFFM.M XD4.XDFFQ.MB 1.21e-17
* device instance cc_XD0_XDFFM_M_XD4_XDFFQ_S r0 *1 0,0
Ccc_XD0_XDFFM_M_XD4_XDFFQ_S XD0.XDFFM.M XD4.XDFFQ.S 1.8151e-17
* device instance cc_XD0_XDFFM_M_XD4_XDFFQ_SB r0 *1 0,0
Ccc_XD0_XDFFM_M_XD4_XDFFQ_SB XD0.XDFFM.M XD4.XDFFQ.SB 1.8151e-17
* device instance cc_XD0_XDFFM_M_XD4_XN2_mid1 r0 *1 0,0
Ccc_XD0_XDFFM_M_XD4_XN2_mid1 XD0.XDFFM.M XD4.XN2.mid1 1.21e-17
* device instance cc_XD0_XDFFM_M_XD4_XN3_mid1 r0 *1 0,0
Ccc_XD0_XDFFM_M_XD4_XN3_mid1 XD0.XDFFM.M XD4.XN3.mid1 1.21e-17
* device instance cc_XD0_XDFFM_M_XD4_XN3_mid2 r0 *1 0,0
Ccc_XD0_XDFFM_M_XD4_XN3_mid2 XD0.XDFFM.M XD4.XN3.mid2 1.21e-17
* device instance cc_XD0_XDFFM_M_XD4_dmodout r0 *1 0,0
Ccc_XD0_XDFFM_M_XD4_dmodout XD0.XDFFM.M XD4.dmodout 1.21e-17
* device instance cc_XD0_XDFFM_M_XD4_dq r0 *1 0,0
Ccc_XD0_XDFFM_M_XD4_dq XD0.XDFFM.M XD4.dq 1.8151e-17
* device instance cc_XD0_XDFFM_M_XD4_nm r0 *1 0,0
Ccc_XD0_XDFFM_M_XD4_nm XD0.XDFFM.M XD4.nm 1.21e-17
* device instance cc_XD0_XDFFM_M_XD4_nt r0 *1 0,0
Ccc_XD0_XDFFM_M_XD4_nt XD0.XDFFM.M XD4.nt 1.21e-17
* device instance cc_XD0_XDFFM_M_XD4_t1 r0 *1 0,0
Ccc_XD0_XDFFM_M_XD4_t1 XD0.XDFFM.M XD4.t1 1.21e-17
* device instance cc_XD0_XDFFM_M_XD5_XDFFM_CLKB r0 *1 0,0
Ccc_XD0_XDFFM_M_XD5_XDFFM_CLKB XD0.XDFFM.M XD5.XDFFM.CLKB 1.8151e-17
* device instance cc_XD0_XDFFM_M_XD5_XDFFM_M r0 *1 0,0
Ccc_XD0_XDFFM_M_XD5_XDFFM_M XD0.XDFFM.M XD5.XDFFM.M 2.4201e-17
* device instance cc_XD0_XDFFM_M_XD5_XDFFM_MB r0 *1 0,0
Ccc_XD0_XDFFM_M_XD5_XDFFM_MB XD0.XDFFM.M XD5.XDFFM.MB 1.21e-17
* device instance cc_XD0_XDFFM_M_XD5_XDFFM_S r0 *1 0,0
Ccc_XD0_XDFFM_M_XD5_XDFFM_S XD0.XDFFM.M XD5.XDFFM.S 1.8151e-17
* device instance cc_XD0_XDFFM_M_XD5_XDFFM_SB r0 *1 0,0
Ccc_XD0_XDFFM_M_XD5_XDFFM_SB XD0.XDFFM.M XD5.XDFFM.SB 1.8151e-17
* device instance cc_XD0_XDFFM_M_XD5_XDFFQ_CLKB r0 *1 0,0
Ccc_XD0_XDFFM_M_XD5_XDFFQ_CLKB XD0.XDFFM.M XD5.XDFFQ.CLKB 1.8151e-17
* device instance cc_XD0_XDFFM_M_XD5_XDFFQ_M r0 *1 0,0
Ccc_XD0_XDFFM_M_XD5_XDFFQ_M XD0.XDFFM.M XD5.XDFFQ.M 2.4201e-17
* device instance cc_XD0_XDFFM_M_XD5_XDFFQ_MB r0 *1 0,0
Ccc_XD0_XDFFM_M_XD5_XDFFQ_MB XD0.XDFFM.M XD5.XDFFQ.MB 1.21e-17
* device instance cc_XD0_XDFFM_M_XD5_XDFFQ_S r0 *1 0,0
Ccc_XD0_XDFFM_M_XD5_XDFFQ_S XD0.XDFFM.M XD5.XDFFQ.S 1.8151e-17
* device instance cc_XD0_XDFFM_M_XD5_XDFFQ_SB r0 *1 0,0
Ccc_XD0_XDFFM_M_XD5_XDFFQ_SB XD0.XDFFM.M XD5.XDFFQ.SB 1.8151e-17
* device instance cc_XD0_XDFFM_M_XD5_XN2_mid1 r0 *1 0,0
Ccc_XD0_XDFFM_M_XD5_XN2_mid1 XD0.XDFFM.M XD5.XN2.mid1 1.21e-17
* device instance cc_XD0_XDFFM_M_XD5_XN3_mid1 r0 *1 0,0
Ccc_XD0_XDFFM_M_XD5_XN3_mid1 XD0.XDFFM.M XD5.XN3.mid1 1.21e-17
* device instance cc_XD0_XDFFM_M_XD5_XN3_mid2 r0 *1 0,0
Ccc_XD0_XDFFM_M_XD5_XN3_mid2 XD0.XDFFM.M XD5.XN3.mid2 1.21e-17
* device instance cc_XD0_XDFFM_M_XD5_dmodout r0 *1 0,0
Ccc_XD0_XDFFM_M_XD5_dmodout XD0.XDFFM.M XD5.dmodout 1.21e-17
* device instance cc_XD0_XDFFM_M_XD5_dq r0 *1 0,0
Ccc_XD0_XDFFM_M_XD5_dq XD0.XDFFM.M XD5.dq 1.8151e-17
* device instance cc_XD0_XDFFM_M_XD5_nm r0 *1 0,0
Ccc_XD0_XDFFM_M_XD5_nm XD0.XDFFM.M XD5.nm 1.21e-17
* device instance cc_XD0_XDFFM_M_XD5_nt r0 *1 0,0
Ccc_XD0_XDFFM_M_XD5_nt XD0.XDFFM.M XD5.nt 1.21e-17
* device instance cc_XD0_XDFFM_M_XD5_t1 r0 *1 0,0
Ccc_XD0_XDFFM_M_XD5_t1 XD0.XDFFM.M XD5.t1 1.21e-17
* device instance cc_XD0_XDFFM_M_XFRT_CLKB r0 *1 0,0
Ccc_XD0_XDFFM_M_XFRT_CLKB XD0.XDFFM.M XFRT.CLKB 1.8151e-17
* device instance cc_XD0_XDFFM_M_XFRT_M r0 *1 0,0
Ccc_XD0_XDFFM_M_XFRT_M XD0.XDFFM.M XFRT.M 2.4201e-17
* device instance cc_XD0_XDFFM_M_XFRT_MB r0 *1 0,0
Ccc_XD0_XDFFM_M_XFRT_MB XD0.XDFFM.M XFRT.MB 1.21e-17
* device instance cc_XD0_XDFFM_M_XFRT_S r0 *1 0,0
Ccc_XD0_XDFFM_M_XFRT_S XD0.XDFFM.M XFRT.S 1.8151e-17
* device instance cc_XD0_XDFFM_M_XFRT_SB r0 *1 0,0
Ccc_XD0_XDFFM_M_XFRT_SB XD0.XDFFM.M XFRT.SB 1.8151e-17
* device instance cc_XD0_XDFFM_M_ck1 r0 *1 0,0
Ccc_XD0_XDFFM_M_ck1 XD0.XDFFM.M ck1 5.4452e-17
* device instance cc_XD0_XDFFM_M_ck2 r0 *1 0,0
Ccc_XD0_XDFFM_M_ck2 XD0.XDFFM.M ck2 5.4452e-17
* device instance cc_XD0_XDFFM_M_ck3 r0 *1 0,0
Ccc_XD0_XDFFM_M_ck3 XD0.XDFFM.M ck3 5.4452e-17
* device instance cc_XD0_XDFFM_M_ck4 r0 *1 0,0
Ccc_XD0_XDFFM_M_ck4 XD0.XDFFM.M ck4 5.4452e-17
* device instance cc_XD0_XDFFM_M_ck5 r0 *1 0,0
Ccc_XD0_XDFFM_M_ck5 XD0.XDFFM.M ck5 5.4452e-17
* device instance cc_XD0_XDFFM_M_mod0 r0 *1 0,0
Ccc_XD0_XDFFM_M_mod0 XD0.XDFFM.M mod0 2.4201e-17
* device instance cc_XD0_XDFFM_M_mod1 r0 *1 0,0
Ccc_XD0_XDFFM_M_mod1 XD0.XDFFM.M mod1 2.4201e-17
* device instance cc_XD0_XDFFM_M_mod2 r0 *1 0,0
Ccc_XD0_XDFFM_M_mod2 XD0.XDFFM.M mod2 2.4201e-17
* device instance cc_XD0_XDFFM_M_mod3 r0 *1 0,0
Ccc_XD0_XDFFM_M_mod3 XD0.XDFFM.M mod3 2.4201e-17
* device instance cc_XD0_XDFFM_M_mod4 r0 *1 0,0
Ccc_XD0_XDFFM_M_mod4 XD0.XDFFM.M mod4 2.4201e-17
* device instance cc_XD0_XDFFM_M_net1 r0 *1 0,0
Ccc_XD0_XDFFM_M_net1 XD0.XDFFM.M net1 1.21e-17
* device instance cc_XD0_XDFFM_MB_XD0_XDFFM_S r0 *1 0,0
Ccc_XD0_XDFFM_MB_XD0_XDFFM_S XD0.XDFFM.MB XD0.XDFFM.S 1.8151e-17
* device instance cc_XD0_XDFFM_MB_XD0_XDFFM_SB r0 *1 0,0
Ccc_XD0_XDFFM_MB_XD0_XDFFM_SB XD0.XDFFM.MB XD0.XDFFM.SB 1.8151e-17
* device instance cc_XD0_XDFFM_MB_XD0_XDFFQ_CLKB r0 *1 0,0
Ccc_XD0_XDFFM_MB_XD0_XDFFQ_CLKB XD0.XDFFM.MB XD0.XDFFQ.CLKB 1.8151e-17
* device instance cc_XD0_XDFFM_MB_XD0_XDFFQ_M r0 *1 0,0
Ccc_XD0_XDFFM_MB_XD0_XDFFQ_M XD0.XDFFM.MB XD0.XDFFQ.M 2.4201e-17
* device instance cc_XD0_XDFFM_MB_XD0_XDFFQ_MB r0 *1 0,0
Ccc_XD0_XDFFM_MB_XD0_XDFFQ_MB XD0.XDFFM.MB XD0.XDFFQ.MB 1.21e-17
* device instance cc_XD0_XDFFM_MB_XD0_XDFFQ_S r0 *1 0,0
Ccc_XD0_XDFFM_MB_XD0_XDFFQ_S XD0.XDFFM.MB XD0.XDFFQ.S 1.8151e-17
* device instance cc_XD0_XDFFM_MB_XD0_XDFFQ_SB r0 *1 0,0
Ccc_XD0_XDFFM_MB_XD0_XDFFQ_SB XD0.XDFFM.MB XD0.XDFFQ.SB 1.8151e-17
* device instance cc_XD0_XDFFM_MB_XD0_XNOR_midp r0 *1 0,0
Ccc_XD0_XDFFM_MB_XD0_XNOR_midp XD0.XDFFM.MB XD0.XNOR.midp 1.21e-17
* device instance cc_XD0_XDFFM_MB_XD0_dmodout r0 *1 0,0
Ccc_XD0_XDFFM_MB_XD0_dmodout XD0.XDFFM.MB XD0.dmodout 1.21e-17
* device instance cc_XD0_XDFFM_MB_XD0_dq r0 *1 0,0
Ccc_XD0_XDFFM_MB_XD0_dq XD0.XDFFM.MB XD0.dq 1.21e-17
* device instance cc_XD0_XDFFM_MB_XD0_nm r0 *1 0,0
Ccc_XD0_XDFFM_MB_XD0_nm XD0.XDFFM.MB XD0.nm 1.8151e-17
* device instance cc_XD0_XDFFM_MB_XD0_nt r0 *1 0,0
Ccc_XD0_XDFFM_MB_XD0_nt XD0.XDFFM.MB XD0.nt 2.4201e-17
* device instance cc_XD0_XDFFM_MB_XD0_t1 r0 *1 0,0
Ccc_XD0_XDFFM_MB_XD0_t1 XD0.XDFFM.MB XD0.t1 1.21e-17
* device instance cc_XD0_XDFFM_MB_XD1_XDFFM_CLKB r0 *1 0,0
Ccc_XD0_XDFFM_MB_XD1_XDFFM_CLKB XD0.XDFFM.MB XD1.XDFFM.CLKB 1.8151e-17
* device instance cc_XD0_XDFFM_MB_XD1_XDFFM_M r0 *1 0,0
Ccc_XD0_XDFFM_MB_XD1_XDFFM_M XD0.XDFFM.MB XD1.XDFFM.M 2.4201e-17
* device instance cc_XD0_XDFFM_MB_XD1_XDFFM_MB r0 *1 0,0
Ccc_XD0_XDFFM_MB_XD1_XDFFM_MB XD0.XDFFM.MB XD1.XDFFM.MB 1.21e-17
* device instance cc_XD0_XDFFM_MB_XD1_XDFFM_S r0 *1 0,0
Ccc_XD0_XDFFM_MB_XD1_XDFFM_S XD0.XDFFM.MB XD1.XDFFM.S 1.8151e-17
* device instance cc_XD0_XDFFM_MB_XD1_XDFFM_SB r0 *1 0,0
Ccc_XD0_XDFFM_MB_XD1_XDFFM_SB XD0.XDFFM.MB XD1.XDFFM.SB 1.8151e-17
* device instance cc_XD0_XDFFM_MB_XD1_XDFFQ_CLKB r0 *1 0,0
Ccc_XD0_XDFFM_MB_XD1_XDFFQ_CLKB XD0.XDFFM.MB XD1.XDFFQ.CLKB 1.8151e-17
* device instance cc_XD0_XDFFM_MB_XD1_XDFFQ_M r0 *1 0,0
Ccc_XD0_XDFFM_MB_XD1_XDFFQ_M XD0.XDFFM.MB XD1.XDFFQ.M 2.4201e-17
* device instance cc_XD0_XDFFM_MB_XD1_XDFFQ_MB r0 *1 0,0
Ccc_XD0_XDFFM_MB_XD1_XDFFQ_MB XD0.XDFFM.MB XD1.XDFFQ.MB 1.21e-17
* device instance cc_XD0_XDFFM_MB_XD1_XDFFQ_S r0 *1 0,0
Ccc_XD0_XDFFM_MB_XD1_XDFFQ_S XD0.XDFFM.MB XD1.XDFFQ.S 1.8151e-17
* device instance cc_XD0_XDFFM_MB_XD1_XDFFQ_SB r0 *1 0,0
Ccc_XD0_XDFFM_MB_XD1_XDFFQ_SB XD0.XDFFM.MB XD1.XDFFQ.SB 1.8151e-17
* device instance cc_XD0_XDFFM_MB_XD1_XN2_mid1 r0 *1 0,0
Ccc_XD0_XDFFM_MB_XD1_XN2_mid1 XD0.XDFFM.MB XD1.XN2.mid1 1.21e-17
* device instance cc_XD0_XDFFM_MB_XD1_XN3_mid1 r0 *1 0,0
Ccc_XD0_XDFFM_MB_XD1_XN3_mid1 XD0.XDFFM.MB XD1.XN3.mid1 1.21e-17
* device instance cc_XD0_XDFFM_MB_XD1_XN3_mid2 r0 *1 0,0
Ccc_XD0_XDFFM_MB_XD1_XN3_mid2 XD0.XDFFM.MB XD1.XN3.mid2 1.21e-17
* device instance cc_XD0_XDFFM_MB_XD1_dmodout r0 *1 0,0
Ccc_XD0_XDFFM_MB_XD1_dmodout XD0.XDFFM.MB XD1.dmodout 1.21e-17
* device instance cc_XD0_XDFFM_MB_XD1_dq r0 *1 0,0
Ccc_XD0_XDFFM_MB_XD1_dq XD0.XDFFM.MB XD1.dq 1.8151e-17
* device instance cc_XD0_XDFFM_MB_XD1_nm r0 *1 0,0
Ccc_XD0_XDFFM_MB_XD1_nm XD0.XDFFM.MB XD1.nm 1.21e-17
* device instance cc_XD0_XDFFM_MB_XD1_nt r0 *1 0,0
Ccc_XD0_XDFFM_MB_XD1_nt XD0.XDFFM.MB XD1.nt 1.21e-17
* device instance cc_XD0_XDFFM_MB_XD1_t1 r0 *1 0,0
Ccc_XD0_XDFFM_MB_XD1_t1 XD0.XDFFM.MB XD1.t1 1.21e-17
* device instance cc_XD0_XDFFM_MB_XD2_XDFFM_CLKB r0 *1 0,0
Ccc_XD0_XDFFM_MB_XD2_XDFFM_CLKB XD0.XDFFM.MB XD2.XDFFM.CLKB 1.8151e-17
* device instance cc_XD0_XDFFM_MB_XD2_XDFFM_M r0 *1 0,0
Ccc_XD0_XDFFM_MB_XD2_XDFFM_M XD0.XDFFM.MB XD2.XDFFM.M 2.4201e-17
* device instance cc_XD0_XDFFM_MB_XD2_XDFFM_MB r0 *1 0,0
Ccc_XD0_XDFFM_MB_XD2_XDFFM_MB XD0.XDFFM.MB XD2.XDFFM.MB 1.21e-17
* device instance cc_XD0_XDFFM_MB_XD2_XDFFM_S r0 *1 0,0
Ccc_XD0_XDFFM_MB_XD2_XDFFM_S XD0.XDFFM.MB XD2.XDFFM.S 1.8151e-17
* device instance cc_XD0_XDFFM_MB_XD2_XDFFM_SB r0 *1 0,0
Ccc_XD0_XDFFM_MB_XD2_XDFFM_SB XD0.XDFFM.MB XD2.XDFFM.SB 1.8151e-17
* device instance cc_XD0_XDFFM_MB_XD2_XDFFQ_CLKB r0 *1 0,0
Ccc_XD0_XDFFM_MB_XD2_XDFFQ_CLKB XD0.XDFFM.MB XD2.XDFFQ.CLKB 1.8151e-17
* device instance cc_XD0_XDFFM_MB_XD2_XDFFQ_M r0 *1 0,0
Ccc_XD0_XDFFM_MB_XD2_XDFFQ_M XD0.XDFFM.MB XD2.XDFFQ.M 2.4201e-17
* device instance cc_XD0_XDFFM_MB_XD2_XDFFQ_MB r0 *1 0,0
Ccc_XD0_XDFFM_MB_XD2_XDFFQ_MB XD0.XDFFM.MB XD2.XDFFQ.MB 1.21e-17
* device instance cc_XD0_XDFFM_MB_XD2_XDFFQ_S r0 *1 0,0
Ccc_XD0_XDFFM_MB_XD2_XDFFQ_S XD0.XDFFM.MB XD2.XDFFQ.S 1.8151e-17
* device instance cc_XD0_XDFFM_MB_XD2_XDFFQ_SB r0 *1 0,0
Ccc_XD0_XDFFM_MB_XD2_XDFFQ_SB XD0.XDFFM.MB XD2.XDFFQ.SB 1.8151e-17
* device instance cc_XD0_XDFFM_MB_XD2_XN2_mid1 r0 *1 0,0
Ccc_XD0_XDFFM_MB_XD2_XN2_mid1 XD0.XDFFM.MB XD2.XN2.mid1 1.21e-17
* device instance cc_XD0_XDFFM_MB_XD2_XN3_mid1 r0 *1 0,0
Ccc_XD0_XDFFM_MB_XD2_XN3_mid1 XD0.XDFFM.MB XD2.XN3.mid1 1.21e-17
* device instance cc_XD0_XDFFM_MB_XD2_XN3_mid2 r0 *1 0,0
Ccc_XD0_XDFFM_MB_XD2_XN3_mid2 XD0.XDFFM.MB XD2.XN3.mid2 1.21e-17
* device instance cc_XD0_XDFFM_MB_XD2_dmodout r0 *1 0,0
Ccc_XD0_XDFFM_MB_XD2_dmodout XD0.XDFFM.MB XD2.dmodout 1.21e-17
* device instance cc_XD0_XDFFM_MB_XD2_dq r0 *1 0,0
Ccc_XD0_XDFFM_MB_XD2_dq XD0.XDFFM.MB XD2.dq 1.8151e-17
* device instance cc_XD0_XDFFM_MB_XD2_nm r0 *1 0,0
Ccc_XD0_XDFFM_MB_XD2_nm XD0.XDFFM.MB XD2.nm 1.21e-17
* device instance cc_XD0_XDFFM_MB_XD2_nt r0 *1 0,0
Ccc_XD0_XDFFM_MB_XD2_nt XD0.XDFFM.MB XD2.nt 1.21e-17
* device instance cc_XD0_XDFFM_MB_XD2_t1 r0 *1 0,0
Ccc_XD0_XDFFM_MB_XD2_t1 XD0.XDFFM.MB XD2.t1 1.21e-17
* device instance cc_XD0_XDFFM_MB_XD3_XDFFM_CLKB r0 *1 0,0
Ccc_XD0_XDFFM_MB_XD3_XDFFM_CLKB XD0.XDFFM.MB XD3.XDFFM.CLKB 1.8151e-17
* device instance cc_XD0_XDFFM_MB_XD3_XDFFM_M r0 *1 0,0
Ccc_XD0_XDFFM_MB_XD3_XDFFM_M XD0.XDFFM.MB XD3.XDFFM.M 2.4201e-17
* device instance cc_XD0_XDFFM_MB_XD3_XDFFM_MB r0 *1 0,0
Ccc_XD0_XDFFM_MB_XD3_XDFFM_MB XD0.XDFFM.MB XD3.XDFFM.MB 1.21e-17
* device instance cc_XD0_XDFFM_MB_XD3_XDFFM_S r0 *1 0,0
Ccc_XD0_XDFFM_MB_XD3_XDFFM_S XD0.XDFFM.MB XD3.XDFFM.S 1.8151e-17
* device instance cc_XD0_XDFFM_MB_XD3_XDFFM_SB r0 *1 0,0
Ccc_XD0_XDFFM_MB_XD3_XDFFM_SB XD0.XDFFM.MB XD3.XDFFM.SB 1.8151e-17
* device instance cc_XD0_XDFFM_MB_XD3_XDFFQ_CLKB r0 *1 0,0
Ccc_XD0_XDFFM_MB_XD3_XDFFQ_CLKB XD0.XDFFM.MB XD3.XDFFQ.CLKB 1.8151e-17
* device instance cc_XD0_XDFFM_MB_XD3_XDFFQ_M r0 *1 0,0
Ccc_XD0_XDFFM_MB_XD3_XDFFQ_M XD0.XDFFM.MB XD3.XDFFQ.M 2.4201e-17
* device instance cc_XD0_XDFFM_MB_XD3_XDFFQ_MB r0 *1 0,0
Ccc_XD0_XDFFM_MB_XD3_XDFFQ_MB XD0.XDFFM.MB XD3.XDFFQ.MB 1.21e-17
* device instance cc_XD0_XDFFM_MB_XD3_XDFFQ_S r0 *1 0,0
Ccc_XD0_XDFFM_MB_XD3_XDFFQ_S XD0.XDFFM.MB XD3.XDFFQ.S 1.8151e-17
* device instance cc_XD0_XDFFM_MB_XD3_XDFFQ_SB r0 *1 0,0
Ccc_XD0_XDFFM_MB_XD3_XDFFQ_SB XD0.XDFFM.MB XD3.XDFFQ.SB 1.8151e-17
* device instance cc_XD0_XDFFM_MB_XD3_XN2_mid1 r0 *1 0,0
Ccc_XD0_XDFFM_MB_XD3_XN2_mid1 XD0.XDFFM.MB XD3.XN2.mid1 1.21e-17
* device instance cc_XD0_XDFFM_MB_XD3_XN3_mid1 r0 *1 0,0
Ccc_XD0_XDFFM_MB_XD3_XN3_mid1 XD0.XDFFM.MB XD3.XN3.mid1 1.21e-17
* device instance cc_XD0_XDFFM_MB_XD3_XN3_mid2 r0 *1 0,0
Ccc_XD0_XDFFM_MB_XD3_XN3_mid2 XD0.XDFFM.MB XD3.XN3.mid2 1.21e-17
* device instance cc_XD0_XDFFM_MB_XD3_dmodout r0 *1 0,0
Ccc_XD0_XDFFM_MB_XD3_dmodout XD0.XDFFM.MB XD3.dmodout 1.21e-17
* device instance cc_XD0_XDFFM_MB_XD3_dq r0 *1 0,0
Ccc_XD0_XDFFM_MB_XD3_dq XD0.XDFFM.MB XD3.dq 1.8151e-17
* device instance cc_XD0_XDFFM_MB_XD3_nm r0 *1 0,0
Ccc_XD0_XDFFM_MB_XD3_nm XD0.XDFFM.MB XD3.nm 1.21e-17
* device instance cc_XD0_XDFFM_MB_XD3_nt r0 *1 0,0
Ccc_XD0_XDFFM_MB_XD3_nt XD0.XDFFM.MB XD3.nt 1.21e-17
* device instance cc_XD0_XDFFM_MB_XD3_t1 r0 *1 0,0
Ccc_XD0_XDFFM_MB_XD3_t1 XD0.XDFFM.MB XD3.t1 1.21e-17
* device instance cc_XD0_XDFFM_MB_XD4_XDFFM_CLKB r0 *1 0,0
Ccc_XD0_XDFFM_MB_XD4_XDFFM_CLKB XD0.XDFFM.MB XD4.XDFFM.CLKB 1.8151e-17
* device instance cc_XD0_XDFFM_MB_XD4_XDFFM_M r0 *1 0,0
Ccc_XD0_XDFFM_MB_XD4_XDFFM_M XD0.XDFFM.MB XD4.XDFFM.M 2.4201e-17
* device instance cc_XD0_XDFFM_MB_XD4_XDFFM_MB r0 *1 0,0
Ccc_XD0_XDFFM_MB_XD4_XDFFM_MB XD0.XDFFM.MB XD4.XDFFM.MB 1.21e-17
* device instance cc_XD0_XDFFM_MB_XD4_XDFFM_S r0 *1 0,0
Ccc_XD0_XDFFM_MB_XD4_XDFFM_S XD0.XDFFM.MB XD4.XDFFM.S 1.8151e-17
* device instance cc_XD0_XDFFM_MB_XD4_XDFFM_SB r0 *1 0,0
Ccc_XD0_XDFFM_MB_XD4_XDFFM_SB XD0.XDFFM.MB XD4.XDFFM.SB 1.8151e-17
* device instance cc_XD0_XDFFM_MB_XD4_XDFFQ_CLKB r0 *1 0,0
Ccc_XD0_XDFFM_MB_XD4_XDFFQ_CLKB XD0.XDFFM.MB XD4.XDFFQ.CLKB 1.8151e-17
* device instance cc_XD0_XDFFM_MB_XD4_XDFFQ_M r0 *1 0,0
Ccc_XD0_XDFFM_MB_XD4_XDFFQ_M XD0.XDFFM.MB XD4.XDFFQ.M 2.4201e-17
* device instance cc_XD0_XDFFM_MB_XD4_XDFFQ_MB r0 *1 0,0
Ccc_XD0_XDFFM_MB_XD4_XDFFQ_MB XD0.XDFFM.MB XD4.XDFFQ.MB 1.21e-17
* device instance cc_XD0_XDFFM_MB_XD4_XDFFQ_S r0 *1 0,0
Ccc_XD0_XDFFM_MB_XD4_XDFFQ_S XD0.XDFFM.MB XD4.XDFFQ.S 1.8151e-17
* device instance cc_XD0_XDFFM_MB_XD4_XDFFQ_SB r0 *1 0,0
Ccc_XD0_XDFFM_MB_XD4_XDFFQ_SB XD0.XDFFM.MB XD4.XDFFQ.SB 1.8151e-17
* device instance cc_XD0_XDFFM_MB_XD4_XN2_mid1 r0 *1 0,0
Ccc_XD0_XDFFM_MB_XD4_XN2_mid1 XD0.XDFFM.MB XD4.XN2.mid1 1.21e-17
* device instance cc_XD0_XDFFM_MB_XD4_XN3_mid1 r0 *1 0,0
Ccc_XD0_XDFFM_MB_XD4_XN3_mid1 XD0.XDFFM.MB XD4.XN3.mid1 1.21e-17
* device instance cc_XD0_XDFFM_MB_XD4_XN3_mid2 r0 *1 0,0
Ccc_XD0_XDFFM_MB_XD4_XN3_mid2 XD0.XDFFM.MB XD4.XN3.mid2 1.21e-17
* device instance cc_XD0_XDFFM_MB_XD4_dmodout r0 *1 0,0
Ccc_XD0_XDFFM_MB_XD4_dmodout XD0.XDFFM.MB XD4.dmodout 1.21e-17
* device instance cc_XD0_XDFFM_MB_XD4_dq r0 *1 0,0
Ccc_XD0_XDFFM_MB_XD4_dq XD0.XDFFM.MB XD4.dq 1.8151e-17
* device instance cc_XD0_XDFFM_MB_XD4_nm r0 *1 0,0
Ccc_XD0_XDFFM_MB_XD4_nm XD0.XDFFM.MB XD4.nm 1.21e-17
* device instance cc_XD0_XDFFM_MB_XD4_nt r0 *1 0,0
Ccc_XD0_XDFFM_MB_XD4_nt XD0.XDFFM.MB XD4.nt 1.21e-17
* device instance cc_XD0_XDFFM_MB_XD4_t1 r0 *1 0,0
Ccc_XD0_XDFFM_MB_XD4_t1 XD0.XDFFM.MB XD4.t1 1.21e-17
* device instance cc_XD0_XDFFM_MB_XD5_XDFFM_CLKB r0 *1 0,0
Ccc_XD0_XDFFM_MB_XD5_XDFFM_CLKB XD0.XDFFM.MB XD5.XDFFM.CLKB 1.8151e-17
* device instance cc_XD0_XDFFM_MB_XD5_XDFFM_M r0 *1 0,0
Ccc_XD0_XDFFM_MB_XD5_XDFFM_M XD0.XDFFM.MB XD5.XDFFM.M 2.4201e-17
* device instance cc_XD0_XDFFM_MB_XD5_XDFFM_MB r0 *1 0,0
Ccc_XD0_XDFFM_MB_XD5_XDFFM_MB XD0.XDFFM.MB XD5.XDFFM.MB 1.21e-17
* device instance cc_XD0_XDFFM_MB_XD5_XDFFM_S r0 *1 0,0
Ccc_XD0_XDFFM_MB_XD5_XDFFM_S XD0.XDFFM.MB XD5.XDFFM.S 1.8151e-17
* device instance cc_XD0_XDFFM_MB_XD5_XDFFM_SB r0 *1 0,0
Ccc_XD0_XDFFM_MB_XD5_XDFFM_SB XD0.XDFFM.MB XD5.XDFFM.SB 1.8151e-17
* device instance cc_XD0_XDFFM_MB_XD5_XDFFQ_CLKB r0 *1 0,0
Ccc_XD0_XDFFM_MB_XD5_XDFFQ_CLKB XD0.XDFFM.MB XD5.XDFFQ.CLKB 1.8151e-17
* device instance cc_XD0_XDFFM_MB_XD5_XDFFQ_M r0 *1 0,0
Ccc_XD0_XDFFM_MB_XD5_XDFFQ_M XD0.XDFFM.MB XD5.XDFFQ.M 2.4201e-17
* device instance cc_XD0_XDFFM_MB_XD5_XDFFQ_MB r0 *1 0,0
Ccc_XD0_XDFFM_MB_XD5_XDFFQ_MB XD0.XDFFM.MB XD5.XDFFQ.MB 1.21e-17
* device instance cc_XD0_XDFFM_MB_XD5_XDFFQ_S r0 *1 0,0
Ccc_XD0_XDFFM_MB_XD5_XDFFQ_S XD0.XDFFM.MB XD5.XDFFQ.S 1.8151e-17
* device instance cc_XD0_XDFFM_MB_XD5_XDFFQ_SB r0 *1 0,0
Ccc_XD0_XDFFM_MB_XD5_XDFFQ_SB XD0.XDFFM.MB XD5.XDFFQ.SB 1.8151e-17
* device instance cc_XD0_XDFFM_MB_XD5_XN2_mid1 r0 *1 0,0
Ccc_XD0_XDFFM_MB_XD5_XN2_mid1 XD0.XDFFM.MB XD5.XN2.mid1 1.21e-17
* device instance cc_XD0_XDFFM_MB_XD5_XN3_mid1 r0 *1 0,0
Ccc_XD0_XDFFM_MB_XD5_XN3_mid1 XD0.XDFFM.MB XD5.XN3.mid1 1.21e-17
* device instance cc_XD0_XDFFM_MB_XD5_XN3_mid2 r0 *1 0,0
Ccc_XD0_XDFFM_MB_XD5_XN3_mid2 XD0.XDFFM.MB XD5.XN3.mid2 1.21e-17
* device instance cc_XD0_XDFFM_MB_XD5_dmodout r0 *1 0,0
Ccc_XD0_XDFFM_MB_XD5_dmodout XD0.XDFFM.MB XD5.dmodout 1.21e-17
* device instance cc_XD0_XDFFM_MB_XD5_dq r0 *1 0,0
Ccc_XD0_XDFFM_MB_XD5_dq XD0.XDFFM.MB XD5.dq 1.8151e-17
* device instance cc_XD0_XDFFM_MB_XD5_nm r0 *1 0,0
Ccc_XD0_XDFFM_MB_XD5_nm XD0.XDFFM.MB XD5.nm 1.21e-17
* device instance cc_XD0_XDFFM_MB_XD5_nt r0 *1 0,0
Ccc_XD0_XDFFM_MB_XD5_nt XD0.XDFFM.MB XD5.nt 1.21e-17
* device instance cc_XD0_XDFFM_MB_XD5_t1 r0 *1 0,0
Ccc_XD0_XDFFM_MB_XD5_t1 XD0.XDFFM.MB XD5.t1 1.21e-17
* device instance cc_XD0_XDFFM_MB_XFRT_CLKB r0 *1 0,0
Ccc_XD0_XDFFM_MB_XFRT_CLKB XD0.XDFFM.MB XFRT.CLKB 1.8151e-17
* device instance cc_XD0_XDFFM_MB_XFRT_M r0 *1 0,0
Ccc_XD0_XDFFM_MB_XFRT_M XD0.XDFFM.MB XFRT.M 2.4201e-17
* device instance cc_XD0_XDFFM_MB_XFRT_MB r0 *1 0,0
Ccc_XD0_XDFFM_MB_XFRT_MB XD0.XDFFM.MB XFRT.MB 1.21e-17
* device instance cc_XD0_XDFFM_MB_XFRT_S r0 *1 0,0
Ccc_XD0_XDFFM_MB_XFRT_S XD0.XDFFM.MB XFRT.S 1.8151e-17
* device instance cc_XD0_XDFFM_MB_XFRT_SB r0 *1 0,0
Ccc_XD0_XDFFM_MB_XFRT_SB XD0.XDFFM.MB XFRT.SB 1.8151e-17
* device instance cc_XD0_XDFFM_MB_ck1 r0 *1 0,0
Ccc_XD0_XDFFM_MB_ck1 XD0.XDFFM.MB ck1 5.4452e-17
* device instance cc_XD0_XDFFM_MB_ck2 r0 *1 0,0
Ccc_XD0_XDFFM_MB_ck2 XD0.XDFFM.MB ck2 5.4452e-17
* device instance cc_XD0_XDFFM_MB_ck3 r0 *1 0,0
Ccc_XD0_XDFFM_MB_ck3 XD0.XDFFM.MB ck3 5.4452e-17
* device instance cc_XD0_XDFFM_MB_ck4 r0 *1 0,0
Ccc_XD0_XDFFM_MB_ck4 XD0.XDFFM.MB ck4 5.4452e-17
* device instance cc_XD0_XDFFM_MB_ck5 r0 *1 0,0
Ccc_XD0_XDFFM_MB_ck5 XD0.XDFFM.MB ck5 5.4452e-17
* device instance cc_XD0_XDFFM_MB_mod0 r0 *1 0,0
Ccc_XD0_XDFFM_MB_mod0 XD0.XDFFM.MB mod0 2.4201e-17
* device instance cc_XD0_XDFFM_MB_mod1 r0 *1 0,0
Ccc_XD0_XDFFM_MB_mod1 XD0.XDFFM.MB mod1 2.4201e-17
* device instance cc_XD0_XDFFM_MB_mod2 r0 *1 0,0
Ccc_XD0_XDFFM_MB_mod2 XD0.XDFFM.MB mod2 2.4201e-17
* device instance cc_XD0_XDFFM_MB_mod3 r0 *1 0,0
Ccc_XD0_XDFFM_MB_mod3 XD0.XDFFM.MB mod3 2.4201e-17
* device instance cc_XD0_XDFFM_MB_mod4 r0 *1 0,0
Ccc_XD0_XDFFM_MB_mod4 XD0.XDFFM.MB mod4 2.4201e-17
* device instance cc_XD0_XDFFM_MB_net1 r0 *1 0,0
Ccc_XD0_XDFFM_MB_net1 XD0.XDFFM.MB net1 1.21e-17
* device instance cc_XD0_XDFFM_S_XD0_XDFFM_SB r0 *1 0,0
Ccc_XD0_XDFFM_S_XD0_XDFFM_SB XD0.XDFFM.S XD0.XDFFM.SB 4.0738e-17
* device instance cc_XD0_XDFFM_S_XD0_XDFFQ_CLKB r0 *1 0,0
Ccc_XD0_XDFFM_S_XD0_XDFFQ_CLKB XD0.XDFFM.S XD0.XDFFQ.CLKB 1.8151e-17
* device instance cc_XD0_XDFFM_S_XD0_XDFFQ_M r0 *1 0,0
Ccc_XD0_XDFFM_S_XD0_XDFFQ_M XD0.XDFFM.S XD0.XDFFQ.M 2.4201e-17
* device instance cc_XD0_XDFFM_S_XD0_XDFFQ_MB r0 *1 0,0
Ccc_XD0_XDFFM_S_XD0_XDFFQ_MB XD0.XDFFM.S XD0.XDFFQ.MB 1.21e-17
* device instance cc_XD0_XDFFM_S_XD0_XDFFQ_S r0 *1 0,0
Ccc_XD0_XDFFM_S_XD0_XDFFQ_S XD0.XDFFM.S XD0.XDFFQ.S 1.8151e-17
* device instance cc_XD0_XDFFM_S_XD0_XDFFQ_SB r0 *1 0,0
Ccc_XD0_XDFFM_S_XD0_XDFFQ_SB XD0.XDFFM.S XD0.XDFFQ.SB 1.8151e-17
* device instance cc_XD0_XDFFM_S_XD0_XNOR_midp r0 *1 0,0
Ccc_XD0_XDFFM_S_XD0_XNOR_midp XD0.XDFFM.S XD0.XNOR.midp 1.21e-17
* device instance cc_XD0_XDFFM_S_XD0_dmodout r0 *1 0,0
Ccc_XD0_XDFFM_S_XD0_dmodout XD0.XDFFM.S XD0.dmodout 1.21e-17
* device instance cc_XD0_XDFFM_S_XD0_dq r0 *1 0,0
Ccc_XD0_XDFFM_S_XD0_dq XD0.XDFFM.S XD0.dq 1.21e-17
* device instance cc_XD0_XDFFM_S_XD0_nm r0 *1 0,0
Ccc_XD0_XDFFM_S_XD0_nm XD0.XDFFM.S XD0.nm 1.8151e-17
* device instance cc_XD0_XDFFM_S_XD0_nt r0 *1 0,0
Ccc_XD0_XDFFM_S_XD0_nt XD0.XDFFM.S XD0.nt 2.4201e-17
* device instance cc_XD0_XDFFM_S_XD0_t1 r0 *1 0,0
Ccc_XD0_XDFFM_S_XD0_t1 XD0.XDFFM.S XD0.t1 1.21e-17
* device instance cc_XD0_XDFFM_S_XD1_XDFFM_CLKB r0 *1 0,0
Ccc_XD0_XDFFM_S_XD1_XDFFM_CLKB XD0.XDFFM.S XD1.XDFFM.CLKB 1.8151e-17
* device instance cc_XD0_XDFFM_S_XD1_XDFFM_M r0 *1 0,0
Ccc_XD0_XDFFM_S_XD1_XDFFM_M XD0.XDFFM.S XD1.XDFFM.M 2.4201e-17
* device instance cc_XD0_XDFFM_S_XD1_XDFFM_MB r0 *1 0,0
Ccc_XD0_XDFFM_S_XD1_XDFFM_MB XD0.XDFFM.S XD1.XDFFM.MB 1.21e-17
* device instance cc_XD0_XDFFM_S_XD1_XDFFM_S r0 *1 0,0
Ccc_XD0_XDFFM_S_XD1_XDFFM_S XD0.XDFFM.S XD1.XDFFM.S 1.8151e-17
* device instance cc_XD0_XDFFM_S_XD1_XDFFM_SB r0 *1 0,0
Ccc_XD0_XDFFM_S_XD1_XDFFM_SB XD0.XDFFM.S XD1.XDFFM.SB 1.8151e-17
* device instance cc_XD0_XDFFM_S_XD1_XDFFQ_CLKB r0 *1 0,0
Ccc_XD0_XDFFM_S_XD1_XDFFQ_CLKB XD0.XDFFM.S XD1.XDFFQ.CLKB 1.8151e-17
* device instance cc_XD0_XDFFM_S_XD1_XDFFQ_M r0 *1 0,0
Ccc_XD0_XDFFM_S_XD1_XDFFQ_M XD0.XDFFM.S XD1.XDFFQ.M 2.4201e-17
* device instance cc_XD0_XDFFM_S_XD1_XDFFQ_MB r0 *1 0,0
Ccc_XD0_XDFFM_S_XD1_XDFFQ_MB XD0.XDFFM.S XD1.XDFFQ.MB 1.21e-17
* device instance cc_XD0_XDFFM_S_XD1_XDFFQ_S r0 *1 0,0
Ccc_XD0_XDFFM_S_XD1_XDFFQ_S XD0.XDFFM.S XD1.XDFFQ.S 1.8151e-17
* device instance cc_XD0_XDFFM_S_XD1_XDFFQ_SB r0 *1 0,0
Ccc_XD0_XDFFM_S_XD1_XDFFQ_SB XD0.XDFFM.S XD1.XDFFQ.SB 1.8151e-17
* device instance cc_XD0_XDFFM_S_XD1_XN2_mid1 r0 *1 0,0
Ccc_XD0_XDFFM_S_XD1_XN2_mid1 XD0.XDFFM.S XD1.XN2.mid1 1.21e-17
* device instance cc_XD0_XDFFM_S_XD1_XN3_mid1 r0 *1 0,0
Ccc_XD0_XDFFM_S_XD1_XN3_mid1 XD0.XDFFM.S XD1.XN3.mid1 1.21e-17
* device instance cc_XD0_XDFFM_S_XD1_XN3_mid2 r0 *1 0,0
Ccc_XD0_XDFFM_S_XD1_XN3_mid2 XD0.XDFFM.S XD1.XN3.mid2 1.21e-17
* device instance cc_XD0_XDFFM_S_XD1_dmodout r0 *1 0,0
Ccc_XD0_XDFFM_S_XD1_dmodout XD0.XDFFM.S XD1.dmodout 1.21e-17
* device instance cc_XD0_XDFFM_S_XD1_dq r0 *1 0,0
Ccc_XD0_XDFFM_S_XD1_dq XD0.XDFFM.S XD1.dq 1.8151e-17
* device instance cc_XD0_XDFFM_S_XD1_nm r0 *1 0,0
Ccc_XD0_XDFFM_S_XD1_nm XD0.XDFFM.S XD1.nm 1.21e-17
* device instance cc_XD0_XDFFM_S_XD1_nt r0 *1 0,0
Ccc_XD0_XDFFM_S_XD1_nt XD0.XDFFM.S XD1.nt 1.21e-17
* device instance cc_XD0_XDFFM_S_XD1_t1 r0 *1 0,0
Ccc_XD0_XDFFM_S_XD1_t1 XD0.XDFFM.S XD1.t1 1.21e-17
* device instance cc_XD0_XDFFM_S_XD2_XDFFM_CLKB r0 *1 0,0
Ccc_XD0_XDFFM_S_XD2_XDFFM_CLKB XD0.XDFFM.S XD2.XDFFM.CLKB 1.8151e-17
* device instance cc_XD0_XDFFM_S_XD2_XDFFM_M r0 *1 0,0
Ccc_XD0_XDFFM_S_XD2_XDFFM_M XD0.XDFFM.S XD2.XDFFM.M 2.4201e-17
* device instance cc_XD0_XDFFM_S_XD2_XDFFM_MB r0 *1 0,0
Ccc_XD0_XDFFM_S_XD2_XDFFM_MB XD0.XDFFM.S XD2.XDFFM.MB 1.21e-17
* device instance cc_XD0_XDFFM_S_XD2_XDFFM_S r0 *1 0,0
Ccc_XD0_XDFFM_S_XD2_XDFFM_S XD0.XDFFM.S XD2.XDFFM.S 1.8151e-17
* device instance cc_XD0_XDFFM_S_XD2_XDFFM_SB r0 *1 0,0
Ccc_XD0_XDFFM_S_XD2_XDFFM_SB XD0.XDFFM.S XD2.XDFFM.SB 1.8151e-17
* device instance cc_XD0_XDFFM_S_XD2_XDFFQ_CLKB r0 *1 0,0
Ccc_XD0_XDFFM_S_XD2_XDFFQ_CLKB XD0.XDFFM.S XD2.XDFFQ.CLKB 1.8151e-17
* device instance cc_XD0_XDFFM_S_XD2_XDFFQ_M r0 *1 0,0
Ccc_XD0_XDFFM_S_XD2_XDFFQ_M XD0.XDFFM.S XD2.XDFFQ.M 2.4201e-17
* device instance cc_XD0_XDFFM_S_XD2_XDFFQ_MB r0 *1 0,0
Ccc_XD0_XDFFM_S_XD2_XDFFQ_MB XD0.XDFFM.S XD2.XDFFQ.MB 1.21e-17
* device instance cc_XD0_XDFFM_S_XD2_XDFFQ_S r0 *1 0,0
Ccc_XD0_XDFFM_S_XD2_XDFFQ_S XD0.XDFFM.S XD2.XDFFQ.S 1.8151e-17
* device instance cc_XD0_XDFFM_S_XD2_XDFFQ_SB r0 *1 0,0
Ccc_XD0_XDFFM_S_XD2_XDFFQ_SB XD0.XDFFM.S XD2.XDFFQ.SB 1.8151e-17
* device instance cc_XD0_XDFFM_S_XD2_XN2_mid1 r0 *1 0,0
Ccc_XD0_XDFFM_S_XD2_XN2_mid1 XD0.XDFFM.S XD2.XN2.mid1 1.21e-17
* device instance cc_XD0_XDFFM_S_XD2_XN3_mid1 r0 *1 0,0
Ccc_XD0_XDFFM_S_XD2_XN3_mid1 XD0.XDFFM.S XD2.XN3.mid1 1.21e-17
* device instance cc_XD0_XDFFM_S_XD2_XN3_mid2 r0 *1 0,0
Ccc_XD0_XDFFM_S_XD2_XN3_mid2 XD0.XDFFM.S XD2.XN3.mid2 1.21e-17
* device instance cc_XD0_XDFFM_S_XD2_dmodout r0 *1 0,0
Ccc_XD0_XDFFM_S_XD2_dmodout XD0.XDFFM.S XD2.dmodout 1.21e-17
* device instance cc_XD0_XDFFM_S_XD2_dq r0 *1 0,0
Ccc_XD0_XDFFM_S_XD2_dq XD0.XDFFM.S XD2.dq 1.8151e-17
* device instance cc_XD0_XDFFM_S_XD2_nm r0 *1 0,0
Ccc_XD0_XDFFM_S_XD2_nm XD0.XDFFM.S XD2.nm 1.21e-17
* device instance cc_XD0_XDFFM_S_XD2_nt r0 *1 0,0
Ccc_XD0_XDFFM_S_XD2_nt XD0.XDFFM.S XD2.nt 1.21e-17
* device instance cc_XD0_XDFFM_S_XD2_t1 r0 *1 0,0
Ccc_XD0_XDFFM_S_XD2_t1 XD0.XDFFM.S XD2.t1 1.21e-17
* device instance cc_XD0_XDFFM_S_XD3_XDFFM_CLKB r0 *1 0,0
Ccc_XD0_XDFFM_S_XD3_XDFFM_CLKB XD0.XDFFM.S XD3.XDFFM.CLKB 1.8151e-17
* device instance cc_XD0_XDFFM_S_XD3_XDFFM_M r0 *1 0,0
Ccc_XD0_XDFFM_S_XD3_XDFFM_M XD0.XDFFM.S XD3.XDFFM.M 2.4201e-17
* device instance cc_XD0_XDFFM_S_XD3_XDFFM_MB r0 *1 0,0
Ccc_XD0_XDFFM_S_XD3_XDFFM_MB XD0.XDFFM.S XD3.XDFFM.MB 1.21e-17
* device instance cc_XD0_XDFFM_S_XD3_XDFFM_S r0 *1 0,0
Ccc_XD0_XDFFM_S_XD3_XDFFM_S XD0.XDFFM.S XD3.XDFFM.S 1.8151e-17
* device instance cc_XD0_XDFFM_S_XD3_XDFFM_SB r0 *1 0,0
Ccc_XD0_XDFFM_S_XD3_XDFFM_SB XD0.XDFFM.S XD3.XDFFM.SB 1.8151e-17
* device instance cc_XD0_XDFFM_S_XD3_XDFFQ_CLKB r0 *1 0,0
Ccc_XD0_XDFFM_S_XD3_XDFFQ_CLKB XD0.XDFFM.S XD3.XDFFQ.CLKB 1.8151e-17
* device instance cc_XD0_XDFFM_S_XD3_XDFFQ_M r0 *1 0,0
Ccc_XD0_XDFFM_S_XD3_XDFFQ_M XD0.XDFFM.S XD3.XDFFQ.M 2.4201e-17
* device instance cc_XD0_XDFFM_S_XD3_XDFFQ_MB r0 *1 0,0
Ccc_XD0_XDFFM_S_XD3_XDFFQ_MB XD0.XDFFM.S XD3.XDFFQ.MB 1.21e-17
* device instance cc_XD0_XDFFM_S_XD3_XDFFQ_S r0 *1 0,0
Ccc_XD0_XDFFM_S_XD3_XDFFQ_S XD0.XDFFM.S XD3.XDFFQ.S 1.8151e-17
* device instance cc_XD0_XDFFM_S_XD3_XDFFQ_SB r0 *1 0,0
Ccc_XD0_XDFFM_S_XD3_XDFFQ_SB XD0.XDFFM.S XD3.XDFFQ.SB 1.8151e-17
* device instance cc_XD0_XDFFM_S_XD3_XN2_mid1 r0 *1 0,0
Ccc_XD0_XDFFM_S_XD3_XN2_mid1 XD0.XDFFM.S XD3.XN2.mid1 1.21e-17
* device instance cc_XD0_XDFFM_S_XD3_XN3_mid1 r0 *1 0,0
Ccc_XD0_XDFFM_S_XD3_XN3_mid1 XD0.XDFFM.S XD3.XN3.mid1 1.21e-17
* device instance cc_XD0_XDFFM_S_XD3_XN3_mid2 r0 *1 0,0
Ccc_XD0_XDFFM_S_XD3_XN3_mid2 XD0.XDFFM.S XD3.XN3.mid2 1.21e-17
* device instance cc_XD0_XDFFM_S_XD3_dmodout r0 *1 0,0
Ccc_XD0_XDFFM_S_XD3_dmodout XD0.XDFFM.S XD3.dmodout 1.21e-17
* device instance cc_XD0_XDFFM_S_XD3_dq r0 *1 0,0
Ccc_XD0_XDFFM_S_XD3_dq XD0.XDFFM.S XD3.dq 1.8151e-17
* device instance cc_XD0_XDFFM_S_XD3_nm r0 *1 0,0
Ccc_XD0_XDFFM_S_XD3_nm XD0.XDFFM.S XD3.nm 1.21e-17
* device instance cc_XD0_XDFFM_S_XD3_nt r0 *1 0,0
Ccc_XD0_XDFFM_S_XD3_nt XD0.XDFFM.S XD3.nt 1.21e-17
* device instance cc_XD0_XDFFM_S_XD3_t1 r0 *1 0,0
Ccc_XD0_XDFFM_S_XD3_t1 XD0.XDFFM.S XD3.t1 1.21e-17
* device instance cc_XD0_XDFFM_S_XD4_XDFFM_CLKB r0 *1 0,0
Ccc_XD0_XDFFM_S_XD4_XDFFM_CLKB XD0.XDFFM.S XD4.XDFFM.CLKB 1.8151e-17
* device instance cc_XD0_XDFFM_S_XD4_XDFFM_M r0 *1 0,0
Ccc_XD0_XDFFM_S_XD4_XDFFM_M XD0.XDFFM.S XD4.XDFFM.M 2.4201e-17
* device instance cc_XD0_XDFFM_S_XD4_XDFFM_MB r0 *1 0,0
Ccc_XD0_XDFFM_S_XD4_XDFFM_MB XD0.XDFFM.S XD4.XDFFM.MB 1.21e-17
* device instance cc_XD0_XDFFM_S_XD4_XDFFM_S r0 *1 0,0
Ccc_XD0_XDFFM_S_XD4_XDFFM_S XD0.XDFFM.S XD4.XDFFM.S 1.8151e-17
* device instance cc_XD0_XDFFM_S_XD4_XDFFM_SB r0 *1 0,0
Ccc_XD0_XDFFM_S_XD4_XDFFM_SB XD0.XDFFM.S XD4.XDFFM.SB 1.8151e-17
* device instance cc_XD0_XDFFM_S_XD4_XDFFQ_CLKB r0 *1 0,0
Ccc_XD0_XDFFM_S_XD4_XDFFQ_CLKB XD0.XDFFM.S XD4.XDFFQ.CLKB 1.8151e-17
* device instance cc_XD0_XDFFM_S_XD4_XDFFQ_M r0 *1 0,0
Ccc_XD0_XDFFM_S_XD4_XDFFQ_M XD0.XDFFM.S XD4.XDFFQ.M 2.4201e-17
* device instance cc_XD0_XDFFM_S_XD4_XDFFQ_MB r0 *1 0,0
Ccc_XD0_XDFFM_S_XD4_XDFFQ_MB XD0.XDFFM.S XD4.XDFFQ.MB 1.21e-17
* device instance cc_XD0_XDFFM_S_XD4_XDFFQ_S r0 *1 0,0
Ccc_XD0_XDFFM_S_XD4_XDFFQ_S XD0.XDFFM.S XD4.XDFFQ.S 1.8151e-17
* device instance cc_XD0_XDFFM_S_XD4_XDFFQ_SB r0 *1 0,0
Ccc_XD0_XDFFM_S_XD4_XDFFQ_SB XD0.XDFFM.S XD4.XDFFQ.SB 1.8151e-17
* device instance cc_XD0_XDFFM_S_XD4_XN2_mid1 r0 *1 0,0
Ccc_XD0_XDFFM_S_XD4_XN2_mid1 XD0.XDFFM.S XD4.XN2.mid1 1.21e-17
* device instance cc_XD0_XDFFM_S_XD4_XN3_mid1 r0 *1 0,0
Ccc_XD0_XDFFM_S_XD4_XN3_mid1 XD0.XDFFM.S XD4.XN3.mid1 1.21e-17
* device instance cc_XD0_XDFFM_S_XD4_XN3_mid2 r0 *1 0,0
Ccc_XD0_XDFFM_S_XD4_XN3_mid2 XD0.XDFFM.S XD4.XN3.mid2 1.21e-17
* device instance cc_XD0_XDFFM_S_XD4_dmodout r0 *1 0,0
Ccc_XD0_XDFFM_S_XD4_dmodout XD0.XDFFM.S XD4.dmodout 1.21e-17
* device instance cc_XD0_XDFFM_S_XD4_dq r0 *1 0,0
Ccc_XD0_XDFFM_S_XD4_dq XD0.XDFFM.S XD4.dq 1.8151e-17
* device instance cc_XD0_XDFFM_S_XD4_nm r0 *1 0,0
Ccc_XD0_XDFFM_S_XD4_nm XD0.XDFFM.S XD4.nm 1.21e-17
* device instance cc_XD0_XDFFM_S_XD4_nt r0 *1 0,0
Ccc_XD0_XDFFM_S_XD4_nt XD0.XDFFM.S XD4.nt 1.21e-17
* device instance cc_XD0_XDFFM_S_XD4_t1 r0 *1 0,0
Ccc_XD0_XDFFM_S_XD4_t1 XD0.XDFFM.S XD4.t1 1.21e-17
* device instance cc_XD0_XDFFM_S_XD5_XDFFM_CLKB r0 *1 0,0
Ccc_XD0_XDFFM_S_XD5_XDFFM_CLKB XD0.XDFFM.S XD5.XDFFM.CLKB 1.8151e-17
* device instance cc_XD0_XDFFM_S_XD5_XDFFM_M r0 *1 0,0
Ccc_XD0_XDFFM_S_XD5_XDFFM_M XD0.XDFFM.S XD5.XDFFM.M 2.4201e-17
* device instance cc_XD0_XDFFM_S_XD5_XDFFM_MB r0 *1 0,0
Ccc_XD0_XDFFM_S_XD5_XDFFM_MB XD0.XDFFM.S XD5.XDFFM.MB 1.21e-17
* device instance cc_XD0_XDFFM_S_XD5_XDFFM_S r0 *1 0,0
Ccc_XD0_XDFFM_S_XD5_XDFFM_S XD0.XDFFM.S XD5.XDFFM.S 1.8151e-17
* device instance cc_XD0_XDFFM_S_XD5_XDFFM_SB r0 *1 0,0
Ccc_XD0_XDFFM_S_XD5_XDFFM_SB XD0.XDFFM.S XD5.XDFFM.SB 1.8151e-17
* device instance cc_XD0_XDFFM_S_XD5_XDFFQ_CLKB r0 *1 0,0
Ccc_XD0_XDFFM_S_XD5_XDFFQ_CLKB XD0.XDFFM.S XD5.XDFFQ.CLKB 1.8151e-17
* device instance cc_XD0_XDFFM_S_XD5_XDFFQ_M r0 *1 0,0
Ccc_XD0_XDFFM_S_XD5_XDFFQ_M XD0.XDFFM.S XD5.XDFFQ.M 2.4201e-17
* device instance cc_XD0_XDFFM_S_XD5_XDFFQ_MB r0 *1 0,0
Ccc_XD0_XDFFM_S_XD5_XDFFQ_MB XD0.XDFFM.S XD5.XDFFQ.MB 1.21e-17
* device instance cc_XD0_XDFFM_S_XD5_XDFFQ_S r0 *1 0,0
Ccc_XD0_XDFFM_S_XD5_XDFFQ_S XD0.XDFFM.S XD5.XDFFQ.S 1.8151e-17
* device instance cc_XD0_XDFFM_S_XD5_XDFFQ_SB r0 *1 0,0
Ccc_XD0_XDFFM_S_XD5_XDFFQ_SB XD0.XDFFM.S XD5.XDFFQ.SB 1.8151e-17
* device instance cc_XD0_XDFFM_S_XD5_XN2_mid1 r0 *1 0,0
Ccc_XD0_XDFFM_S_XD5_XN2_mid1 XD0.XDFFM.S XD5.XN2.mid1 1.21e-17
* device instance cc_XD0_XDFFM_S_XD5_XN3_mid1 r0 *1 0,0
Ccc_XD0_XDFFM_S_XD5_XN3_mid1 XD0.XDFFM.S XD5.XN3.mid1 1.21e-17
* device instance cc_XD0_XDFFM_S_XD5_XN3_mid2 r0 *1 0,0
Ccc_XD0_XDFFM_S_XD5_XN3_mid2 XD0.XDFFM.S XD5.XN3.mid2 1.21e-17
* device instance cc_XD0_XDFFM_S_XD5_dmodout r0 *1 0,0
Ccc_XD0_XDFFM_S_XD5_dmodout XD0.XDFFM.S XD5.dmodout 1.21e-17
* device instance cc_XD0_XDFFM_S_XD5_dq r0 *1 0,0
Ccc_XD0_XDFFM_S_XD5_dq XD0.XDFFM.S XD5.dq 1.8151e-17
* device instance cc_XD0_XDFFM_S_XD5_nm r0 *1 0,0
Ccc_XD0_XDFFM_S_XD5_nm XD0.XDFFM.S XD5.nm 1.21e-17
* device instance cc_XD0_XDFFM_S_XD5_nt r0 *1 0,0
Ccc_XD0_XDFFM_S_XD5_nt XD0.XDFFM.S XD5.nt 1.21e-17
* device instance cc_XD0_XDFFM_S_XD5_t1 r0 *1 0,0
Ccc_XD0_XDFFM_S_XD5_t1 XD0.XDFFM.S XD5.t1 1.21e-17
* device instance cc_XD0_XDFFM_S_XFRT_CLKB r0 *1 0,0
Ccc_XD0_XDFFM_S_XFRT_CLKB XD0.XDFFM.S XFRT.CLKB 1.8151e-17
* device instance cc_XD0_XDFFM_S_XFRT_M r0 *1 0,0
Ccc_XD0_XDFFM_S_XFRT_M XD0.XDFFM.S XFRT.M 2.4201e-17
* device instance cc_XD0_XDFFM_S_XFRT_MB r0 *1 0,0
Ccc_XD0_XDFFM_S_XFRT_MB XD0.XDFFM.S XFRT.MB 1.21e-17
* device instance cc_XD0_XDFFM_S_XFRT_S r0 *1 0,0
Ccc_XD0_XDFFM_S_XFRT_S XD0.XDFFM.S XFRT.S 1.8151e-17
* device instance cc_XD0_XDFFM_S_XFRT_SB r0 *1 0,0
Ccc_XD0_XDFFM_S_XFRT_SB XD0.XDFFM.S XFRT.SB 1.8151e-17
* device instance cc_XD0_XDFFM_S_ck1 r0 *1 0,0
Ccc_XD0_XDFFM_S_ck1 XD0.XDFFM.S ck1 5.4452e-17
* device instance cc_XD0_XDFFM_S_ck2 r0 *1 0,0
Ccc_XD0_XDFFM_S_ck2 XD0.XDFFM.S ck2 5.4452e-17
* device instance cc_XD0_XDFFM_S_ck3 r0 *1 0,0
Ccc_XD0_XDFFM_S_ck3 XD0.XDFFM.S ck3 5.4452e-17
* device instance cc_XD0_XDFFM_S_ck4 r0 *1 0,0
Ccc_XD0_XDFFM_S_ck4 XD0.XDFFM.S ck4 5.4452e-17
* device instance cc_XD0_XDFFM_S_ck5 r0 *1 0,0
Ccc_XD0_XDFFM_S_ck5 XD0.XDFFM.S ck5 5.4452e-17
* device instance cc_XD0_XDFFM_S_mod0 r0 *1 0,0
Ccc_XD0_XDFFM_S_mod0 XD0.XDFFM.S mod0 2.4201e-17
* device instance cc_XD0_XDFFM_S_mod1 r0 *1 0,0
Ccc_XD0_XDFFM_S_mod1 XD0.XDFFM.S mod1 2.4201e-17
* device instance cc_XD0_XDFFM_S_mod2 r0 *1 0,0
Ccc_XD0_XDFFM_S_mod2 XD0.XDFFM.S mod2 2.4201e-17
* device instance cc_XD0_XDFFM_S_mod3 r0 *1 0,0
Ccc_XD0_XDFFM_S_mod3 XD0.XDFFM.S mod3 2.4201e-17
* device instance cc_XD0_XDFFM_S_mod4 r0 *1 0,0
Ccc_XD0_XDFFM_S_mod4 XD0.XDFFM.S mod4 2.4201e-17
* device instance cc_XD0_XDFFM_S_net1 r0 *1 0,0
Ccc_XD0_XDFFM_S_net1 XD0.XDFFM.S net1 1.21e-17
* device instance cc_XD0_XDFFM_SB_XD0_XDFFQ_CLKB r0 *1 0,0
Ccc_XD0_XDFFM_SB_XD0_XDFFQ_CLKB XD0.XDFFM.SB XD0.XDFFQ.CLKB 1.8151e-17
* device instance cc_XD0_XDFFM_SB_XD0_XDFFQ_M r0 *1 0,0
Ccc_XD0_XDFFM_SB_XD0_XDFFQ_M XD0.XDFFM.SB XD0.XDFFQ.M 2.4201e-17
* device instance cc_XD0_XDFFM_SB_XD0_XDFFQ_MB r0 *1 0,0
Ccc_XD0_XDFFM_SB_XD0_XDFFQ_MB XD0.XDFFM.SB XD0.XDFFQ.MB 1.21e-17
* device instance cc_XD0_XDFFM_SB_XD0_XDFFQ_S r0 *1 0,0
Ccc_XD0_XDFFM_SB_XD0_XDFFQ_S XD0.XDFFM.SB XD0.XDFFQ.S 1.8151e-17
* device instance cc_XD0_XDFFM_SB_XD0_XDFFQ_SB r0 *1 0,0
Ccc_XD0_XDFFM_SB_XD0_XDFFQ_SB XD0.XDFFM.SB XD0.XDFFQ.SB 1.8151e-17
* device instance cc_XD0_XDFFM_SB_XD0_XNOR_midp r0 *1 0,0
Ccc_XD0_XDFFM_SB_XD0_XNOR_midp XD0.XDFFM.SB XD0.XNOR.midp 1.21e-17
* device instance cc_XD0_XDFFM_SB_XD0_dmodout r0 *1 0,0
Ccc_XD0_XDFFM_SB_XD0_dmodout XD0.XDFFM.SB XD0.dmodout 1.21e-17
* device instance cc_XD0_XDFFM_SB_XD0_dq r0 *1 0,0
Ccc_XD0_XDFFM_SB_XD0_dq XD0.XDFFM.SB XD0.dq 1.21e-17
* device instance cc_XD0_XDFFM_SB_XD0_nm r0 *1 0,0
Ccc_XD0_XDFFM_SB_XD0_nm XD0.XDFFM.SB XD0.nm 1.8151e-17
* device instance cc_XD0_XDFFM_SB_XD0_nt r0 *1 0,0
Ccc_XD0_XDFFM_SB_XD0_nt XD0.XDFFM.SB XD0.nt 2.4201e-17
* device instance cc_XD0_XDFFM_SB_XD0_t1 r0 *1 0,0
Ccc_XD0_XDFFM_SB_XD0_t1 XD0.XDFFM.SB XD0.t1 1.21e-17
* device instance cc_XD0_XDFFM_SB_XD1_XDFFM_CLKB r0 *1 0,0
Ccc_XD0_XDFFM_SB_XD1_XDFFM_CLKB XD0.XDFFM.SB XD1.XDFFM.CLKB 1.8151e-17
* device instance cc_XD0_XDFFM_SB_XD1_XDFFM_M r0 *1 0,0
Ccc_XD0_XDFFM_SB_XD1_XDFFM_M XD0.XDFFM.SB XD1.XDFFM.M 2.4201e-17
* device instance cc_XD0_XDFFM_SB_XD1_XDFFM_MB r0 *1 0,0
Ccc_XD0_XDFFM_SB_XD1_XDFFM_MB XD0.XDFFM.SB XD1.XDFFM.MB 1.21e-17
* device instance cc_XD0_XDFFM_SB_XD1_XDFFM_S r0 *1 0,0
Ccc_XD0_XDFFM_SB_XD1_XDFFM_S XD0.XDFFM.SB XD1.XDFFM.S 1.8151e-17
* device instance cc_XD0_XDFFM_SB_XD1_XDFFM_SB r0 *1 0,0
Ccc_XD0_XDFFM_SB_XD1_XDFFM_SB XD0.XDFFM.SB XD1.XDFFM.SB 1.8151e-17
* device instance cc_XD0_XDFFM_SB_XD1_XDFFQ_CLKB r0 *1 0,0
Ccc_XD0_XDFFM_SB_XD1_XDFFQ_CLKB XD0.XDFFM.SB XD1.XDFFQ.CLKB 1.8151e-17
* device instance cc_XD0_XDFFM_SB_XD1_XDFFQ_M r0 *1 0,0
Ccc_XD0_XDFFM_SB_XD1_XDFFQ_M XD0.XDFFM.SB XD1.XDFFQ.M 2.4201e-17
* device instance cc_XD0_XDFFM_SB_XD1_XDFFQ_MB r0 *1 0,0
Ccc_XD0_XDFFM_SB_XD1_XDFFQ_MB XD0.XDFFM.SB XD1.XDFFQ.MB 1.21e-17
* device instance cc_XD0_XDFFM_SB_XD1_XDFFQ_S r0 *1 0,0
Ccc_XD0_XDFFM_SB_XD1_XDFFQ_S XD0.XDFFM.SB XD1.XDFFQ.S 1.8151e-17
* device instance cc_XD0_XDFFM_SB_XD1_XDFFQ_SB r0 *1 0,0
Ccc_XD0_XDFFM_SB_XD1_XDFFQ_SB XD0.XDFFM.SB XD1.XDFFQ.SB 1.8151e-17
* device instance cc_XD0_XDFFM_SB_XD1_XN2_mid1 r0 *1 0,0
Ccc_XD0_XDFFM_SB_XD1_XN2_mid1 XD0.XDFFM.SB XD1.XN2.mid1 1.21e-17
* device instance cc_XD0_XDFFM_SB_XD1_XN3_mid1 r0 *1 0,0
Ccc_XD0_XDFFM_SB_XD1_XN3_mid1 XD0.XDFFM.SB XD1.XN3.mid1 1.21e-17
* device instance cc_XD0_XDFFM_SB_XD1_XN3_mid2 r0 *1 0,0
Ccc_XD0_XDFFM_SB_XD1_XN3_mid2 XD0.XDFFM.SB XD1.XN3.mid2 1.21e-17
* device instance cc_XD0_XDFFM_SB_XD1_dmodout r0 *1 0,0
Ccc_XD0_XDFFM_SB_XD1_dmodout XD0.XDFFM.SB XD1.dmodout 1.21e-17
* device instance cc_XD0_XDFFM_SB_XD1_dq r0 *1 0,0
Ccc_XD0_XDFFM_SB_XD1_dq XD0.XDFFM.SB XD1.dq 1.8151e-17
* device instance cc_XD0_XDFFM_SB_XD1_nm r0 *1 0,0
Ccc_XD0_XDFFM_SB_XD1_nm XD0.XDFFM.SB XD1.nm 1.21e-17
* device instance cc_XD0_XDFFM_SB_XD1_nt r0 *1 0,0
Ccc_XD0_XDFFM_SB_XD1_nt XD0.XDFFM.SB XD1.nt 1.21e-17
* device instance cc_XD0_XDFFM_SB_XD1_t1 r0 *1 0,0
Ccc_XD0_XDFFM_SB_XD1_t1 XD0.XDFFM.SB XD1.t1 1.21e-17
* device instance cc_XD0_XDFFM_SB_XD2_XDFFM_CLKB r0 *1 0,0
Ccc_XD0_XDFFM_SB_XD2_XDFFM_CLKB XD0.XDFFM.SB XD2.XDFFM.CLKB 1.8151e-17
* device instance cc_XD0_XDFFM_SB_XD2_XDFFM_M r0 *1 0,0
Ccc_XD0_XDFFM_SB_XD2_XDFFM_M XD0.XDFFM.SB XD2.XDFFM.M 2.4201e-17
* device instance cc_XD0_XDFFM_SB_XD2_XDFFM_MB r0 *1 0,0
Ccc_XD0_XDFFM_SB_XD2_XDFFM_MB XD0.XDFFM.SB XD2.XDFFM.MB 1.21e-17
* device instance cc_XD0_XDFFM_SB_XD2_XDFFM_S r0 *1 0,0
Ccc_XD0_XDFFM_SB_XD2_XDFFM_S XD0.XDFFM.SB XD2.XDFFM.S 1.8151e-17
* device instance cc_XD0_XDFFM_SB_XD2_XDFFM_SB r0 *1 0,0
Ccc_XD0_XDFFM_SB_XD2_XDFFM_SB XD0.XDFFM.SB XD2.XDFFM.SB 1.8151e-17
* device instance cc_XD0_XDFFM_SB_XD2_XDFFQ_CLKB r0 *1 0,0
Ccc_XD0_XDFFM_SB_XD2_XDFFQ_CLKB XD0.XDFFM.SB XD2.XDFFQ.CLKB 1.8151e-17
* device instance cc_XD0_XDFFM_SB_XD2_XDFFQ_M r0 *1 0,0
Ccc_XD0_XDFFM_SB_XD2_XDFFQ_M XD0.XDFFM.SB XD2.XDFFQ.M 2.4201e-17
* device instance cc_XD0_XDFFM_SB_XD2_XDFFQ_MB r0 *1 0,0
Ccc_XD0_XDFFM_SB_XD2_XDFFQ_MB XD0.XDFFM.SB XD2.XDFFQ.MB 1.21e-17
* device instance cc_XD0_XDFFM_SB_XD2_XDFFQ_S r0 *1 0,0
Ccc_XD0_XDFFM_SB_XD2_XDFFQ_S XD0.XDFFM.SB XD2.XDFFQ.S 1.8151e-17
* device instance cc_XD0_XDFFM_SB_XD2_XDFFQ_SB r0 *1 0,0
Ccc_XD0_XDFFM_SB_XD2_XDFFQ_SB XD0.XDFFM.SB XD2.XDFFQ.SB 1.8151e-17
* device instance cc_XD0_XDFFM_SB_XD2_XN2_mid1 r0 *1 0,0
Ccc_XD0_XDFFM_SB_XD2_XN2_mid1 XD0.XDFFM.SB XD2.XN2.mid1 1.21e-17
* device instance cc_XD0_XDFFM_SB_XD2_XN3_mid1 r0 *1 0,0
Ccc_XD0_XDFFM_SB_XD2_XN3_mid1 XD0.XDFFM.SB XD2.XN3.mid1 1.21e-17
* device instance cc_XD0_XDFFM_SB_XD2_XN3_mid2 r0 *1 0,0
Ccc_XD0_XDFFM_SB_XD2_XN3_mid2 XD0.XDFFM.SB XD2.XN3.mid2 1.21e-17
* device instance cc_XD0_XDFFM_SB_XD2_dmodout r0 *1 0,0
Ccc_XD0_XDFFM_SB_XD2_dmodout XD0.XDFFM.SB XD2.dmodout 1.21e-17
* device instance cc_XD0_XDFFM_SB_XD2_dq r0 *1 0,0
Ccc_XD0_XDFFM_SB_XD2_dq XD0.XDFFM.SB XD2.dq 1.8151e-17
* device instance cc_XD0_XDFFM_SB_XD2_nm r0 *1 0,0
Ccc_XD0_XDFFM_SB_XD2_nm XD0.XDFFM.SB XD2.nm 1.21e-17
* device instance cc_XD0_XDFFM_SB_XD2_nt r0 *1 0,0
Ccc_XD0_XDFFM_SB_XD2_nt XD0.XDFFM.SB XD2.nt 1.21e-17
* device instance cc_XD0_XDFFM_SB_XD2_t1 r0 *1 0,0
Ccc_XD0_XDFFM_SB_XD2_t1 XD0.XDFFM.SB XD2.t1 1.21e-17
* device instance cc_XD0_XDFFM_SB_XD3_XDFFM_CLKB r0 *1 0,0
Ccc_XD0_XDFFM_SB_XD3_XDFFM_CLKB XD0.XDFFM.SB XD3.XDFFM.CLKB 1.8151e-17
* device instance cc_XD0_XDFFM_SB_XD3_XDFFM_M r0 *1 0,0
Ccc_XD0_XDFFM_SB_XD3_XDFFM_M XD0.XDFFM.SB XD3.XDFFM.M 2.4201e-17
* device instance cc_XD0_XDFFM_SB_XD3_XDFFM_MB r0 *1 0,0
Ccc_XD0_XDFFM_SB_XD3_XDFFM_MB XD0.XDFFM.SB XD3.XDFFM.MB 1.21e-17
* device instance cc_XD0_XDFFM_SB_XD3_XDFFM_S r0 *1 0,0
Ccc_XD0_XDFFM_SB_XD3_XDFFM_S XD0.XDFFM.SB XD3.XDFFM.S 1.8151e-17
* device instance cc_XD0_XDFFM_SB_XD3_XDFFM_SB r0 *1 0,0
Ccc_XD0_XDFFM_SB_XD3_XDFFM_SB XD0.XDFFM.SB XD3.XDFFM.SB 1.8151e-17
* device instance cc_XD0_XDFFM_SB_XD3_XDFFQ_CLKB r0 *1 0,0
Ccc_XD0_XDFFM_SB_XD3_XDFFQ_CLKB XD0.XDFFM.SB XD3.XDFFQ.CLKB 1.8151e-17
* device instance cc_XD0_XDFFM_SB_XD3_XDFFQ_M r0 *1 0,0
Ccc_XD0_XDFFM_SB_XD3_XDFFQ_M XD0.XDFFM.SB XD3.XDFFQ.M 2.4201e-17
* device instance cc_XD0_XDFFM_SB_XD3_XDFFQ_MB r0 *1 0,0
Ccc_XD0_XDFFM_SB_XD3_XDFFQ_MB XD0.XDFFM.SB XD3.XDFFQ.MB 1.21e-17
* device instance cc_XD0_XDFFM_SB_XD3_XDFFQ_S r0 *1 0,0
Ccc_XD0_XDFFM_SB_XD3_XDFFQ_S XD0.XDFFM.SB XD3.XDFFQ.S 1.8151e-17
* device instance cc_XD0_XDFFM_SB_XD3_XDFFQ_SB r0 *1 0,0
Ccc_XD0_XDFFM_SB_XD3_XDFFQ_SB XD0.XDFFM.SB XD3.XDFFQ.SB 1.8151e-17
* device instance cc_XD0_XDFFM_SB_XD3_XN2_mid1 r0 *1 0,0
Ccc_XD0_XDFFM_SB_XD3_XN2_mid1 XD0.XDFFM.SB XD3.XN2.mid1 1.21e-17
* device instance cc_XD0_XDFFM_SB_XD3_XN3_mid1 r0 *1 0,0
Ccc_XD0_XDFFM_SB_XD3_XN3_mid1 XD0.XDFFM.SB XD3.XN3.mid1 1.21e-17
* device instance cc_XD0_XDFFM_SB_XD3_XN3_mid2 r0 *1 0,0
Ccc_XD0_XDFFM_SB_XD3_XN3_mid2 XD0.XDFFM.SB XD3.XN3.mid2 1.21e-17
* device instance cc_XD0_XDFFM_SB_XD3_dmodout r0 *1 0,0
Ccc_XD0_XDFFM_SB_XD3_dmodout XD0.XDFFM.SB XD3.dmodout 1.21e-17
* device instance cc_XD0_XDFFM_SB_XD3_dq r0 *1 0,0
Ccc_XD0_XDFFM_SB_XD3_dq XD0.XDFFM.SB XD3.dq 1.8151e-17
* device instance cc_XD0_XDFFM_SB_XD3_nm r0 *1 0,0
Ccc_XD0_XDFFM_SB_XD3_nm XD0.XDFFM.SB XD3.nm 1.21e-17
* device instance cc_XD0_XDFFM_SB_XD3_nt r0 *1 0,0
Ccc_XD0_XDFFM_SB_XD3_nt XD0.XDFFM.SB XD3.nt 1.21e-17
* device instance cc_XD0_XDFFM_SB_XD3_t1 r0 *1 0,0
Ccc_XD0_XDFFM_SB_XD3_t1 XD0.XDFFM.SB XD3.t1 1.21e-17
* device instance cc_XD0_XDFFM_SB_XD4_XDFFM_CLKB r0 *1 0,0
Ccc_XD0_XDFFM_SB_XD4_XDFFM_CLKB XD0.XDFFM.SB XD4.XDFFM.CLKB 1.8151e-17
* device instance cc_XD0_XDFFM_SB_XD4_XDFFM_M r0 *1 0,0
Ccc_XD0_XDFFM_SB_XD4_XDFFM_M XD0.XDFFM.SB XD4.XDFFM.M 2.4201e-17
* device instance cc_XD0_XDFFM_SB_XD4_XDFFM_MB r0 *1 0,0
Ccc_XD0_XDFFM_SB_XD4_XDFFM_MB XD0.XDFFM.SB XD4.XDFFM.MB 1.21e-17
* device instance cc_XD0_XDFFM_SB_XD4_XDFFM_S r0 *1 0,0
Ccc_XD0_XDFFM_SB_XD4_XDFFM_S XD0.XDFFM.SB XD4.XDFFM.S 1.8151e-17
* device instance cc_XD0_XDFFM_SB_XD4_XDFFM_SB r0 *1 0,0
Ccc_XD0_XDFFM_SB_XD4_XDFFM_SB XD0.XDFFM.SB XD4.XDFFM.SB 1.8151e-17
* device instance cc_XD0_XDFFM_SB_XD4_XDFFQ_CLKB r0 *1 0,0
Ccc_XD0_XDFFM_SB_XD4_XDFFQ_CLKB XD0.XDFFM.SB XD4.XDFFQ.CLKB 1.8151e-17
* device instance cc_XD0_XDFFM_SB_XD4_XDFFQ_M r0 *1 0,0
Ccc_XD0_XDFFM_SB_XD4_XDFFQ_M XD0.XDFFM.SB XD4.XDFFQ.M 2.4201e-17
* device instance cc_XD0_XDFFM_SB_XD4_XDFFQ_MB r0 *1 0,0
Ccc_XD0_XDFFM_SB_XD4_XDFFQ_MB XD0.XDFFM.SB XD4.XDFFQ.MB 1.21e-17
* device instance cc_XD0_XDFFM_SB_XD4_XDFFQ_S r0 *1 0,0
Ccc_XD0_XDFFM_SB_XD4_XDFFQ_S XD0.XDFFM.SB XD4.XDFFQ.S 1.8151e-17
* device instance cc_XD0_XDFFM_SB_XD4_XDFFQ_SB r0 *1 0,0
Ccc_XD0_XDFFM_SB_XD4_XDFFQ_SB XD0.XDFFM.SB XD4.XDFFQ.SB 1.8151e-17
* device instance cc_XD0_XDFFM_SB_XD4_XN2_mid1 r0 *1 0,0
Ccc_XD0_XDFFM_SB_XD4_XN2_mid1 XD0.XDFFM.SB XD4.XN2.mid1 1.21e-17
* device instance cc_XD0_XDFFM_SB_XD4_XN3_mid1 r0 *1 0,0
Ccc_XD0_XDFFM_SB_XD4_XN3_mid1 XD0.XDFFM.SB XD4.XN3.mid1 1.21e-17
* device instance cc_XD0_XDFFM_SB_XD4_XN3_mid2 r0 *1 0,0
Ccc_XD0_XDFFM_SB_XD4_XN3_mid2 XD0.XDFFM.SB XD4.XN3.mid2 1.21e-17
* device instance cc_XD0_XDFFM_SB_XD4_dmodout r0 *1 0,0
Ccc_XD0_XDFFM_SB_XD4_dmodout XD0.XDFFM.SB XD4.dmodout 1.21e-17
* device instance cc_XD0_XDFFM_SB_XD4_dq r0 *1 0,0
Ccc_XD0_XDFFM_SB_XD4_dq XD0.XDFFM.SB XD4.dq 1.8151e-17
* device instance cc_XD0_XDFFM_SB_XD4_nm r0 *1 0,0
Ccc_XD0_XDFFM_SB_XD4_nm XD0.XDFFM.SB XD4.nm 1.21e-17
* device instance cc_XD0_XDFFM_SB_XD4_nt r0 *1 0,0
Ccc_XD0_XDFFM_SB_XD4_nt XD0.XDFFM.SB XD4.nt 1.21e-17
* device instance cc_XD0_XDFFM_SB_XD4_t1 r0 *1 0,0
Ccc_XD0_XDFFM_SB_XD4_t1 XD0.XDFFM.SB XD4.t1 1.21e-17
* device instance cc_XD0_XDFFM_SB_XD5_XDFFM_CLKB r0 *1 0,0
Ccc_XD0_XDFFM_SB_XD5_XDFFM_CLKB XD0.XDFFM.SB XD5.XDFFM.CLKB 1.8151e-17
* device instance cc_XD0_XDFFM_SB_XD5_XDFFM_M r0 *1 0,0
Ccc_XD0_XDFFM_SB_XD5_XDFFM_M XD0.XDFFM.SB XD5.XDFFM.M 2.4201e-17
* device instance cc_XD0_XDFFM_SB_XD5_XDFFM_MB r0 *1 0,0
Ccc_XD0_XDFFM_SB_XD5_XDFFM_MB XD0.XDFFM.SB XD5.XDFFM.MB 1.21e-17
* device instance cc_XD0_XDFFM_SB_XD5_XDFFM_S r0 *1 0,0
Ccc_XD0_XDFFM_SB_XD5_XDFFM_S XD0.XDFFM.SB XD5.XDFFM.S 1.8151e-17
* device instance cc_XD0_XDFFM_SB_XD5_XDFFM_SB r0 *1 0,0
Ccc_XD0_XDFFM_SB_XD5_XDFFM_SB XD0.XDFFM.SB XD5.XDFFM.SB 1.8151e-17
* device instance cc_XD0_XDFFM_SB_XD5_XDFFQ_CLKB r0 *1 0,0
Ccc_XD0_XDFFM_SB_XD5_XDFFQ_CLKB XD0.XDFFM.SB XD5.XDFFQ.CLKB 1.8151e-17
* device instance cc_XD0_XDFFM_SB_XD5_XDFFQ_M r0 *1 0,0
Ccc_XD0_XDFFM_SB_XD5_XDFFQ_M XD0.XDFFM.SB XD5.XDFFQ.M 2.4201e-17
* device instance cc_XD0_XDFFM_SB_XD5_XDFFQ_MB r0 *1 0,0
Ccc_XD0_XDFFM_SB_XD5_XDFFQ_MB XD0.XDFFM.SB XD5.XDFFQ.MB 1.21e-17
* device instance cc_XD0_XDFFM_SB_XD5_XDFFQ_S r0 *1 0,0
Ccc_XD0_XDFFM_SB_XD5_XDFFQ_S XD0.XDFFM.SB XD5.XDFFQ.S 1.8151e-17
* device instance cc_XD0_XDFFM_SB_XD5_XDFFQ_SB r0 *1 0,0
Ccc_XD0_XDFFM_SB_XD5_XDFFQ_SB XD0.XDFFM.SB XD5.XDFFQ.SB 1.8151e-17
* device instance cc_XD0_XDFFM_SB_XD5_XN2_mid1 r0 *1 0,0
Ccc_XD0_XDFFM_SB_XD5_XN2_mid1 XD0.XDFFM.SB XD5.XN2.mid1 1.21e-17
* device instance cc_XD0_XDFFM_SB_XD5_XN3_mid1 r0 *1 0,0
Ccc_XD0_XDFFM_SB_XD5_XN3_mid1 XD0.XDFFM.SB XD5.XN3.mid1 1.21e-17
* device instance cc_XD0_XDFFM_SB_XD5_XN3_mid2 r0 *1 0,0
Ccc_XD0_XDFFM_SB_XD5_XN3_mid2 XD0.XDFFM.SB XD5.XN3.mid2 1.21e-17
* device instance cc_XD0_XDFFM_SB_XD5_dmodout r0 *1 0,0
Ccc_XD0_XDFFM_SB_XD5_dmodout XD0.XDFFM.SB XD5.dmodout 1.21e-17
* device instance cc_XD0_XDFFM_SB_XD5_dq r0 *1 0,0
Ccc_XD0_XDFFM_SB_XD5_dq XD0.XDFFM.SB XD5.dq 1.8151e-17
* device instance cc_XD0_XDFFM_SB_XD5_nm r0 *1 0,0
Ccc_XD0_XDFFM_SB_XD5_nm XD0.XDFFM.SB XD5.nm 1.21e-17
* device instance cc_XD0_XDFFM_SB_XD5_nt r0 *1 0,0
Ccc_XD0_XDFFM_SB_XD5_nt XD0.XDFFM.SB XD5.nt 1.21e-17
* device instance cc_XD0_XDFFM_SB_XD5_t1 r0 *1 0,0
Ccc_XD0_XDFFM_SB_XD5_t1 XD0.XDFFM.SB XD5.t1 1.21e-17
* device instance cc_XD0_XDFFM_SB_XFRT_CLKB r0 *1 0,0
Ccc_XD0_XDFFM_SB_XFRT_CLKB XD0.XDFFM.SB XFRT.CLKB 1.8151e-17
* device instance cc_XD0_XDFFM_SB_XFRT_M r0 *1 0,0
Ccc_XD0_XDFFM_SB_XFRT_M XD0.XDFFM.SB XFRT.M 2.4201e-17
* device instance cc_XD0_XDFFM_SB_XFRT_MB r0 *1 0,0
Ccc_XD0_XDFFM_SB_XFRT_MB XD0.XDFFM.SB XFRT.MB 1.21e-17
* device instance cc_XD0_XDFFM_SB_XFRT_S r0 *1 0,0
Ccc_XD0_XDFFM_SB_XFRT_S XD0.XDFFM.SB XFRT.S 1.8151e-17
* device instance cc_XD0_XDFFM_SB_XFRT_SB r0 *1 0,0
Ccc_XD0_XDFFM_SB_XFRT_SB XD0.XDFFM.SB XFRT.SB 1.8151e-17
* device instance cc_XD0_XDFFM_SB_ck1 r0 *1 0,0
Ccc_XD0_XDFFM_SB_ck1 XD0.XDFFM.SB ck1 5.4452e-17
* device instance cc_XD0_XDFFM_SB_ck2 r0 *1 0,0
Ccc_XD0_XDFFM_SB_ck2 XD0.XDFFM.SB ck2 5.4452e-17
* device instance cc_XD0_XDFFM_SB_ck3 r0 *1 0,0
Ccc_XD0_XDFFM_SB_ck3 XD0.XDFFM.SB ck3 5.4452e-17
* device instance cc_XD0_XDFFM_SB_ck4 r0 *1 0,0
Ccc_XD0_XDFFM_SB_ck4 XD0.XDFFM.SB ck4 5.4452e-17
* device instance cc_XD0_XDFFM_SB_ck5 r0 *1 0,0
Ccc_XD0_XDFFM_SB_ck5 XD0.XDFFM.SB ck5 5.4452e-17
* device instance cc_XD0_XDFFM_SB_mod0 r0 *1 0,0
Ccc_XD0_XDFFM_SB_mod0 XD0.XDFFM.SB mod0 2.4201e-17
* device instance cc_XD0_XDFFM_SB_mod1 r0 *1 0,0
Ccc_XD0_XDFFM_SB_mod1 XD0.XDFFM.SB mod1 2.4201e-17
* device instance cc_XD0_XDFFM_SB_mod2 r0 *1 0,0
Ccc_XD0_XDFFM_SB_mod2 XD0.XDFFM.SB mod2 2.4201e-17
* device instance cc_XD0_XDFFM_SB_mod3 r0 *1 0,0
Ccc_XD0_XDFFM_SB_mod3 XD0.XDFFM.SB mod3 2.4201e-17
* device instance cc_XD0_XDFFM_SB_mod4 r0 *1 0,0
Ccc_XD0_XDFFM_SB_mod4 XD0.XDFFM.SB mod4 2.4201e-17
* device instance cc_XD0_XDFFM_SB_net1 r0 *1 0,0
Ccc_XD0_XDFFM_SB_net1 XD0.XDFFM.SB net1 1.21e-17
* device instance cc_XD0_XDFFQ_CLKB_XD0_XDFFQ_M r0 *1 0,0
Ccc_XD0_XDFFQ_CLKB_XD0_XDFFQ_M XD0.XDFFQ.CLKB XD0.XDFFQ.M 4.2352e-17
* device instance cc_XD0_XDFFQ_CLKB_XD0_XDFFQ_MB r0 *1 0,0
Ccc_XD0_XDFFQ_CLKB_XD0_XDFFQ_MB XD0.XDFFQ.CLKB XD0.XDFFQ.MB 2.4201e-17
* device instance cc_XD0_XDFFQ_CLKB_XD0_XDFFQ_S r0 *1 0,0
Ccc_XD0_XDFFQ_CLKB_XD0_XDFFQ_S XD0.XDFFQ.CLKB XD0.XDFFQ.S 1.8151e-17
* device instance cc_XD0_XDFFQ_CLKB_XD0_XDFFQ_SB r0 *1 0,0
Ccc_XD0_XDFFQ_CLKB_XD0_XDFFQ_SB XD0.XDFFQ.CLKB XD0.XDFFQ.SB 1.8151e-17
* device instance cc_XD0_XDFFQ_CLKB_XD0_XN2_mid1 r0 *1 0,0
Ccc_XD0_XDFFQ_CLKB_XD0_XN2_mid1 XD0.XDFFQ.CLKB XD0.XN2.mid1 1.21e-17
* device instance cc_XD0_XDFFQ_CLKB_XD0_XNOR_midp r0 *1 0,0
Ccc_XD0_XDFFQ_CLKB_XD0_XNOR_midp XD0.XDFFQ.CLKB XD0.XNOR.midp 1.21e-17
* device instance cc_XD0_XDFFQ_CLKB_XD0_dmodout r0 *1 0,0
Ccc_XD0_XDFFQ_CLKB_XD0_dmodout XD0.XDFFQ.CLKB XD0.dmodout 1.21e-17
* device instance cc_XD0_XDFFQ_CLKB_XD0_dq r0 *1 0,0
Ccc_XD0_XDFFQ_CLKB_XD0_dq XD0.XDFFQ.CLKB XD0.dq 1.8151e-17
* device instance cc_XD0_XDFFQ_CLKB_XD0_nm r0 *1 0,0
Ccc_XD0_XDFFQ_CLKB_XD0_nm XD0.XDFFQ.CLKB XD0.nm 1.21e-17
* device instance cc_XD0_XDFFQ_CLKB_XD0_nt r0 *1 0,0
Ccc_XD0_XDFFQ_CLKB_XD0_nt XD0.XDFFQ.CLKB XD0.nt 2.4201e-17
* device instance cc_XD0_XDFFQ_CLKB_XD0_t1 r0 *1 0,0
Ccc_XD0_XDFFQ_CLKB_XD0_t1 XD0.XDFFQ.CLKB XD0.t1 1.21e-17
* device instance cc_XD0_XDFFQ_CLKB_XD1_XDFFM_CLKB r0 *1 0,0
Ccc_XD0_XDFFQ_CLKB_XD1_XDFFM_CLKB XD0.XDFFQ.CLKB XD1.XDFFM.CLKB 1.8151e-17
* device instance cc_XD0_XDFFQ_CLKB_XD1_XDFFM_M r0 *1 0,0
Ccc_XD0_XDFFQ_CLKB_XD1_XDFFM_M XD0.XDFFQ.CLKB XD1.XDFFM.M 2.4201e-17
* device instance cc_XD0_XDFFQ_CLKB_XD1_XDFFM_MB r0 *1 0,0
Ccc_XD0_XDFFQ_CLKB_XD1_XDFFM_MB XD0.XDFFQ.CLKB XD1.XDFFM.MB 1.21e-17
* device instance cc_XD0_XDFFQ_CLKB_XD1_XDFFM_S r0 *1 0,0
Ccc_XD0_XDFFQ_CLKB_XD1_XDFFM_S XD0.XDFFQ.CLKB XD1.XDFFM.S 1.8151e-17
* device instance cc_XD0_XDFFQ_CLKB_XD1_XDFFM_SB r0 *1 0,0
Ccc_XD0_XDFFQ_CLKB_XD1_XDFFM_SB XD0.XDFFQ.CLKB XD1.XDFFM.SB 1.8151e-17
* device instance cc_XD0_XDFFQ_CLKB_XD1_XDFFQ_CLKB r0 *1 0,0
Ccc_XD0_XDFFQ_CLKB_XD1_XDFFQ_CLKB XD0.XDFFQ.CLKB XD1.XDFFQ.CLKB 1.8151e-17
* device instance cc_XD0_XDFFQ_CLKB_XD1_XDFFQ_M r0 *1 0,0
Ccc_XD0_XDFFQ_CLKB_XD1_XDFFQ_M XD0.XDFFQ.CLKB XD1.XDFFQ.M 2.4201e-17
* device instance cc_XD0_XDFFQ_CLKB_XD1_XDFFQ_MB r0 *1 0,0
Ccc_XD0_XDFFQ_CLKB_XD1_XDFFQ_MB XD0.XDFFQ.CLKB XD1.XDFFQ.MB 1.21e-17
* device instance cc_XD0_XDFFQ_CLKB_XD1_XDFFQ_S r0 *1 0,0
Ccc_XD0_XDFFQ_CLKB_XD1_XDFFQ_S XD0.XDFFQ.CLKB XD1.XDFFQ.S 1.8151e-17
* device instance cc_XD0_XDFFQ_CLKB_XD1_XDFFQ_SB r0 *1 0,0
Ccc_XD0_XDFFQ_CLKB_XD1_XDFFQ_SB XD0.XDFFQ.CLKB XD1.XDFFQ.SB 1.8151e-17
* device instance cc_XD0_XDFFQ_CLKB_XD1_XN2_mid1 r0 *1 0,0
Ccc_XD0_XDFFQ_CLKB_XD1_XN2_mid1 XD0.XDFFQ.CLKB XD1.XN2.mid1 1.21e-17
* device instance cc_XD0_XDFFQ_CLKB_XD1_XN3_mid1 r0 *1 0,0
Ccc_XD0_XDFFQ_CLKB_XD1_XN3_mid1 XD0.XDFFQ.CLKB XD1.XN3.mid1 1.21e-17
* device instance cc_XD0_XDFFQ_CLKB_XD1_XN3_mid2 r0 *1 0,0
Ccc_XD0_XDFFQ_CLKB_XD1_XN3_mid2 XD0.XDFFQ.CLKB XD1.XN3.mid2 1.21e-17
* device instance cc_XD0_XDFFQ_CLKB_XD1_dmodout r0 *1 0,0
Ccc_XD0_XDFFQ_CLKB_XD1_dmodout XD0.XDFFQ.CLKB XD1.dmodout 1.21e-17
* device instance cc_XD0_XDFFQ_CLKB_XD1_dq r0 *1 0,0
Ccc_XD0_XDFFQ_CLKB_XD1_dq XD0.XDFFQ.CLKB XD1.dq 1.8151e-17
* device instance cc_XD0_XDFFQ_CLKB_XD1_nm r0 *1 0,0
Ccc_XD0_XDFFQ_CLKB_XD1_nm XD0.XDFFQ.CLKB XD1.nm 1.21e-17
* device instance cc_XD0_XDFFQ_CLKB_XD1_nt r0 *1 0,0
Ccc_XD0_XDFFQ_CLKB_XD1_nt XD0.XDFFQ.CLKB XD1.nt 1.21e-17
* device instance cc_XD0_XDFFQ_CLKB_XD1_t1 r0 *1 0,0
Ccc_XD0_XDFFQ_CLKB_XD1_t1 XD0.XDFFQ.CLKB XD1.t1 1.21e-17
* device instance cc_XD0_XDFFQ_CLKB_XD2_XDFFM_CLKB r0 *1 0,0
Ccc_XD0_XDFFQ_CLKB_XD2_XDFFM_CLKB XD0.XDFFQ.CLKB XD2.XDFFM.CLKB 1.8151e-17
* device instance cc_XD0_XDFFQ_CLKB_XD2_XDFFM_M r0 *1 0,0
Ccc_XD0_XDFFQ_CLKB_XD2_XDFFM_M XD0.XDFFQ.CLKB XD2.XDFFM.M 2.4201e-17
* device instance cc_XD0_XDFFQ_CLKB_XD2_XDFFM_MB r0 *1 0,0
Ccc_XD0_XDFFQ_CLKB_XD2_XDFFM_MB XD0.XDFFQ.CLKB XD2.XDFFM.MB 1.21e-17
* device instance cc_XD0_XDFFQ_CLKB_XD2_XDFFM_S r0 *1 0,0
Ccc_XD0_XDFFQ_CLKB_XD2_XDFFM_S XD0.XDFFQ.CLKB XD2.XDFFM.S 1.8151e-17
* device instance cc_XD0_XDFFQ_CLKB_XD2_XDFFM_SB r0 *1 0,0
Ccc_XD0_XDFFQ_CLKB_XD2_XDFFM_SB XD0.XDFFQ.CLKB XD2.XDFFM.SB 1.8151e-17
* device instance cc_XD0_XDFFQ_CLKB_XD2_XDFFQ_CLKB r0 *1 0,0
Ccc_XD0_XDFFQ_CLKB_XD2_XDFFQ_CLKB XD0.XDFFQ.CLKB XD2.XDFFQ.CLKB 1.8151e-17
* device instance cc_XD0_XDFFQ_CLKB_XD2_XDFFQ_M r0 *1 0,0
Ccc_XD0_XDFFQ_CLKB_XD2_XDFFQ_M XD0.XDFFQ.CLKB XD2.XDFFQ.M 2.4201e-17
* device instance cc_XD0_XDFFQ_CLKB_XD2_XDFFQ_MB r0 *1 0,0
Ccc_XD0_XDFFQ_CLKB_XD2_XDFFQ_MB XD0.XDFFQ.CLKB XD2.XDFFQ.MB 1.21e-17
* device instance cc_XD0_XDFFQ_CLKB_XD2_XDFFQ_S r0 *1 0,0
Ccc_XD0_XDFFQ_CLKB_XD2_XDFFQ_S XD0.XDFFQ.CLKB XD2.XDFFQ.S 1.8151e-17
* device instance cc_XD0_XDFFQ_CLKB_XD2_XDFFQ_SB r0 *1 0,0
Ccc_XD0_XDFFQ_CLKB_XD2_XDFFQ_SB XD0.XDFFQ.CLKB XD2.XDFFQ.SB 1.8151e-17
* device instance cc_XD0_XDFFQ_CLKB_XD2_XN2_mid1 r0 *1 0,0
Ccc_XD0_XDFFQ_CLKB_XD2_XN2_mid1 XD0.XDFFQ.CLKB XD2.XN2.mid1 1.21e-17
* device instance cc_XD0_XDFFQ_CLKB_XD2_XN3_mid1 r0 *1 0,0
Ccc_XD0_XDFFQ_CLKB_XD2_XN3_mid1 XD0.XDFFQ.CLKB XD2.XN3.mid1 1.21e-17
* device instance cc_XD0_XDFFQ_CLKB_XD2_XN3_mid2 r0 *1 0,0
Ccc_XD0_XDFFQ_CLKB_XD2_XN3_mid2 XD0.XDFFQ.CLKB XD2.XN3.mid2 1.21e-17
* device instance cc_XD0_XDFFQ_CLKB_XD2_dmodout r0 *1 0,0
Ccc_XD0_XDFFQ_CLKB_XD2_dmodout XD0.XDFFQ.CLKB XD2.dmodout 1.21e-17
* device instance cc_XD0_XDFFQ_CLKB_XD2_dq r0 *1 0,0
Ccc_XD0_XDFFQ_CLKB_XD2_dq XD0.XDFFQ.CLKB XD2.dq 1.8151e-17
* device instance cc_XD0_XDFFQ_CLKB_XD2_nm r0 *1 0,0
Ccc_XD0_XDFFQ_CLKB_XD2_nm XD0.XDFFQ.CLKB XD2.nm 1.21e-17
* device instance cc_XD0_XDFFQ_CLKB_XD2_nt r0 *1 0,0
Ccc_XD0_XDFFQ_CLKB_XD2_nt XD0.XDFFQ.CLKB XD2.nt 1.21e-17
* device instance cc_XD0_XDFFQ_CLKB_XD2_t1 r0 *1 0,0
Ccc_XD0_XDFFQ_CLKB_XD2_t1 XD0.XDFFQ.CLKB XD2.t1 1.21e-17
* device instance cc_XD0_XDFFQ_CLKB_XD3_XDFFM_CLKB r0 *1 0,0
Ccc_XD0_XDFFQ_CLKB_XD3_XDFFM_CLKB XD0.XDFFQ.CLKB XD3.XDFFM.CLKB 1.8151e-17
* device instance cc_XD0_XDFFQ_CLKB_XD3_XDFFM_M r0 *1 0,0
Ccc_XD0_XDFFQ_CLKB_XD3_XDFFM_M XD0.XDFFQ.CLKB XD3.XDFFM.M 2.4201e-17
* device instance cc_XD0_XDFFQ_CLKB_XD3_XDFFM_MB r0 *1 0,0
Ccc_XD0_XDFFQ_CLKB_XD3_XDFFM_MB XD0.XDFFQ.CLKB XD3.XDFFM.MB 1.21e-17
* device instance cc_XD0_XDFFQ_CLKB_XD3_XDFFM_S r0 *1 0,0
Ccc_XD0_XDFFQ_CLKB_XD3_XDFFM_S XD0.XDFFQ.CLKB XD3.XDFFM.S 1.8151e-17
* device instance cc_XD0_XDFFQ_CLKB_XD3_XDFFM_SB r0 *1 0,0
Ccc_XD0_XDFFQ_CLKB_XD3_XDFFM_SB XD0.XDFFQ.CLKB XD3.XDFFM.SB 1.8151e-17
* device instance cc_XD0_XDFFQ_CLKB_XD3_XDFFQ_CLKB r0 *1 0,0
Ccc_XD0_XDFFQ_CLKB_XD3_XDFFQ_CLKB XD0.XDFFQ.CLKB XD3.XDFFQ.CLKB 1.8151e-17
* device instance cc_XD0_XDFFQ_CLKB_XD3_XDFFQ_M r0 *1 0,0
Ccc_XD0_XDFFQ_CLKB_XD3_XDFFQ_M XD0.XDFFQ.CLKB XD3.XDFFQ.M 2.4201e-17
* device instance cc_XD0_XDFFQ_CLKB_XD3_XDFFQ_MB r0 *1 0,0
Ccc_XD0_XDFFQ_CLKB_XD3_XDFFQ_MB XD0.XDFFQ.CLKB XD3.XDFFQ.MB 1.21e-17
* device instance cc_XD0_XDFFQ_CLKB_XD3_XDFFQ_S r0 *1 0,0
Ccc_XD0_XDFFQ_CLKB_XD3_XDFFQ_S XD0.XDFFQ.CLKB XD3.XDFFQ.S 1.8151e-17
* device instance cc_XD0_XDFFQ_CLKB_XD3_XDFFQ_SB r0 *1 0,0
Ccc_XD0_XDFFQ_CLKB_XD3_XDFFQ_SB XD0.XDFFQ.CLKB XD3.XDFFQ.SB 1.8151e-17
* device instance cc_XD0_XDFFQ_CLKB_XD3_XN2_mid1 r0 *1 0,0
Ccc_XD0_XDFFQ_CLKB_XD3_XN2_mid1 XD0.XDFFQ.CLKB XD3.XN2.mid1 1.21e-17
* device instance cc_XD0_XDFFQ_CLKB_XD3_XN3_mid1 r0 *1 0,0
Ccc_XD0_XDFFQ_CLKB_XD3_XN3_mid1 XD0.XDFFQ.CLKB XD3.XN3.mid1 1.21e-17
* device instance cc_XD0_XDFFQ_CLKB_XD3_XN3_mid2 r0 *1 0,0
Ccc_XD0_XDFFQ_CLKB_XD3_XN3_mid2 XD0.XDFFQ.CLKB XD3.XN3.mid2 1.21e-17
* device instance cc_XD0_XDFFQ_CLKB_XD3_dmodout r0 *1 0,0
Ccc_XD0_XDFFQ_CLKB_XD3_dmodout XD0.XDFFQ.CLKB XD3.dmodout 1.21e-17
* device instance cc_XD0_XDFFQ_CLKB_XD3_dq r0 *1 0,0
Ccc_XD0_XDFFQ_CLKB_XD3_dq XD0.XDFFQ.CLKB XD3.dq 1.8151e-17
* device instance cc_XD0_XDFFQ_CLKB_XD3_nm r0 *1 0,0
Ccc_XD0_XDFFQ_CLKB_XD3_nm XD0.XDFFQ.CLKB XD3.nm 1.21e-17
* device instance cc_XD0_XDFFQ_CLKB_XD3_nt r0 *1 0,0
Ccc_XD0_XDFFQ_CLKB_XD3_nt XD0.XDFFQ.CLKB XD3.nt 1.21e-17
* device instance cc_XD0_XDFFQ_CLKB_XD3_t1 r0 *1 0,0
Ccc_XD0_XDFFQ_CLKB_XD3_t1 XD0.XDFFQ.CLKB XD3.t1 1.21e-17
* device instance cc_XD0_XDFFQ_CLKB_XD4_XDFFM_CLKB r0 *1 0,0
Ccc_XD0_XDFFQ_CLKB_XD4_XDFFM_CLKB XD0.XDFFQ.CLKB XD4.XDFFM.CLKB 1.8151e-17
* device instance cc_XD0_XDFFQ_CLKB_XD4_XDFFM_M r0 *1 0,0
Ccc_XD0_XDFFQ_CLKB_XD4_XDFFM_M XD0.XDFFQ.CLKB XD4.XDFFM.M 2.4201e-17
* device instance cc_XD0_XDFFQ_CLKB_XD4_XDFFM_MB r0 *1 0,0
Ccc_XD0_XDFFQ_CLKB_XD4_XDFFM_MB XD0.XDFFQ.CLKB XD4.XDFFM.MB 1.21e-17
* device instance cc_XD0_XDFFQ_CLKB_XD4_XDFFM_S r0 *1 0,0
Ccc_XD0_XDFFQ_CLKB_XD4_XDFFM_S XD0.XDFFQ.CLKB XD4.XDFFM.S 1.8151e-17
* device instance cc_XD0_XDFFQ_CLKB_XD4_XDFFM_SB r0 *1 0,0
Ccc_XD0_XDFFQ_CLKB_XD4_XDFFM_SB XD0.XDFFQ.CLKB XD4.XDFFM.SB 1.8151e-17
* device instance cc_XD0_XDFFQ_CLKB_XD4_XDFFQ_CLKB r0 *1 0,0
Ccc_XD0_XDFFQ_CLKB_XD4_XDFFQ_CLKB XD0.XDFFQ.CLKB XD4.XDFFQ.CLKB 1.8151e-17
* device instance cc_XD0_XDFFQ_CLKB_XD4_XDFFQ_M r0 *1 0,0
Ccc_XD0_XDFFQ_CLKB_XD4_XDFFQ_M XD0.XDFFQ.CLKB XD4.XDFFQ.M 2.4201e-17
* device instance cc_XD0_XDFFQ_CLKB_XD4_XDFFQ_MB r0 *1 0,0
Ccc_XD0_XDFFQ_CLKB_XD4_XDFFQ_MB XD0.XDFFQ.CLKB XD4.XDFFQ.MB 1.21e-17
* device instance cc_XD0_XDFFQ_CLKB_XD4_XDFFQ_S r0 *1 0,0
Ccc_XD0_XDFFQ_CLKB_XD4_XDFFQ_S XD0.XDFFQ.CLKB XD4.XDFFQ.S 1.8151e-17
* device instance cc_XD0_XDFFQ_CLKB_XD4_XDFFQ_SB r0 *1 0,0
Ccc_XD0_XDFFQ_CLKB_XD4_XDFFQ_SB XD0.XDFFQ.CLKB XD4.XDFFQ.SB 1.8151e-17
* device instance cc_XD0_XDFFQ_CLKB_XD4_XN2_mid1 r0 *1 0,0
Ccc_XD0_XDFFQ_CLKB_XD4_XN2_mid1 XD0.XDFFQ.CLKB XD4.XN2.mid1 1.21e-17
* device instance cc_XD0_XDFFQ_CLKB_XD4_XN3_mid1 r0 *1 0,0
Ccc_XD0_XDFFQ_CLKB_XD4_XN3_mid1 XD0.XDFFQ.CLKB XD4.XN3.mid1 1.21e-17
* device instance cc_XD0_XDFFQ_CLKB_XD4_XN3_mid2 r0 *1 0,0
Ccc_XD0_XDFFQ_CLKB_XD4_XN3_mid2 XD0.XDFFQ.CLKB XD4.XN3.mid2 1.21e-17
* device instance cc_XD0_XDFFQ_CLKB_XD4_dmodout r0 *1 0,0
Ccc_XD0_XDFFQ_CLKB_XD4_dmodout XD0.XDFFQ.CLKB XD4.dmodout 1.21e-17
* device instance cc_XD0_XDFFQ_CLKB_XD4_dq r0 *1 0,0
Ccc_XD0_XDFFQ_CLKB_XD4_dq XD0.XDFFQ.CLKB XD4.dq 1.8151e-17
* device instance cc_XD0_XDFFQ_CLKB_XD4_nm r0 *1 0,0
Ccc_XD0_XDFFQ_CLKB_XD4_nm XD0.XDFFQ.CLKB XD4.nm 1.21e-17
* device instance cc_XD0_XDFFQ_CLKB_XD4_nt r0 *1 0,0
Ccc_XD0_XDFFQ_CLKB_XD4_nt XD0.XDFFQ.CLKB XD4.nt 1.21e-17
* device instance cc_XD0_XDFFQ_CLKB_XD4_t1 r0 *1 0,0
Ccc_XD0_XDFFQ_CLKB_XD4_t1 XD0.XDFFQ.CLKB XD4.t1 1.21e-17
* device instance cc_XD0_XDFFQ_CLKB_XD5_XDFFM_CLKB r0 *1 0,0
Ccc_XD0_XDFFQ_CLKB_XD5_XDFFM_CLKB XD0.XDFFQ.CLKB XD5.XDFFM.CLKB 1.8151e-17
* device instance cc_XD0_XDFFQ_CLKB_XD5_XDFFM_M r0 *1 0,0
Ccc_XD0_XDFFQ_CLKB_XD5_XDFFM_M XD0.XDFFQ.CLKB XD5.XDFFM.M 2.4201e-17
* device instance cc_XD0_XDFFQ_CLKB_XD5_XDFFM_MB r0 *1 0,0
Ccc_XD0_XDFFQ_CLKB_XD5_XDFFM_MB XD0.XDFFQ.CLKB XD5.XDFFM.MB 1.21e-17
* device instance cc_XD0_XDFFQ_CLKB_XD5_XDFFM_S r0 *1 0,0
Ccc_XD0_XDFFQ_CLKB_XD5_XDFFM_S XD0.XDFFQ.CLKB XD5.XDFFM.S 1.8151e-17
* device instance cc_XD0_XDFFQ_CLKB_XD5_XDFFM_SB r0 *1 0,0
Ccc_XD0_XDFFQ_CLKB_XD5_XDFFM_SB XD0.XDFFQ.CLKB XD5.XDFFM.SB 1.8151e-17
* device instance cc_XD0_XDFFQ_CLKB_XD5_XDFFQ_CLKB r0 *1 0,0
Ccc_XD0_XDFFQ_CLKB_XD5_XDFFQ_CLKB XD0.XDFFQ.CLKB XD5.XDFFQ.CLKB 1.8151e-17
* device instance cc_XD0_XDFFQ_CLKB_XD5_XDFFQ_M r0 *1 0,0
Ccc_XD0_XDFFQ_CLKB_XD5_XDFFQ_M XD0.XDFFQ.CLKB XD5.XDFFQ.M 2.4201e-17
* device instance cc_XD0_XDFFQ_CLKB_XD5_XDFFQ_MB r0 *1 0,0
Ccc_XD0_XDFFQ_CLKB_XD5_XDFFQ_MB XD0.XDFFQ.CLKB XD5.XDFFQ.MB 1.21e-17
* device instance cc_XD0_XDFFQ_CLKB_XD5_XDFFQ_S r0 *1 0,0
Ccc_XD0_XDFFQ_CLKB_XD5_XDFFQ_S XD0.XDFFQ.CLKB XD5.XDFFQ.S 1.8151e-17
* device instance cc_XD0_XDFFQ_CLKB_XD5_XDFFQ_SB r0 *1 0,0
Ccc_XD0_XDFFQ_CLKB_XD5_XDFFQ_SB XD0.XDFFQ.CLKB XD5.XDFFQ.SB 1.8151e-17
* device instance cc_XD0_XDFFQ_CLKB_XD5_XN2_mid1 r0 *1 0,0
Ccc_XD0_XDFFQ_CLKB_XD5_XN2_mid1 XD0.XDFFQ.CLKB XD5.XN2.mid1 1.21e-17
* device instance cc_XD0_XDFFQ_CLKB_XD5_XN3_mid1 r0 *1 0,0
Ccc_XD0_XDFFQ_CLKB_XD5_XN3_mid1 XD0.XDFFQ.CLKB XD5.XN3.mid1 1.21e-17
* device instance cc_XD0_XDFFQ_CLKB_XD5_XN3_mid2 r0 *1 0,0
Ccc_XD0_XDFFQ_CLKB_XD5_XN3_mid2 XD0.XDFFQ.CLKB XD5.XN3.mid2 1.21e-17
* device instance cc_XD0_XDFFQ_CLKB_XD5_dmodout r0 *1 0,0
Ccc_XD0_XDFFQ_CLKB_XD5_dmodout XD0.XDFFQ.CLKB XD5.dmodout 1.21e-17
* device instance cc_XD0_XDFFQ_CLKB_XD5_dq r0 *1 0,0
Ccc_XD0_XDFFQ_CLKB_XD5_dq XD0.XDFFQ.CLKB XD5.dq 1.8151e-17
* device instance cc_XD0_XDFFQ_CLKB_XD5_nm r0 *1 0,0
Ccc_XD0_XDFFQ_CLKB_XD5_nm XD0.XDFFQ.CLKB XD5.nm 1.21e-17
* device instance cc_XD0_XDFFQ_CLKB_XD5_nt r0 *1 0,0
Ccc_XD0_XDFFQ_CLKB_XD5_nt XD0.XDFFQ.CLKB XD5.nt 1.21e-17
* device instance cc_XD0_XDFFQ_CLKB_XD5_t1 r0 *1 0,0
Ccc_XD0_XDFFQ_CLKB_XD5_t1 XD0.XDFFQ.CLKB XD5.t1 1.21e-17
* device instance cc_XD0_XDFFQ_CLKB_XFRT_CLKB r0 *1 0,0
Ccc_XD0_XDFFQ_CLKB_XFRT_CLKB XD0.XDFFQ.CLKB XFRT.CLKB 1.8151e-17
* device instance cc_XD0_XDFFQ_CLKB_XFRT_M r0 *1 0,0
Ccc_XD0_XDFFQ_CLKB_XFRT_M XD0.XDFFQ.CLKB XFRT.M 2.4201e-17
* device instance cc_XD0_XDFFQ_CLKB_XFRT_MB r0 *1 0,0
Ccc_XD0_XDFFQ_CLKB_XFRT_MB XD0.XDFFQ.CLKB XFRT.MB 1.21e-17
* device instance cc_XD0_XDFFQ_CLKB_XFRT_S r0 *1 0,0
Ccc_XD0_XDFFQ_CLKB_XFRT_S XD0.XDFFQ.CLKB XFRT.S 1.8151e-17
* device instance cc_XD0_XDFFQ_CLKB_XFRT_SB r0 *1 0,0
Ccc_XD0_XDFFQ_CLKB_XFRT_SB XD0.XDFFQ.CLKB XFRT.SB 1.8151e-17
* device instance cc_XD0_XDFFQ_CLKB_ck1 r0 *1 0,0
Ccc_XD0_XDFFQ_CLKB_ck1 XD0.XDFFQ.CLKB ck1 5.4452e-17
* device instance cc_XD0_XDFFQ_CLKB_ck2 r0 *1 0,0
Ccc_XD0_XDFFQ_CLKB_ck2 XD0.XDFFQ.CLKB ck2 5.4452e-17
* device instance cc_XD0_XDFFQ_CLKB_ck3 r0 *1 0,0
Ccc_XD0_XDFFQ_CLKB_ck3 XD0.XDFFQ.CLKB ck3 5.4452e-17
* device instance cc_XD0_XDFFQ_CLKB_ck4 r0 *1 0,0
Ccc_XD0_XDFFQ_CLKB_ck4 XD0.XDFFQ.CLKB ck4 5.4452e-17
* device instance cc_XD0_XDFFQ_CLKB_ck5 r0 *1 0,0
Ccc_XD0_XDFFQ_CLKB_ck5 XD0.XDFFQ.CLKB ck5 5.4452e-17
* device instance cc_XD0_XDFFQ_CLKB_mod0 r0 *1 0,0
Ccc_XD0_XDFFQ_CLKB_mod0 XD0.XDFFQ.CLKB mod0 2.4201e-17
* device instance cc_XD0_XDFFQ_CLKB_mod1 r0 *1 0,0
Ccc_XD0_XDFFQ_CLKB_mod1 XD0.XDFFQ.CLKB mod1 2.4201e-17
* device instance cc_XD0_XDFFQ_CLKB_mod2 r0 *1 0,0
Ccc_XD0_XDFFQ_CLKB_mod2 XD0.XDFFQ.CLKB mod2 2.4201e-17
* device instance cc_XD0_XDFFQ_CLKB_mod3 r0 *1 0,0
Ccc_XD0_XDFFQ_CLKB_mod3 XD0.XDFFQ.CLKB mod3 2.4201e-17
* device instance cc_XD0_XDFFQ_CLKB_mod4 r0 *1 0,0
Ccc_XD0_XDFFQ_CLKB_mod4 XD0.XDFFQ.CLKB mod4 2.4201e-17
* device instance cc_XD0_XDFFQ_CLKB_net1 r0 *1 0,0
Ccc_XD0_XDFFQ_CLKB_net1 XD0.XDFFQ.CLKB net1 1.21e-17
* device instance cc_XD0_XDFFQ_M_XD0_XDFFQ_MB r0 *1 0,0
Ccc_XD0_XDFFQ_M_XD0_XDFFQ_MB XD0.XDFFQ.M XD0.XDFFQ.MB 3.4688e-17
* device instance cc_XD0_XDFFQ_M_XD0_XDFFQ_S r0 *1 0,0
Ccc_XD0_XDFFQ_M_XD0_XDFFQ_S XD0.XDFFQ.M XD0.XDFFQ.S 2.8638e-17
* device instance cc_XD0_XDFFQ_M_XD0_XDFFQ_SB r0 *1 0,0
Ccc_XD0_XDFFQ_M_XD0_XDFFQ_SB XD0.XDFFQ.M XD0.XDFFQ.SB 1.8151e-17
* device instance cc_XD0_XDFFQ_M_XD0_XN2_mid1 r0 *1 0,0
Ccc_XD0_XDFFQ_M_XD0_XN2_mid1 XD0.XDFFQ.M XD0.XN2.mid1 1.21e-17
* device instance cc_XD0_XDFFQ_M_XD0_XNOR_midp r0 *1 0,0
Ccc_XD0_XDFFQ_M_XD0_XNOR_midp XD0.XDFFQ.M XD0.XNOR.midp 1.21e-17
* device instance cc_XD0_XDFFQ_M_XD0_dmodout r0 *1 0,0
Ccc_XD0_XDFFQ_M_XD0_dmodout XD0.XDFFQ.M XD0.dmodout 1.21e-17
* device instance cc_XD0_XDFFQ_M_XD0_dq r0 *1 0,0
Ccc_XD0_XDFFQ_M_XD0_dq XD0.XDFFQ.M XD0.dq 2.8638e-17
* device instance cc_XD0_XDFFQ_M_XD0_nm r0 *1 0,0
Ccc_XD0_XDFFQ_M_XD0_nm XD0.XDFFQ.M XD0.nm 1.21e-17
* device instance cc_XD0_XDFFQ_M_XD0_nt r0 *1 0,0
Ccc_XD0_XDFFQ_M_XD0_nt XD0.XDFFQ.M XD0.nt 2.4201e-17
* device instance cc_XD0_XDFFQ_M_XD0_t1 r0 *1 0,0
Ccc_XD0_XDFFQ_M_XD0_t1 XD0.XDFFQ.M XD0.t1 1.21e-17
* device instance cc_XD0_XDFFQ_M_XD1_XDFFM_CLKB r0 *1 0,0
Ccc_XD0_XDFFQ_M_XD1_XDFFM_CLKB XD0.XDFFQ.M XD1.XDFFM.CLKB 1.8151e-17
* device instance cc_XD0_XDFFQ_M_XD1_XDFFM_M r0 *1 0,0
Ccc_XD0_XDFFQ_M_XD1_XDFFM_M XD0.XDFFQ.M XD1.XDFFM.M 2.4201e-17
* device instance cc_XD0_XDFFQ_M_XD1_XDFFM_MB r0 *1 0,0
Ccc_XD0_XDFFQ_M_XD1_XDFFM_MB XD0.XDFFQ.M XD1.XDFFM.MB 1.21e-17
* device instance cc_XD0_XDFFQ_M_XD1_XDFFM_S r0 *1 0,0
Ccc_XD0_XDFFQ_M_XD1_XDFFM_S XD0.XDFFQ.M XD1.XDFFM.S 1.8151e-17
* device instance cc_XD0_XDFFQ_M_XD1_XDFFM_SB r0 *1 0,0
Ccc_XD0_XDFFQ_M_XD1_XDFFM_SB XD0.XDFFQ.M XD1.XDFFM.SB 1.8151e-17
* device instance cc_XD0_XDFFQ_M_XD1_XDFFQ_CLKB r0 *1 0,0
Ccc_XD0_XDFFQ_M_XD1_XDFFQ_CLKB XD0.XDFFQ.M XD1.XDFFQ.CLKB 1.8151e-17
* device instance cc_XD0_XDFFQ_M_XD1_XDFFQ_M r0 *1 0,0
Ccc_XD0_XDFFQ_M_XD1_XDFFQ_M XD0.XDFFQ.M XD1.XDFFQ.M 2.4201e-17
* device instance cc_XD0_XDFFQ_M_XD1_XDFFQ_MB r0 *1 0,0
Ccc_XD0_XDFFQ_M_XD1_XDFFQ_MB XD0.XDFFQ.M XD1.XDFFQ.MB 1.21e-17
* device instance cc_XD0_XDFFQ_M_XD1_XDFFQ_S r0 *1 0,0
Ccc_XD0_XDFFQ_M_XD1_XDFFQ_S XD0.XDFFQ.M XD1.XDFFQ.S 1.8151e-17
* device instance cc_XD0_XDFFQ_M_XD1_XDFFQ_SB r0 *1 0,0
Ccc_XD0_XDFFQ_M_XD1_XDFFQ_SB XD0.XDFFQ.M XD1.XDFFQ.SB 1.8151e-17
* device instance cc_XD0_XDFFQ_M_XD1_XN2_mid1 r0 *1 0,0
Ccc_XD0_XDFFQ_M_XD1_XN2_mid1 XD0.XDFFQ.M XD1.XN2.mid1 1.21e-17
* device instance cc_XD0_XDFFQ_M_XD1_XN3_mid1 r0 *1 0,0
Ccc_XD0_XDFFQ_M_XD1_XN3_mid1 XD0.XDFFQ.M XD1.XN3.mid1 1.21e-17
* device instance cc_XD0_XDFFQ_M_XD1_XN3_mid2 r0 *1 0,0
Ccc_XD0_XDFFQ_M_XD1_XN3_mid2 XD0.XDFFQ.M XD1.XN3.mid2 1.21e-17
* device instance cc_XD0_XDFFQ_M_XD1_dmodout r0 *1 0,0
Ccc_XD0_XDFFQ_M_XD1_dmodout XD0.XDFFQ.M XD1.dmodout 1.21e-17
* device instance cc_XD0_XDFFQ_M_XD1_dq r0 *1 0,0
Ccc_XD0_XDFFQ_M_XD1_dq XD0.XDFFQ.M XD1.dq 1.8151e-17
* device instance cc_XD0_XDFFQ_M_XD1_nm r0 *1 0,0
Ccc_XD0_XDFFQ_M_XD1_nm XD0.XDFFQ.M XD1.nm 1.21e-17
* device instance cc_XD0_XDFFQ_M_XD1_nt r0 *1 0,0
Ccc_XD0_XDFFQ_M_XD1_nt XD0.XDFFQ.M XD1.nt 1.21e-17
* device instance cc_XD0_XDFFQ_M_XD1_t1 r0 *1 0,0
Ccc_XD0_XDFFQ_M_XD1_t1 XD0.XDFFQ.M XD1.t1 1.21e-17
* device instance cc_XD0_XDFFQ_M_XD2_XDFFM_CLKB r0 *1 0,0
Ccc_XD0_XDFFQ_M_XD2_XDFFM_CLKB XD0.XDFFQ.M XD2.XDFFM.CLKB 1.8151e-17
* device instance cc_XD0_XDFFQ_M_XD2_XDFFM_M r0 *1 0,0
Ccc_XD0_XDFFQ_M_XD2_XDFFM_M XD0.XDFFQ.M XD2.XDFFM.M 2.4201e-17
* device instance cc_XD0_XDFFQ_M_XD2_XDFFM_MB r0 *1 0,0
Ccc_XD0_XDFFQ_M_XD2_XDFFM_MB XD0.XDFFQ.M XD2.XDFFM.MB 1.21e-17
* device instance cc_XD0_XDFFQ_M_XD2_XDFFM_S r0 *1 0,0
Ccc_XD0_XDFFQ_M_XD2_XDFFM_S XD0.XDFFQ.M XD2.XDFFM.S 1.8151e-17
* device instance cc_XD0_XDFFQ_M_XD2_XDFFM_SB r0 *1 0,0
Ccc_XD0_XDFFQ_M_XD2_XDFFM_SB XD0.XDFFQ.M XD2.XDFFM.SB 1.8151e-17
* device instance cc_XD0_XDFFQ_M_XD2_XDFFQ_CLKB r0 *1 0,0
Ccc_XD0_XDFFQ_M_XD2_XDFFQ_CLKB XD0.XDFFQ.M XD2.XDFFQ.CLKB 1.8151e-17
* device instance cc_XD0_XDFFQ_M_XD2_XDFFQ_M r0 *1 0,0
Ccc_XD0_XDFFQ_M_XD2_XDFFQ_M XD0.XDFFQ.M XD2.XDFFQ.M 2.4201e-17
* device instance cc_XD0_XDFFQ_M_XD2_XDFFQ_MB r0 *1 0,0
Ccc_XD0_XDFFQ_M_XD2_XDFFQ_MB XD0.XDFFQ.M XD2.XDFFQ.MB 1.21e-17
* device instance cc_XD0_XDFFQ_M_XD2_XDFFQ_S r0 *1 0,0
Ccc_XD0_XDFFQ_M_XD2_XDFFQ_S XD0.XDFFQ.M XD2.XDFFQ.S 1.8151e-17
* device instance cc_XD0_XDFFQ_M_XD2_XDFFQ_SB r0 *1 0,0
Ccc_XD0_XDFFQ_M_XD2_XDFFQ_SB XD0.XDFFQ.M XD2.XDFFQ.SB 1.8151e-17
* device instance cc_XD0_XDFFQ_M_XD2_XN2_mid1 r0 *1 0,0
Ccc_XD0_XDFFQ_M_XD2_XN2_mid1 XD0.XDFFQ.M XD2.XN2.mid1 1.21e-17
* device instance cc_XD0_XDFFQ_M_XD2_XN3_mid1 r0 *1 0,0
Ccc_XD0_XDFFQ_M_XD2_XN3_mid1 XD0.XDFFQ.M XD2.XN3.mid1 1.21e-17
* device instance cc_XD0_XDFFQ_M_XD2_XN3_mid2 r0 *1 0,0
Ccc_XD0_XDFFQ_M_XD2_XN3_mid2 XD0.XDFFQ.M XD2.XN3.mid2 1.21e-17
* device instance cc_XD0_XDFFQ_M_XD2_dmodout r0 *1 0,0
Ccc_XD0_XDFFQ_M_XD2_dmodout XD0.XDFFQ.M XD2.dmodout 1.21e-17
* device instance cc_XD0_XDFFQ_M_XD2_dq r0 *1 0,0
Ccc_XD0_XDFFQ_M_XD2_dq XD0.XDFFQ.M XD2.dq 1.8151e-17
* device instance cc_XD0_XDFFQ_M_XD2_nm r0 *1 0,0
Ccc_XD0_XDFFQ_M_XD2_nm XD0.XDFFQ.M XD2.nm 1.21e-17
* device instance cc_XD0_XDFFQ_M_XD2_nt r0 *1 0,0
Ccc_XD0_XDFFQ_M_XD2_nt XD0.XDFFQ.M XD2.nt 1.21e-17
* device instance cc_XD0_XDFFQ_M_XD2_t1 r0 *1 0,0
Ccc_XD0_XDFFQ_M_XD2_t1 XD0.XDFFQ.M XD2.t1 1.21e-17
* device instance cc_XD0_XDFFQ_M_XD3_XDFFM_CLKB r0 *1 0,0
Ccc_XD0_XDFFQ_M_XD3_XDFFM_CLKB XD0.XDFFQ.M XD3.XDFFM.CLKB 1.8151e-17
* device instance cc_XD0_XDFFQ_M_XD3_XDFFM_M r0 *1 0,0
Ccc_XD0_XDFFQ_M_XD3_XDFFM_M XD0.XDFFQ.M XD3.XDFFM.M 2.4201e-17
* device instance cc_XD0_XDFFQ_M_XD3_XDFFM_MB r0 *1 0,0
Ccc_XD0_XDFFQ_M_XD3_XDFFM_MB XD0.XDFFQ.M XD3.XDFFM.MB 1.21e-17
* device instance cc_XD0_XDFFQ_M_XD3_XDFFM_S r0 *1 0,0
Ccc_XD0_XDFFQ_M_XD3_XDFFM_S XD0.XDFFQ.M XD3.XDFFM.S 1.8151e-17
* device instance cc_XD0_XDFFQ_M_XD3_XDFFM_SB r0 *1 0,0
Ccc_XD0_XDFFQ_M_XD3_XDFFM_SB XD0.XDFFQ.M XD3.XDFFM.SB 1.8151e-17
* device instance cc_XD0_XDFFQ_M_XD3_XDFFQ_CLKB r0 *1 0,0
Ccc_XD0_XDFFQ_M_XD3_XDFFQ_CLKB XD0.XDFFQ.M XD3.XDFFQ.CLKB 1.8151e-17
* device instance cc_XD0_XDFFQ_M_XD3_XDFFQ_M r0 *1 0,0
Ccc_XD0_XDFFQ_M_XD3_XDFFQ_M XD0.XDFFQ.M XD3.XDFFQ.M 2.4201e-17
* device instance cc_XD0_XDFFQ_M_XD3_XDFFQ_MB r0 *1 0,0
Ccc_XD0_XDFFQ_M_XD3_XDFFQ_MB XD0.XDFFQ.M XD3.XDFFQ.MB 1.21e-17
* device instance cc_XD0_XDFFQ_M_XD3_XDFFQ_S r0 *1 0,0
Ccc_XD0_XDFFQ_M_XD3_XDFFQ_S XD0.XDFFQ.M XD3.XDFFQ.S 1.8151e-17
* device instance cc_XD0_XDFFQ_M_XD3_XDFFQ_SB r0 *1 0,0
Ccc_XD0_XDFFQ_M_XD3_XDFFQ_SB XD0.XDFFQ.M XD3.XDFFQ.SB 1.8151e-17
* device instance cc_XD0_XDFFQ_M_XD3_XN2_mid1 r0 *1 0,0
Ccc_XD0_XDFFQ_M_XD3_XN2_mid1 XD0.XDFFQ.M XD3.XN2.mid1 1.21e-17
* device instance cc_XD0_XDFFQ_M_XD3_XN3_mid1 r0 *1 0,0
Ccc_XD0_XDFFQ_M_XD3_XN3_mid1 XD0.XDFFQ.M XD3.XN3.mid1 1.21e-17
* device instance cc_XD0_XDFFQ_M_XD3_XN3_mid2 r0 *1 0,0
Ccc_XD0_XDFFQ_M_XD3_XN3_mid2 XD0.XDFFQ.M XD3.XN3.mid2 1.21e-17
* device instance cc_XD0_XDFFQ_M_XD3_dmodout r0 *1 0,0
Ccc_XD0_XDFFQ_M_XD3_dmodout XD0.XDFFQ.M XD3.dmodout 1.21e-17
* device instance cc_XD0_XDFFQ_M_XD3_dq r0 *1 0,0
Ccc_XD0_XDFFQ_M_XD3_dq XD0.XDFFQ.M XD3.dq 1.8151e-17
* device instance cc_XD0_XDFFQ_M_XD3_nm r0 *1 0,0
Ccc_XD0_XDFFQ_M_XD3_nm XD0.XDFFQ.M XD3.nm 1.21e-17
* device instance cc_XD0_XDFFQ_M_XD3_nt r0 *1 0,0
Ccc_XD0_XDFFQ_M_XD3_nt XD0.XDFFQ.M XD3.nt 1.21e-17
* device instance cc_XD0_XDFFQ_M_XD3_t1 r0 *1 0,0
Ccc_XD0_XDFFQ_M_XD3_t1 XD0.XDFFQ.M XD3.t1 1.21e-17
* device instance cc_XD0_XDFFQ_M_XD4_XDFFM_CLKB r0 *1 0,0
Ccc_XD0_XDFFQ_M_XD4_XDFFM_CLKB XD0.XDFFQ.M XD4.XDFFM.CLKB 1.8151e-17
* device instance cc_XD0_XDFFQ_M_XD4_XDFFM_M r0 *1 0,0
Ccc_XD0_XDFFQ_M_XD4_XDFFM_M XD0.XDFFQ.M XD4.XDFFM.M 2.4201e-17
* device instance cc_XD0_XDFFQ_M_XD4_XDFFM_MB r0 *1 0,0
Ccc_XD0_XDFFQ_M_XD4_XDFFM_MB XD0.XDFFQ.M XD4.XDFFM.MB 1.21e-17
* device instance cc_XD0_XDFFQ_M_XD4_XDFFM_S r0 *1 0,0
Ccc_XD0_XDFFQ_M_XD4_XDFFM_S XD0.XDFFQ.M XD4.XDFFM.S 1.8151e-17
* device instance cc_XD0_XDFFQ_M_XD4_XDFFM_SB r0 *1 0,0
Ccc_XD0_XDFFQ_M_XD4_XDFFM_SB XD0.XDFFQ.M XD4.XDFFM.SB 1.8151e-17
* device instance cc_XD0_XDFFQ_M_XD4_XDFFQ_CLKB r0 *1 0,0
Ccc_XD0_XDFFQ_M_XD4_XDFFQ_CLKB XD0.XDFFQ.M XD4.XDFFQ.CLKB 1.8151e-17
* device instance cc_XD0_XDFFQ_M_XD4_XDFFQ_M r0 *1 0,0
Ccc_XD0_XDFFQ_M_XD4_XDFFQ_M XD0.XDFFQ.M XD4.XDFFQ.M 2.4201e-17
* device instance cc_XD0_XDFFQ_M_XD4_XDFFQ_MB r0 *1 0,0
Ccc_XD0_XDFFQ_M_XD4_XDFFQ_MB XD0.XDFFQ.M XD4.XDFFQ.MB 1.21e-17
* device instance cc_XD0_XDFFQ_M_XD4_XDFFQ_S r0 *1 0,0
Ccc_XD0_XDFFQ_M_XD4_XDFFQ_S XD0.XDFFQ.M XD4.XDFFQ.S 1.8151e-17
* device instance cc_XD0_XDFFQ_M_XD4_XDFFQ_SB r0 *1 0,0
Ccc_XD0_XDFFQ_M_XD4_XDFFQ_SB XD0.XDFFQ.M XD4.XDFFQ.SB 1.8151e-17
* device instance cc_XD0_XDFFQ_M_XD4_XN2_mid1 r0 *1 0,0
Ccc_XD0_XDFFQ_M_XD4_XN2_mid1 XD0.XDFFQ.M XD4.XN2.mid1 1.21e-17
* device instance cc_XD0_XDFFQ_M_XD4_XN3_mid1 r0 *1 0,0
Ccc_XD0_XDFFQ_M_XD4_XN3_mid1 XD0.XDFFQ.M XD4.XN3.mid1 1.21e-17
* device instance cc_XD0_XDFFQ_M_XD4_XN3_mid2 r0 *1 0,0
Ccc_XD0_XDFFQ_M_XD4_XN3_mid2 XD0.XDFFQ.M XD4.XN3.mid2 1.21e-17
* device instance cc_XD0_XDFFQ_M_XD4_dmodout r0 *1 0,0
Ccc_XD0_XDFFQ_M_XD4_dmodout XD0.XDFFQ.M XD4.dmodout 1.21e-17
* device instance cc_XD0_XDFFQ_M_XD4_dq r0 *1 0,0
Ccc_XD0_XDFFQ_M_XD4_dq XD0.XDFFQ.M XD4.dq 1.8151e-17
* device instance cc_XD0_XDFFQ_M_XD4_nm r0 *1 0,0
Ccc_XD0_XDFFQ_M_XD4_nm XD0.XDFFQ.M XD4.nm 1.21e-17
* device instance cc_XD0_XDFFQ_M_XD4_nt r0 *1 0,0
Ccc_XD0_XDFFQ_M_XD4_nt XD0.XDFFQ.M XD4.nt 1.21e-17
* device instance cc_XD0_XDFFQ_M_XD4_t1 r0 *1 0,0
Ccc_XD0_XDFFQ_M_XD4_t1 XD0.XDFFQ.M XD4.t1 1.21e-17
* device instance cc_XD0_XDFFQ_M_XD5_XDFFM_CLKB r0 *1 0,0
Ccc_XD0_XDFFQ_M_XD5_XDFFM_CLKB XD0.XDFFQ.M XD5.XDFFM.CLKB 1.8151e-17
* device instance cc_XD0_XDFFQ_M_XD5_XDFFM_M r0 *1 0,0
Ccc_XD0_XDFFQ_M_XD5_XDFFM_M XD0.XDFFQ.M XD5.XDFFM.M 2.4201e-17
* device instance cc_XD0_XDFFQ_M_XD5_XDFFM_MB r0 *1 0,0
Ccc_XD0_XDFFQ_M_XD5_XDFFM_MB XD0.XDFFQ.M XD5.XDFFM.MB 1.21e-17
* device instance cc_XD0_XDFFQ_M_XD5_XDFFM_S r0 *1 0,0
Ccc_XD0_XDFFQ_M_XD5_XDFFM_S XD0.XDFFQ.M XD5.XDFFM.S 1.8151e-17
* device instance cc_XD0_XDFFQ_M_XD5_XDFFM_SB r0 *1 0,0
Ccc_XD0_XDFFQ_M_XD5_XDFFM_SB XD0.XDFFQ.M XD5.XDFFM.SB 1.8151e-17
* device instance cc_XD0_XDFFQ_M_XD5_XDFFQ_CLKB r0 *1 0,0
Ccc_XD0_XDFFQ_M_XD5_XDFFQ_CLKB XD0.XDFFQ.M XD5.XDFFQ.CLKB 1.8151e-17
* device instance cc_XD0_XDFFQ_M_XD5_XDFFQ_M r0 *1 0,0
Ccc_XD0_XDFFQ_M_XD5_XDFFQ_M XD0.XDFFQ.M XD5.XDFFQ.M 2.4201e-17
* device instance cc_XD0_XDFFQ_M_XD5_XDFFQ_MB r0 *1 0,0
Ccc_XD0_XDFFQ_M_XD5_XDFFQ_MB XD0.XDFFQ.M XD5.XDFFQ.MB 1.21e-17
* device instance cc_XD0_XDFFQ_M_XD5_XDFFQ_S r0 *1 0,0
Ccc_XD0_XDFFQ_M_XD5_XDFFQ_S XD0.XDFFQ.M XD5.XDFFQ.S 1.8151e-17
* device instance cc_XD0_XDFFQ_M_XD5_XDFFQ_SB r0 *1 0,0
Ccc_XD0_XDFFQ_M_XD5_XDFFQ_SB XD0.XDFFQ.M XD5.XDFFQ.SB 1.8151e-17
* device instance cc_XD0_XDFFQ_M_XD5_XN2_mid1 r0 *1 0,0
Ccc_XD0_XDFFQ_M_XD5_XN2_mid1 XD0.XDFFQ.M XD5.XN2.mid1 1.21e-17
* device instance cc_XD0_XDFFQ_M_XD5_XN3_mid1 r0 *1 0,0
Ccc_XD0_XDFFQ_M_XD5_XN3_mid1 XD0.XDFFQ.M XD5.XN3.mid1 1.21e-17
* device instance cc_XD0_XDFFQ_M_XD5_XN3_mid2 r0 *1 0,0
Ccc_XD0_XDFFQ_M_XD5_XN3_mid2 XD0.XDFFQ.M XD5.XN3.mid2 1.21e-17
* device instance cc_XD0_XDFFQ_M_XD5_dmodout r0 *1 0,0
Ccc_XD0_XDFFQ_M_XD5_dmodout XD0.XDFFQ.M XD5.dmodout 1.21e-17
* device instance cc_XD0_XDFFQ_M_XD5_dq r0 *1 0,0
Ccc_XD0_XDFFQ_M_XD5_dq XD0.XDFFQ.M XD5.dq 1.8151e-17
* device instance cc_XD0_XDFFQ_M_XD5_nm r0 *1 0,0
Ccc_XD0_XDFFQ_M_XD5_nm XD0.XDFFQ.M XD5.nm 1.21e-17
* device instance cc_XD0_XDFFQ_M_XD5_nt r0 *1 0,0
Ccc_XD0_XDFFQ_M_XD5_nt XD0.XDFFQ.M XD5.nt 1.21e-17
* device instance cc_XD0_XDFFQ_M_XD5_t1 r0 *1 0,0
Ccc_XD0_XDFFQ_M_XD5_t1 XD0.XDFFQ.M XD5.t1 1.21e-17
* device instance cc_XD0_XDFFQ_M_XFRT_CLKB r0 *1 0,0
Ccc_XD0_XDFFQ_M_XFRT_CLKB XD0.XDFFQ.M XFRT.CLKB 1.8151e-17
* device instance cc_XD0_XDFFQ_M_XFRT_M r0 *1 0,0
Ccc_XD0_XDFFQ_M_XFRT_M XD0.XDFFQ.M XFRT.M 2.4201e-17
* device instance cc_XD0_XDFFQ_M_XFRT_MB r0 *1 0,0
Ccc_XD0_XDFFQ_M_XFRT_MB XD0.XDFFQ.M XFRT.MB 1.21e-17
* device instance cc_XD0_XDFFQ_M_XFRT_S r0 *1 0,0
Ccc_XD0_XDFFQ_M_XFRT_S XD0.XDFFQ.M XFRT.S 1.8151e-17
* device instance cc_XD0_XDFFQ_M_XFRT_SB r0 *1 0,0
Ccc_XD0_XDFFQ_M_XFRT_SB XD0.XDFFQ.M XFRT.SB 1.8151e-17
* device instance cc_XD0_XDFFQ_M_ck1 r0 *1 0,0
Ccc_XD0_XDFFQ_M_ck1 XD0.XDFFQ.M ck1 5.4452e-17
* device instance cc_XD0_XDFFQ_M_ck2 r0 *1 0,0
Ccc_XD0_XDFFQ_M_ck2 XD0.XDFFQ.M ck2 5.4452e-17
* device instance cc_XD0_XDFFQ_M_ck3 r0 *1 0,0
Ccc_XD0_XDFFQ_M_ck3 XD0.XDFFQ.M ck3 5.4452e-17
* device instance cc_XD0_XDFFQ_M_ck4 r0 *1 0,0
Ccc_XD0_XDFFQ_M_ck4 XD0.XDFFQ.M ck4 5.4452e-17
* device instance cc_XD0_XDFFQ_M_ck5 r0 *1 0,0
Ccc_XD0_XDFFQ_M_ck5 XD0.XDFFQ.M ck5 5.4452e-17
* device instance cc_XD0_XDFFQ_M_mod0 r0 *1 0,0
Ccc_XD0_XDFFQ_M_mod0 XD0.XDFFQ.M mod0 2.4201e-17
* device instance cc_XD0_XDFFQ_M_mod1 r0 *1 0,0
Ccc_XD0_XDFFQ_M_mod1 XD0.XDFFQ.M mod1 2.4201e-17
* device instance cc_XD0_XDFFQ_M_mod2 r0 *1 0,0
Ccc_XD0_XDFFQ_M_mod2 XD0.XDFFQ.M mod2 2.4201e-17
* device instance cc_XD0_XDFFQ_M_mod3 r0 *1 0,0
Ccc_XD0_XDFFQ_M_mod3 XD0.XDFFQ.M mod3 2.4201e-17
* device instance cc_XD0_XDFFQ_M_mod4 r0 *1 0,0
Ccc_XD0_XDFFQ_M_mod4 XD0.XDFFQ.M mod4 2.4201e-17
* device instance cc_XD0_XDFFQ_M_net1 r0 *1 0,0
Ccc_XD0_XDFFQ_M_net1 XD0.XDFFQ.M net1 1.21e-17
* device instance cc_XD0_XDFFQ_MB_XD0_XDFFQ_S r0 *1 0,0
Ccc_XD0_XDFFQ_MB_XD0_XDFFQ_S XD0.XDFFQ.MB XD0.XDFFQ.S 1.8151e-17
* device instance cc_XD0_XDFFQ_MB_XD0_XDFFQ_SB r0 *1 0,0
Ccc_XD0_XDFFQ_MB_XD0_XDFFQ_SB XD0.XDFFQ.MB XD0.XDFFQ.SB 1.8151e-17
* device instance cc_XD0_XDFFQ_MB_XD0_XN2_mid1 r0 *1 0,0
Ccc_XD0_XDFFQ_MB_XD0_XN2_mid1 XD0.XDFFQ.MB XD0.XN2.mid1 1.21e-17
* device instance cc_XD0_XDFFQ_MB_XD0_XNOR_midp r0 *1 0,0
Ccc_XD0_XDFFQ_MB_XD0_XNOR_midp XD0.XDFFQ.MB XD0.XNOR.midp 1.21e-17
* device instance cc_XD0_XDFFQ_MB_XD0_dmodout r0 *1 0,0
Ccc_XD0_XDFFQ_MB_XD0_dmodout XD0.XDFFQ.MB XD0.dmodout 1.21e-17
* device instance cc_XD0_XDFFQ_MB_XD0_dq r0 *1 0,0
Ccc_XD0_XDFFQ_MB_XD0_dq XD0.XDFFQ.MB XD0.dq 1.21e-17
* device instance cc_XD0_XDFFQ_MB_XD0_nm r0 *1 0,0
Ccc_XD0_XDFFQ_MB_XD0_nm XD0.XDFFQ.MB XD0.nm 1.21e-17
* device instance cc_XD0_XDFFQ_MB_XD0_nt r0 *1 0,0
Ccc_XD0_XDFFQ_MB_XD0_nt XD0.XDFFQ.MB XD0.nt 2.4201e-17
* device instance cc_XD0_XDFFQ_MB_XD0_t1 r0 *1 0,0
Ccc_XD0_XDFFQ_MB_XD0_t1 XD0.XDFFQ.MB XD0.t1 1.21e-17
* device instance cc_XD0_XDFFQ_MB_XD1_XDFFM_CLKB r0 *1 0,0
Ccc_XD0_XDFFQ_MB_XD1_XDFFM_CLKB XD0.XDFFQ.MB XD1.XDFFM.CLKB 1.8151e-17
* device instance cc_XD0_XDFFQ_MB_XD1_XDFFM_M r0 *1 0,0
Ccc_XD0_XDFFQ_MB_XD1_XDFFM_M XD0.XDFFQ.MB XD1.XDFFM.M 2.4201e-17
* device instance cc_XD0_XDFFQ_MB_XD1_XDFFM_MB r0 *1 0,0
Ccc_XD0_XDFFQ_MB_XD1_XDFFM_MB XD0.XDFFQ.MB XD1.XDFFM.MB 1.21e-17
* device instance cc_XD0_XDFFQ_MB_XD1_XDFFM_S r0 *1 0,0
Ccc_XD0_XDFFQ_MB_XD1_XDFFM_S XD0.XDFFQ.MB XD1.XDFFM.S 1.8151e-17
* device instance cc_XD0_XDFFQ_MB_XD1_XDFFM_SB r0 *1 0,0
Ccc_XD0_XDFFQ_MB_XD1_XDFFM_SB XD0.XDFFQ.MB XD1.XDFFM.SB 1.8151e-17
* device instance cc_XD0_XDFFQ_MB_XD1_XDFFQ_CLKB r0 *1 0,0
Ccc_XD0_XDFFQ_MB_XD1_XDFFQ_CLKB XD0.XDFFQ.MB XD1.XDFFQ.CLKB 1.8151e-17
* device instance cc_XD0_XDFFQ_MB_XD1_XDFFQ_M r0 *1 0,0
Ccc_XD0_XDFFQ_MB_XD1_XDFFQ_M XD0.XDFFQ.MB XD1.XDFFQ.M 2.4201e-17
* device instance cc_XD0_XDFFQ_MB_XD1_XDFFQ_MB r0 *1 0,0
Ccc_XD0_XDFFQ_MB_XD1_XDFFQ_MB XD0.XDFFQ.MB XD1.XDFFQ.MB 1.21e-17
* device instance cc_XD0_XDFFQ_MB_XD1_XDFFQ_S r0 *1 0,0
Ccc_XD0_XDFFQ_MB_XD1_XDFFQ_S XD0.XDFFQ.MB XD1.XDFFQ.S 1.8151e-17
* device instance cc_XD0_XDFFQ_MB_XD1_XDFFQ_SB r0 *1 0,0
Ccc_XD0_XDFFQ_MB_XD1_XDFFQ_SB XD0.XDFFQ.MB XD1.XDFFQ.SB 1.8151e-17
* device instance cc_XD0_XDFFQ_MB_XD1_XN2_mid1 r0 *1 0,0
Ccc_XD0_XDFFQ_MB_XD1_XN2_mid1 XD0.XDFFQ.MB XD1.XN2.mid1 1.21e-17
* device instance cc_XD0_XDFFQ_MB_XD1_XN3_mid1 r0 *1 0,0
Ccc_XD0_XDFFQ_MB_XD1_XN3_mid1 XD0.XDFFQ.MB XD1.XN3.mid1 1.21e-17
* device instance cc_XD0_XDFFQ_MB_XD1_XN3_mid2 r0 *1 0,0
Ccc_XD0_XDFFQ_MB_XD1_XN3_mid2 XD0.XDFFQ.MB XD1.XN3.mid2 1.21e-17
* device instance cc_XD0_XDFFQ_MB_XD1_dmodout r0 *1 0,0
Ccc_XD0_XDFFQ_MB_XD1_dmodout XD0.XDFFQ.MB XD1.dmodout 1.21e-17
* device instance cc_XD0_XDFFQ_MB_XD1_dq r0 *1 0,0
Ccc_XD0_XDFFQ_MB_XD1_dq XD0.XDFFQ.MB XD1.dq 1.8151e-17
* device instance cc_XD0_XDFFQ_MB_XD1_nm r0 *1 0,0
Ccc_XD0_XDFFQ_MB_XD1_nm XD0.XDFFQ.MB XD1.nm 1.21e-17
* device instance cc_XD0_XDFFQ_MB_XD1_nt r0 *1 0,0
Ccc_XD0_XDFFQ_MB_XD1_nt XD0.XDFFQ.MB XD1.nt 1.21e-17
* device instance cc_XD0_XDFFQ_MB_XD1_t1 r0 *1 0,0
Ccc_XD0_XDFFQ_MB_XD1_t1 XD0.XDFFQ.MB XD1.t1 1.21e-17
* device instance cc_XD0_XDFFQ_MB_XD2_XDFFM_CLKB r0 *1 0,0
Ccc_XD0_XDFFQ_MB_XD2_XDFFM_CLKB XD0.XDFFQ.MB XD2.XDFFM.CLKB 1.8151e-17
* device instance cc_XD0_XDFFQ_MB_XD2_XDFFM_M r0 *1 0,0
Ccc_XD0_XDFFQ_MB_XD2_XDFFM_M XD0.XDFFQ.MB XD2.XDFFM.M 2.4201e-17
* device instance cc_XD0_XDFFQ_MB_XD2_XDFFM_MB r0 *1 0,0
Ccc_XD0_XDFFQ_MB_XD2_XDFFM_MB XD0.XDFFQ.MB XD2.XDFFM.MB 1.21e-17
* device instance cc_XD0_XDFFQ_MB_XD2_XDFFM_S r0 *1 0,0
Ccc_XD0_XDFFQ_MB_XD2_XDFFM_S XD0.XDFFQ.MB XD2.XDFFM.S 1.8151e-17
* device instance cc_XD0_XDFFQ_MB_XD2_XDFFM_SB r0 *1 0,0
Ccc_XD0_XDFFQ_MB_XD2_XDFFM_SB XD0.XDFFQ.MB XD2.XDFFM.SB 1.8151e-17
* device instance cc_XD0_XDFFQ_MB_XD2_XDFFQ_CLKB r0 *1 0,0
Ccc_XD0_XDFFQ_MB_XD2_XDFFQ_CLKB XD0.XDFFQ.MB XD2.XDFFQ.CLKB 1.8151e-17
* device instance cc_XD0_XDFFQ_MB_XD2_XDFFQ_M r0 *1 0,0
Ccc_XD0_XDFFQ_MB_XD2_XDFFQ_M XD0.XDFFQ.MB XD2.XDFFQ.M 2.4201e-17
* device instance cc_XD0_XDFFQ_MB_XD2_XDFFQ_MB r0 *1 0,0
Ccc_XD0_XDFFQ_MB_XD2_XDFFQ_MB XD0.XDFFQ.MB XD2.XDFFQ.MB 1.21e-17
* device instance cc_XD0_XDFFQ_MB_XD2_XDFFQ_S r0 *1 0,0
Ccc_XD0_XDFFQ_MB_XD2_XDFFQ_S XD0.XDFFQ.MB XD2.XDFFQ.S 1.8151e-17
* device instance cc_XD0_XDFFQ_MB_XD2_XDFFQ_SB r0 *1 0,0
Ccc_XD0_XDFFQ_MB_XD2_XDFFQ_SB XD0.XDFFQ.MB XD2.XDFFQ.SB 1.8151e-17
* device instance cc_XD0_XDFFQ_MB_XD2_XN2_mid1 r0 *1 0,0
Ccc_XD0_XDFFQ_MB_XD2_XN2_mid1 XD0.XDFFQ.MB XD2.XN2.mid1 1.21e-17
* device instance cc_XD0_XDFFQ_MB_XD2_XN3_mid1 r0 *1 0,0
Ccc_XD0_XDFFQ_MB_XD2_XN3_mid1 XD0.XDFFQ.MB XD2.XN3.mid1 1.21e-17
* device instance cc_XD0_XDFFQ_MB_XD2_XN3_mid2 r0 *1 0,0
Ccc_XD0_XDFFQ_MB_XD2_XN3_mid2 XD0.XDFFQ.MB XD2.XN3.mid2 1.21e-17
* device instance cc_XD0_XDFFQ_MB_XD2_dmodout r0 *1 0,0
Ccc_XD0_XDFFQ_MB_XD2_dmodout XD0.XDFFQ.MB XD2.dmodout 1.21e-17
* device instance cc_XD0_XDFFQ_MB_XD2_dq r0 *1 0,0
Ccc_XD0_XDFFQ_MB_XD2_dq XD0.XDFFQ.MB XD2.dq 1.8151e-17
* device instance cc_XD0_XDFFQ_MB_XD2_nm r0 *1 0,0
Ccc_XD0_XDFFQ_MB_XD2_nm XD0.XDFFQ.MB XD2.nm 1.21e-17
* device instance cc_XD0_XDFFQ_MB_XD2_nt r0 *1 0,0
Ccc_XD0_XDFFQ_MB_XD2_nt XD0.XDFFQ.MB XD2.nt 1.21e-17
* device instance cc_XD0_XDFFQ_MB_XD2_t1 r0 *1 0,0
Ccc_XD0_XDFFQ_MB_XD2_t1 XD0.XDFFQ.MB XD2.t1 1.21e-17
* device instance cc_XD0_XDFFQ_MB_XD3_XDFFM_CLKB r0 *1 0,0
Ccc_XD0_XDFFQ_MB_XD3_XDFFM_CLKB XD0.XDFFQ.MB XD3.XDFFM.CLKB 1.8151e-17
* device instance cc_XD0_XDFFQ_MB_XD3_XDFFM_M r0 *1 0,0
Ccc_XD0_XDFFQ_MB_XD3_XDFFM_M XD0.XDFFQ.MB XD3.XDFFM.M 2.4201e-17
* device instance cc_XD0_XDFFQ_MB_XD3_XDFFM_MB r0 *1 0,0
Ccc_XD0_XDFFQ_MB_XD3_XDFFM_MB XD0.XDFFQ.MB XD3.XDFFM.MB 1.21e-17
* device instance cc_XD0_XDFFQ_MB_XD3_XDFFM_S r0 *1 0,0
Ccc_XD0_XDFFQ_MB_XD3_XDFFM_S XD0.XDFFQ.MB XD3.XDFFM.S 1.8151e-17
* device instance cc_XD0_XDFFQ_MB_XD3_XDFFM_SB r0 *1 0,0
Ccc_XD0_XDFFQ_MB_XD3_XDFFM_SB XD0.XDFFQ.MB XD3.XDFFM.SB 1.8151e-17
* device instance cc_XD0_XDFFQ_MB_XD3_XDFFQ_CLKB r0 *1 0,0
Ccc_XD0_XDFFQ_MB_XD3_XDFFQ_CLKB XD0.XDFFQ.MB XD3.XDFFQ.CLKB 1.8151e-17
* device instance cc_XD0_XDFFQ_MB_XD3_XDFFQ_M r0 *1 0,0
Ccc_XD0_XDFFQ_MB_XD3_XDFFQ_M XD0.XDFFQ.MB XD3.XDFFQ.M 2.4201e-17
* device instance cc_XD0_XDFFQ_MB_XD3_XDFFQ_MB r0 *1 0,0
Ccc_XD0_XDFFQ_MB_XD3_XDFFQ_MB XD0.XDFFQ.MB XD3.XDFFQ.MB 1.21e-17
* device instance cc_XD0_XDFFQ_MB_XD3_XDFFQ_S r0 *1 0,0
Ccc_XD0_XDFFQ_MB_XD3_XDFFQ_S XD0.XDFFQ.MB XD3.XDFFQ.S 1.8151e-17
* device instance cc_XD0_XDFFQ_MB_XD3_XDFFQ_SB r0 *1 0,0
Ccc_XD0_XDFFQ_MB_XD3_XDFFQ_SB XD0.XDFFQ.MB XD3.XDFFQ.SB 1.8151e-17
* device instance cc_XD0_XDFFQ_MB_XD3_XN2_mid1 r0 *1 0,0
Ccc_XD0_XDFFQ_MB_XD3_XN2_mid1 XD0.XDFFQ.MB XD3.XN2.mid1 1.21e-17
* device instance cc_XD0_XDFFQ_MB_XD3_XN3_mid1 r0 *1 0,0
Ccc_XD0_XDFFQ_MB_XD3_XN3_mid1 XD0.XDFFQ.MB XD3.XN3.mid1 1.21e-17
* device instance cc_XD0_XDFFQ_MB_XD3_XN3_mid2 r0 *1 0,0
Ccc_XD0_XDFFQ_MB_XD3_XN3_mid2 XD0.XDFFQ.MB XD3.XN3.mid2 1.21e-17
* device instance cc_XD0_XDFFQ_MB_XD3_dmodout r0 *1 0,0
Ccc_XD0_XDFFQ_MB_XD3_dmodout XD0.XDFFQ.MB XD3.dmodout 1.21e-17
* device instance cc_XD0_XDFFQ_MB_XD3_dq r0 *1 0,0
Ccc_XD0_XDFFQ_MB_XD3_dq XD0.XDFFQ.MB XD3.dq 1.8151e-17
* device instance cc_XD0_XDFFQ_MB_XD3_nm r0 *1 0,0
Ccc_XD0_XDFFQ_MB_XD3_nm XD0.XDFFQ.MB XD3.nm 1.21e-17
* device instance cc_XD0_XDFFQ_MB_XD3_nt r0 *1 0,0
Ccc_XD0_XDFFQ_MB_XD3_nt XD0.XDFFQ.MB XD3.nt 1.21e-17
* device instance cc_XD0_XDFFQ_MB_XD3_t1 r0 *1 0,0
Ccc_XD0_XDFFQ_MB_XD3_t1 XD0.XDFFQ.MB XD3.t1 1.21e-17
* device instance cc_XD0_XDFFQ_MB_XD4_XDFFM_CLKB r0 *1 0,0
Ccc_XD0_XDFFQ_MB_XD4_XDFFM_CLKB XD0.XDFFQ.MB XD4.XDFFM.CLKB 1.8151e-17
* device instance cc_XD0_XDFFQ_MB_XD4_XDFFM_M r0 *1 0,0
Ccc_XD0_XDFFQ_MB_XD4_XDFFM_M XD0.XDFFQ.MB XD4.XDFFM.M 2.4201e-17
* device instance cc_XD0_XDFFQ_MB_XD4_XDFFM_MB r0 *1 0,0
Ccc_XD0_XDFFQ_MB_XD4_XDFFM_MB XD0.XDFFQ.MB XD4.XDFFM.MB 1.21e-17
* device instance cc_XD0_XDFFQ_MB_XD4_XDFFM_S r0 *1 0,0
Ccc_XD0_XDFFQ_MB_XD4_XDFFM_S XD0.XDFFQ.MB XD4.XDFFM.S 1.8151e-17
* device instance cc_XD0_XDFFQ_MB_XD4_XDFFM_SB r0 *1 0,0
Ccc_XD0_XDFFQ_MB_XD4_XDFFM_SB XD0.XDFFQ.MB XD4.XDFFM.SB 1.8151e-17
* device instance cc_XD0_XDFFQ_MB_XD4_XDFFQ_CLKB r0 *1 0,0
Ccc_XD0_XDFFQ_MB_XD4_XDFFQ_CLKB XD0.XDFFQ.MB XD4.XDFFQ.CLKB 1.8151e-17
* device instance cc_XD0_XDFFQ_MB_XD4_XDFFQ_M r0 *1 0,0
Ccc_XD0_XDFFQ_MB_XD4_XDFFQ_M XD0.XDFFQ.MB XD4.XDFFQ.M 2.4201e-17
* device instance cc_XD0_XDFFQ_MB_XD4_XDFFQ_MB r0 *1 0,0
Ccc_XD0_XDFFQ_MB_XD4_XDFFQ_MB XD0.XDFFQ.MB XD4.XDFFQ.MB 1.21e-17
* device instance cc_XD0_XDFFQ_MB_XD4_XDFFQ_S r0 *1 0,0
Ccc_XD0_XDFFQ_MB_XD4_XDFFQ_S XD0.XDFFQ.MB XD4.XDFFQ.S 1.8151e-17
* device instance cc_XD0_XDFFQ_MB_XD4_XDFFQ_SB r0 *1 0,0
Ccc_XD0_XDFFQ_MB_XD4_XDFFQ_SB XD0.XDFFQ.MB XD4.XDFFQ.SB 1.8151e-17
* device instance cc_XD0_XDFFQ_MB_XD4_XN2_mid1 r0 *1 0,0
Ccc_XD0_XDFFQ_MB_XD4_XN2_mid1 XD0.XDFFQ.MB XD4.XN2.mid1 1.21e-17
* device instance cc_XD0_XDFFQ_MB_XD4_XN3_mid1 r0 *1 0,0
Ccc_XD0_XDFFQ_MB_XD4_XN3_mid1 XD0.XDFFQ.MB XD4.XN3.mid1 1.21e-17
* device instance cc_XD0_XDFFQ_MB_XD4_XN3_mid2 r0 *1 0,0
Ccc_XD0_XDFFQ_MB_XD4_XN3_mid2 XD0.XDFFQ.MB XD4.XN3.mid2 1.21e-17
* device instance cc_XD0_XDFFQ_MB_XD4_dmodout r0 *1 0,0
Ccc_XD0_XDFFQ_MB_XD4_dmodout XD0.XDFFQ.MB XD4.dmodout 1.21e-17
* device instance cc_XD0_XDFFQ_MB_XD4_dq r0 *1 0,0
Ccc_XD0_XDFFQ_MB_XD4_dq XD0.XDFFQ.MB XD4.dq 1.8151e-17
* device instance cc_XD0_XDFFQ_MB_XD4_nm r0 *1 0,0
Ccc_XD0_XDFFQ_MB_XD4_nm XD0.XDFFQ.MB XD4.nm 1.21e-17
* device instance cc_XD0_XDFFQ_MB_XD4_nt r0 *1 0,0
Ccc_XD0_XDFFQ_MB_XD4_nt XD0.XDFFQ.MB XD4.nt 1.21e-17
* device instance cc_XD0_XDFFQ_MB_XD4_t1 r0 *1 0,0
Ccc_XD0_XDFFQ_MB_XD4_t1 XD0.XDFFQ.MB XD4.t1 1.21e-17
* device instance cc_XD0_XDFFQ_MB_XD5_XDFFM_CLKB r0 *1 0,0
Ccc_XD0_XDFFQ_MB_XD5_XDFFM_CLKB XD0.XDFFQ.MB XD5.XDFFM.CLKB 1.8151e-17
* device instance cc_XD0_XDFFQ_MB_XD5_XDFFM_M r0 *1 0,0
Ccc_XD0_XDFFQ_MB_XD5_XDFFM_M XD0.XDFFQ.MB XD5.XDFFM.M 2.4201e-17
* device instance cc_XD0_XDFFQ_MB_XD5_XDFFM_MB r0 *1 0,0
Ccc_XD0_XDFFQ_MB_XD5_XDFFM_MB XD0.XDFFQ.MB XD5.XDFFM.MB 1.21e-17
* device instance cc_XD0_XDFFQ_MB_XD5_XDFFM_S r0 *1 0,0
Ccc_XD0_XDFFQ_MB_XD5_XDFFM_S XD0.XDFFQ.MB XD5.XDFFM.S 1.8151e-17
* device instance cc_XD0_XDFFQ_MB_XD5_XDFFM_SB r0 *1 0,0
Ccc_XD0_XDFFQ_MB_XD5_XDFFM_SB XD0.XDFFQ.MB XD5.XDFFM.SB 1.8151e-17
* device instance cc_XD0_XDFFQ_MB_XD5_XDFFQ_CLKB r0 *1 0,0
Ccc_XD0_XDFFQ_MB_XD5_XDFFQ_CLKB XD0.XDFFQ.MB XD5.XDFFQ.CLKB 1.8151e-17
* device instance cc_XD0_XDFFQ_MB_XD5_XDFFQ_M r0 *1 0,0
Ccc_XD0_XDFFQ_MB_XD5_XDFFQ_M XD0.XDFFQ.MB XD5.XDFFQ.M 2.4201e-17
* device instance cc_XD0_XDFFQ_MB_XD5_XDFFQ_MB r0 *1 0,0
Ccc_XD0_XDFFQ_MB_XD5_XDFFQ_MB XD0.XDFFQ.MB XD5.XDFFQ.MB 1.21e-17
* device instance cc_XD0_XDFFQ_MB_XD5_XDFFQ_S r0 *1 0,0
Ccc_XD0_XDFFQ_MB_XD5_XDFFQ_S XD0.XDFFQ.MB XD5.XDFFQ.S 1.8151e-17
* device instance cc_XD0_XDFFQ_MB_XD5_XDFFQ_SB r0 *1 0,0
Ccc_XD0_XDFFQ_MB_XD5_XDFFQ_SB XD0.XDFFQ.MB XD5.XDFFQ.SB 1.8151e-17
* device instance cc_XD0_XDFFQ_MB_XD5_XN2_mid1 r0 *1 0,0
Ccc_XD0_XDFFQ_MB_XD5_XN2_mid1 XD0.XDFFQ.MB XD5.XN2.mid1 1.21e-17
* device instance cc_XD0_XDFFQ_MB_XD5_XN3_mid1 r0 *1 0,0
Ccc_XD0_XDFFQ_MB_XD5_XN3_mid1 XD0.XDFFQ.MB XD5.XN3.mid1 1.21e-17
* device instance cc_XD0_XDFFQ_MB_XD5_XN3_mid2 r0 *1 0,0
Ccc_XD0_XDFFQ_MB_XD5_XN3_mid2 XD0.XDFFQ.MB XD5.XN3.mid2 1.21e-17
* device instance cc_XD0_XDFFQ_MB_XD5_dmodout r0 *1 0,0
Ccc_XD0_XDFFQ_MB_XD5_dmodout XD0.XDFFQ.MB XD5.dmodout 1.21e-17
* device instance cc_XD0_XDFFQ_MB_XD5_dq r0 *1 0,0
Ccc_XD0_XDFFQ_MB_XD5_dq XD0.XDFFQ.MB XD5.dq 1.8151e-17
* device instance cc_XD0_XDFFQ_MB_XD5_nm r0 *1 0,0
Ccc_XD0_XDFFQ_MB_XD5_nm XD0.XDFFQ.MB XD5.nm 1.21e-17
* device instance cc_XD0_XDFFQ_MB_XD5_nt r0 *1 0,0
Ccc_XD0_XDFFQ_MB_XD5_nt XD0.XDFFQ.MB XD5.nt 1.21e-17
* device instance cc_XD0_XDFFQ_MB_XD5_t1 r0 *1 0,0
Ccc_XD0_XDFFQ_MB_XD5_t1 XD0.XDFFQ.MB XD5.t1 1.21e-17
* device instance cc_XD0_XDFFQ_MB_XFRT_CLKB r0 *1 0,0
Ccc_XD0_XDFFQ_MB_XFRT_CLKB XD0.XDFFQ.MB XFRT.CLKB 1.8151e-17
* device instance cc_XD0_XDFFQ_MB_XFRT_M r0 *1 0,0
Ccc_XD0_XDFFQ_MB_XFRT_M XD0.XDFFQ.MB XFRT.M 2.4201e-17
* device instance cc_XD0_XDFFQ_MB_XFRT_MB r0 *1 0,0
Ccc_XD0_XDFFQ_MB_XFRT_MB XD0.XDFFQ.MB XFRT.MB 1.21e-17
* device instance cc_XD0_XDFFQ_MB_XFRT_S r0 *1 0,0
Ccc_XD0_XDFFQ_MB_XFRT_S XD0.XDFFQ.MB XFRT.S 1.8151e-17
* device instance cc_XD0_XDFFQ_MB_XFRT_SB r0 *1 0,0
Ccc_XD0_XDFFQ_MB_XFRT_SB XD0.XDFFQ.MB XFRT.SB 1.8151e-17
* device instance cc_XD0_XDFFQ_MB_ck1 r0 *1 0,0
Ccc_XD0_XDFFQ_MB_ck1 XD0.XDFFQ.MB ck1 5.4452e-17
* device instance cc_XD0_XDFFQ_MB_ck2 r0 *1 0,0
Ccc_XD0_XDFFQ_MB_ck2 XD0.XDFFQ.MB ck2 5.4452e-17
* device instance cc_XD0_XDFFQ_MB_ck3 r0 *1 0,0
Ccc_XD0_XDFFQ_MB_ck3 XD0.XDFFQ.MB ck3 5.4452e-17
* device instance cc_XD0_XDFFQ_MB_ck4 r0 *1 0,0
Ccc_XD0_XDFFQ_MB_ck4 XD0.XDFFQ.MB ck4 5.4452e-17
* device instance cc_XD0_XDFFQ_MB_ck5 r0 *1 0,0
Ccc_XD0_XDFFQ_MB_ck5 XD0.XDFFQ.MB ck5 5.4452e-17
* device instance cc_XD0_XDFFQ_MB_mod0 r0 *1 0,0
Ccc_XD0_XDFFQ_MB_mod0 XD0.XDFFQ.MB mod0 2.4201e-17
* device instance cc_XD0_XDFFQ_MB_mod1 r0 *1 0,0
Ccc_XD0_XDFFQ_MB_mod1 XD0.XDFFQ.MB mod1 2.4201e-17
* device instance cc_XD0_XDFFQ_MB_mod2 r0 *1 0,0
Ccc_XD0_XDFFQ_MB_mod2 XD0.XDFFQ.MB mod2 2.4201e-17
* device instance cc_XD0_XDFFQ_MB_mod3 r0 *1 0,0
Ccc_XD0_XDFFQ_MB_mod3 XD0.XDFFQ.MB mod3 2.4201e-17
* device instance cc_XD0_XDFFQ_MB_mod4 r0 *1 0,0
Ccc_XD0_XDFFQ_MB_mod4 XD0.XDFFQ.MB mod4 2.4201e-17
* device instance cc_XD0_XDFFQ_MB_net1 r0 *1 0,0
Ccc_XD0_XDFFQ_MB_net1 XD0.XDFFQ.MB net1 1.21e-17
* device instance cc_XD0_XDFFQ_S_XD0_XDFFQ_SB r0 *1 0,0
Ccc_XD0_XDFFQ_S_XD0_XDFFQ_SB XD0.XDFFQ.S XD0.XDFFQ.SB 4.0738e-17
* device instance cc_XD0_XDFFQ_S_XD0_XN2_mid1 r0 *1 0,0
Ccc_XD0_XDFFQ_S_XD0_XN2_mid1 XD0.XDFFQ.S XD0.XN2.mid1 1.21e-17
* device instance cc_XD0_XDFFQ_S_XD0_XNOR_midp r0 *1 0,0
Ccc_XD0_XDFFQ_S_XD0_XNOR_midp XD0.XDFFQ.S XD0.XNOR.midp 1.21e-17
* device instance cc_XD0_XDFFQ_S_XD0_dmodout r0 *1 0,0
Ccc_XD0_XDFFQ_S_XD0_dmodout XD0.XDFFQ.S XD0.dmodout 1.21e-17
* device instance cc_XD0_XDFFQ_S_XD0_dq r0 *1 0,0
Ccc_XD0_XDFFQ_S_XD0_dq XD0.XDFFQ.S XD0.dq 1.21e-17
* device instance cc_XD0_XDFFQ_S_XD0_nm r0 *1 0,0
Ccc_XD0_XDFFQ_S_XD0_nm XD0.XDFFQ.S XD0.nm 1.21e-17
* device instance cc_XD0_XDFFQ_S_XD0_nt r0 *1 0,0
Ccc_XD0_XDFFQ_S_XD0_nt XD0.XDFFQ.S XD0.nt 2.4201e-17
* device instance cc_XD0_XDFFQ_S_XD0_t1 r0 *1 0,0
Ccc_XD0_XDFFQ_S_XD0_t1 XD0.XDFFQ.S XD0.t1 1.21e-17
* device instance cc_XD0_XDFFQ_S_XD1_XDFFM_CLKB r0 *1 0,0
Ccc_XD0_XDFFQ_S_XD1_XDFFM_CLKB XD0.XDFFQ.S XD1.XDFFM.CLKB 1.8151e-17
* device instance cc_XD0_XDFFQ_S_XD1_XDFFM_M r0 *1 0,0
Ccc_XD0_XDFFQ_S_XD1_XDFFM_M XD0.XDFFQ.S XD1.XDFFM.M 2.4201e-17
* device instance cc_XD0_XDFFQ_S_XD1_XDFFM_MB r0 *1 0,0
Ccc_XD0_XDFFQ_S_XD1_XDFFM_MB XD0.XDFFQ.S XD1.XDFFM.MB 1.21e-17
* device instance cc_XD0_XDFFQ_S_XD1_XDFFM_S r0 *1 0,0
Ccc_XD0_XDFFQ_S_XD1_XDFFM_S XD0.XDFFQ.S XD1.XDFFM.S 1.8151e-17
* device instance cc_XD0_XDFFQ_S_XD1_XDFFM_SB r0 *1 0,0
Ccc_XD0_XDFFQ_S_XD1_XDFFM_SB XD0.XDFFQ.S XD1.XDFFM.SB 1.8151e-17
* device instance cc_XD0_XDFFQ_S_XD1_XDFFQ_CLKB r0 *1 0,0
Ccc_XD0_XDFFQ_S_XD1_XDFFQ_CLKB XD0.XDFFQ.S XD1.XDFFQ.CLKB 1.8151e-17
* device instance cc_XD0_XDFFQ_S_XD1_XDFFQ_M r0 *1 0,0
Ccc_XD0_XDFFQ_S_XD1_XDFFQ_M XD0.XDFFQ.S XD1.XDFFQ.M 2.4201e-17
* device instance cc_XD0_XDFFQ_S_XD1_XDFFQ_MB r0 *1 0,0
Ccc_XD0_XDFFQ_S_XD1_XDFFQ_MB XD0.XDFFQ.S XD1.XDFFQ.MB 1.21e-17
* device instance cc_XD0_XDFFQ_S_XD1_XDFFQ_S r0 *1 0,0
Ccc_XD0_XDFFQ_S_XD1_XDFFQ_S XD0.XDFFQ.S XD1.XDFFQ.S 1.8151e-17
* device instance cc_XD0_XDFFQ_S_XD1_XDFFQ_SB r0 *1 0,0
Ccc_XD0_XDFFQ_S_XD1_XDFFQ_SB XD0.XDFFQ.S XD1.XDFFQ.SB 1.8151e-17
* device instance cc_XD0_XDFFQ_S_XD1_XN2_mid1 r0 *1 0,0
Ccc_XD0_XDFFQ_S_XD1_XN2_mid1 XD0.XDFFQ.S XD1.XN2.mid1 1.21e-17
* device instance cc_XD0_XDFFQ_S_XD1_XN3_mid1 r0 *1 0,0
Ccc_XD0_XDFFQ_S_XD1_XN3_mid1 XD0.XDFFQ.S XD1.XN3.mid1 1.21e-17
* device instance cc_XD0_XDFFQ_S_XD1_XN3_mid2 r0 *1 0,0
Ccc_XD0_XDFFQ_S_XD1_XN3_mid2 XD0.XDFFQ.S XD1.XN3.mid2 1.21e-17
* device instance cc_XD0_XDFFQ_S_XD1_dmodout r0 *1 0,0
Ccc_XD0_XDFFQ_S_XD1_dmodout XD0.XDFFQ.S XD1.dmodout 1.21e-17
* device instance cc_XD0_XDFFQ_S_XD1_dq r0 *1 0,0
Ccc_XD0_XDFFQ_S_XD1_dq XD0.XDFFQ.S XD1.dq 1.8151e-17
* device instance cc_XD0_XDFFQ_S_XD1_nm r0 *1 0,0
Ccc_XD0_XDFFQ_S_XD1_nm XD0.XDFFQ.S XD1.nm 1.21e-17
* device instance cc_XD0_XDFFQ_S_XD1_nt r0 *1 0,0
Ccc_XD0_XDFFQ_S_XD1_nt XD0.XDFFQ.S XD1.nt 1.21e-17
* device instance cc_XD0_XDFFQ_S_XD1_t1 r0 *1 0,0
Ccc_XD0_XDFFQ_S_XD1_t1 XD0.XDFFQ.S XD1.t1 1.21e-17
* device instance cc_XD0_XDFFQ_S_XD2_XDFFM_CLKB r0 *1 0,0
Ccc_XD0_XDFFQ_S_XD2_XDFFM_CLKB XD0.XDFFQ.S XD2.XDFFM.CLKB 1.8151e-17
* device instance cc_XD0_XDFFQ_S_XD2_XDFFM_M r0 *1 0,0
Ccc_XD0_XDFFQ_S_XD2_XDFFM_M XD0.XDFFQ.S XD2.XDFFM.M 2.4201e-17
* device instance cc_XD0_XDFFQ_S_XD2_XDFFM_MB r0 *1 0,0
Ccc_XD0_XDFFQ_S_XD2_XDFFM_MB XD0.XDFFQ.S XD2.XDFFM.MB 1.21e-17
* device instance cc_XD0_XDFFQ_S_XD2_XDFFM_S r0 *1 0,0
Ccc_XD0_XDFFQ_S_XD2_XDFFM_S XD0.XDFFQ.S XD2.XDFFM.S 1.8151e-17
* device instance cc_XD0_XDFFQ_S_XD2_XDFFM_SB r0 *1 0,0
Ccc_XD0_XDFFQ_S_XD2_XDFFM_SB XD0.XDFFQ.S XD2.XDFFM.SB 1.8151e-17
* device instance cc_XD0_XDFFQ_S_XD2_XDFFQ_CLKB r0 *1 0,0
Ccc_XD0_XDFFQ_S_XD2_XDFFQ_CLKB XD0.XDFFQ.S XD2.XDFFQ.CLKB 1.8151e-17
* device instance cc_XD0_XDFFQ_S_XD2_XDFFQ_M r0 *1 0,0
Ccc_XD0_XDFFQ_S_XD2_XDFFQ_M XD0.XDFFQ.S XD2.XDFFQ.M 2.4201e-17
* device instance cc_XD0_XDFFQ_S_XD2_XDFFQ_MB r0 *1 0,0
Ccc_XD0_XDFFQ_S_XD2_XDFFQ_MB XD0.XDFFQ.S XD2.XDFFQ.MB 1.21e-17
* device instance cc_XD0_XDFFQ_S_XD2_XDFFQ_S r0 *1 0,0
Ccc_XD0_XDFFQ_S_XD2_XDFFQ_S XD0.XDFFQ.S XD2.XDFFQ.S 1.8151e-17
* device instance cc_XD0_XDFFQ_S_XD2_XDFFQ_SB r0 *1 0,0
Ccc_XD0_XDFFQ_S_XD2_XDFFQ_SB XD0.XDFFQ.S XD2.XDFFQ.SB 1.8151e-17
* device instance cc_XD0_XDFFQ_S_XD2_XN2_mid1 r0 *1 0,0
Ccc_XD0_XDFFQ_S_XD2_XN2_mid1 XD0.XDFFQ.S XD2.XN2.mid1 1.21e-17
* device instance cc_XD0_XDFFQ_S_XD2_XN3_mid1 r0 *1 0,0
Ccc_XD0_XDFFQ_S_XD2_XN3_mid1 XD0.XDFFQ.S XD2.XN3.mid1 1.21e-17
* device instance cc_XD0_XDFFQ_S_XD2_XN3_mid2 r0 *1 0,0
Ccc_XD0_XDFFQ_S_XD2_XN3_mid2 XD0.XDFFQ.S XD2.XN3.mid2 1.21e-17
* device instance cc_XD0_XDFFQ_S_XD2_dmodout r0 *1 0,0
Ccc_XD0_XDFFQ_S_XD2_dmodout XD0.XDFFQ.S XD2.dmodout 1.21e-17
* device instance cc_XD0_XDFFQ_S_XD2_dq r0 *1 0,0
Ccc_XD0_XDFFQ_S_XD2_dq XD0.XDFFQ.S XD2.dq 1.8151e-17
* device instance cc_XD0_XDFFQ_S_XD2_nm r0 *1 0,0
Ccc_XD0_XDFFQ_S_XD2_nm XD0.XDFFQ.S XD2.nm 1.21e-17
* device instance cc_XD0_XDFFQ_S_XD2_nt r0 *1 0,0
Ccc_XD0_XDFFQ_S_XD2_nt XD0.XDFFQ.S XD2.nt 1.21e-17
* device instance cc_XD0_XDFFQ_S_XD2_t1 r0 *1 0,0
Ccc_XD0_XDFFQ_S_XD2_t1 XD0.XDFFQ.S XD2.t1 1.21e-17
* device instance cc_XD0_XDFFQ_S_XD3_XDFFM_CLKB r0 *1 0,0
Ccc_XD0_XDFFQ_S_XD3_XDFFM_CLKB XD0.XDFFQ.S XD3.XDFFM.CLKB 1.8151e-17
* device instance cc_XD0_XDFFQ_S_XD3_XDFFM_M r0 *1 0,0
Ccc_XD0_XDFFQ_S_XD3_XDFFM_M XD0.XDFFQ.S XD3.XDFFM.M 2.4201e-17
* device instance cc_XD0_XDFFQ_S_XD3_XDFFM_MB r0 *1 0,0
Ccc_XD0_XDFFQ_S_XD3_XDFFM_MB XD0.XDFFQ.S XD3.XDFFM.MB 1.21e-17
* device instance cc_XD0_XDFFQ_S_XD3_XDFFM_S r0 *1 0,0
Ccc_XD0_XDFFQ_S_XD3_XDFFM_S XD0.XDFFQ.S XD3.XDFFM.S 1.8151e-17
* device instance cc_XD0_XDFFQ_S_XD3_XDFFM_SB r0 *1 0,0
Ccc_XD0_XDFFQ_S_XD3_XDFFM_SB XD0.XDFFQ.S XD3.XDFFM.SB 1.8151e-17
* device instance cc_XD0_XDFFQ_S_XD3_XDFFQ_CLKB r0 *1 0,0
Ccc_XD0_XDFFQ_S_XD3_XDFFQ_CLKB XD0.XDFFQ.S XD3.XDFFQ.CLKB 1.8151e-17
* device instance cc_XD0_XDFFQ_S_XD3_XDFFQ_M r0 *1 0,0
Ccc_XD0_XDFFQ_S_XD3_XDFFQ_M XD0.XDFFQ.S XD3.XDFFQ.M 2.4201e-17
* device instance cc_XD0_XDFFQ_S_XD3_XDFFQ_MB r0 *1 0,0
Ccc_XD0_XDFFQ_S_XD3_XDFFQ_MB XD0.XDFFQ.S XD3.XDFFQ.MB 1.21e-17
* device instance cc_XD0_XDFFQ_S_XD3_XDFFQ_S r0 *1 0,0
Ccc_XD0_XDFFQ_S_XD3_XDFFQ_S XD0.XDFFQ.S XD3.XDFFQ.S 1.8151e-17
* device instance cc_XD0_XDFFQ_S_XD3_XDFFQ_SB r0 *1 0,0
Ccc_XD0_XDFFQ_S_XD3_XDFFQ_SB XD0.XDFFQ.S XD3.XDFFQ.SB 1.8151e-17
* device instance cc_XD0_XDFFQ_S_XD3_XN2_mid1 r0 *1 0,0
Ccc_XD0_XDFFQ_S_XD3_XN2_mid1 XD0.XDFFQ.S XD3.XN2.mid1 1.21e-17
* device instance cc_XD0_XDFFQ_S_XD3_XN3_mid1 r0 *1 0,0
Ccc_XD0_XDFFQ_S_XD3_XN3_mid1 XD0.XDFFQ.S XD3.XN3.mid1 1.21e-17
* device instance cc_XD0_XDFFQ_S_XD3_XN3_mid2 r0 *1 0,0
Ccc_XD0_XDFFQ_S_XD3_XN3_mid2 XD0.XDFFQ.S XD3.XN3.mid2 1.21e-17
* device instance cc_XD0_XDFFQ_S_XD3_dmodout r0 *1 0,0
Ccc_XD0_XDFFQ_S_XD3_dmodout XD0.XDFFQ.S XD3.dmodout 1.21e-17
* device instance cc_XD0_XDFFQ_S_XD3_dq r0 *1 0,0
Ccc_XD0_XDFFQ_S_XD3_dq XD0.XDFFQ.S XD3.dq 1.8151e-17
* device instance cc_XD0_XDFFQ_S_XD3_nm r0 *1 0,0
Ccc_XD0_XDFFQ_S_XD3_nm XD0.XDFFQ.S XD3.nm 1.21e-17
* device instance cc_XD0_XDFFQ_S_XD3_nt r0 *1 0,0
Ccc_XD0_XDFFQ_S_XD3_nt XD0.XDFFQ.S XD3.nt 1.21e-17
* device instance cc_XD0_XDFFQ_S_XD3_t1 r0 *1 0,0
Ccc_XD0_XDFFQ_S_XD3_t1 XD0.XDFFQ.S XD3.t1 1.21e-17
* device instance cc_XD0_XDFFQ_S_XD4_XDFFM_CLKB r0 *1 0,0
Ccc_XD0_XDFFQ_S_XD4_XDFFM_CLKB XD0.XDFFQ.S XD4.XDFFM.CLKB 1.8151e-17
* device instance cc_XD0_XDFFQ_S_XD4_XDFFM_M r0 *1 0,0
Ccc_XD0_XDFFQ_S_XD4_XDFFM_M XD0.XDFFQ.S XD4.XDFFM.M 2.4201e-17
* device instance cc_XD0_XDFFQ_S_XD4_XDFFM_MB r0 *1 0,0
Ccc_XD0_XDFFQ_S_XD4_XDFFM_MB XD0.XDFFQ.S XD4.XDFFM.MB 1.21e-17
* device instance cc_XD0_XDFFQ_S_XD4_XDFFM_S r0 *1 0,0
Ccc_XD0_XDFFQ_S_XD4_XDFFM_S XD0.XDFFQ.S XD4.XDFFM.S 1.8151e-17
* device instance cc_XD0_XDFFQ_S_XD4_XDFFM_SB r0 *1 0,0
Ccc_XD0_XDFFQ_S_XD4_XDFFM_SB XD0.XDFFQ.S XD4.XDFFM.SB 1.8151e-17
* device instance cc_XD0_XDFFQ_S_XD4_XDFFQ_CLKB r0 *1 0,0
Ccc_XD0_XDFFQ_S_XD4_XDFFQ_CLKB XD0.XDFFQ.S XD4.XDFFQ.CLKB 1.8151e-17
* device instance cc_XD0_XDFFQ_S_XD4_XDFFQ_M r0 *1 0,0
Ccc_XD0_XDFFQ_S_XD4_XDFFQ_M XD0.XDFFQ.S XD4.XDFFQ.M 2.4201e-17
* device instance cc_XD0_XDFFQ_S_XD4_XDFFQ_MB r0 *1 0,0
Ccc_XD0_XDFFQ_S_XD4_XDFFQ_MB XD0.XDFFQ.S XD4.XDFFQ.MB 1.21e-17
* device instance cc_XD0_XDFFQ_S_XD4_XDFFQ_S r0 *1 0,0
Ccc_XD0_XDFFQ_S_XD4_XDFFQ_S XD0.XDFFQ.S XD4.XDFFQ.S 1.8151e-17
* device instance cc_XD0_XDFFQ_S_XD4_XDFFQ_SB r0 *1 0,0
Ccc_XD0_XDFFQ_S_XD4_XDFFQ_SB XD0.XDFFQ.S XD4.XDFFQ.SB 1.8151e-17
* device instance cc_XD0_XDFFQ_S_XD4_XN2_mid1 r0 *1 0,0
Ccc_XD0_XDFFQ_S_XD4_XN2_mid1 XD0.XDFFQ.S XD4.XN2.mid1 1.21e-17
* device instance cc_XD0_XDFFQ_S_XD4_XN3_mid1 r0 *1 0,0
Ccc_XD0_XDFFQ_S_XD4_XN3_mid1 XD0.XDFFQ.S XD4.XN3.mid1 1.21e-17
* device instance cc_XD0_XDFFQ_S_XD4_XN3_mid2 r0 *1 0,0
Ccc_XD0_XDFFQ_S_XD4_XN3_mid2 XD0.XDFFQ.S XD4.XN3.mid2 1.21e-17
* device instance cc_XD0_XDFFQ_S_XD4_dmodout r0 *1 0,0
Ccc_XD0_XDFFQ_S_XD4_dmodout XD0.XDFFQ.S XD4.dmodout 1.21e-17
* device instance cc_XD0_XDFFQ_S_XD4_dq r0 *1 0,0
Ccc_XD0_XDFFQ_S_XD4_dq XD0.XDFFQ.S XD4.dq 1.8151e-17
* device instance cc_XD0_XDFFQ_S_XD4_nm r0 *1 0,0
Ccc_XD0_XDFFQ_S_XD4_nm XD0.XDFFQ.S XD4.nm 1.21e-17
* device instance cc_XD0_XDFFQ_S_XD4_nt r0 *1 0,0
Ccc_XD0_XDFFQ_S_XD4_nt XD0.XDFFQ.S XD4.nt 1.21e-17
* device instance cc_XD0_XDFFQ_S_XD4_t1 r0 *1 0,0
Ccc_XD0_XDFFQ_S_XD4_t1 XD0.XDFFQ.S XD4.t1 1.21e-17
* device instance cc_XD0_XDFFQ_S_XD5_XDFFM_CLKB r0 *1 0,0
Ccc_XD0_XDFFQ_S_XD5_XDFFM_CLKB XD0.XDFFQ.S XD5.XDFFM.CLKB 1.8151e-17
* device instance cc_XD0_XDFFQ_S_XD5_XDFFM_M r0 *1 0,0
Ccc_XD0_XDFFQ_S_XD5_XDFFM_M XD0.XDFFQ.S XD5.XDFFM.M 2.4201e-17
* device instance cc_XD0_XDFFQ_S_XD5_XDFFM_MB r0 *1 0,0
Ccc_XD0_XDFFQ_S_XD5_XDFFM_MB XD0.XDFFQ.S XD5.XDFFM.MB 1.21e-17
* device instance cc_XD0_XDFFQ_S_XD5_XDFFM_S r0 *1 0,0
Ccc_XD0_XDFFQ_S_XD5_XDFFM_S XD0.XDFFQ.S XD5.XDFFM.S 1.8151e-17
* device instance cc_XD0_XDFFQ_S_XD5_XDFFM_SB r0 *1 0,0
Ccc_XD0_XDFFQ_S_XD5_XDFFM_SB XD0.XDFFQ.S XD5.XDFFM.SB 1.8151e-17
* device instance cc_XD0_XDFFQ_S_XD5_XDFFQ_CLKB r0 *1 0,0
Ccc_XD0_XDFFQ_S_XD5_XDFFQ_CLKB XD0.XDFFQ.S XD5.XDFFQ.CLKB 1.8151e-17
* device instance cc_XD0_XDFFQ_S_XD5_XDFFQ_M r0 *1 0,0
Ccc_XD0_XDFFQ_S_XD5_XDFFQ_M XD0.XDFFQ.S XD5.XDFFQ.M 2.4201e-17
* device instance cc_XD0_XDFFQ_S_XD5_XDFFQ_MB r0 *1 0,0
Ccc_XD0_XDFFQ_S_XD5_XDFFQ_MB XD0.XDFFQ.S XD5.XDFFQ.MB 1.21e-17
* device instance cc_XD0_XDFFQ_S_XD5_XDFFQ_S r0 *1 0,0
Ccc_XD0_XDFFQ_S_XD5_XDFFQ_S XD0.XDFFQ.S XD5.XDFFQ.S 1.8151e-17
* device instance cc_XD0_XDFFQ_S_XD5_XDFFQ_SB r0 *1 0,0
Ccc_XD0_XDFFQ_S_XD5_XDFFQ_SB XD0.XDFFQ.S XD5.XDFFQ.SB 1.8151e-17
* device instance cc_XD0_XDFFQ_S_XD5_XN2_mid1 r0 *1 0,0
Ccc_XD0_XDFFQ_S_XD5_XN2_mid1 XD0.XDFFQ.S XD5.XN2.mid1 1.21e-17
* device instance cc_XD0_XDFFQ_S_XD5_XN3_mid1 r0 *1 0,0
Ccc_XD0_XDFFQ_S_XD5_XN3_mid1 XD0.XDFFQ.S XD5.XN3.mid1 1.21e-17
* device instance cc_XD0_XDFFQ_S_XD5_XN3_mid2 r0 *1 0,0
Ccc_XD0_XDFFQ_S_XD5_XN3_mid2 XD0.XDFFQ.S XD5.XN3.mid2 1.21e-17
* device instance cc_XD0_XDFFQ_S_XD5_dmodout r0 *1 0,0
Ccc_XD0_XDFFQ_S_XD5_dmodout XD0.XDFFQ.S XD5.dmodout 1.21e-17
* device instance cc_XD0_XDFFQ_S_XD5_dq r0 *1 0,0
Ccc_XD0_XDFFQ_S_XD5_dq XD0.XDFFQ.S XD5.dq 1.8151e-17
* device instance cc_XD0_XDFFQ_S_XD5_nm r0 *1 0,0
Ccc_XD0_XDFFQ_S_XD5_nm XD0.XDFFQ.S XD5.nm 1.21e-17
* device instance cc_XD0_XDFFQ_S_XD5_nt r0 *1 0,0
Ccc_XD0_XDFFQ_S_XD5_nt XD0.XDFFQ.S XD5.nt 1.21e-17
* device instance cc_XD0_XDFFQ_S_XD5_t1 r0 *1 0,0
Ccc_XD0_XDFFQ_S_XD5_t1 XD0.XDFFQ.S XD5.t1 1.21e-17
* device instance cc_XD0_XDFFQ_S_XFRT_CLKB r0 *1 0,0
Ccc_XD0_XDFFQ_S_XFRT_CLKB XD0.XDFFQ.S XFRT.CLKB 1.8151e-17
* device instance cc_XD0_XDFFQ_S_XFRT_M r0 *1 0,0
Ccc_XD0_XDFFQ_S_XFRT_M XD0.XDFFQ.S XFRT.M 2.4201e-17
* device instance cc_XD0_XDFFQ_S_XFRT_MB r0 *1 0,0
Ccc_XD0_XDFFQ_S_XFRT_MB XD0.XDFFQ.S XFRT.MB 1.21e-17
* device instance cc_XD0_XDFFQ_S_XFRT_S r0 *1 0,0
Ccc_XD0_XDFFQ_S_XFRT_S XD0.XDFFQ.S XFRT.S 1.8151e-17
* device instance cc_XD0_XDFFQ_S_XFRT_SB r0 *1 0,0
Ccc_XD0_XDFFQ_S_XFRT_SB XD0.XDFFQ.S XFRT.SB 1.8151e-17
* device instance cc_XD0_XDFFQ_S_ck1 r0 *1 0,0
Ccc_XD0_XDFFQ_S_ck1 XD0.XDFFQ.S ck1 5.4452e-17
* device instance cc_XD0_XDFFQ_S_ck2 r0 *1 0,0
Ccc_XD0_XDFFQ_S_ck2 XD0.XDFFQ.S ck2 5.4452e-17
* device instance cc_XD0_XDFFQ_S_ck3 r0 *1 0,0
Ccc_XD0_XDFFQ_S_ck3 XD0.XDFFQ.S ck3 5.4452e-17
* device instance cc_XD0_XDFFQ_S_ck4 r0 *1 0,0
Ccc_XD0_XDFFQ_S_ck4 XD0.XDFFQ.S ck4 5.4452e-17
* device instance cc_XD0_XDFFQ_S_ck5 r0 *1 0,0
Ccc_XD0_XDFFQ_S_ck5 XD0.XDFFQ.S ck5 5.4452e-17
* device instance cc_XD0_XDFFQ_S_mod0 r0 *1 0,0
Ccc_XD0_XDFFQ_S_mod0 XD0.XDFFQ.S mod0 2.4201e-17
* device instance cc_XD0_XDFFQ_S_mod1 r0 *1 0,0
Ccc_XD0_XDFFQ_S_mod1 XD0.XDFFQ.S mod1 2.4201e-17
* device instance cc_XD0_XDFFQ_S_mod2 r0 *1 0,0
Ccc_XD0_XDFFQ_S_mod2 XD0.XDFFQ.S mod2 2.4201e-17
* device instance cc_XD0_XDFFQ_S_mod3 r0 *1 0,0
Ccc_XD0_XDFFQ_S_mod3 XD0.XDFFQ.S mod3 2.4201e-17
* device instance cc_XD0_XDFFQ_S_mod4 r0 *1 0,0
Ccc_XD0_XDFFQ_S_mod4 XD0.XDFFQ.S mod4 2.4201e-17
* device instance cc_XD0_XDFFQ_S_net1 r0 *1 0,0
Ccc_XD0_XDFFQ_S_net1 XD0.XDFFQ.S net1 1.21e-17
* device instance cc_XD0_XDFFQ_SB_XD0_XN2_mid1 r0 *1 0,0
Ccc_XD0_XDFFQ_SB_XD0_XN2_mid1 XD0.XDFFQ.SB XD0.XN2.mid1 1.21e-17
* device instance cc_XD0_XDFFQ_SB_XD0_XNOR_midp r0 *1 0,0
Ccc_XD0_XDFFQ_SB_XD0_XNOR_midp XD0.XDFFQ.SB XD0.XNOR.midp 1.21e-17
* device instance cc_XD0_XDFFQ_SB_XD0_dmodout r0 *1 0,0
Ccc_XD0_XDFFQ_SB_XD0_dmodout XD0.XDFFQ.SB XD0.dmodout 1.21e-17
* device instance cc_XD0_XDFFQ_SB_XD0_dq r0 *1 0,0
Ccc_XD0_XDFFQ_SB_XD0_dq XD0.XDFFQ.SB XD0.dq 1.21e-17
* device instance cc_XD0_XDFFQ_SB_XD0_nm r0 *1 0,0
Ccc_XD0_XDFFQ_SB_XD0_nm XD0.XDFFQ.SB XD0.nm 1.21e-17
* device instance cc_XD0_XDFFQ_SB_XD0_nt r0 *1 0,0
Ccc_XD0_XDFFQ_SB_XD0_nt XD0.XDFFQ.SB XD0.nt 2.4201e-17
* device instance cc_XD0_XDFFQ_SB_XD0_t1 r0 *1 0,0
Ccc_XD0_XDFFQ_SB_XD0_t1 XD0.XDFFQ.SB XD0.t1 1.21e-17
* device instance cc_XD0_XDFFQ_SB_XD1_XDFFM_CLKB r0 *1 0,0
Ccc_XD0_XDFFQ_SB_XD1_XDFFM_CLKB XD0.XDFFQ.SB XD1.XDFFM.CLKB 1.8151e-17
* device instance cc_XD0_XDFFQ_SB_XD1_XDFFM_M r0 *1 0,0
Ccc_XD0_XDFFQ_SB_XD1_XDFFM_M XD0.XDFFQ.SB XD1.XDFFM.M 2.4201e-17
* device instance cc_XD0_XDFFQ_SB_XD1_XDFFM_MB r0 *1 0,0
Ccc_XD0_XDFFQ_SB_XD1_XDFFM_MB XD0.XDFFQ.SB XD1.XDFFM.MB 1.21e-17
* device instance cc_XD0_XDFFQ_SB_XD1_XDFFM_S r0 *1 0,0
Ccc_XD0_XDFFQ_SB_XD1_XDFFM_S XD0.XDFFQ.SB XD1.XDFFM.S 1.8151e-17
* device instance cc_XD0_XDFFQ_SB_XD1_XDFFM_SB r0 *1 0,0
Ccc_XD0_XDFFQ_SB_XD1_XDFFM_SB XD0.XDFFQ.SB XD1.XDFFM.SB 1.8151e-17
* device instance cc_XD0_XDFFQ_SB_XD1_XDFFQ_CLKB r0 *1 0,0
Ccc_XD0_XDFFQ_SB_XD1_XDFFQ_CLKB XD0.XDFFQ.SB XD1.XDFFQ.CLKB 1.8151e-17
* device instance cc_XD0_XDFFQ_SB_XD1_XDFFQ_M r0 *1 0,0
Ccc_XD0_XDFFQ_SB_XD1_XDFFQ_M XD0.XDFFQ.SB XD1.XDFFQ.M 2.4201e-17
* device instance cc_XD0_XDFFQ_SB_XD1_XDFFQ_MB r0 *1 0,0
Ccc_XD0_XDFFQ_SB_XD1_XDFFQ_MB XD0.XDFFQ.SB XD1.XDFFQ.MB 1.21e-17
* device instance cc_XD0_XDFFQ_SB_XD1_XDFFQ_S r0 *1 0,0
Ccc_XD0_XDFFQ_SB_XD1_XDFFQ_S XD0.XDFFQ.SB XD1.XDFFQ.S 1.8151e-17
* device instance cc_XD0_XDFFQ_SB_XD1_XDFFQ_SB r0 *1 0,0
Ccc_XD0_XDFFQ_SB_XD1_XDFFQ_SB XD0.XDFFQ.SB XD1.XDFFQ.SB 1.8151e-17
* device instance cc_XD0_XDFFQ_SB_XD1_XN2_mid1 r0 *1 0,0
Ccc_XD0_XDFFQ_SB_XD1_XN2_mid1 XD0.XDFFQ.SB XD1.XN2.mid1 1.21e-17
* device instance cc_XD0_XDFFQ_SB_XD1_XN3_mid1 r0 *1 0,0
Ccc_XD0_XDFFQ_SB_XD1_XN3_mid1 XD0.XDFFQ.SB XD1.XN3.mid1 1.21e-17
* device instance cc_XD0_XDFFQ_SB_XD1_XN3_mid2 r0 *1 0,0
Ccc_XD0_XDFFQ_SB_XD1_XN3_mid2 XD0.XDFFQ.SB XD1.XN3.mid2 1.21e-17
* device instance cc_XD0_XDFFQ_SB_XD1_dmodout r0 *1 0,0
Ccc_XD0_XDFFQ_SB_XD1_dmodout XD0.XDFFQ.SB XD1.dmodout 1.21e-17
* device instance cc_XD0_XDFFQ_SB_XD1_dq r0 *1 0,0
Ccc_XD0_XDFFQ_SB_XD1_dq XD0.XDFFQ.SB XD1.dq 1.8151e-17
* device instance cc_XD0_XDFFQ_SB_XD1_nm r0 *1 0,0
Ccc_XD0_XDFFQ_SB_XD1_nm XD0.XDFFQ.SB XD1.nm 1.21e-17
* device instance cc_XD0_XDFFQ_SB_XD1_nt r0 *1 0,0
Ccc_XD0_XDFFQ_SB_XD1_nt XD0.XDFFQ.SB XD1.nt 1.21e-17
* device instance cc_XD0_XDFFQ_SB_XD1_t1 r0 *1 0,0
Ccc_XD0_XDFFQ_SB_XD1_t1 XD0.XDFFQ.SB XD1.t1 1.21e-17
* device instance cc_XD0_XDFFQ_SB_XD2_XDFFM_CLKB r0 *1 0,0
Ccc_XD0_XDFFQ_SB_XD2_XDFFM_CLKB XD0.XDFFQ.SB XD2.XDFFM.CLKB 1.8151e-17
* device instance cc_XD0_XDFFQ_SB_XD2_XDFFM_M r0 *1 0,0
Ccc_XD0_XDFFQ_SB_XD2_XDFFM_M XD0.XDFFQ.SB XD2.XDFFM.M 2.4201e-17
* device instance cc_XD0_XDFFQ_SB_XD2_XDFFM_MB r0 *1 0,0
Ccc_XD0_XDFFQ_SB_XD2_XDFFM_MB XD0.XDFFQ.SB XD2.XDFFM.MB 1.21e-17
* device instance cc_XD0_XDFFQ_SB_XD2_XDFFM_S r0 *1 0,0
Ccc_XD0_XDFFQ_SB_XD2_XDFFM_S XD0.XDFFQ.SB XD2.XDFFM.S 1.8151e-17
* device instance cc_XD0_XDFFQ_SB_XD2_XDFFM_SB r0 *1 0,0
Ccc_XD0_XDFFQ_SB_XD2_XDFFM_SB XD0.XDFFQ.SB XD2.XDFFM.SB 1.8151e-17
* device instance cc_XD0_XDFFQ_SB_XD2_XDFFQ_CLKB r0 *1 0,0
Ccc_XD0_XDFFQ_SB_XD2_XDFFQ_CLKB XD0.XDFFQ.SB XD2.XDFFQ.CLKB 1.8151e-17
* device instance cc_XD0_XDFFQ_SB_XD2_XDFFQ_M r0 *1 0,0
Ccc_XD0_XDFFQ_SB_XD2_XDFFQ_M XD0.XDFFQ.SB XD2.XDFFQ.M 2.4201e-17
* device instance cc_XD0_XDFFQ_SB_XD2_XDFFQ_MB r0 *1 0,0
Ccc_XD0_XDFFQ_SB_XD2_XDFFQ_MB XD0.XDFFQ.SB XD2.XDFFQ.MB 1.21e-17
* device instance cc_XD0_XDFFQ_SB_XD2_XDFFQ_S r0 *1 0,0
Ccc_XD0_XDFFQ_SB_XD2_XDFFQ_S XD0.XDFFQ.SB XD2.XDFFQ.S 1.8151e-17
* device instance cc_XD0_XDFFQ_SB_XD2_XDFFQ_SB r0 *1 0,0
Ccc_XD0_XDFFQ_SB_XD2_XDFFQ_SB XD0.XDFFQ.SB XD2.XDFFQ.SB 1.8151e-17
* device instance cc_XD0_XDFFQ_SB_XD2_XN2_mid1 r0 *1 0,0
Ccc_XD0_XDFFQ_SB_XD2_XN2_mid1 XD0.XDFFQ.SB XD2.XN2.mid1 1.21e-17
* device instance cc_XD0_XDFFQ_SB_XD2_XN3_mid1 r0 *1 0,0
Ccc_XD0_XDFFQ_SB_XD2_XN3_mid1 XD0.XDFFQ.SB XD2.XN3.mid1 1.21e-17
* device instance cc_XD0_XDFFQ_SB_XD2_XN3_mid2 r0 *1 0,0
Ccc_XD0_XDFFQ_SB_XD2_XN3_mid2 XD0.XDFFQ.SB XD2.XN3.mid2 1.21e-17
* device instance cc_XD0_XDFFQ_SB_XD2_dmodout r0 *1 0,0
Ccc_XD0_XDFFQ_SB_XD2_dmodout XD0.XDFFQ.SB XD2.dmodout 1.21e-17
* device instance cc_XD0_XDFFQ_SB_XD2_dq r0 *1 0,0
Ccc_XD0_XDFFQ_SB_XD2_dq XD0.XDFFQ.SB XD2.dq 1.8151e-17
* device instance cc_XD0_XDFFQ_SB_XD2_nm r0 *1 0,0
Ccc_XD0_XDFFQ_SB_XD2_nm XD0.XDFFQ.SB XD2.nm 1.21e-17
* device instance cc_XD0_XDFFQ_SB_XD2_nt r0 *1 0,0
Ccc_XD0_XDFFQ_SB_XD2_nt XD0.XDFFQ.SB XD2.nt 1.21e-17
* device instance cc_XD0_XDFFQ_SB_XD2_t1 r0 *1 0,0
Ccc_XD0_XDFFQ_SB_XD2_t1 XD0.XDFFQ.SB XD2.t1 1.21e-17
* device instance cc_XD0_XDFFQ_SB_XD3_XDFFM_CLKB r0 *1 0,0
Ccc_XD0_XDFFQ_SB_XD3_XDFFM_CLKB XD0.XDFFQ.SB XD3.XDFFM.CLKB 1.8151e-17
* device instance cc_XD0_XDFFQ_SB_XD3_XDFFM_M r0 *1 0,0
Ccc_XD0_XDFFQ_SB_XD3_XDFFM_M XD0.XDFFQ.SB XD3.XDFFM.M 2.4201e-17
* device instance cc_XD0_XDFFQ_SB_XD3_XDFFM_MB r0 *1 0,0
Ccc_XD0_XDFFQ_SB_XD3_XDFFM_MB XD0.XDFFQ.SB XD3.XDFFM.MB 1.21e-17
* device instance cc_XD0_XDFFQ_SB_XD3_XDFFM_S r0 *1 0,0
Ccc_XD0_XDFFQ_SB_XD3_XDFFM_S XD0.XDFFQ.SB XD3.XDFFM.S 1.8151e-17
* device instance cc_XD0_XDFFQ_SB_XD3_XDFFM_SB r0 *1 0,0
Ccc_XD0_XDFFQ_SB_XD3_XDFFM_SB XD0.XDFFQ.SB XD3.XDFFM.SB 1.8151e-17
* device instance cc_XD0_XDFFQ_SB_XD3_XDFFQ_CLKB r0 *1 0,0
Ccc_XD0_XDFFQ_SB_XD3_XDFFQ_CLKB XD0.XDFFQ.SB XD3.XDFFQ.CLKB 1.8151e-17
* device instance cc_XD0_XDFFQ_SB_XD3_XDFFQ_M r0 *1 0,0
Ccc_XD0_XDFFQ_SB_XD3_XDFFQ_M XD0.XDFFQ.SB XD3.XDFFQ.M 2.4201e-17
* device instance cc_XD0_XDFFQ_SB_XD3_XDFFQ_MB r0 *1 0,0
Ccc_XD0_XDFFQ_SB_XD3_XDFFQ_MB XD0.XDFFQ.SB XD3.XDFFQ.MB 1.21e-17
* device instance cc_XD0_XDFFQ_SB_XD3_XDFFQ_S r0 *1 0,0
Ccc_XD0_XDFFQ_SB_XD3_XDFFQ_S XD0.XDFFQ.SB XD3.XDFFQ.S 1.8151e-17
* device instance cc_XD0_XDFFQ_SB_XD3_XDFFQ_SB r0 *1 0,0
Ccc_XD0_XDFFQ_SB_XD3_XDFFQ_SB XD0.XDFFQ.SB XD3.XDFFQ.SB 1.8151e-17
* device instance cc_XD0_XDFFQ_SB_XD3_XN2_mid1 r0 *1 0,0
Ccc_XD0_XDFFQ_SB_XD3_XN2_mid1 XD0.XDFFQ.SB XD3.XN2.mid1 1.21e-17
* device instance cc_XD0_XDFFQ_SB_XD3_XN3_mid1 r0 *1 0,0
Ccc_XD0_XDFFQ_SB_XD3_XN3_mid1 XD0.XDFFQ.SB XD3.XN3.mid1 1.21e-17
* device instance cc_XD0_XDFFQ_SB_XD3_XN3_mid2 r0 *1 0,0
Ccc_XD0_XDFFQ_SB_XD3_XN3_mid2 XD0.XDFFQ.SB XD3.XN3.mid2 1.21e-17
* device instance cc_XD0_XDFFQ_SB_XD3_dmodout r0 *1 0,0
Ccc_XD0_XDFFQ_SB_XD3_dmodout XD0.XDFFQ.SB XD3.dmodout 1.21e-17
* device instance cc_XD0_XDFFQ_SB_XD3_dq r0 *1 0,0
Ccc_XD0_XDFFQ_SB_XD3_dq XD0.XDFFQ.SB XD3.dq 1.8151e-17
* device instance cc_XD0_XDFFQ_SB_XD3_nm r0 *1 0,0
Ccc_XD0_XDFFQ_SB_XD3_nm XD0.XDFFQ.SB XD3.nm 1.21e-17
* device instance cc_XD0_XDFFQ_SB_XD3_nt r0 *1 0,0
Ccc_XD0_XDFFQ_SB_XD3_nt XD0.XDFFQ.SB XD3.nt 1.21e-17
* device instance cc_XD0_XDFFQ_SB_XD3_t1 r0 *1 0,0
Ccc_XD0_XDFFQ_SB_XD3_t1 XD0.XDFFQ.SB XD3.t1 1.21e-17
* device instance cc_XD0_XDFFQ_SB_XD4_XDFFM_CLKB r0 *1 0,0
Ccc_XD0_XDFFQ_SB_XD4_XDFFM_CLKB XD0.XDFFQ.SB XD4.XDFFM.CLKB 1.8151e-17
* device instance cc_XD0_XDFFQ_SB_XD4_XDFFM_M r0 *1 0,0
Ccc_XD0_XDFFQ_SB_XD4_XDFFM_M XD0.XDFFQ.SB XD4.XDFFM.M 2.4201e-17
* device instance cc_XD0_XDFFQ_SB_XD4_XDFFM_MB r0 *1 0,0
Ccc_XD0_XDFFQ_SB_XD4_XDFFM_MB XD0.XDFFQ.SB XD4.XDFFM.MB 1.21e-17
* device instance cc_XD0_XDFFQ_SB_XD4_XDFFM_S r0 *1 0,0
Ccc_XD0_XDFFQ_SB_XD4_XDFFM_S XD0.XDFFQ.SB XD4.XDFFM.S 1.8151e-17
* device instance cc_XD0_XDFFQ_SB_XD4_XDFFM_SB r0 *1 0,0
Ccc_XD0_XDFFQ_SB_XD4_XDFFM_SB XD0.XDFFQ.SB XD4.XDFFM.SB 1.8151e-17
* device instance cc_XD0_XDFFQ_SB_XD4_XDFFQ_CLKB r0 *1 0,0
Ccc_XD0_XDFFQ_SB_XD4_XDFFQ_CLKB XD0.XDFFQ.SB XD4.XDFFQ.CLKB 1.8151e-17
* device instance cc_XD0_XDFFQ_SB_XD4_XDFFQ_M r0 *1 0,0
Ccc_XD0_XDFFQ_SB_XD4_XDFFQ_M XD0.XDFFQ.SB XD4.XDFFQ.M 2.4201e-17
* device instance cc_XD0_XDFFQ_SB_XD4_XDFFQ_MB r0 *1 0,0
Ccc_XD0_XDFFQ_SB_XD4_XDFFQ_MB XD0.XDFFQ.SB XD4.XDFFQ.MB 1.21e-17
* device instance cc_XD0_XDFFQ_SB_XD4_XDFFQ_S r0 *1 0,0
Ccc_XD0_XDFFQ_SB_XD4_XDFFQ_S XD0.XDFFQ.SB XD4.XDFFQ.S 1.8151e-17
* device instance cc_XD0_XDFFQ_SB_XD4_XDFFQ_SB r0 *1 0,0
Ccc_XD0_XDFFQ_SB_XD4_XDFFQ_SB XD0.XDFFQ.SB XD4.XDFFQ.SB 1.8151e-17
* device instance cc_XD0_XDFFQ_SB_XD4_XN2_mid1 r0 *1 0,0
Ccc_XD0_XDFFQ_SB_XD4_XN2_mid1 XD0.XDFFQ.SB XD4.XN2.mid1 1.21e-17
* device instance cc_XD0_XDFFQ_SB_XD4_XN3_mid1 r0 *1 0,0
Ccc_XD0_XDFFQ_SB_XD4_XN3_mid1 XD0.XDFFQ.SB XD4.XN3.mid1 1.21e-17
* device instance cc_XD0_XDFFQ_SB_XD4_XN3_mid2 r0 *1 0,0
Ccc_XD0_XDFFQ_SB_XD4_XN3_mid2 XD0.XDFFQ.SB XD4.XN3.mid2 1.21e-17
* device instance cc_XD0_XDFFQ_SB_XD4_dmodout r0 *1 0,0
Ccc_XD0_XDFFQ_SB_XD4_dmodout XD0.XDFFQ.SB XD4.dmodout 1.21e-17
* device instance cc_XD0_XDFFQ_SB_XD4_dq r0 *1 0,0
Ccc_XD0_XDFFQ_SB_XD4_dq XD0.XDFFQ.SB XD4.dq 1.8151e-17
* device instance cc_XD0_XDFFQ_SB_XD4_nm r0 *1 0,0
Ccc_XD0_XDFFQ_SB_XD4_nm XD0.XDFFQ.SB XD4.nm 1.21e-17
* device instance cc_XD0_XDFFQ_SB_XD4_nt r0 *1 0,0
Ccc_XD0_XDFFQ_SB_XD4_nt XD0.XDFFQ.SB XD4.nt 1.21e-17
* device instance cc_XD0_XDFFQ_SB_XD4_t1 r0 *1 0,0
Ccc_XD0_XDFFQ_SB_XD4_t1 XD0.XDFFQ.SB XD4.t1 1.21e-17
* device instance cc_XD0_XDFFQ_SB_XD5_XDFFM_CLKB r0 *1 0,0
Ccc_XD0_XDFFQ_SB_XD5_XDFFM_CLKB XD0.XDFFQ.SB XD5.XDFFM.CLKB 1.8151e-17
* device instance cc_XD0_XDFFQ_SB_XD5_XDFFM_M r0 *1 0,0
Ccc_XD0_XDFFQ_SB_XD5_XDFFM_M XD0.XDFFQ.SB XD5.XDFFM.M 2.4201e-17
* device instance cc_XD0_XDFFQ_SB_XD5_XDFFM_MB r0 *1 0,0
Ccc_XD0_XDFFQ_SB_XD5_XDFFM_MB XD0.XDFFQ.SB XD5.XDFFM.MB 1.21e-17
* device instance cc_XD0_XDFFQ_SB_XD5_XDFFM_S r0 *1 0,0
Ccc_XD0_XDFFQ_SB_XD5_XDFFM_S XD0.XDFFQ.SB XD5.XDFFM.S 1.8151e-17
* device instance cc_XD0_XDFFQ_SB_XD5_XDFFM_SB r0 *1 0,0
Ccc_XD0_XDFFQ_SB_XD5_XDFFM_SB XD0.XDFFQ.SB XD5.XDFFM.SB 1.8151e-17
* device instance cc_XD0_XDFFQ_SB_XD5_XDFFQ_CLKB r0 *1 0,0
Ccc_XD0_XDFFQ_SB_XD5_XDFFQ_CLKB XD0.XDFFQ.SB XD5.XDFFQ.CLKB 1.8151e-17
* device instance cc_XD0_XDFFQ_SB_XD5_XDFFQ_M r0 *1 0,0
Ccc_XD0_XDFFQ_SB_XD5_XDFFQ_M XD0.XDFFQ.SB XD5.XDFFQ.M 2.4201e-17
* device instance cc_XD0_XDFFQ_SB_XD5_XDFFQ_MB r0 *1 0,0
Ccc_XD0_XDFFQ_SB_XD5_XDFFQ_MB XD0.XDFFQ.SB XD5.XDFFQ.MB 1.21e-17
* device instance cc_XD0_XDFFQ_SB_XD5_XDFFQ_S r0 *1 0,0
Ccc_XD0_XDFFQ_SB_XD5_XDFFQ_S XD0.XDFFQ.SB XD5.XDFFQ.S 1.8151e-17
* device instance cc_XD0_XDFFQ_SB_XD5_XDFFQ_SB r0 *1 0,0
Ccc_XD0_XDFFQ_SB_XD5_XDFFQ_SB XD0.XDFFQ.SB XD5.XDFFQ.SB 1.8151e-17
* device instance cc_XD0_XDFFQ_SB_XD5_XN2_mid1 r0 *1 0,0
Ccc_XD0_XDFFQ_SB_XD5_XN2_mid1 XD0.XDFFQ.SB XD5.XN2.mid1 1.21e-17
* device instance cc_XD0_XDFFQ_SB_XD5_XN3_mid1 r0 *1 0,0
Ccc_XD0_XDFFQ_SB_XD5_XN3_mid1 XD0.XDFFQ.SB XD5.XN3.mid1 1.21e-17
* device instance cc_XD0_XDFFQ_SB_XD5_XN3_mid2 r0 *1 0,0
Ccc_XD0_XDFFQ_SB_XD5_XN3_mid2 XD0.XDFFQ.SB XD5.XN3.mid2 1.21e-17
* device instance cc_XD0_XDFFQ_SB_XD5_dmodout r0 *1 0,0
Ccc_XD0_XDFFQ_SB_XD5_dmodout XD0.XDFFQ.SB XD5.dmodout 1.21e-17
* device instance cc_XD0_XDFFQ_SB_XD5_dq r0 *1 0,0
Ccc_XD0_XDFFQ_SB_XD5_dq XD0.XDFFQ.SB XD5.dq 1.8151e-17
* device instance cc_XD0_XDFFQ_SB_XD5_nm r0 *1 0,0
Ccc_XD0_XDFFQ_SB_XD5_nm XD0.XDFFQ.SB XD5.nm 1.21e-17
* device instance cc_XD0_XDFFQ_SB_XD5_nt r0 *1 0,0
Ccc_XD0_XDFFQ_SB_XD5_nt XD0.XDFFQ.SB XD5.nt 1.21e-17
* device instance cc_XD0_XDFFQ_SB_XD5_t1 r0 *1 0,0
Ccc_XD0_XDFFQ_SB_XD5_t1 XD0.XDFFQ.SB XD5.t1 1.21e-17
* device instance cc_XD0_XDFFQ_SB_XFRT_CLKB r0 *1 0,0
Ccc_XD0_XDFFQ_SB_XFRT_CLKB XD0.XDFFQ.SB XFRT.CLKB 1.8151e-17
* device instance cc_XD0_XDFFQ_SB_XFRT_M r0 *1 0,0
Ccc_XD0_XDFFQ_SB_XFRT_M XD0.XDFFQ.SB XFRT.M 2.4201e-17
* device instance cc_XD0_XDFFQ_SB_XFRT_MB r0 *1 0,0
Ccc_XD0_XDFFQ_SB_XFRT_MB XD0.XDFFQ.SB XFRT.MB 1.21e-17
* device instance cc_XD0_XDFFQ_SB_XFRT_S r0 *1 0,0
Ccc_XD0_XDFFQ_SB_XFRT_S XD0.XDFFQ.SB XFRT.S 1.8151e-17
* device instance cc_XD0_XDFFQ_SB_XFRT_SB r0 *1 0,0
Ccc_XD0_XDFFQ_SB_XFRT_SB XD0.XDFFQ.SB XFRT.SB 1.8151e-17
* device instance cc_XD0_XDFFQ_SB_ck1 r0 *1 0,0
Ccc_XD0_XDFFQ_SB_ck1 XD0.XDFFQ.SB ck1 5.4452e-17
* device instance cc_XD0_XDFFQ_SB_ck2 r0 *1 0,0
Ccc_XD0_XDFFQ_SB_ck2 XD0.XDFFQ.SB ck2 5.4452e-17
* device instance cc_XD0_XDFFQ_SB_ck3 r0 *1 0,0
Ccc_XD0_XDFFQ_SB_ck3 XD0.XDFFQ.SB ck3 5.4452e-17
* device instance cc_XD0_XDFFQ_SB_ck4 r0 *1 0,0
Ccc_XD0_XDFFQ_SB_ck4 XD0.XDFFQ.SB ck4 5.4452e-17
* device instance cc_XD0_XDFFQ_SB_ck5 r0 *1 0,0
Ccc_XD0_XDFFQ_SB_ck5 XD0.XDFFQ.SB ck5 5.4452e-17
* device instance cc_XD0_XDFFQ_SB_mod0 r0 *1 0,0
Ccc_XD0_XDFFQ_SB_mod0 XD0.XDFFQ.SB mod0 2.4201e-17
* device instance cc_XD0_XDFFQ_SB_mod1 r0 *1 0,0
Ccc_XD0_XDFFQ_SB_mod1 XD0.XDFFQ.SB mod1 2.4201e-17
* device instance cc_XD0_XDFFQ_SB_mod2 r0 *1 0,0
Ccc_XD0_XDFFQ_SB_mod2 XD0.XDFFQ.SB mod2 2.4201e-17
* device instance cc_XD0_XDFFQ_SB_mod3 r0 *1 0,0
Ccc_XD0_XDFFQ_SB_mod3 XD0.XDFFQ.SB mod3 2.4201e-17
* device instance cc_XD0_XDFFQ_SB_mod4 r0 *1 0,0
Ccc_XD0_XDFFQ_SB_mod4 XD0.XDFFQ.SB mod4 2.4201e-17
* device instance cc_XD0_XDFFQ_SB_net1 r0 *1 0,0
Ccc_XD0_XDFFQ_SB_net1 XD0.XDFFQ.SB net1 1.21e-17
* device instance cc_XD0_XN2_mid1_XD0_nm r0 *1 0,0
Ccc_XD0_XN2_mid1_XD0_nm XD0.XN2.mid1 XD0.nm 1.1294e-17
* device instance cc_XD0_XN2_mid1_ck1 r0 *1 0,0
Ccc_XD0_XN2_mid1_ck1 XD0.XN2.mid1 ck1 6.05e-18
* device instance cc_XD0_XN3_mid1_XD0_XN3_mid2 r0 *1 0,0
Ccc_XD0_XN3_mid1_XD0_XN3_mid2 XD0.XN3.mid1 XD0.XN3.mid2 1.1294e-17
* device instance cc_XD0_XN3_mid1_XD0_nt r0 *1 0,0
Ccc_XD0_XN3_mid1_XD0_nt XD0.XN3.mid1 XD0.nt 1.1294e-17
* device instance cc_XD0_XN3_mid2_net1 r0 *1 0,0
Ccc_XD0_XN3_mid2_net1 XD0.XN3.mid2 net1 6.05e-18
* device instance cc_XD0_XNOR_midp_XD0_dq r0 *1 0,0
Ccc_XD0_XNOR_midp_XD0_dq XD0.XNOR.midp XD0.dq 5.244e-18
* device instance cc_XD0_XNOR_midp_XD0_t1 r0 *1 0,0
Ccc_XD0_XNOR_midp_XD0_t1 XD0.XNOR.midp XD0.t1 6.05e-18
* device instance cc_XD0_dmodout_XD0_dq r0 *1 0,0
Ccc_XD0_dmodout_XD0_dq XD0.dmodout XD0.dq 1.21e-17
* device instance cc_XD0_dmodout_XD0_nm r0 *1 0,0
Ccc_XD0_dmodout_XD0_nm XD0.dmodout XD0.nm 1.8151e-17
* device instance cc_XD0_dmodout_XD0_nt r0 *1 0,0
Ccc_XD0_dmodout_XD0_nt XD0.dmodout XD0.nt 2.4201e-17
* device instance cc_XD0_dmodout_XD0_t1 r0 *1 0,0
Ccc_XD0_dmodout_XD0_t1 XD0.dmodout XD0.t1 1.21e-17
* device instance cc_XD0_dmodout_XD1_XDFFM_CLKB r0 *1 0,0
Ccc_XD0_dmodout_XD1_XDFFM_CLKB XD0.dmodout XD1.XDFFM.CLKB 1.8151e-17
* device instance cc_XD0_dmodout_XD1_XDFFM_M r0 *1 0,0
Ccc_XD0_dmodout_XD1_XDFFM_M XD0.dmodout XD1.XDFFM.M 2.4201e-17
* device instance cc_XD0_dmodout_XD1_XDFFM_MB r0 *1 0,0
Ccc_XD0_dmodout_XD1_XDFFM_MB XD0.dmodout XD1.XDFFM.MB 1.21e-17
* device instance cc_XD0_dmodout_XD1_XDFFM_S r0 *1 0,0
Ccc_XD0_dmodout_XD1_XDFFM_S XD0.dmodout XD1.XDFFM.S 1.8151e-17
* device instance cc_XD0_dmodout_XD1_XDFFM_SB r0 *1 0,0
Ccc_XD0_dmodout_XD1_XDFFM_SB XD0.dmodout XD1.XDFFM.SB 1.8151e-17
* device instance cc_XD0_dmodout_XD1_XDFFQ_CLKB r0 *1 0,0
Ccc_XD0_dmodout_XD1_XDFFQ_CLKB XD0.dmodout XD1.XDFFQ.CLKB 1.8151e-17
* device instance cc_XD0_dmodout_XD1_XDFFQ_M r0 *1 0,0
Ccc_XD0_dmodout_XD1_XDFFQ_M XD0.dmodout XD1.XDFFQ.M 2.4201e-17
* device instance cc_XD0_dmodout_XD1_XDFFQ_MB r0 *1 0,0
Ccc_XD0_dmodout_XD1_XDFFQ_MB XD0.dmodout XD1.XDFFQ.MB 1.21e-17
* device instance cc_XD0_dmodout_XD1_XDFFQ_S r0 *1 0,0
Ccc_XD0_dmodout_XD1_XDFFQ_S XD0.dmodout XD1.XDFFQ.S 1.8151e-17
* device instance cc_XD0_dmodout_XD1_XDFFQ_SB r0 *1 0,0
Ccc_XD0_dmodout_XD1_XDFFQ_SB XD0.dmodout XD1.XDFFQ.SB 1.8151e-17
* device instance cc_XD0_dmodout_XD1_XN2_mid1 r0 *1 0,0
Ccc_XD0_dmodout_XD1_XN2_mid1 XD0.dmodout XD1.XN2.mid1 1.21e-17
* device instance cc_XD0_dmodout_XD1_XN3_mid1 r0 *1 0,0
Ccc_XD0_dmodout_XD1_XN3_mid1 XD0.dmodout XD1.XN3.mid1 1.21e-17
* device instance cc_XD0_dmodout_XD1_XN3_mid2 r0 *1 0,0
Ccc_XD0_dmodout_XD1_XN3_mid2 XD0.dmodout XD1.XN3.mid2 1.21e-17
* device instance cc_XD0_dmodout_XD1_dmodout r0 *1 0,0
Ccc_XD0_dmodout_XD1_dmodout XD0.dmodout XD1.dmodout 1.21e-17
* device instance cc_XD0_dmodout_XD1_dq r0 *1 0,0
Ccc_XD0_dmodout_XD1_dq XD0.dmodout XD1.dq 1.8151e-17
* device instance cc_XD0_dmodout_XD1_nm r0 *1 0,0
Ccc_XD0_dmodout_XD1_nm XD0.dmodout XD1.nm 1.21e-17
* device instance cc_XD0_dmodout_XD1_nt r0 *1 0,0
Ccc_XD0_dmodout_XD1_nt XD0.dmodout XD1.nt 1.21e-17
* device instance cc_XD0_dmodout_XD1_t1 r0 *1 0,0
Ccc_XD0_dmodout_XD1_t1 XD0.dmodout XD1.t1 1.21e-17
* device instance cc_XD0_dmodout_XD2_XDFFM_CLKB r0 *1 0,0
Ccc_XD0_dmodout_XD2_XDFFM_CLKB XD0.dmodout XD2.XDFFM.CLKB 1.8151e-17
* device instance cc_XD0_dmodout_XD2_XDFFM_M r0 *1 0,0
Ccc_XD0_dmodout_XD2_XDFFM_M XD0.dmodout XD2.XDFFM.M 2.4201e-17
* device instance cc_XD0_dmodout_XD2_XDFFM_MB r0 *1 0,0
Ccc_XD0_dmodout_XD2_XDFFM_MB XD0.dmodout XD2.XDFFM.MB 1.21e-17
* device instance cc_XD0_dmodout_XD2_XDFFM_S r0 *1 0,0
Ccc_XD0_dmodout_XD2_XDFFM_S XD0.dmodout XD2.XDFFM.S 1.8151e-17
* device instance cc_XD0_dmodout_XD2_XDFFM_SB r0 *1 0,0
Ccc_XD0_dmodout_XD2_XDFFM_SB XD0.dmodout XD2.XDFFM.SB 1.8151e-17
* device instance cc_XD0_dmodout_XD2_XDFFQ_CLKB r0 *1 0,0
Ccc_XD0_dmodout_XD2_XDFFQ_CLKB XD0.dmodout XD2.XDFFQ.CLKB 1.8151e-17
* device instance cc_XD0_dmodout_XD2_XDFFQ_M r0 *1 0,0
Ccc_XD0_dmodout_XD2_XDFFQ_M XD0.dmodout XD2.XDFFQ.M 2.4201e-17
* device instance cc_XD0_dmodout_XD2_XDFFQ_MB r0 *1 0,0
Ccc_XD0_dmodout_XD2_XDFFQ_MB XD0.dmodout XD2.XDFFQ.MB 1.21e-17
* device instance cc_XD0_dmodout_XD2_XDFFQ_S r0 *1 0,0
Ccc_XD0_dmodout_XD2_XDFFQ_S XD0.dmodout XD2.XDFFQ.S 1.8151e-17
* device instance cc_XD0_dmodout_XD2_XDFFQ_SB r0 *1 0,0
Ccc_XD0_dmodout_XD2_XDFFQ_SB XD0.dmodout XD2.XDFFQ.SB 1.8151e-17
* device instance cc_XD0_dmodout_XD2_XN2_mid1 r0 *1 0,0
Ccc_XD0_dmodout_XD2_XN2_mid1 XD0.dmodout XD2.XN2.mid1 1.21e-17
* device instance cc_XD0_dmodout_XD2_XN3_mid1 r0 *1 0,0
Ccc_XD0_dmodout_XD2_XN3_mid1 XD0.dmodout XD2.XN3.mid1 1.21e-17
* device instance cc_XD0_dmodout_XD2_XN3_mid2 r0 *1 0,0
Ccc_XD0_dmodout_XD2_XN3_mid2 XD0.dmodout XD2.XN3.mid2 1.21e-17
* device instance cc_XD0_dmodout_XD2_dmodout r0 *1 0,0
Ccc_XD0_dmodout_XD2_dmodout XD0.dmodout XD2.dmodout 1.21e-17
* device instance cc_XD0_dmodout_XD2_dq r0 *1 0,0
Ccc_XD0_dmodout_XD2_dq XD0.dmodout XD2.dq 1.8151e-17
* device instance cc_XD0_dmodout_XD2_nm r0 *1 0,0
Ccc_XD0_dmodout_XD2_nm XD0.dmodout XD2.nm 1.21e-17
* device instance cc_XD0_dmodout_XD2_nt r0 *1 0,0
Ccc_XD0_dmodout_XD2_nt XD0.dmodout XD2.nt 1.21e-17
* device instance cc_XD0_dmodout_XD2_t1 r0 *1 0,0
Ccc_XD0_dmodout_XD2_t1 XD0.dmodout XD2.t1 1.21e-17
* device instance cc_XD0_dmodout_XD3_XDFFM_CLKB r0 *1 0,0
Ccc_XD0_dmodout_XD3_XDFFM_CLKB XD0.dmodout XD3.XDFFM.CLKB 1.8151e-17
* device instance cc_XD0_dmodout_XD3_XDFFM_M r0 *1 0,0
Ccc_XD0_dmodout_XD3_XDFFM_M XD0.dmodout XD3.XDFFM.M 2.4201e-17
* device instance cc_XD0_dmodout_XD3_XDFFM_MB r0 *1 0,0
Ccc_XD0_dmodout_XD3_XDFFM_MB XD0.dmodout XD3.XDFFM.MB 1.21e-17
* device instance cc_XD0_dmodout_XD3_XDFFM_S r0 *1 0,0
Ccc_XD0_dmodout_XD3_XDFFM_S XD0.dmodout XD3.XDFFM.S 1.8151e-17
* device instance cc_XD0_dmodout_XD3_XDFFM_SB r0 *1 0,0
Ccc_XD0_dmodout_XD3_XDFFM_SB XD0.dmodout XD3.XDFFM.SB 1.8151e-17
* device instance cc_XD0_dmodout_XD3_XDFFQ_CLKB r0 *1 0,0
Ccc_XD0_dmodout_XD3_XDFFQ_CLKB XD0.dmodout XD3.XDFFQ.CLKB 1.8151e-17
* device instance cc_XD0_dmodout_XD3_XDFFQ_M r0 *1 0,0
Ccc_XD0_dmodout_XD3_XDFFQ_M XD0.dmodout XD3.XDFFQ.M 2.4201e-17
* device instance cc_XD0_dmodout_XD3_XDFFQ_MB r0 *1 0,0
Ccc_XD0_dmodout_XD3_XDFFQ_MB XD0.dmodout XD3.XDFFQ.MB 1.21e-17
* device instance cc_XD0_dmodout_XD3_XDFFQ_S r0 *1 0,0
Ccc_XD0_dmodout_XD3_XDFFQ_S XD0.dmodout XD3.XDFFQ.S 1.8151e-17
* device instance cc_XD0_dmodout_XD3_XDFFQ_SB r0 *1 0,0
Ccc_XD0_dmodout_XD3_XDFFQ_SB XD0.dmodout XD3.XDFFQ.SB 1.8151e-17
* device instance cc_XD0_dmodout_XD3_XN2_mid1 r0 *1 0,0
Ccc_XD0_dmodout_XD3_XN2_mid1 XD0.dmodout XD3.XN2.mid1 1.21e-17
* device instance cc_XD0_dmodout_XD3_XN3_mid1 r0 *1 0,0
Ccc_XD0_dmodout_XD3_XN3_mid1 XD0.dmodout XD3.XN3.mid1 1.21e-17
* device instance cc_XD0_dmodout_XD3_XN3_mid2 r0 *1 0,0
Ccc_XD0_dmodout_XD3_XN3_mid2 XD0.dmodout XD3.XN3.mid2 1.21e-17
* device instance cc_XD0_dmodout_XD3_dmodout r0 *1 0,0
Ccc_XD0_dmodout_XD3_dmodout XD0.dmodout XD3.dmodout 1.21e-17
* device instance cc_XD0_dmodout_XD3_dq r0 *1 0,0
Ccc_XD0_dmodout_XD3_dq XD0.dmodout XD3.dq 1.8151e-17
* device instance cc_XD0_dmodout_XD3_nm r0 *1 0,0
Ccc_XD0_dmodout_XD3_nm XD0.dmodout XD3.nm 1.21e-17
* device instance cc_XD0_dmodout_XD3_nt r0 *1 0,0
Ccc_XD0_dmodout_XD3_nt XD0.dmodout XD3.nt 1.21e-17
* device instance cc_XD0_dmodout_XD3_t1 r0 *1 0,0
Ccc_XD0_dmodout_XD3_t1 XD0.dmodout XD3.t1 1.21e-17
* device instance cc_XD0_dmodout_XD4_XDFFM_CLKB r0 *1 0,0
Ccc_XD0_dmodout_XD4_XDFFM_CLKB XD0.dmodout XD4.XDFFM.CLKB 1.8151e-17
* device instance cc_XD0_dmodout_XD4_XDFFM_M r0 *1 0,0
Ccc_XD0_dmodout_XD4_XDFFM_M XD0.dmodout XD4.XDFFM.M 2.4201e-17
* device instance cc_XD0_dmodout_XD4_XDFFM_MB r0 *1 0,0
Ccc_XD0_dmodout_XD4_XDFFM_MB XD0.dmodout XD4.XDFFM.MB 1.21e-17
* device instance cc_XD0_dmodout_XD4_XDFFM_S r0 *1 0,0
Ccc_XD0_dmodout_XD4_XDFFM_S XD0.dmodout XD4.XDFFM.S 1.8151e-17
* device instance cc_XD0_dmodout_XD4_XDFFM_SB r0 *1 0,0
Ccc_XD0_dmodout_XD4_XDFFM_SB XD0.dmodout XD4.XDFFM.SB 1.8151e-17
* device instance cc_XD0_dmodout_XD4_XDFFQ_CLKB r0 *1 0,0
Ccc_XD0_dmodout_XD4_XDFFQ_CLKB XD0.dmodout XD4.XDFFQ.CLKB 1.8151e-17
* device instance cc_XD0_dmodout_XD4_XDFFQ_M r0 *1 0,0
Ccc_XD0_dmodout_XD4_XDFFQ_M XD0.dmodout XD4.XDFFQ.M 2.4201e-17
* device instance cc_XD0_dmodout_XD4_XDFFQ_MB r0 *1 0,0
Ccc_XD0_dmodout_XD4_XDFFQ_MB XD0.dmodout XD4.XDFFQ.MB 1.21e-17
* device instance cc_XD0_dmodout_XD4_XDFFQ_S r0 *1 0,0
Ccc_XD0_dmodout_XD4_XDFFQ_S XD0.dmodout XD4.XDFFQ.S 1.8151e-17
* device instance cc_XD0_dmodout_XD4_XDFFQ_SB r0 *1 0,0
Ccc_XD0_dmodout_XD4_XDFFQ_SB XD0.dmodout XD4.XDFFQ.SB 1.8151e-17
* device instance cc_XD0_dmodout_XD4_XN2_mid1 r0 *1 0,0
Ccc_XD0_dmodout_XD4_XN2_mid1 XD0.dmodout XD4.XN2.mid1 1.21e-17
* device instance cc_XD0_dmodout_XD4_XN3_mid1 r0 *1 0,0
Ccc_XD0_dmodout_XD4_XN3_mid1 XD0.dmodout XD4.XN3.mid1 1.21e-17
* device instance cc_XD0_dmodout_XD4_XN3_mid2 r0 *1 0,0
Ccc_XD0_dmodout_XD4_XN3_mid2 XD0.dmodout XD4.XN3.mid2 1.21e-17
* device instance cc_XD0_dmodout_XD4_dmodout r0 *1 0,0
Ccc_XD0_dmodout_XD4_dmodout XD0.dmodout XD4.dmodout 1.21e-17
* device instance cc_XD0_dmodout_XD4_dq r0 *1 0,0
Ccc_XD0_dmodout_XD4_dq XD0.dmodout XD4.dq 1.8151e-17
* device instance cc_XD0_dmodout_XD4_nm r0 *1 0,0
Ccc_XD0_dmodout_XD4_nm XD0.dmodout XD4.nm 1.21e-17
* device instance cc_XD0_dmodout_XD4_nt r0 *1 0,0
Ccc_XD0_dmodout_XD4_nt XD0.dmodout XD4.nt 1.21e-17
* device instance cc_XD0_dmodout_XD4_t1 r0 *1 0,0
Ccc_XD0_dmodout_XD4_t1 XD0.dmodout XD4.t1 1.21e-17
* device instance cc_XD0_dmodout_XD5_XDFFM_CLKB r0 *1 0,0
Ccc_XD0_dmodout_XD5_XDFFM_CLKB XD0.dmodout XD5.XDFFM.CLKB 1.8151e-17
* device instance cc_XD0_dmodout_XD5_XDFFM_M r0 *1 0,0
Ccc_XD0_dmodout_XD5_XDFFM_M XD0.dmodout XD5.XDFFM.M 2.4201e-17
* device instance cc_XD0_dmodout_XD5_XDFFM_MB r0 *1 0,0
Ccc_XD0_dmodout_XD5_XDFFM_MB XD0.dmodout XD5.XDFFM.MB 1.21e-17
* device instance cc_XD0_dmodout_XD5_XDFFM_S r0 *1 0,0
Ccc_XD0_dmodout_XD5_XDFFM_S XD0.dmodout XD5.XDFFM.S 1.8151e-17
* device instance cc_XD0_dmodout_XD5_XDFFM_SB r0 *1 0,0
Ccc_XD0_dmodout_XD5_XDFFM_SB XD0.dmodout XD5.XDFFM.SB 1.8151e-17
* device instance cc_XD0_dmodout_XD5_XDFFQ_CLKB r0 *1 0,0
Ccc_XD0_dmodout_XD5_XDFFQ_CLKB XD0.dmodout XD5.XDFFQ.CLKB 1.8151e-17
* device instance cc_XD0_dmodout_XD5_XDFFQ_M r0 *1 0,0
Ccc_XD0_dmodout_XD5_XDFFQ_M XD0.dmodout XD5.XDFFQ.M 2.4201e-17
* device instance cc_XD0_dmodout_XD5_XDFFQ_MB r0 *1 0,0
Ccc_XD0_dmodout_XD5_XDFFQ_MB XD0.dmodout XD5.XDFFQ.MB 1.21e-17
* device instance cc_XD0_dmodout_XD5_XDFFQ_S r0 *1 0,0
Ccc_XD0_dmodout_XD5_XDFFQ_S XD0.dmodout XD5.XDFFQ.S 1.8151e-17
* device instance cc_XD0_dmodout_XD5_XDFFQ_SB r0 *1 0,0
Ccc_XD0_dmodout_XD5_XDFFQ_SB XD0.dmodout XD5.XDFFQ.SB 1.8151e-17
* device instance cc_XD0_dmodout_XD5_XN2_mid1 r0 *1 0,0
Ccc_XD0_dmodout_XD5_XN2_mid1 XD0.dmodout XD5.XN2.mid1 1.21e-17
* device instance cc_XD0_dmodout_XD5_XN3_mid1 r0 *1 0,0
Ccc_XD0_dmodout_XD5_XN3_mid1 XD0.dmodout XD5.XN3.mid1 1.21e-17
* device instance cc_XD0_dmodout_XD5_XN3_mid2 r0 *1 0,0
Ccc_XD0_dmodout_XD5_XN3_mid2 XD0.dmodout XD5.XN3.mid2 1.21e-17
* device instance cc_XD0_dmodout_XD5_dmodout r0 *1 0,0
Ccc_XD0_dmodout_XD5_dmodout XD0.dmodout XD5.dmodout 1.21e-17
* device instance cc_XD0_dmodout_XD5_dq r0 *1 0,0
Ccc_XD0_dmodout_XD5_dq XD0.dmodout XD5.dq 1.8151e-17
* device instance cc_XD0_dmodout_XD5_nm r0 *1 0,0
Ccc_XD0_dmodout_XD5_nm XD0.dmodout XD5.nm 1.21e-17
* device instance cc_XD0_dmodout_XD5_nt r0 *1 0,0
Ccc_XD0_dmodout_XD5_nt XD0.dmodout XD5.nt 1.21e-17
* device instance cc_XD0_dmodout_XD5_t1 r0 *1 0,0
Ccc_XD0_dmodout_XD5_t1 XD0.dmodout XD5.t1 1.21e-17
* device instance cc_XD0_dmodout_XFRT_CLKB r0 *1 0,0
Ccc_XD0_dmodout_XFRT_CLKB XD0.dmodout XFRT.CLKB 1.8151e-17
* device instance cc_XD0_dmodout_XFRT_M r0 *1 0,0
Ccc_XD0_dmodout_XFRT_M XD0.dmodout XFRT.M 2.4201e-17
* device instance cc_XD0_dmodout_XFRT_MB r0 *1 0,0
Ccc_XD0_dmodout_XFRT_MB XD0.dmodout XFRT.MB 1.21e-17
* device instance cc_XD0_dmodout_XFRT_S r0 *1 0,0
Ccc_XD0_dmodout_XFRT_S XD0.dmodout XFRT.S 1.8151e-17
* device instance cc_XD0_dmodout_XFRT_SB r0 *1 0,0
Ccc_XD0_dmodout_XFRT_SB XD0.dmodout XFRT.SB 1.8151e-17
* device instance cc_XD0_dmodout_ck1 r0 *1 0,0
Ccc_XD0_dmodout_ck1 XD0.dmodout ck1 5.4452e-17
* device instance cc_XD0_dmodout_ck2 r0 *1 0,0
Ccc_XD0_dmodout_ck2 XD0.dmodout ck2 5.4452e-17
* device instance cc_XD0_dmodout_ck3 r0 *1 0,0
Ccc_XD0_dmodout_ck3 XD0.dmodout ck3 5.4452e-17
* device instance cc_XD0_dmodout_ck4 r0 *1 0,0
Ccc_XD0_dmodout_ck4 XD0.dmodout ck4 5.4452e-17
* device instance cc_XD0_dmodout_ck5 r0 *1 0,0
Ccc_XD0_dmodout_ck5 XD0.dmodout ck5 5.4452e-17
* device instance cc_XD0_dmodout_mod0 r0 *1 0,0
Ccc_XD0_dmodout_mod0 XD0.dmodout mod0 2.4201e-17
* device instance cc_XD0_dmodout_mod1 r0 *1 0,0
Ccc_XD0_dmodout_mod1 XD0.dmodout mod1 2.4201e-17
* device instance cc_XD0_dmodout_mod2 r0 *1 0,0
Ccc_XD0_dmodout_mod2 XD0.dmodout mod2 2.4201e-17
* device instance cc_XD0_dmodout_mod3 r0 *1 0,0
Ccc_XD0_dmodout_mod3 XD0.dmodout mod3 2.4201e-17
* device instance cc_XD0_dmodout_mod4 r0 *1 0,0
Ccc_XD0_dmodout_mod4 XD0.dmodout mod4 2.4201e-17
* device instance cc_XD0_dmodout_net1 r0 *1 0,0
Ccc_XD0_dmodout_net1 XD0.dmodout net1 1.21e-17
* device instance cc_XD0_dq_XD0_nm r0 *1 0,0
Ccc_XD0_dq_XD0_nm XD0.dq XD0.nm 1.21e-17
* device instance cc_XD0_dq_XD0_nt r0 *1 0,0
Ccc_XD0_dq_XD0_nt XD0.dq XD0.nt 2.4201e-17
* device instance cc_XD0_dq_XD0_t1 r0 *1 0,0
Ccc_XD0_dq_XD0_t1 XD0.dq XD0.t1 1.8151e-17
* device instance cc_XD0_dq_XD1_XDFFM_CLKB r0 *1 0,0
Ccc_XD0_dq_XD1_XDFFM_CLKB XD0.dq XD1.XDFFM.CLKB 1.8151e-17
* device instance cc_XD0_dq_XD1_XDFFM_M r0 *1 0,0
Ccc_XD0_dq_XD1_XDFFM_M XD0.dq XD1.XDFFM.M 2.4201e-17
* device instance cc_XD0_dq_XD1_XDFFM_MB r0 *1 0,0
Ccc_XD0_dq_XD1_XDFFM_MB XD0.dq XD1.XDFFM.MB 1.21e-17
* device instance cc_XD0_dq_XD1_XDFFM_S r0 *1 0,0
Ccc_XD0_dq_XD1_XDFFM_S XD0.dq XD1.XDFFM.S 1.8151e-17
* device instance cc_XD0_dq_XD1_XDFFM_SB r0 *1 0,0
Ccc_XD0_dq_XD1_XDFFM_SB XD0.dq XD1.XDFFM.SB 1.8151e-17
* device instance cc_XD0_dq_XD1_XDFFQ_CLKB r0 *1 0,0
Ccc_XD0_dq_XD1_XDFFQ_CLKB XD0.dq XD1.XDFFQ.CLKB 1.8151e-17
* device instance cc_XD0_dq_XD1_XDFFQ_M r0 *1 0,0
Ccc_XD0_dq_XD1_XDFFQ_M XD0.dq XD1.XDFFQ.M 2.4201e-17
* device instance cc_XD0_dq_XD1_XDFFQ_MB r0 *1 0,0
Ccc_XD0_dq_XD1_XDFFQ_MB XD0.dq XD1.XDFFQ.MB 1.21e-17
* device instance cc_XD0_dq_XD1_XDFFQ_S r0 *1 0,0
Ccc_XD0_dq_XD1_XDFFQ_S XD0.dq XD1.XDFFQ.S 1.8151e-17
* device instance cc_XD0_dq_XD1_XDFFQ_SB r0 *1 0,0
Ccc_XD0_dq_XD1_XDFFQ_SB XD0.dq XD1.XDFFQ.SB 1.8151e-17
* device instance cc_XD0_dq_XD1_XN2_mid1 r0 *1 0,0
Ccc_XD0_dq_XD1_XN2_mid1 XD0.dq XD1.XN2.mid1 1.21e-17
* device instance cc_XD0_dq_XD1_XN3_mid1 r0 *1 0,0
Ccc_XD0_dq_XD1_XN3_mid1 XD0.dq XD1.XN3.mid1 1.21e-17
* device instance cc_XD0_dq_XD1_XN3_mid2 r0 *1 0,0
Ccc_XD0_dq_XD1_XN3_mid2 XD0.dq XD1.XN3.mid2 1.21e-17
* device instance cc_XD0_dq_XD1_dmodout r0 *1 0,0
Ccc_XD0_dq_XD1_dmodout XD0.dq XD1.dmodout 1.21e-17
* device instance cc_XD0_dq_XD1_dq r0 *1 0,0
Ccc_XD0_dq_XD1_dq XD0.dq XD1.dq 1.8151e-17
* device instance cc_XD0_dq_XD1_nm r0 *1 0,0
Ccc_XD0_dq_XD1_nm XD0.dq XD1.nm 1.21e-17
* device instance cc_XD0_dq_XD1_nt r0 *1 0,0
Ccc_XD0_dq_XD1_nt XD0.dq XD1.nt 1.21e-17
* device instance cc_XD0_dq_XD1_t1 r0 *1 0,0
Ccc_XD0_dq_XD1_t1 XD0.dq XD1.t1 1.21e-17
* device instance cc_XD0_dq_XD2_XDFFM_CLKB r0 *1 0,0
Ccc_XD0_dq_XD2_XDFFM_CLKB XD0.dq XD2.XDFFM.CLKB 1.8151e-17
* device instance cc_XD0_dq_XD2_XDFFM_M r0 *1 0,0
Ccc_XD0_dq_XD2_XDFFM_M XD0.dq XD2.XDFFM.M 2.4201e-17
* device instance cc_XD0_dq_XD2_XDFFM_MB r0 *1 0,0
Ccc_XD0_dq_XD2_XDFFM_MB XD0.dq XD2.XDFFM.MB 1.21e-17
* device instance cc_XD0_dq_XD2_XDFFM_S r0 *1 0,0
Ccc_XD0_dq_XD2_XDFFM_S XD0.dq XD2.XDFFM.S 1.8151e-17
* device instance cc_XD0_dq_XD2_XDFFM_SB r0 *1 0,0
Ccc_XD0_dq_XD2_XDFFM_SB XD0.dq XD2.XDFFM.SB 1.8151e-17
* device instance cc_XD0_dq_XD2_XDFFQ_CLKB r0 *1 0,0
Ccc_XD0_dq_XD2_XDFFQ_CLKB XD0.dq XD2.XDFFQ.CLKB 1.8151e-17
* device instance cc_XD0_dq_XD2_XDFFQ_M r0 *1 0,0
Ccc_XD0_dq_XD2_XDFFQ_M XD0.dq XD2.XDFFQ.M 2.4201e-17
* device instance cc_XD0_dq_XD2_XDFFQ_MB r0 *1 0,0
Ccc_XD0_dq_XD2_XDFFQ_MB XD0.dq XD2.XDFFQ.MB 1.21e-17
* device instance cc_XD0_dq_XD2_XDFFQ_S r0 *1 0,0
Ccc_XD0_dq_XD2_XDFFQ_S XD0.dq XD2.XDFFQ.S 1.8151e-17
* device instance cc_XD0_dq_XD2_XDFFQ_SB r0 *1 0,0
Ccc_XD0_dq_XD2_XDFFQ_SB XD0.dq XD2.XDFFQ.SB 1.8151e-17
* device instance cc_XD0_dq_XD2_XN2_mid1 r0 *1 0,0
Ccc_XD0_dq_XD2_XN2_mid1 XD0.dq XD2.XN2.mid1 1.21e-17
* device instance cc_XD0_dq_XD2_XN3_mid1 r0 *1 0,0
Ccc_XD0_dq_XD2_XN3_mid1 XD0.dq XD2.XN3.mid1 1.21e-17
* device instance cc_XD0_dq_XD2_XN3_mid2 r0 *1 0,0
Ccc_XD0_dq_XD2_XN3_mid2 XD0.dq XD2.XN3.mid2 1.21e-17
* device instance cc_XD0_dq_XD2_dmodout r0 *1 0,0
Ccc_XD0_dq_XD2_dmodout XD0.dq XD2.dmodout 1.21e-17
* device instance cc_XD0_dq_XD2_dq r0 *1 0,0
Ccc_XD0_dq_XD2_dq XD0.dq XD2.dq 1.8151e-17
* device instance cc_XD0_dq_XD2_nm r0 *1 0,0
Ccc_XD0_dq_XD2_nm XD0.dq XD2.nm 1.21e-17
* device instance cc_XD0_dq_XD2_nt r0 *1 0,0
Ccc_XD0_dq_XD2_nt XD0.dq XD2.nt 1.21e-17
* device instance cc_XD0_dq_XD2_t1 r0 *1 0,0
Ccc_XD0_dq_XD2_t1 XD0.dq XD2.t1 1.21e-17
* device instance cc_XD0_dq_XD3_XDFFM_CLKB r0 *1 0,0
Ccc_XD0_dq_XD3_XDFFM_CLKB XD0.dq XD3.XDFFM.CLKB 1.8151e-17
* device instance cc_XD0_dq_XD3_XDFFM_M r0 *1 0,0
Ccc_XD0_dq_XD3_XDFFM_M XD0.dq XD3.XDFFM.M 2.4201e-17
* device instance cc_XD0_dq_XD3_XDFFM_MB r0 *1 0,0
Ccc_XD0_dq_XD3_XDFFM_MB XD0.dq XD3.XDFFM.MB 1.21e-17
* device instance cc_XD0_dq_XD3_XDFFM_S r0 *1 0,0
Ccc_XD0_dq_XD3_XDFFM_S XD0.dq XD3.XDFFM.S 1.8151e-17
* device instance cc_XD0_dq_XD3_XDFFM_SB r0 *1 0,0
Ccc_XD0_dq_XD3_XDFFM_SB XD0.dq XD3.XDFFM.SB 1.8151e-17
* device instance cc_XD0_dq_XD3_XDFFQ_CLKB r0 *1 0,0
Ccc_XD0_dq_XD3_XDFFQ_CLKB XD0.dq XD3.XDFFQ.CLKB 1.8151e-17
* device instance cc_XD0_dq_XD3_XDFFQ_M r0 *1 0,0
Ccc_XD0_dq_XD3_XDFFQ_M XD0.dq XD3.XDFFQ.M 2.4201e-17
* device instance cc_XD0_dq_XD3_XDFFQ_MB r0 *1 0,0
Ccc_XD0_dq_XD3_XDFFQ_MB XD0.dq XD3.XDFFQ.MB 1.21e-17
* device instance cc_XD0_dq_XD3_XDFFQ_S r0 *1 0,0
Ccc_XD0_dq_XD3_XDFFQ_S XD0.dq XD3.XDFFQ.S 1.8151e-17
* device instance cc_XD0_dq_XD3_XDFFQ_SB r0 *1 0,0
Ccc_XD0_dq_XD3_XDFFQ_SB XD0.dq XD3.XDFFQ.SB 1.8151e-17
* device instance cc_XD0_dq_XD3_XN2_mid1 r0 *1 0,0
Ccc_XD0_dq_XD3_XN2_mid1 XD0.dq XD3.XN2.mid1 1.21e-17
* device instance cc_XD0_dq_XD3_XN3_mid1 r0 *1 0,0
Ccc_XD0_dq_XD3_XN3_mid1 XD0.dq XD3.XN3.mid1 1.21e-17
* device instance cc_XD0_dq_XD3_XN3_mid2 r0 *1 0,0
Ccc_XD0_dq_XD3_XN3_mid2 XD0.dq XD3.XN3.mid2 1.21e-17
* device instance cc_XD0_dq_XD3_dmodout r0 *1 0,0
Ccc_XD0_dq_XD3_dmodout XD0.dq XD3.dmodout 1.21e-17
* device instance cc_XD0_dq_XD3_dq r0 *1 0,0
Ccc_XD0_dq_XD3_dq XD0.dq XD3.dq 1.8151e-17
* device instance cc_XD0_dq_XD3_nm r0 *1 0,0
Ccc_XD0_dq_XD3_nm XD0.dq XD3.nm 1.21e-17
* device instance cc_XD0_dq_XD3_nt r0 *1 0,0
Ccc_XD0_dq_XD3_nt XD0.dq XD3.nt 1.21e-17
* device instance cc_XD0_dq_XD3_t1 r0 *1 0,0
Ccc_XD0_dq_XD3_t1 XD0.dq XD3.t1 1.21e-17
* device instance cc_XD0_dq_XD4_XDFFM_CLKB r0 *1 0,0
Ccc_XD0_dq_XD4_XDFFM_CLKB XD0.dq XD4.XDFFM.CLKB 1.8151e-17
* device instance cc_XD0_dq_XD4_XDFFM_M r0 *1 0,0
Ccc_XD0_dq_XD4_XDFFM_M XD0.dq XD4.XDFFM.M 2.4201e-17
* device instance cc_XD0_dq_XD4_XDFFM_MB r0 *1 0,0
Ccc_XD0_dq_XD4_XDFFM_MB XD0.dq XD4.XDFFM.MB 1.21e-17
* device instance cc_XD0_dq_XD4_XDFFM_S r0 *1 0,0
Ccc_XD0_dq_XD4_XDFFM_S XD0.dq XD4.XDFFM.S 1.8151e-17
* device instance cc_XD0_dq_XD4_XDFFM_SB r0 *1 0,0
Ccc_XD0_dq_XD4_XDFFM_SB XD0.dq XD4.XDFFM.SB 1.8151e-17
* device instance cc_XD0_dq_XD4_XDFFQ_CLKB r0 *1 0,0
Ccc_XD0_dq_XD4_XDFFQ_CLKB XD0.dq XD4.XDFFQ.CLKB 1.8151e-17
* device instance cc_XD0_dq_XD4_XDFFQ_M r0 *1 0,0
Ccc_XD0_dq_XD4_XDFFQ_M XD0.dq XD4.XDFFQ.M 2.4201e-17
* device instance cc_XD0_dq_XD4_XDFFQ_MB r0 *1 0,0
Ccc_XD0_dq_XD4_XDFFQ_MB XD0.dq XD4.XDFFQ.MB 1.21e-17
* device instance cc_XD0_dq_XD4_XDFFQ_S r0 *1 0,0
Ccc_XD0_dq_XD4_XDFFQ_S XD0.dq XD4.XDFFQ.S 1.8151e-17
* device instance cc_XD0_dq_XD4_XDFFQ_SB r0 *1 0,0
Ccc_XD0_dq_XD4_XDFFQ_SB XD0.dq XD4.XDFFQ.SB 1.8151e-17
* device instance cc_XD0_dq_XD4_XN2_mid1 r0 *1 0,0
Ccc_XD0_dq_XD4_XN2_mid1 XD0.dq XD4.XN2.mid1 1.21e-17
* device instance cc_XD0_dq_XD4_XN3_mid1 r0 *1 0,0
Ccc_XD0_dq_XD4_XN3_mid1 XD0.dq XD4.XN3.mid1 1.21e-17
* device instance cc_XD0_dq_XD4_XN3_mid2 r0 *1 0,0
Ccc_XD0_dq_XD4_XN3_mid2 XD0.dq XD4.XN3.mid2 1.21e-17
* device instance cc_XD0_dq_XD4_dmodout r0 *1 0,0
Ccc_XD0_dq_XD4_dmodout XD0.dq XD4.dmodout 1.21e-17
* device instance cc_XD0_dq_XD4_dq r0 *1 0,0
Ccc_XD0_dq_XD4_dq XD0.dq XD4.dq 1.8151e-17
* device instance cc_XD0_dq_XD4_nm r0 *1 0,0
Ccc_XD0_dq_XD4_nm XD0.dq XD4.nm 1.21e-17
* device instance cc_XD0_dq_XD4_nt r0 *1 0,0
Ccc_XD0_dq_XD4_nt XD0.dq XD4.nt 1.21e-17
* device instance cc_XD0_dq_XD4_t1 r0 *1 0,0
Ccc_XD0_dq_XD4_t1 XD0.dq XD4.t1 1.21e-17
* device instance cc_XD0_dq_XD5_XDFFM_CLKB r0 *1 0,0
Ccc_XD0_dq_XD5_XDFFM_CLKB XD0.dq XD5.XDFFM.CLKB 1.8151e-17
* device instance cc_XD0_dq_XD5_XDFFM_M r0 *1 0,0
Ccc_XD0_dq_XD5_XDFFM_M XD0.dq XD5.XDFFM.M 2.4201e-17
* device instance cc_XD0_dq_XD5_XDFFM_MB r0 *1 0,0
Ccc_XD0_dq_XD5_XDFFM_MB XD0.dq XD5.XDFFM.MB 1.21e-17
* device instance cc_XD0_dq_XD5_XDFFM_S r0 *1 0,0
Ccc_XD0_dq_XD5_XDFFM_S XD0.dq XD5.XDFFM.S 1.8151e-17
* device instance cc_XD0_dq_XD5_XDFFM_SB r0 *1 0,0
Ccc_XD0_dq_XD5_XDFFM_SB XD0.dq XD5.XDFFM.SB 1.8151e-17
* device instance cc_XD0_dq_XD5_XDFFQ_CLKB r0 *1 0,0
Ccc_XD0_dq_XD5_XDFFQ_CLKB XD0.dq XD5.XDFFQ.CLKB 1.8151e-17
* device instance cc_XD0_dq_XD5_XDFFQ_M r0 *1 0,0
Ccc_XD0_dq_XD5_XDFFQ_M XD0.dq XD5.XDFFQ.M 2.4201e-17
* device instance cc_XD0_dq_XD5_XDFFQ_MB r0 *1 0,0
Ccc_XD0_dq_XD5_XDFFQ_MB XD0.dq XD5.XDFFQ.MB 1.21e-17
* device instance cc_XD0_dq_XD5_XDFFQ_S r0 *1 0,0
Ccc_XD0_dq_XD5_XDFFQ_S XD0.dq XD5.XDFFQ.S 1.8151e-17
* device instance cc_XD0_dq_XD5_XDFFQ_SB r0 *1 0,0
Ccc_XD0_dq_XD5_XDFFQ_SB XD0.dq XD5.XDFFQ.SB 1.8151e-17
* device instance cc_XD0_dq_XD5_XN2_mid1 r0 *1 0,0
Ccc_XD0_dq_XD5_XN2_mid1 XD0.dq XD5.XN2.mid1 1.21e-17
* device instance cc_XD0_dq_XD5_XN3_mid1 r0 *1 0,0
Ccc_XD0_dq_XD5_XN3_mid1 XD0.dq XD5.XN3.mid1 1.21e-17
* device instance cc_XD0_dq_XD5_XN3_mid2 r0 *1 0,0
Ccc_XD0_dq_XD5_XN3_mid2 XD0.dq XD5.XN3.mid2 1.21e-17
* device instance cc_XD0_dq_XD5_dmodout r0 *1 0,0
Ccc_XD0_dq_XD5_dmodout XD0.dq XD5.dmodout 1.21e-17
* device instance cc_XD0_dq_XD5_dq r0 *1 0,0
Ccc_XD0_dq_XD5_dq XD0.dq XD5.dq 1.8151e-17
* device instance cc_XD0_dq_XD5_nm r0 *1 0,0
Ccc_XD0_dq_XD5_nm XD0.dq XD5.nm 1.21e-17
* device instance cc_XD0_dq_XD5_nt r0 *1 0,0
Ccc_XD0_dq_XD5_nt XD0.dq XD5.nt 1.21e-17
* device instance cc_XD0_dq_XD5_t1 r0 *1 0,0
Ccc_XD0_dq_XD5_t1 XD0.dq XD5.t1 1.21e-17
* device instance cc_XD0_dq_XFRT_CLKB r0 *1 0,0
Ccc_XD0_dq_XFRT_CLKB XD0.dq XFRT.CLKB 1.8151e-17
* device instance cc_XD0_dq_XFRT_M r0 *1 0,0
Ccc_XD0_dq_XFRT_M XD0.dq XFRT.M 2.4201e-17
* device instance cc_XD0_dq_XFRT_MB r0 *1 0,0
Ccc_XD0_dq_XFRT_MB XD0.dq XFRT.MB 1.21e-17
* device instance cc_XD0_dq_XFRT_S r0 *1 0,0
Ccc_XD0_dq_XFRT_S XD0.dq XFRT.S 1.8151e-17
* device instance cc_XD0_dq_XFRT_SB r0 *1 0,0
Ccc_XD0_dq_XFRT_SB XD0.dq XFRT.SB 1.8151e-17
* device instance cc_XD0_dq_ck1 r0 *1 0,0
Ccc_XD0_dq_ck1 XD0.dq ck1 5.4452e-17
* device instance cc_XD0_dq_ck2 r0 *1 0,0
Ccc_XD0_dq_ck2 XD0.dq ck2 5.4452e-17
* device instance cc_XD0_dq_ck3 r0 *1 0,0
Ccc_XD0_dq_ck3 XD0.dq ck3 5.4452e-17
* device instance cc_XD0_dq_ck4 r0 *1 0,0
Ccc_XD0_dq_ck4 XD0.dq ck4 5.4452e-17
* device instance cc_XD0_dq_ck5 r0 *1 0,0
Ccc_XD0_dq_ck5 XD0.dq ck5 5.4452e-17
* device instance cc_XD0_dq_mod0 r0 *1 0,0
Ccc_XD0_dq_mod0 XD0.dq mod0 2.4201e-17
* device instance cc_XD0_dq_mod1 r0 *1 0,0
Ccc_XD0_dq_mod1 XD0.dq mod1 2.4201e-17
* device instance cc_XD0_dq_mod2 r0 *1 0,0
Ccc_XD0_dq_mod2 XD0.dq mod2 2.4201e-17
* device instance cc_XD0_dq_mod3 r0 *1 0,0
Ccc_XD0_dq_mod3 XD0.dq mod3 2.4201e-17
* device instance cc_XD0_dq_mod4 r0 *1 0,0
Ccc_XD0_dq_mod4 XD0.dq mod4 2.4201e-17
* device instance cc_XD0_dq_net1 r0 *1 0,0
Ccc_XD0_dq_net1 XD0.dq net1 1.21e-17
* device instance cc_XD0_nm_XD0_nt r0 *1 0,0
Ccc_XD0_nm_XD0_nt XD0.nm XD0.nt 2.4201e-17
* device instance cc_XD0_nm_XD0_t1 r0 *1 0,0
Ccc_XD0_nm_XD0_t1 XD0.nm XD0.t1 1.21e-17
* device instance cc_XD0_nm_XD1_XDFFM_CLKB r0 *1 0,0
Ccc_XD0_nm_XD1_XDFFM_CLKB XD0.nm XD1.XDFFM.CLKB 1.8151e-17
* device instance cc_XD0_nm_XD1_XDFFM_M r0 *1 0,0
Ccc_XD0_nm_XD1_XDFFM_M XD0.nm XD1.XDFFM.M 2.4201e-17
* device instance cc_XD0_nm_XD1_XDFFM_MB r0 *1 0,0
Ccc_XD0_nm_XD1_XDFFM_MB XD0.nm XD1.XDFFM.MB 1.21e-17
* device instance cc_XD0_nm_XD1_XDFFM_S r0 *1 0,0
Ccc_XD0_nm_XD1_XDFFM_S XD0.nm XD1.XDFFM.S 1.8151e-17
* device instance cc_XD0_nm_XD1_XDFFM_SB r0 *1 0,0
Ccc_XD0_nm_XD1_XDFFM_SB XD0.nm XD1.XDFFM.SB 1.8151e-17
* device instance cc_XD0_nm_XD1_XDFFQ_CLKB r0 *1 0,0
Ccc_XD0_nm_XD1_XDFFQ_CLKB XD0.nm XD1.XDFFQ.CLKB 1.8151e-17
* device instance cc_XD0_nm_XD1_XDFFQ_M r0 *1 0,0
Ccc_XD0_nm_XD1_XDFFQ_M XD0.nm XD1.XDFFQ.M 2.4201e-17
* device instance cc_XD0_nm_XD1_XDFFQ_MB r0 *1 0,0
Ccc_XD0_nm_XD1_XDFFQ_MB XD0.nm XD1.XDFFQ.MB 1.21e-17
* device instance cc_XD0_nm_XD1_XDFFQ_S r0 *1 0,0
Ccc_XD0_nm_XD1_XDFFQ_S XD0.nm XD1.XDFFQ.S 1.8151e-17
* device instance cc_XD0_nm_XD1_XDFFQ_SB r0 *1 0,0
Ccc_XD0_nm_XD1_XDFFQ_SB XD0.nm XD1.XDFFQ.SB 1.8151e-17
* device instance cc_XD0_nm_XD1_XN2_mid1 r0 *1 0,0
Ccc_XD0_nm_XD1_XN2_mid1 XD0.nm XD1.XN2.mid1 1.21e-17
* device instance cc_XD0_nm_XD1_XN3_mid1 r0 *1 0,0
Ccc_XD0_nm_XD1_XN3_mid1 XD0.nm XD1.XN3.mid1 1.21e-17
* device instance cc_XD0_nm_XD1_XN3_mid2 r0 *1 0,0
Ccc_XD0_nm_XD1_XN3_mid2 XD0.nm XD1.XN3.mid2 1.21e-17
* device instance cc_XD0_nm_XD1_dmodout r0 *1 0,0
Ccc_XD0_nm_XD1_dmodout XD0.nm XD1.dmodout 1.21e-17
* device instance cc_XD0_nm_XD1_dq r0 *1 0,0
Ccc_XD0_nm_XD1_dq XD0.nm XD1.dq 1.8151e-17
* device instance cc_XD0_nm_XD1_nm r0 *1 0,0
Ccc_XD0_nm_XD1_nm XD0.nm XD1.nm 1.21e-17
* device instance cc_XD0_nm_XD1_nt r0 *1 0,0
Ccc_XD0_nm_XD1_nt XD0.nm XD1.nt 1.21e-17
* device instance cc_XD0_nm_XD1_t1 r0 *1 0,0
Ccc_XD0_nm_XD1_t1 XD0.nm XD1.t1 1.21e-17
* device instance cc_XD0_nm_XD2_XDFFM_CLKB r0 *1 0,0
Ccc_XD0_nm_XD2_XDFFM_CLKB XD0.nm XD2.XDFFM.CLKB 1.8151e-17
* device instance cc_XD0_nm_XD2_XDFFM_M r0 *1 0,0
Ccc_XD0_nm_XD2_XDFFM_M XD0.nm XD2.XDFFM.M 2.4201e-17
* device instance cc_XD0_nm_XD2_XDFFM_MB r0 *1 0,0
Ccc_XD0_nm_XD2_XDFFM_MB XD0.nm XD2.XDFFM.MB 1.21e-17
* device instance cc_XD0_nm_XD2_XDFFM_S r0 *1 0,0
Ccc_XD0_nm_XD2_XDFFM_S XD0.nm XD2.XDFFM.S 1.8151e-17
* device instance cc_XD0_nm_XD2_XDFFM_SB r0 *1 0,0
Ccc_XD0_nm_XD2_XDFFM_SB XD0.nm XD2.XDFFM.SB 1.8151e-17
* device instance cc_XD0_nm_XD2_XDFFQ_CLKB r0 *1 0,0
Ccc_XD0_nm_XD2_XDFFQ_CLKB XD0.nm XD2.XDFFQ.CLKB 1.8151e-17
* device instance cc_XD0_nm_XD2_XDFFQ_M r0 *1 0,0
Ccc_XD0_nm_XD2_XDFFQ_M XD0.nm XD2.XDFFQ.M 2.4201e-17
* device instance cc_XD0_nm_XD2_XDFFQ_MB r0 *1 0,0
Ccc_XD0_nm_XD2_XDFFQ_MB XD0.nm XD2.XDFFQ.MB 1.21e-17
* device instance cc_XD0_nm_XD2_XDFFQ_S r0 *1 0,0
Ccc_XD0_nm_XD2_XDFFQ_S XD0.nm XD2.XDFFQ.S 1.8151e-17
* device instance cc_XD0_nm_XD2_XDFFQ_SB r0 *1 0,0
Ccc_XD0_nm_XD2_XDFFQ_SB XD0.nm XD2.XDFFQ.SB 1.8151e-17
* device instance cc_XD0_nm_XD2_XN2_mid1 r0 *1 0,0
Ccc_XD0_nm_XD2_XN2_mid1 XD0.nm XD2.XN2.mid1 1.21e-17
* device instance cc_XD0_nm_XD2_XN3_mid1 r0 *1 0,0
Ccc_XD0_nm_XD2_XN3_mid1 XD0.nm XD2.XN3.mid1 1.21e-17
* device instance cc_XD0_nm_XD2_XN3_mid2 r0 *1 0,0
Ccc_XD0_nm_XD2_XN3_mid2 XD0.nm XD2.XN3.mid2 1.21e-17
* device instance cc_XD0_nm_XD2_dmodout r0 *1 0,0
Ccc_XD0_nm_XD2_dmodout XD0.nm XD2.dmodout 1.21e-17
* device instance cc_XD0_nm_XD2_dq r0 *1 0,0
Ccc_XD0_nm_XD2_dq XD0.nm XD2.dq 1.8151e-17
* device instance cc_XD0_nm_XD2_nm r0 *1 0,0
Ccc_XD0_nm_XD2_nm XD0.nm XD2.nm 1.21e-17
* device instance cc_XD0_nm_XD2_nt r0 *1 0,0
Ccc_XD0_nm_XD2_nt XD0.nm XD2.nt 1.21e-17
* device instance cc_XD0_nm_XD2_t1 r0 *1 0,0
Ccc_XD0_nm_XD2_t1 XD0.nm XD2.t1 1.21e-17
* device instance cc_XD0_nm_XD3_XDFFM_CLKB r0 *1 0,0
Ccc_XD0_nm_XD3_XDFFM_CLKB XD0.nm XD3.XDFFM.CLKB 1.8151e-17
* device instance cc_XD0_nm_XD3_XDFFM_M r0 *1 0,0
Ccc_XD0_nm_XD3_XDFFM_M XD0.nm XD3.XDFFM.M 2.4201e-17
* device instance cc_XD0_nm_XD3_XDFFM_MB r0 *1 0,0
Ccc_XD0_nm_XD3_XDFFM_MB XD0.nm XD3.XDFFM.MB 1.21e-17
* device instance cc_XD0_nm_XD3_XDFFM_S r0 *1 0,0
Ccc_XD0_nm_XD3_XDFFM_S XD0.nm XD3.XDFFM.S 1.8151e-17
* device instance cc_XD0_nm_XD3_XDFFM_SB r0 *1 0,0
Ccc_XD0_nm_XD3_XDFFM_SB XD0.nm XD3.XDFFM.SB 1.8151e-17
* device instance cc_XD0_nm_XD3_XDFFQ_CLKB r0 *1 0,0
Ccc_XD0_nm_XD3_XDFFQ_CLKB XD0.nm XD3.XDFFQ.CLKB 1.8151e-17
* device instance cc_XD0_nm_XD3_XDFFQ_M r0 *1 0,0
Ccc_XD0_nm_XD3_XDFFQ_M XD0.nm XD3.XDFFQ.M 2.4201e-17
* device instance cc_XD0_nm_XD3_XDFFQ_MB r0 *1 0,0
Ccc_XD0_nm_XD3_XDFFQ_MB XD0.nm XD3.XDFFQ.MB 1.21e-17
* device instance cc_XD0_nm_XD3_XDFFQ_S r0 *1 0,0
Ccc_XD0_nm_XD3_XDFFQ_S XD0.nm XD3.XDFFQ.S 1.8151e-17
* device instance cc_XD0_nm_XD3_XDFFQ_SB r0 *1 0,0
Ccc_XD0_nm_XD3_XDFFQ_SB XD0.nm XD3.XDFFQ.SB 1.8151e-17
* device instance cc_XD0_nm_XD3_XN2_mid1 r0 *1 0,0
Ccc_XD0_nm_XD3_XN2_mid1 XD0.nm XD3.XN2.mid1 1.21e-17
* device instance cc_XD0_nm_XD3_XN3_mid1 r0 *1 0,0
Ccc_XD0_nm_XD3_XN3_mid1 XD0.nm XD3.XN3.mid1 1.21e-17
* device instance cc_XD0_nm_XD3_XN3_mid2 r0 *1 0,0
Ccc_XD0_nm_XD3_XN3_mid2 XD0.nm XD3.XN3.mid2 1.21e-17
* device instance cc_XD0_nm_XD3_dmodout r0 *1 0,0
Ccc_XD0_nm_XD3_dmodout XD0.nm XD3.dmodout 1.21e-17
* device instance cc_XD0_nm_XD3_dq r0 *1 0,0
Ccc_XD0_nm_XD3_dq XD0.nm XD3.dq 1.8151e-17
* device instance cc_XD0_nm_XD3_nm r0 *1 0,0
Ccc_XD0_nm_XD3_nm XD0.nm XD3.nm 1.21e-17
* device instance cc_XD0_nm_XD3_nt r0 *1 0,0
Ccc_XD0_nm_XD3_nt XD0.nm XD3.nt 1.21e-17
* device instance cc_XD0_nm_XD3_t1 r0 *1 0,0
Ccc_XD0_nm_XD3_t1 XD0.nm XD3.t1 1.21e-17
* device instance cc_XD0_nm_XD4_XDFFM_CLKB r0 *1 0,0
Ccc_XD0_nm_XD4_XDFFM_CLKB XD0.nm XD4.XDFFM.CLKB 1.8151e-17
* device instance cc_XD0_nm_XD4_XDFFM_M r0 *1 0,0
Ccc_XD0_nm_XD4_XDFFM_M XD0.nm XD4.XDFFM.M 2.4201e-17
* device instance cc_XD0_nm_XD4_XDFFM_MB r0 *1 0,0
Ccc_XD0_nm_XD4_XDFFM_MB XD0.nm XD4.XDFFM.MB 1.21e-17
* device instance cc_XD0_nm_XD4_XDFFM_S r0 *1 0,0
Ccc_XD0_nm_XD4_XDFFM_S XD0.nm XD4.XDFFM.S 1.8151e-17
* device instance cc_XD0_nm_XD4_XDFFM_SB r0 *1 0,0
Ccc_XD0_nm_XD4_XDFFM_SB XD0.nm XD4.XDFFM.SB 1.8151e-17
* device instance cc_XD0_nm_XD4_XDFFQ_CLKB r0 *1 0,0
Ccc_XD0_nm_XD4_XDFFQ_CLKB XD0.nm XD4.XDFFQ.CLKB 1.8151e-17
* device instance cc_XD0_nm_XD4_XDFFQ_M r0 *1 0,0
Ccc_XD0_nm_XD4_XDFFQ_M XD0.nm XD4.XDFFQ.M 2.4201e-17
* device instance cc_XD0_nm_XD4_XDFFQ_MB r0 *1 0,0
Ccc_XD0_nm_XD4_XDFFQ_MB XD0.nm XD4.XDFFQ.MB 1.21e-17
* device instance cc_XD0_nm_XD4_XDFFQ_S r0 *1 0,0
Ccc_XD0_nm_XD4_XDFFQ_S XD0.nm XD4.XDFFQ.S 1.8151e-17
* device instance cc_XD0_nm_XD4_XDFFQ_SB r0 *1 0,0
Ccc_XD0_nm_XD4_XDFFQ_SB XD0.nm XD4.XDFFQ.SB 1.8151e-17
* device instance cc_XD0_nm_XD4_XN2_mid1 r0 *1 0,0
Ccc_XD0_nm_XD4_XN2_mid1 XD0.nm XD4.XN2.mid1 1.21e-17
* device instance cc_XD0_nm_XD4_XN3_mid1 r0 *1 0,0
Ccc_XD0_nm_XD4_XN3_mid1 XD0.nm XD4.XN3.mid1 1.21e-17
* device instance cc_XD0_nm_XD4_XN3_mid2 r0 *1 0,0
Ccc_XD0_nm_XD4_XN3_mid2 XD0.nm XD4.XN3.mid2 1.21e-17
* device instance cc_XD0_nm_XD4_dmodout r0 *1 0,0
Ccc_XD0_nm_XD4_dmodout XD0.nm XD4.dmodout 1.21e-17
* device instance cc_XD0_nm_XD4_dq r0 *1 0,0
Ccc_XD0_nm_XD4_dq XD0.nm XD4.dq 1.8151e-17
* device instance cc_XD0_nm_XD4_nm r0 *1 0,0
Ccc_XD0_nm_XD4_nm XD0.nm XD4.nm 1.21e-17
* device instance cc_XD0_nm_XD4_nt r0 *1 0,0
Ccc_XD0_nm_XD4_nt XD0.nm XD4.nt 1.21e-17
* device instance cc_XD0_nm_XD4_t1 r0 *1 0,0
Ccc_XD0_nm_XD4_t1 XD0.nm XD4.t1 1.21e-17
* device instance cc_XD0_nm_XD5_XDFFM_CLKB r0 *1 0,0
Ccc_XD0_nm_XD5_XDFFM_CLKB XD0.nm XD5.XDFFM.CLKB 1.8151e-17
* device instance cc_XD0_nm_XD5_XDFFM_M r0 *1 0,0
Ccc_XD0_nm_XD5_XDFFM_M XD0.nm XD5.XDFFM.M 2.4201e-17
* device instance cc_XD0_nm_XD5_XDFFM_MB r0 *1 0,0
Ccc_XD0_nm_XD5_XDFFM_MB XD0.nm XD5.XDFFM.MB 1.21e-17
* device instance cc_XD0_nm_XD5_XDFFM_S r0 *1 0,0
Ccc_XD0_nm_XD5_XDFFM_S XD0.nm XD5.XDFFM.S 1.8151e-17
* device instance cc_XD0_nm_XD5_XDFFM_SB r0 *1 0,0
Ccc_XD0_nm_XD5_XDFFM_SB XD0.nm XD5.XDFFM.SB 1.8151e-17
* device instance cc_XD0_nm_XD5_XDFFQ_CLKB r0 *1 0,0
Ccc_XD0_nm_XD5_XDFFQ_CLKB XD0.nm XD5.XDFFQ.CLKB 1.8151e-17
* device instance cc_XD0_nm_XD5_XDFFQ_M r0 *1 0,0
Ccc_XD0_nm_XD5_XDFFQ_M XD0.nm XD5.XDFFQ.M 2.4201e-17
* device instance cc_XD0_nm_XD5_XDFFQ_MB r0 *1 0,0
Ccc_XD0_nm_XD5_XDFFQ_MB XD0.nm XD5.XDFFQ.MB 1.21e-17
* device instance cc_XD0_nm_XD5_XDFFQ_S r0 *1 0,0
Ccc_XD0_nm_XD5_XDFFQ_S XD0.nm XD5.XDFFQ.S 1.8151e-17
* device instance cc_XD0_nm_XD5_XDFFQ_SB r0 *1 0,0
Ccc_XD0_nm_XD5_XDFFQ_SB XD0.nm XD5.XDFFQ.SB 1.8151e-17
* device instance cc_XD0_nm_XD5_XN2_mid1 r0 *1 0,0
Ccc_XD0_nm_XD5_XN2_mid1 XD0.nm XD5.XN2.mid1 1.21e-17
* device instance cc_XD0_nm_XD5_XN3_mid1 r0 *1 0,0
Ccc_XD0_nm_XD5_XN3_mid1 XD0.nm XD5.XN3.mid1 1.21e-17
* device instance cc_XD0_nm_XD5_XN3_mid2 r0 *1 0,0
Ccc_XD0_nm_XD5_XN3_mid2 XD0.nm XD5.XN3.mid2 1.21e-17
* device instance cc_XD0_nm_XD5_dmodout r0 *1 0,0
Ccc_XD0_nm_XD5_dmodout XD0.nm XD5.dmodout 1.21e-17
* device instance cc_XD0_nm_XD5_dq r0 *1 0,0
Ccc_XD0_nm_XD5_dq XD0.nm XD5.dq 1.8151e-17
* device instance cc_XD0_nm_XD5_nm r0 *1 0,0
Ccc_XD0_nm_XD5_nm XD0.nm XD5.nm 1.21e-17
* device instance cc_XD0_nm_XD5_nt r0 *1 0,0
Ccc_XD0_nm_XD5_nt XD0.nm XD5.nt 1.21e-17
* device instance cc_XD0_nm_XD5_t1 r0 *1 0,0
Ccc_XD0_nm_XD5_t1 XD0.nm XD5.t1 1.21e-17
* device instance cc_XD0_nm_XFRT_CLKB r0 *1 0,0
Ccc_XD0_nm_XFRT_CLKB XD0.nm XFRT.CLKB 1.8151e-17
* device instance cc_XD0_nm_XFRT_M r0 *1 0,0
Ccc_XD0_nm_XFRT_M XD0.nm XFRT.M 2.4201e-17
* device instance cc_XD0_nm_XFRT_MB r0 *1 0,0
Ccc_XD0_nm_XFRT_MB XD0.nm XFRT.MB 1.21e-17
* device instance cc_XD0_nm_XFRT_S r0 *1 0,0
Ccc_XD0_nm_XFRT_S XD0.nm XFRT.S 1.8151e-17
* device instance cc_XD0_nm_XFRT_SB r0 *1 0,0
Ccc_XD0_nm_XFRT_SB XD0.nm XFRT.SB 1.8151e-17
* device instance cc_XD0_nm_ck1 r0 *1 0,0
Ccc_XD0_nm_ck1 XD0.nm ck1 6.0502e-17
* device instance cc_XD0_nm_ck2 r0 *1 0,0
Ccc_XD0_nm_ck2 XD0.nm ck2 5.4452e-17
* device instance cc_XD0_nm_ck3 r0 *1 0,0
Ccc_XD0_nm_ck3 XD0.nm ck3 5.4452e-17
* device instance cc_XD0_nm_ck4 r0 *1 0,0
Ccc_XD0_nm_ck4 XD0.nm ck4 5.4452e-17
* device instance cc_XD0_nm_ck5 r0 *1 0,0
Ccc_XD0_nm_ck5 XD0.nm ck5 5.4452e-17
* device instance cc_XD0_nm_mod0 r0 *1 0,0
Ccc_XD0_nm_mod0 XD0.nm mod0 2.4201e-17
* device instance cc_XD0_nm_mod1 r0 *1 0,0
Ccc_XD0_nm_mod1 XD0.nm mod1 2.4201e-17
* device instance cc_XD0_nm_mod2 r0 *1 0,0
Ccc_XD0_nm_mod2 XD0.nm mod2 2.4201e-17
* device instance cc_XD0_nm_mod3 r0 *1 0,0
Ccc_XD0_nm_mod3 XD0.nm mod3 2.4201e-17
* device instance cc_XD0_nm_mod4 r0 *1 0,0
Ccc_XD0_nm_mod4 XD0.nm mod4 2.4201e-17
* device instance cc_XD0_nm_net1 r0 *1 0,0
Ccc_XD0_nm_net1 XD0.nm net1 1.21e-17
* device instance cc_XD0_nt_XD0_t1 r0 *1 0,0
Ccc_XD0_nt_XD0_t1 XD0.nt XD0.t1 1.21e-17
* device instance cc_XD0_nt_XD1_XDFFM_CLKB r0 *1 0,0
Ccc_XD0_nt_XD1_XDFFM_CLKB XD0.nt XD1.XDFFM.CLKB 1.8151e-17
* device instance cc_XD0_nt_XD1_XDFFM_M r0 *1 0,0
Ccc_XD0_nt_XD1_XDFFM_M XD0.nt XD1.XDFFM.M 2.4201e-17
* device instance cc_XD0_nt_XD1_XDFFM_MB r0 *1 0,0
Ccc_XD0_nt_XD1_XDFFM_MB XD0.nt XD1.XDFFM.MB 1.21e-17
* device instance cc_XD0_nt_XD1_XDFFM_S r0 *1 0,0
Ccc_XD0_nt_XD1_XDFFM_S XD0.nt XD1.XDFFM.S 1.8151e-17
* device instance cc_XD0_nt_XD1_XDFFM_SB r0 *1 0,0
Ccc_XD0_nt_XD1_XDFFM_SB XD0.nt XD1.XDFFM.SB 1.8151e-17
* device instance cc_XD0_nt_XD1_XDFFQ_CLKB r0 *1 0,0
Ccc_XD0_nt_XD1_XDFFQ_CLKB XD0.nt XD1.XDFFQ.CLKB 1.8151e-17
* device instance cc_XD0_nt_XD1_XDFFQ_M r0 *1 0,0
Ccc_XD0_nt_XD1_XDFFQ_M XD0.nt XD1.XDFFQ.M 2.4201e-17
* device instance cc_XD0_nt_XD1_XDFFQ_MB r0 *1 0,0
Ccc_XD0_nt_XD1_XDFFQ_MB XD0.nt XD1.XDFFQ.MB 1.21e-17
* device instance cc_XD0_nt_XD1_XDFFQ_S r0 *1 0,0
Ccc_XD0_nt_XD1_XDFFQ_S XD0.nt XD1.XDFFQ.S 1.8151e-17
* device instance cc_XD0_nt_XD1_XDFFQ_SB r0 *1 0,0
Ccc_XD0_nt_XD1_XDFFQ_SB XD0.nt XD1.XDFFQ.SB 1.8151e-17
* device instance cc_XD0_nt_XD1_XN2_mid1 r0 *1 0,0
Ccc_XD0_nt_XD1_XN2_mid1 XD0.nt XD1.XN2.mid1 1.21e-17
* device instance cc_XD0_nt_XD1_XN3_mid1 r0 *1 0,0
Ccc_XD0_nt_XD1_XN3_mid1 XD0.nt XD1.XN3.mid1 1.21e-17
* device instance cc_XD0_nt_XD1_XN3_mid2 r0 *1 0,0
Ccc_XD0_nt_XD1_XN3_mid2 XD0.nt XD1.XN3.mid2 1.21e-17
* device instance cc_XD0_nt_XD1_dmodout r0 *1 0,0
Ccc_XD0_nt_XD1_dmodout XD0.nt XD1.dmodout 1.21e-17
* device instance cc_XD0_nt_XD1_dq r0 *1 0,0
Ccc_XD0_nt_XD1_dq XD0.nt XD1.dq 1.8151e-17
* device instance cc_XD0_nt_XD1_nm r0 *1 0,0
Ccc_XD0_nt_XD1_nm XD0.nt XD1.nm 1.21e-17
* device instance cc_XD0_nt_XD1_nt r0 *1 0,0
Ccc_XD0_nt_XD1_nt XD0.nt XD1.nt 1.21e-17
* device instance cc_XD0_nt_XD1_t1 r0 *1 0,0
Ccc_XD0_nt_XD1_t1 XD0.nt XD1.t1 1.21e-17
* device instance cc_XD0_nt_XD2_XDFFM_CLKB r0 *1 0,0
Ccc_XD0_nt_XD2_XDFFM_CLKB XD0.nt XD2.XDFFM.CLKB 1.8151e-17
* device instance cc_XD0_nt_XD2_XDFFM_M r0 *1 0,0
Ccc_XD0_nt_XD2_XDFFM_M XD0.nt XD2.XDFFM.M 2.4201e-17
* device instance cc_XD0_nt_XD2_XDFFM_MB r0 *1 0,0
Ccc_XD0_nt_XD2_XDFFM_MB XD0.nt XD2.XDFFM.MB 1.21e-17
* device instance cc_XD0_nt_XD2_XDFFM_S r0 *1 0,0
Ccc_XD0_nt_XD2_XDFFM_S XD0.nt XD2.XDFFM.S 1.8151e-17
* device instance cc_XD0_nt_XD2_XDFFM_SB r0 *1 0,0
Ccc_XD0_nt_XD2_XDFFM_SB XD0.nt XD2.XDFFM.SB 1.8151e-17
* device instance cc_XD0_nt_XD2_XDFFQ_CLKB r0 *1 0,0
Ccc_XD0_nt_XD2_XDFFQ_CLKB XD0.nt XD2.XDFFQ.CLKB 1.8151e-17
* device instance cc_XD0_nt_XD2_XDFFQ_M r0 *1 0,0
Ccc_XD0_nt_XD2_XDFFQ_M XD0.nt XD2.XDFFQ.M 2.4201e-17
* device instance cc_XD0_nt_XD2_XDFFQ_MB r0 *1 0,0
Ccc_XD0_nt_XD2_XDFFQ_MB XD0.nt XD2.XDFFQ.MB 1.21e-17
* device instance cc_XD0_nt_XD2_XDFFQ_S r0 *1 0,0
Ccc_XD0_nt_XD2_XDFFQ_S XD0.nt XD2.XDFFQ.S 1.8151e-17
* device instance cc_XD0_nt_XD2_XDFFQ_SB r0 *1 0,0
Ccc_XD0_nt_XD2_XDFFQ_SB XD0.nt XD2.XDFFQ.SB 1.8151e-17
* device instance cc_XD0_nt_XD2_XN2_mid1 r0 *1 0,0
Ccc_XD0_nt_XD2_XN2_mid1 XD0.nt XD2.XN2.mid1 1.21e-17
* device instance cc_XD0_nt_XD2_XN3_mid1 r0 *1 0,0
Ccc_XD0_nt_XD2_XN3_mid1 XD0.nt XD2.XN3.mid1 1.21e-17
* device instance cc_XD0_nt_XD2_XN3_mid2 r0 *1 0,0
Ccc_XD0_nt_XD2_XN3_mid2 XD0.nt XD2.XN3.mid2 1.21e-17
* device instance cc_XD0_nt_XD2_dmodout r0 *1 0,0
Ccc_XD0_nt_XD2_dmodout XD0.nt XD2.dmodout 1.21e-17
* device instance cc_XD0_nt_XD2_dq r0 *1 0,0
Ccc_XD0_nt_XD2_dq XD0.nt XD2.dq 1.8151e-17
* device instance cc_XD0_nt_XD2_nm r0 *1 0,0
Ccc_XD0_nt_XD2_nm XD0.nt XD2.nm 1.21e-17
* device instance cc_XD0_nt_XD2_nt r0 *1 0,0
Ccc_XD0_nt_XD2_nt XD0.nt XD2.nt 1.21e-17
* device instance cc_XD0_nt_XD2_t1 r0 *1 0,0
Ccc_XD0_nt_XD2_t1 XD0.nt XD2.t1 1.21e-17
* device instance cc_XD0_nt_XD3_XDFFM_CLKB r0 *1 0,0
Ccc_XD0_nt_XD3_XDFFM_CLKB XD0.nt XD3.XDFFM.CLKB 1.8151e-17
* device instance cc_XD0_nt_XD3_XDFFM_M r0 *1 0,0
Ccc_XD0_nt_XD3_XDFFM_M XD0.nt XD3.XDFFM.M 2.4201e-17
* device instance cc_XD0_nt_XD3_XDFFM_MB r0 *1 0,0
Ccc_XD0_nt_XD3_XDFFM_MB XD0.nt XD3.XDFFM.MB 1.21e-17
* device instance cc_XD0_nt_XD3_XDFFM_S r0 *1 0,0
Ccc_XD0_nt_XD3_XDFFM_S XD0.nt XD3.XDFFM.S 1.8151e-17
* device instance cc_XD0_nt_XD3_XDFFM_SB r0 *1 0,0
Ccc_XD0_nt_XD3_XDFFM_SB XD0.nt XD3.XDFFM.SB 1.8151e-17
* device instance cc_XD0_nt_XD3_XDFFQ_CLKB r0 *1 0,0
Ccc_XD0_nt_XD3_XDFFQ_CLKB XD0.nt XD3.XDFFQ.CLKB 1.8151e-17
* device instance cc_XD0_nt_XD3_XDFFQ_M r0 *1 0,0
Ccc_XD0_nt_XD3_XDFFQ_M XD0.nt XD3.XDFFQ.M 2.4201e-17
* device instance cc_XD0_nt_XD3_XDFFQ_MB r0 *1 0,0
Ccc_XD0_nt_XD3_XDFFQ_MB XD0.nt XD3.XDFFQ.MB 1.21e-17
* device instance cc_XD0_nt_XD3_XDFFQ_S r0 *1 0,0
Ccc_XD0_nt_XD3_XDFFQ_S XD0.nt XD3.XDFFQ.S 1.8151e-17
* device instance cc_XD0_nt_XD3_XDFFQ_SB r0 *1 0,0
Ccc_XD0_nt_XD3_XDFFQ_SB XD0.nt XD3.XDFFQ.SB 1.8151e-17
* device instance cc_XD0_nt_XD3_XN2_mid1 r0 *1 0,0
Ccc_XD0_nt_XD3_XN2_mid1 XD0.nt XD3.XN2.mid1 1.21e-17
* device instance cc_XD0_nt_XD3_XN3_mid1 r0 *1 0,0
Ccc_XD0_nt_XD3_XN3_mid1 XD0.nt XD3.XN3.mid1 1.21e-17
* device instance cc_XD0_nt_XD3_XN3_mid2 r0 *1 0,0
Ccc_XD0_nt_XD3_XN3_mid2 XD0.nt XD3.XN3.mid2 1.21e-17
* device instance cc_XD0_nt_XD3_dmodout r0 *1 0,0
Ccc_XD0_nt_XD3_dmodout XD0.nt XD3.dmodout 1.21e-17
* device instance cc_XD0_nt_XD3_dq r0 *1 0,0
Ccc_XD0_nt_XD3_dq XD0.nt XD3.dq 1.8151e-17
* device instance cc_XD0_nt_XD3_nm r0 *1 0,0
Ccc_XD0_nt_XD3_nm XD0.nt XD3.nm 1.21e-17
* device instance cc_XD0_nt_XD3_nt r0 *1 0,0
Ccc_XD0_nt_XD3_nt XD0.nt XD3.nt 1.21e-17
* device instance cc_XD0_nt_XD3_t1 r0 *1 0,0
Ccc_XD0_nt_XD3_t1 XD0.nt XD3.t1 1.21e-17
* device instance cc_XD0_nt_XD4_XDFFM_CLKB r0 *1 0,0
Ccc_XD0_nt_XD4_XDFFM_CLKB XD0.nt XD4.XDFFM.CLKB 1.8151e-17
* device instance cc_XD0_nt_XD4_XDFFM_M r0 *1 0,0
Ccc_XD0_nt_XD4_XDFFM_M XD0.nt XD4.XDFFM.M 2.4201e-17
* device instance cc_XD0_nt_XD4_XDFFM_MB r0 *1 0,0
Ccc_XD0_nt_XD4_XDFFM_MB XD0.nt XD4.XDFFM.MB 1.21e-17
* device instance cc_XD0_nt_XD4_XDFFM_S r0 *1 0,0
Ccc_XD0_nt_XD4_XDFFM_S XD0.nt XD4.XDFFM.S 1.8151e-17
* device instance cc_XD0_nt_XD4_XDFFM_SB r0 *1 0,0
Ccc_XD0_nt_XD4_XDFFM_SB XD0.nt XD4.XDFFM.SB 1.8151e-17
* device instance cc_XD0_nt_XD4_XDFFQ_CLKB r0 *1 0,0
Ccc_XD0_nt_XD4_XDFFQ_CLKB XD0.nt XD4.XDFFQ.CLKB 1.8151e-17
* device instance cc_XD0_nt_XD4_XDFFQ_M r0 *1 0,0
Ccc_XD0_nt_XD4_XDFFQ_M XD0.nt XD4.XDFFQ.M 2.4201e-17
* device instance cc_XD0_nt_XD4_XDFFQ_MB r0 *1 0,0
Ccc_XD0_nt_XD4_XDFFQ_MB XD0.nt XD4.XDFFQ.MB 1.21e-17
* device instance cc_XD0_nt_XD4_XDFFQ_S r0 *1 0,0
Ccc_XD0_nt_XD4_XDFFQ_S XD0.nt XD4.XDFFQ.S 1.8151e-17
* device instance cc_XD0_nt_XD4_XDFFQ_SB r0 *1 0,0
Ccc_XD0_nt_XD4_XDFFQ_SB XD0.nt XD4.XDFFQ.SB 1.8151e-17
* device instance cc_XD0_nt_XD4_XN2_mid1 r0 *1 0,0
Ccc_XD0_nt_XD4_XN2_mid1 XD0.nt XD4.XN2.mid1 1.21e-17
* device instance cc_XD0_nt_XD4_XN3_mid1 r0 *1 0,0
Ccc_XD0_nt_XD4_XN3_mid1 XD0.nt XD4.XN3.mid1 1.21e-17
* device instance cc_XD0_nt_XD4_XN3_mid2 r0 *1 0,0
Ccc_XD0_nt_XD4_XN3_mid2 XD0.nt XD4.XN3.mid2 1.21e-17
* device instance cc_XD0_nt_XD4_dmodout r0 *1 0,0
Ccc_XD0_nt_XD4_dmodout XD0.nt XD4.dmodout 1.21e-17
* device instance cc_XD0_nt_XD4_dq r0 *1 0,0
Ccc_XD0_nt_XD4_dq XD0.nt XD4.dq 1.8151e-17
* device instance cc_XD0_nt_XD4_nm r0 *1 0,0
Ccc_XD0_nt_XD4_nm XD0.nt XD4.nm 1.21e-17
* device instance cc_XD0_nt_XD4_nt r0 *1 0,0
Ccc_XD0_nt_XD4_nt XD0.nt XD4.nt 1.21e-17
* device instance cc_XD0_nt_XD4_t1 r0 *1 0,0
Ccc_XD0_nt_XD4_t1 XD0.nt XD4.t1 1.21e-17
* device instance cc_XD0_nt_XD5_XDFFM_CLKB r0 *1 0,0
Ccc_XD0_nt_XD5_XDFFM_CLKB XD0.nt XD5.XDFFM.CLKB 1.8151e-17
* device instance cc_XD0_nt_XD5_XDFFM_M r0 *1 0,0
Ccc_XD0_nt_XD5_XDFFM_M XD0.nt XD5.XDFFM.M 2.4201e-17
* device instance cc_XD0_nt_XD5_XDFFM_MB r0 *1 0,0
Ccc_XD0_nt_XD5_XDFFM_MB XD0.nt XD5.XDFFM.MB 1.21e-17
* device instance cc_XD0_nt_XD5_XDFFM_S r0 *1 0,0
Ccc_XD0_nt_XD5_XDFFM_S XD0.nt XD5.XDFFM.S 1.8151e-17
* device instance cc_XD0_nt_XD5_XDFFM_SB r0 *1 0,0
Ccc_XD0_nt_XD5_XDFFM_SB XD0.nt XD5.XDFFM.SB 1.8151e-17
* device instance cc_XD0_nt_XD5_XDFFQ_CLKB r0 *1 0,0
Ccc_XD0_nt_XD5_XDFFQ_CLKB XD0.nt XD5.XDFFQ.CLKB 1.8151e-17
* device instance cc_XD0_nt_XD5_XDFFQ_M r0 *1 0,0
Ccc_XD0_nt_XD5_XDFFQ_M XD0.nt XD5.XDFFQ.M 2.4201e-17
* device instance cc_XD0_nt_XD5_XDFFQ_MB r0 *1 0,0
Ccc_XD0_nt_XD5_XDFFQ_MB XD0.nt XD5.XDFFQ.MB 1.21e-17
* device instance cc_XD0_nt_XD5_XDFFQ_S r0 *1 0,0
Ccc_XD0_nt_XD5_XDFFQ_S XD0.nt XD5.XDFFQ.S 1.8151e-17
* device instance cc_XD0_nt_XD5_XDFFQ_SB r0 *1 0,0
Ccc_XD0_nt_XD5_XDFFQ_SB XD0.nt XD5.XDFFQ.SB 1.8151e-17
* device instance cc_XD0_nt_XD5_XN2_mid1 r0 *1 0,0
Ccc_XD0_nt_XD5_XN2_mid1 XD0.nt XD5.XN2.mid1 1.21e-17
* device instance cc_XD0_nt_XD5_XN3_mid1 r0 *1 0,0
Ccc_XD0_nt_XD5_XN3_mid1 XD0.nt XD5.XN3.mid1 1.21e-17
* device instance cc_XD0_nt_XD5_XN3_mid2 r0 *1 0,0
Ccc_XD0_nt_XD5_XN3_mid2 XD0.nt XD5.XN3.mid2 1.21e-17
* device instance cc_XD0_nt_XD5_dmodout r0 *1 0,0
Ccc_XD0_nt_XD5_dmodout XD0.nt XD5.dmodout 1.21e-17
* device instance cc_XD0_nt_XD5_dq r0 *1 0,0
Ccc_XD0_nt_XD5_dq XD0.nt XD5.dq 1.8151e-17
* device instance cc_XD0_nt_XD5_nm r0 *1 0,0
Ccc_XD0_nt_XD5_nm XD0.nt XD5.nm 1.21e-17
* device instance cc_XD0_nt_XD5_nt r0 *1 0,0
Ccc_XD0_nt_XD5_nt XD0.nt XD5.nt 1.21e-17
* device instance cc_XD0_nt_XD5_t1 r0 *1 0,0
Ccc_XD0_nt_XD5_t1 XD0.nt XD5.t1 1.21e-17
* device instance cc_XD0_nt_XFRT_CLKB r0 *1 0,0
Ccc_XD0_nt_XFRT_CLKB XD0.nt XFRT.CLKB 1.8151e-17
* device instance cc_XD0_nt_XFRT_M r0 *1 0,0
Ccc_XD0_nt_XFRT_M XD0.nt XFRT.M 2.4201e-17
* device instance cc_XD0_nt_XFRT_MB r0 *1 0,0
Ccc_XD0_nt_XFRT_MB XD0.nt XFRT.MB 1.21e-17
* device instance cc_XD0_nt_XFRT_S r0 *1 0,0
Ccc_XD0_nt_XFRT_S XD0.nt XFRT.S 1.8151e-17
* device instance cc_XD0_nt_XFRT_SB r0 *1 0,0
Ccc_XD0_nt_XFRT_SB XD0.nt XFRT.SB 1.8151e-17
* device instance cc_XD0_nt_ck1 r0 *1 0,0
Ccc_XD0_nt_ck1 XD0.nt ck1 5.4452e-17
* device instance cc_XD0_nt_ck2 r0 *1 0,0
Ccc_XD0_nt_ck2 XD0.nt ck2 5.4452e-17
* device instance cc_XD0_nt_ck3 r0 *1 0,0
Ccc_XD0_nt_ck3 XD0.nt ck3 5.4452e-17
* device instance cc_XD0_nt_ck4 r0 *1 0,0
Ccc_XD0_nt_ck4 XD0.nt ck4 5.4452e-17
* device instance cc_XD0_nt_ck5 r0 *1 0,0
Ccc_XD0_nt_ck5 XD0.nt ck5 5.4452e-17
* device instance cc_XD0_nt_mod0 r0 *1 0,0
Ccc_XD0_nt_mod0 XD0.nt mod0 2.4201e-17
* device instance cc_XD0_nt_mod1 r0 *1 0,0
Ccc_XD0_nt_mod1 XD0.nt mod1 2.4201e-17
* device instance cc_XD0_nt_mod2 r0 *1 0,0
Ccc_XD0_nt_mod2 XD0.nt mod2 2.4201e-17
* device instance cc_XD0_nt_mod3 r0 *1 0,0
Ccc_XD0_nt_mod3 XD0.nt mod3 2.4201e-17
* device instance cc_XD0_nt_mod4 r0 *1 0,0
Ccc_XD0_nt_mod4 XD0.nt mod4 2.4201e-17
* device instance cc_XD0_nt_net1 r0 *1 0,0
Ccc_XD0_nt_net1 XD0.nt net1 1.8151e-17
* device instance cc_XD0_t1_XD1_XDFFM_CLKB r0 *1 0,0
Ccc_XD0_t1_XD1_XDFFM_CLKB XD0.t1 XD1.XDFFM.CLKB 1.8151e-17
* device instance cc_XD0_t1_XD1_XDFFM_M r0 *1 0,0
Ccc_XD0_t1_XD1_XDFFM_M XD0.t1 XD1.XDFFM.M 2.4201e-17
* device instance cc_XD0_t1_XD1_XDFFM_MB r0 *1 0,0
Ccc_XD0_t1_XD1_XDFFM_MB XD0.t1 XD1.XDFFM.MB 1.21e-17
* device instance cc_XD0_t1_XD1_XDFFM_S r0 *1 0,0
Ccc_XD0_t1_XD1_XDFFM_S XD0.t1 XD1.XDFFM.S 1.8151e-17
* device instance cc_XD0_t1_XD1_XDFFM_SB r0 *1 0,0
Ccc_XD0_t1_XD1_XDFFM_SB XD0.t1 XD1.XDFFM.SB 1.8151e-17
* device instance cc_XD0_t1_XD1_XDFFQ_CLKB r0 *1 0,0
Ccc_XD0_t1_XD1_XDFFQ_CLKB XD0.t1 XD1.XDFFQ.CLKB 1.8151e-17
* device instance cc_XD0_t1_XD1_XDFFQ_M r0 *1 0,0
Ccc_XD0_t1_XD1_XDFFQ_M XD0.t1 XD1.XDFFQ.M 2.4201e-17
* device instance cc_XD0_t1_XD1_XDFFQ_MB r0 *1 0,0
Ccc_XD0_t1_XD1_XDFFQ_MB XD0.t1 XD1.XDFFQ.MB 1.21e-17
* device instance cc_XD0_t1_XD1_XDFFQ_S r0 *1 0,0
Ccc_XD0_t1_XD1_XDFFQ_S XD0.t1 XD1.XDFFQ.S 1.8151e-17
* device instance cc_XD0_t1_XD1_XDFFQ_SB r0 *1 0,0
Ccc_XD0_t1_XD1_XDFFQ_SB XD0.t1 XD1.XDFFQ.SB 1.8151e-17
* device instance cc_XD0_t1_XD1_XN2_mid1 r0 *1 0,0
Ccc_XD0_t1_XD1_XN2_mid1 XD0.t1 XD1.XN2.mid1 1.21e-17
* device instance cc_XD0_t1_XD1_XN3_mid1 r0 *1 0,0
Ccc_XD0_t1_XD1_XN3_mid1 XD0.t1 XD1.XN3.mid1 1.21e-17
* device instance cc_XD0_t1_XD1_XN3_mid2 r0 *1 0,0
Ccc_XD0_t1_XD1_XN3_mid2 XD0.t1 XD1.XN3.mid2 1.21e-17
* device instance cc_XD0_t1_XD1_dmodout r0 *1 0,0
Ccc_XD0_t1_XD1_dmodout XD0.t1 XD1.dmodout 1.21e-17
* device instance cc_XD0_t1_XD1_dq r0 *1 0,0
Ccc_XD0_t1_XD1_dq XD0.t1 XD1.dq 1.8151e-17
* device instance cc_XD0_t1_XD1_nm r0 *1 0,0
Ccc_XD0_t1_XD1_nm XD0.t1 XD1.nm 1.21e-17
* device instance cc_XD0_t1_XD1_nt r0 *1 0,0
Ccc_XD0_t1_XD1_nt XD0.t1 XD1.nt 1.21e-17
* device instance cc_XD0_t1_XD1_t1 r0 *1 0,0
Ccc_XD0_t1_XD1_t1 XD0.t1 XD1.t1 1.21e-17
* device instance cc_XD0_t1_XD2_XDFFM_CLKB r0 *1 0,0
Ccc_XD0_t1_XD2_XDFFM_CLKB XD0.t1 XD2.XDFFM.CLKB 1.8151e-17
* device instance cc_XD0_t1_XD2_XDFFM_M r0 *1 0,0
Ccc_XD0_t1_XD2_XDFFM_M XD0.t1 XD2.XDFFM.M 2.4201e-17
* device instance cc_XD0_t1_XD2_XDFFM_MB r0 *1 0,0
Ccc_XD0_t1_XD2_XDFFM_MB XD0.t1 XD2.XDFFM.MB 1.21e-17
* device instance cc_XD0_t1_XD2_XDFFM_S r0 *1 0,0
Ccc_XD0_t1_XD2_XDFFM_S XD0.t1 XD2.XDFFM.S 1.8151e-17
* device instance cc_XD0_t1_XD2_XDFFM_SB r0 *1 0,0
Ccc_XD0_t1_XD2_XDFFM_SB XD0.t1 XD2.XDFFM.SB 1.8151e-17
* device instance cc_XD0_t1_XD2_XDFFQ_CLKB r0 *1 0,0
Ccc_XD0_t1_XD2_XDFFQ_CLKB XD0.t1 XD2.XDFFQ.CLKB 1.8151e-17
* device instance cc_XD0_t1_XD2_XDFFQ_M r0 *1 0,0
Ccc_XD0_t1_XD2_XDFFQ_M XD0.t1 XD2.XDFFQ.M 2.4201e-17
* device instance cc_XD0_t1_XD2_XDFFQ_MB r0 *1 0,0
Ccc_XD0_t1_XD2_XDFFQ_MB XD0.t1 XD2.XDFFQ.MB 1.21e-17
* device instance cc_XD0_t1_XD2_XDFFQ_S r0 *1 0,0
Ccc_XD0_t1_XD2_XDFFQ_S XD0.t1 XD2.XDFFQ.S 1.8151e-17
* device instance cc_XD0_t1_XD2_XDFFQ_SB r0 *1 0,0
Ccc_XD0_t1_XD2_XDFFQ_SB XD0.t1 XD2.XDFFQ.SB 1.8151e-17
* device instance cc_XD0_t1_XD2_XN2_mid1 r0 *1 0,0
Ccc_XD0_t1_XD2_XN2_mid1 XD0.t1 XD2.XN2.mid1 1.21e-17
* device instance cc_XD0_t1_XD2_XN3_mid1 r0 *1 0,0
Ccc_XD0_t1_XD2_XN3_mid1 XD0.t1 XD2.XN3.mid1 1.21e-17
* device instance cc_XD0_t1_XD2_XN3_mid2 r0 *1 0,0
Ccc_XD0_t1_XD2_XN3_mid2 XD0.t1 XD2.XN3.mid2 1.21e-17
* device instance cc_XD0_t1_XD2_dmodout r0 *1 0,0
Ccc_XD0_t1_XD2_dmodout XD0.t1 XD2.dmodout 1.21e-17
* device instance cc_XD0_t1_XD2_dq r0 *1 0,0
Ccc_XD0_t1_XD2_dq XD0.t1 XD2.dq 1.8151e-17
* device instance cc_XD0_t1_XD2_nm r0 *1 0,0
Ccc_XD0_t1_XD2_nm XD0.t1 XD2.nm 1.21e-17
* device instance cc_XD0_t1_XD2_nt r0 *1 0,0
Ccc_XD0_t1_XD2_nt XD0.t1 XD2.nt 1.21e-17
* device instance cc_XD0_t1_XD2_t1 r0 *1 0,0
Ccc_XD0_t1_XD2_t1 XD0.t1 XD2.t1 1.21e-17
* device instance cc_XD0_t1_XD3_XDFFM_CLKB r0 *1 0,0
Ccc_XD0_t1_XD3_XDFFM_CLKB XD0.t1 XD3.XDFFM.CLKB 1.8151e-17
* device instance cc_XD0_t1_XD3_XDFFM_M r0 *1 0,0
Ccc_XD0_t1_XD3_XDFFM_M XD0.t1 XD3.XDFFM.M 2.4201e-17
* device instance cc_XD0_t1_XD3_XDFFM_MB r0 *1 0,0
Ccc_XD0_t1_XD3_XDFFM_MB XD0.t1 XD3.XDFFM.MB 1.21e-17
* device instance cc_XD0_t1_XD3_XDFFM_S r0 *1 0,0
Ccc_XD0_t1_XD3_XDFFM_S XD0.t1 XD3.XDFFM.S 1.8151e-17
* device instance cc_XD0_t1_XD3_XDFFM_SB r0 *1 0,0
Ccc_XD0_t1_XD3_XDFFM_SB XD0.t1 XD3.XDFFM.SB 1.8151e-17
* device instance cc_XD0_t1_XD3_XDFFQ_CLKB r0 *1 0,0
Ccc_XD0_t1_XD3_XDFFQ_CLKB XD0.t1 XD3.XDFFQ.CLKB 1.8151e-17
* device instance cc_XD0_t1_XD3_XDFFQ_M r0 *1 0,0
Ccc_XD0_t1_XD3_XDFFQ_M XD0.t1 XD3.XDFFQ.M 2.4201e-17
* device instance cc_XD0_t1_XD3_XDFFQ_MB r0 *1 0,0
Ccc_XD0_t1_XD3_XDFFQ_MB XD0.t1 XD3.XDFFQ.MB 1.21e-17
* device instance cc_XD0_t1_XD3_XDFFQ_S r0 *1 0,0
Ccc_XD0_t1_XD3_XDFFQ_S XD0.t1 XD3.XDFFQ.S 1.8151e-17
* device instance cc_XD0_t1_XD3_XDFFQ_SB r0 *1 0,0
Ccc_XD0_t1_XD3_XDFFQ_SB XD0.t1 XD3.XDFFQ.SB 1.8151e-17
* device instance cc_XD0_t1_XD3_XN2_mid1 r0 *1 0,0
Ccc_XD0_t1_XD3_XN2_mid1 XD0.t1 XD3.XN2.mid1 1.21e-17
* device instance cc_XD0_t1_XD3_XN3_mid1 r0 *1 0,0
Ccc_XD0_t1_XD3_XN3_mid1 XD0.t1 XD3.XN3.mid1 1.21e-17
* device instance cc_XD0_t1_XD3_XN3_mid2 r0 *1 0,0
Ccc_XD0_t1_XD3_XN3_mid2 XD0.t1 XD3.XN3.mid2 1.21e-17
* device instance cc_XD0_t1_XD3_dmodout r0 *1 0,0
Ccc_XD0_t1_XD3_dmodout XD0.t1 XD3.dmodout 1.21e-17
* device instance cc_XD0_t1_XD3_dq r0 *1 0,0
Ccc_XD0_t1_XD3_dq XD0.t1 XD3.dq 1.8151e-17
* device instance cc_XD0_t1_XD3_nm r0 *1 0,0
Ccc_XD0_t1_XD3_nm XD0.t1 XD3.nm 1.21e-17
* device instance cc_XD0_t1_XD3_nt r0 *1 0,0
Ccc_XD0_t1_XD3_nt XD0.t1 XD3.nt 1.21e-17
* device instance cc_XD0_t1_XD3_t1 r0 *1 0,0
Ccc_XD0_t1_XD3_t1 XD0.t1 XD3.t1 1.21e-17
* device instance cc_XD0_t1_XD4_XDFFM_CLKB r0 *1 0,0
Ccc_XD0_t1_XD4_XDFFM_CLKB XD0.t1 XD4.XDFFM.CLKB 1.8151e-17
* device instance cc_XD0_t1_XD4_XDFFM_M r0 *1 0,0
Ccc_XD0_t1_XD4_XDFFM_M XD0.t1 XD4.XDFFM.M 2.4201e-17
* device instance cc_XD0_t1_XD4_XDFFM_MB r0 *1 0,0
Ccc_XD0_t1_XD4_XDFFM_MB XD0.t1 XD4.XDFFM.MB 1.21e-17
* device instance cc_XD0_t1_XD4_XDFFM_S r0 *1 0,0
Ccc_XD0_t1_XD4_XDFFM_S XD0.t1 XD4.XDFFM.S 1.8151e-17
* device instance cc_XD0_t1_XD4_XDFFM_SB r0 *1 0,0
Ccc_XD0_t1_XD4_XDFFM_SB XD0.t1 XD4.XDFFM.SB 1.8151e-17
* device instance cc_XD0_t1_XD4_XDFFQ_CLKB r0 *1 0,0
Ccc_XD0_t1_XD4_XDFFQ_CLKB XD0.t1 XD4.XDFFQ.CLKB 1.8151e-17
* device instance cc_XD0_t1_XD4_XDFFQ_M r0 *1 0,0
Ccc_XD0_t1_XD4_XDFFQ_M XD0.t1 XD4.XDFFQ.M 2.4201e-17
* device instance cc_XD0_t1_XD4_XDFFQ_MB r0 *1 0,0
Ccc_XD0_t1_XD4_XDFFQ_MB XD0.t1 XD4.XDFFQ.MB 1.21e-17
* device instance cc_XD0_t1_XD4_XDFFQ_S r0 *1 0,0
Ccc_XD0_t1_XD4_XDFFQ_S XD0.t1 XD4.XDFFQ.S 1.8151e-17
* device instance cc_XD0_t1_XD4_XDFFQ_SB r0 *1 0,0
Ccc_XD0_t1_XD4_XDFFQ_SB XD0.t1 XD4.XDFFQ.SB 1.8151e-17
* device instance cc_XD0_t1_XD4_XN2_mid1 r0 *1 0,0
Ccc_XD0_t1_XD4_XN2_mid1 XD0.t1 XD4.XN2.mid1 1.21e-17
* device instance cc_XD0_t1_XD4_XN3_mid1 r0 *1 0,0
Ccc_XD0_t1_XD4_XN3_mid1 XD0.t1 XD4.XN3.mid1 1.21e-17
* device instance cc_XD0_t1_XD4_XN3_mid2 r0 *1 0,0
Ccc_XD0_t1_XD4_XN3_mid2 XD0.t1 XD4.XN3.mid2 1.21e-17
* device instance cc_XD0_t1_XD4_dmodout r0 *1 0,0
Ccc_XD0_t1_XD4_dmodout XD0.t1 XD4.dmodout 1.21e-17
* device instance cc_XD0_t1_XD4_dq r0 *1 0,0
Ccc_XD0_t1_XD4_dq XD0.t1 XD4.dq 1.8151e-17
* device instance cc_XD0_t1_XD4_nm r0 *1 0,0
Ccc_XD0_t1_XD4_nm XD0.t1 XD4.nm 1.21e-17
* device instance cc_XD0_t1_XD4_nt r0 *1 0,0
Ccc_XD0_t1_XD4_nt XD0.t1 XD4.nt 1.21e-17
* device instance cc_XD0_t1_XD4_t1 r0 *1 0,0
Ccc_XD0_t1_XD4_t1 XD0.t1 XD4.t1 1.21e-17
* device instance cc_XD0_t1_XD5_XDFFM_CLKB r0 *1 0,0
Ccc_XD0_t1_XD5_XDFFM_CLKB XD0.t1 XD5.XDFFM.CLKB 1.8151e-17
* device instance cc_XD0_t1_XD5_XDFFM_M r0 *1 0,0
Ccc_XD0_t1_XD5_XDFFM_M XD0.t1 XD5.XDFFM.M 2.4201e-17
* device instance cc_XD0_t1_XD5_XDFFM_MB r0 *1 0,0
Ccc_XD0_t1_XD5_XDFFM_MB XD0.t1 XD5.XDFFM.MB 1.21e-17
* device instance cc_XD0_t1_XD5_XDFFM_S r0 *1 0,0
Ccc_XD0_t1_XD5_XDFFM_S XD0.t1 XD5.XDFFM.S 1.8151e-17
* device instance cc_XD0_t1_XD5_XDFFM_SB r0 *1 0,0
Ccc_XD0_t1_XD5_XDFFM_SB XD0.t1 XD5.XDFFM.SB 1.8151e-17
* device instance cc_XD0_t1_XD5_XDFFQ_CLKB r0 *1 0,0
Ccc_XD0_t1_XD5_XDFFQ_CLKB XD0.t1 XD5.XDFFQ.CLKB 1.8151e-17
* device instance cc_XD0_t1_XD5_XDFFQ_M r0 *1 0,0
Ccc_XD0_t1_XD5_XDFFQ_M XD0.t1 XD5.XDFFQ.M 2.4201e-17
* device instance cc_XD0_t1_XD5_XDFFQ_MB r0 *1 0,0
Ccc_XD0_t1_XD5_XDFFQ_MB XD0.t1 XD5.XDFFQ.MB 1.21e-17
* device instance cc_XD0_t1_XD5_XDFFQ_S r0 *1 0,0
Ccc_XD0_t1_XD5_XDFFQ_S XD0.t1 XD5.XDFFQ.S 1.8151e-17
* device instance cc_XD0_t1_XD5_XDFFQ_SB r0 *1 0,0
Ccc_XD0_t1_XD5_XDFFQ_SB XD0.t1 XD5.XDFFQ.SB 1.8151e-17
* device instance cc_XD0_t1_XD5_XN2_mid1 r0 *1 0,0
Ccc_XD0_t1_XD5_XN2_mid1 XD0.t1 XD5.XN2.mid1 1.21e-17
* device instance cc_XD0_t1_XD5_XN3_mid1 r0 *1 0,0
Ccc_XD0_t1_XD5_XN3_mid1 XD0.t1 XD5.XN3.mid1 1.21e-17
* device instance cc_XD0_t1_XD5_XN3_mid2 r0 *1 0,0
Ccc_XD0_t1_XD5_XN3_mid2 XD0.t1 XD5.XN3.mid2 1.21e-17
* device instance cc_XD0_t1_XD5_dmodout r0 *1 0,0
Ccc_XD0_t1_XD5_dmodout XD0.t1 XD5.dmodout 1.21e-17
* device instance cc_XD0_t1_XD5_dq r0 *1 0,0
Ccc_XD0_t1_XD5_dq XD0.t1 XD5.dq 1.8151e-17
* device instance cc_XD0_t1_XD5_nm r0 *1 0,0
Ccc_XD0_t1_XD5_nm XD0.t1 XD5.nm 1.21e-17
* device instance cc_XD0_t1_XD5_nt r0 *1 0,0
Ccc_XD0_t1_XD5_nt XD0.t1 XD5.nt 1.21e-17
* device instance cc_XD0_t1_XD5_t1 r0 *1 0,0
Ccc_XD0_t1_XD5_t1 XD0.t1 XD5.t1 1.21e-17
* device instance cc_XD0_t1_XFRT_CLKB r0 *1 0,0
Ccc_XD0_t1_XFRT_CLKB XD0.t1 XFRT.CLKB 1.8151e-17
* device instance cc_XD0_t1_XFRT_M r0 *1 0,0
Ccc_XD0_t1_XFRT_M XD0.t1 XFRT.M 2.4201e-17
* device instance cc_XD0_t1_XFRT_MB r0 *1 0,0
Ccc_XD0_t1_XFRT_MB XD0.t1 XFRT.MB 1.21e-17
* device instance cc_XD0_t1_XFRT_S r0 *1 0,0
Ccc_XD0_t1_XFRT_S XD0.t1 XFRT.S 1.8151e-17
* device instance cc_XD0_t1_XFRT_SB r0 *1 0,0
Ccc_XD0_t1_XFRT_SB XD0.t1 XFRT.SB 1.8151e-17
* device instance cc_XD0_t1_ck1 r0 *1 0,0
Ccc_XD0_t1_ck1 XD0.t1 ck1 6.0502e-17
* device instance cc_XD0_t1_ck2 r0 *1 0,0
Ccc_XD0_t1_ck2 XD0.t1 ck2 5.4452e-17
* device instance cc_XD0_t1_ck3 r0 *1 0,0
Ccc_XD0_t1_ck3 XD0.t1 ck3 5.4452e-17
* device instance cc_XD0_t1_ck4 r0 *1 0,0
Ccc_XD0_t1_ck4 XD0.t1 ck4 5.4452e-17
* device instance cc_XD0_t1_ck5 r0 *1 0,0
Ccc_XD0_t1_ck5 XD0.t1 ck5 5.4452e-17
* device instance cc_XD0_t1_mod0 r0 *1 0,0
Ccc_XD0_t1_mod0 XD0.t1 mod0 2.4201e-17
* device instance cc_XD0_t1_mod1 r0 *1 0,0
Ccc_XD0_t1_mod1 XD0.t1 mod1 2.4201e-17
* device instance cc_XD0_t1_mod2 r0 *1 0,0
Ccc_XD0_t1_mod2 XD0.t1 mod2 2.4201e-17
* device instance cc_XD0_t1_mod3 r0 *1 0,0
Ccc_XD0_t1_mod3 XD0.t1 mod3 2.4201e-17
* device instance cc_XD0_t1_mod4 r0 *1 0,0
Ccc_XD0_t1_mod4 XD0.t1 mod4 2.4201e-17
* device instance cc_XD0_t1_net1 r0 *1 0,0
Ccc_XD0_t1_net1 XD0.t1 net1 1.21e-17
* device instance cc_XD1_XDFFM_CLKB_XD1_XDFFM_M r0 *1 0,0
Ccc_XD1_XDFFM_CLKB_XD1_XDFFM_M XD1.XDFFM.CLKB XD1.XDFFM.M 4.2352e-17
* device instance cc_XD1_XDFFM_CLKB_XD1_XDFFM_MB r0 *1 0,0
Ccc_XD1_XDFFM_CLKB_XD1_XDFFM_MB XD1.XDFFM.CLKB XD1.XDFFM.MB 2.4201e-17
* device instance cc_XD1_XDFFM_CLKB_XD1_XDFFM_S r0 *1 0,0
Ccc_XD1_XDFFM_CLKB_XD1_XDFFM_S XD1.XDFFM.CLKB XD1.XDFFM.S 1.8151e-17
* device instance cc_XD1_XDFFM_CLKB_XD1_XDFFM_SB r0 *1 0,0
Ccc_XD1_XDFFM_CLKB_XD1_XDFFM_SB XD1.XDFFM.CLKB XD1.XDFFM.SB 1.8151e-17
* device instance cc_XD1_XDFFM_CLKB_XD1_XDFFQ_CLKB r0 *1 0,0
Ccc_XD1_XDFFM_CLKB_XD1_XDFFQ_CLKB XD1.XDFFM.CLKB XD1.XDFFQ.CLKB 1.8151e-17
* device instance cc_XD1_XDFFM_CLKB_XD1_XDFFQ_M r0 *1 0,0
Ccc_XD1_XDFFM_CLKB_XD1_XDFFQ_M XD1.XDFFM.CLKB XD1.XDFFQ.M 2.4201e-17
* device instance cc_XD1_XDFFM_CLKB_XD1_XDFFQ_MB r0 *1 0,0
Ccc_XD1_XDFFM_CLKB_XD1_XDFFQ_MB XD1.XDFFM.CLKB XD1.XDFFQ.MB 1.21e-17
* device instance cc_XD1_XDFFM_CLKB_XD1_XDFFQ_S r0 *1 0,0
Ccc_XD1_XDFFM_CLKB_XD1_XDFFQ_S XD1.XDFFM.CLKB XD1.XDFFQ.S 1.8151e-17
* device instance cc_XD1_XDFFM_CLKB_XD1_XDFFQ_SB r0 *1 0,0
Ccc_XD1_XDFFM_CLKB_XD1_XDFFQ_SB XD1.XDFFM.CLKB XD1.XDFFQ.SB 1.8151e-17
* device instance cc_XD1_XDFFM_CLKB_XD1_XNOR_midp r0 *1 0,0
Ccc_XD1_XDFFM_CLKB_XD1_XNOR_midp XD1.XDFFM.CLKB XD1.XNOR.midp 1.21e-17
* device instance cc_XD1_XDFFM_CLKB_XD1_dmodout r0 *1 0,0
Ccc_XD1_XDFFM_CLKB_XD1_dmodout XD1.XDFFM.CLKB XD1.dmodout 1.8151e-17
* device instance cc_XD1_XDFFM_CLKB_XD1_dq r0 *1 0,0
Ccc_XD1_XDFFM_CLKB_XD1_dq XD1.XDFFM.CLKB XD1.dq 1.21e-17
* device instance cc_XD1_XDFFM_CLKB_XD1_nm r0 *1 0,0
Ccc_XD1_XDFFM_CLKB_XD1_nm XD1.XDFFM.CLKB XD1.nm 1.8151e-17
* device instance cc_XD1_XDFFM_CLKB_XD1_nt r0 *1 0,0
Ccc_XD1_XDFFM_CLKB_XD1_nt XD1.XDFFM.CLKB XD1.nt 2.4201e-17
* device instance cc_XD1_XDFFM_CLKB_XD1_t1 r0 *1 0,0
Ccc_XD1_XDFFM_CLKB_XD1_t1 XD1.XDFFM.CLKB XD1.t1 1.21e-17
* device instance cc_XD1_XDFFM_CLKB_XD2_XDFFM_CLKB r0 *1 0,0
Ccc_XD1_XDFFM_CLKB_XD2_XDFFM_CLKB XD1.XDFFM.CLKB XD2.XDFFM.CLKB 1.8151e-17
* device instance cc_XD1_XDFFM_CLKB_XD2_XDFFM_M r0 *1 0,0
Ccc_XD1_XDFFM_CLKB_XD2_XDFFM_M XD1.XDFFM.CLKB XD2.XDFFM.M 2.4201e-17
* device instance cc_XD1_XDFFM_CLKB_XD2_XDFFM_MB r0 *1 0,0
Ccc_XD1_XDFFM_CLKB_XD2_XDFFM_MB XD1.XDFFM.CLKB XD2.XDFFM.MB 1.21e-17
* device instance cc_XD1_XDFFM_CLKB_XD2_XDFFM_S r0 *1 0,0
Ccc_XD1_XDFFM_CLKB_XD2_XDFFM_S XD1.XDFFM.CLKB XD2.XDFFM.S 1.8151e-17
* device instance cc_XD1_XDFFM_CLKB_XD2_XDFFM_SB r0 *1 0,0
Ccc_XD1_XDFFM_CLKB_XD2_XDFFM_SB XD1.XDFFM.CLKB XD2.XDFFM.SB 1.8151e-17
* device instance cc_XD1_XDFFM_CLKB_XD2_XDFFQ_CLKB r0 *1 0,0
Ccc_XD1_XDFFM_CLKB_XD2_XDFFQ_CLKB XD1.XDFFM.CLKB XD2.XDFFQ.CLKB 1.8151e-17
* device instance cc_XD1_XDFFM_CLKB_XD2_XDFFQ_M r0 *1 0,0
Ccc_XD1_XDFFM_CLKB_XD2_XDFFQ_M XD1.XDFFM.CLKB XD2.XDFFQ.M 2.4201e-17
* device instance cc_XD1_XDFFM_CLKB_XD2_XDFFQ_MB r0 *1 0,0
Ccc_XD1_XDFFM_CLKB_XD2_XDFFQ_MB XD1.XDFFM.CLKB XD2.XDFFQ.MB 1.21e-17
* device instance cc_XD1_XDFFM_CLKB_XD2_XDFFQ_S r0 *1 0,0
Ccc_XD1_XDFFM_CLKB_XD2_XDFFQ_S XD1.XDFFM.CLKB XD2.XDFFQ.S 1.8151e-17
* device instance cc_XD1_XDFFM_CLKB_XD2_XDFFQ_SB r0 *1 0,0
Ccc_XD1_XDFFM_CLKB_XD2_XDFFQ_SB XD1.XDFFM.CLKB XD2.XDFFQ.SB 1.8151e-17
* device instance cc_XD1_XDFFM_CLKB_XD2_XN2_mid1 r0 *1 0,0
Ccc_XD1_XDFFM_CLKB_XD2_XN2_mid1 XD1.XDFFM.CLKB XD2.XN2.mid1 1.21e-17
* device instance cc_XD1_XDFFM_CLKB_XD2_XN3_mid1 r0 *1 0,0
Ccc_XD1_XDFFM_CLKB_XD2_XN3_mid1 XD1.XDFFM.CLKB XD2.XN3.mid1 1.21e-17
* device instance cc_XD1_XDFFM_CLKB_XD2_XN3_mid2 r0 *1 0,0
Ccc_XD1_XDFFM_CLKB_XD2_XN3_mid2 XD1.XDFFM.CLKB XD2.XN3.mid2 1.21e-17
* device instance cc_XD1_XDFFM_CLKB_XD2_dmodout r0 *1 0,0
Ccc_XD1_XDFFM_CLKB_XD2_dmodout XD1.XDFFM.CLKB XD2.dmodout 1.21e-17
* device instance cc_XD1_XDFFM_CLKB_XD2_dq r0 *1 0,0
Ccc_XD1_XDFFM_CLKB_XD2_dq XD1.XDFFM.CLKB XD2.dq 1.8151e-17
* device instance cc_XD1_XDFFM_CLKB_XD2_nm r0 *1 0,0
Ccc_XD1_XDFFM_CLKB_XD2_nm XD1.XDFFM.CLKB XD2.nm 1.21e-17
* device instance cc_XD1_XDFFM_CLKB_XD2_nt r0 *1 0,0
Ccc_XD1_XDFFM_CLKB_XD2_nt XD1.XDFFM.CLKB XD2.nt 1.21e-17
* device instance cc_XD1_XDFFM_CLKB_XD2_t1 r0 *1 0,0
Ccc_XD1_XDFFM_CLKB_XD2_t1 XD1.XDFFM.CLKB XD2.t1 1.21e-17
* device instance cc_XD1_XDFFM_CLKB_XD3_XDFFM_CLKB r0 *1 0,0
Ccc_XD1_XDFFM_CLKB_XD3_XDFFM_CLKB XD1.XDFFM.CLKB XD3.XDFFM.CLKB 1.8151e-17
* device instance cc_XD1_XDFFM_CLKB_XD3_XDFFM_M r0 *1 0,0
Ccc_XD1_XDFFM_CLKB_XD3_XDFFM_M XD1.XDFFM.CLKB XD3.XDFFM.M 2.4201e-17
* device instance cc_XD1_XDFFM_CLKB_XD3_XDFFM_MB r0 *1 0,0
Ccc_XD1_XDFFM_CLKB_XD3_XDFFM_MB XD1.XDFFM.CLKB XD3.XDFFM.MB 1.21e-17
* device instance cc_XD1_XDFFM_CLKB_XD3_XDFFM_S r0 *1 0,0
Ccc_XD1_XDFFM_CLKB_XD3_XDFFM_S XD1.XDFFM.CLKB XD3.XDFFM.S 1.8151e-17
* device instance cc_XD1_XDFFM_CLKB_XD3_XDFFM_SB r0 *1 0,0
Ccc_XD1_XDFFM_CLKB_XD3_XDFFM_SB XD1.XDFFM.CLKB XD3.XDFFM.SB 1.8151e-17
* device instance cc_XD1_XDFFM_CLKB_XD3_XDFFQ_CLKB r0 *1 0,0
Ccc_XD1_XDFFM_CLKB_XD3_XDFFQ_CLKB XD1.XDFFM.CLKB XD3.XDFFQ.CLKB 1.8151e-17
* device instance cc_XD1_XDFFM_CLKB_XD3_XDFFQ_M r0 *1 0,0
Ccc_XD1_XDFFM_CLKB_XD3_XDFFQ_M XD1.XDFFM.CLKB XD3.XDFFQ.M 2.4201e-17
* device instance cc_XD1_XDFFM_CLKB_XD3_XDFFQ_MB r0 *1 0,0
Ccc_XD1_XDFFM_CLKB_XD3_XDFFQ_MB XD1.XDFFM.CLKB XD3.XDFFQ.MB 1.21e-17
* device instance cc_XD1_XDFFM_CLKB_XD3_XDFFQ_S r0 *1 0,0
Ccc_XD1_XDFFM_CLKB_XD3_XDFFQ_S XD1.XDFFM.CLKB XD3.XDFFQ.S 1.8151e-17
* device instance cc_XD1_XDFFM_CLKB_XD3_XDFFQ_SB r0 *1 0,0
Ccc_XD1_XDFFM_CLKB_XD3_XDFFQ_SB XD1.XDFFM.CLKB XD3.XDFFQ.SB 1.8151e-17
* device instance cc_XD1_XDFFM_CLKB_XD3_XN2_mid1 r0 *1 0,0
Ccc_XD1_XDFFM_CLKB_XD3_XN2_mid1 XD1.XDFFM.CLKB XD3.XN2.mid1 1.21e-17
* device instance cc_XD1_XDFFM_CLKB_XD3_XN3_mid1 r0 *1 0,0
Ccc_XD1_XDFFM_CLKB_XD3_XN3_mid1 XD1.XDFFM.CLKB XD3.XN3.mid1 1.21e-17
* device instance cc_XD1_XDFFM_CLKB_XD3_XN3_mid2 r0 *1 0,0
Ccc_XD1_XDFFM_CLKB_XD3_XN3_mid2 XD1.XDFFM.CLKB XD3.XN3.mid2 1.21e-17
* device instance cc_XD1_XDFFM_CLKB_XD3_dmodout r0 *1 0,0
Ccc_XD1_XDFFM_CLKB_XD3_dmodout XD1.XDFFM.CLKB XD3.dmodout 1.21e-17
* device instance cc_XD1_XDFFM_CLKB_XD3_dq r0 *1 0,0
Ccc_XD1_XDFFM_CLKB_XD3_dq XD1.XDFFM.CLKB XD3.dq 1.8151e-17
* device instance cc_XD1_XDFFM_CLKB_XD3_nm r0 *1 0,0
Ccc_XD1_XDFFM_CLKB_XD3_nm XD1.XDFFM.CLKB XD3.nm 1.21e-17
* device instance cc_XD1_XDFFM_CLKB_XD3_nt r0 *1 0,0
Ccc_XD1_XDFFM_CLKB_XD3_nt XD1.XDFFM.CLKB XD3.nt 1.21e-17
* device instance cc_XD1_XDFFM_CLKB_XD3_t1 r0 *1 0,0
Ccc_XD1_XDFFM_CLKB_XD3_t1 XD1.XDFFM.CLKB XD3.t1 1.21e-17
* device instance cc_XD1_XDFFM_CLKB_XD4_XDFFM_CLKB r0 *1 0,0
Ccc_XD1_XDFFM_CLKB_XD4_XDFFM_CLKB XD1.XDFFM.CLKB XD4.XDFFM.CLKB 1.8151e-17
* device instance cc_XD1_XDFFM_CLKB_XD4_XDFFM_M r0 *1 0,0
Ccc_XD1_XDFFM_CLKB_XD4_XDFFM_M XD1.XDFFM.CLKB XD4.XDFFM.M 2.4201e-17
* device instance cc_XD1_XDFFM_CLKB_XD4_XDFFM_MB r0 *1 0,0
Ccc_XD1_XDFFM_CLKB_XD4_XDFFM_MB XD1.XDFFM.CLKB XD4.XDFFM.MB 1.21e-17
* device instance cc_XD1_XDFFM_CLKB_XD4_XDFFM_S r0 *1 0,0
Ccc_XD1_XDFFM_CLKB_XD4_XDFFM_S XD1.XDFFM.CLKB XD4.XDFFM.S 1.8151e-17
* device instance cc_XD1_XDFFM_CLKB_XD4_XDFFM_SB r0 *1 0,0
Ccc_XD1_XDFFM_CLKB_XD4_XDFFM_SB XD1.XDFFM.CLKB XD4.XDFFM.SB 1.8151e-17
* device instance cc_XD1_XDFFM_CLKB_XD4_XDFFQ_CLKB r0 *1 0,0
Ccc_XD1_XDFFM_CLKB_XD4_XDFFQ_CLKB XD1.XDFFM.CLKB XD4.XDFFQ.CLKB 1.8151e-17
* device instance cc_XD1_XDFFM_CLKB_XD4_XDFFQ_M r0 *1 0,0
Ccc_XD1_XDFFM_CLKB_XD4_XDFFQ_M XD1.XDFFM.CLKB XD4.XDFFQ.M 2.4201e-17
* device instance cc_XD1_XDFFM_CLKB_XD4_XDFFQ_MB r0 *1 0,0
Ccc_XD1_XDFFM_CLKB_XD4_XDFFQ_MB XD1.XDFFM.CLKB XD4.XDFFQ.MB 1.21e-17
* device instance cc_XD1_XDFFM_CLKB_XD4_XDFFQ_S r0 *1 0,0
Ccc_XD1_XDFFM_CLKB_XD4_XDFFQ_S XD1.XDFFM.CLKB XD4.XDFFQ.S 1.8151e-17
* device instance cc_XD1_XDFFM_CLKB_XD4_XDFFQ_SB r0 *1 0,0
Ccc_XD1_XDFFM_CLKB_XD4_XDFFQ_SB XD1.XDFFM.CLKB XD4.XDFFQ.SB 1.8151e-17
* device instance cc_XD1_XDFFM_CLKB_XD4_XN2_mid1 r0 *1 0,0
Ccc_XD1_XDFFM_CLKB_XD4_XN2_mid1 XD1.XDFFM.CLKB XD4.XN2.mid1 1.21e-17
* device instance cc_XD1_XDFFM_CLKB_XD4_XN3_mid1 r0 *1 0,0
Ccc_XD1_XDFFM_CLKB_XD4_XN3_mid1 XD1.XDFFM.CLKB XD4.XN3.mid1 1.21e-17
* device instance cc_XD1_XDFFM_CLKB_XD4_XN3_mid2 r0 *1 0,0
Ccc_XD1_XDFFM_CLKB_XD4_XN3_mid2 XD1.XDFFM.CLKB XD4.XN3.mid2 1.21e-17
* device instance cc_XD1_XDFFM_CLKB_XD4_dmodout r0 *1 0,0
Ccc_XD1_XDFFM_CLKB_XD4_dmodout XD1.XDFFM.CLKB XD4.dmodout 1.21e-17
* device instance cc_XD1_XDFFM_CLKB_XD4_dq r0 *1 0,0
Ccc_XD1_XDFFM_CLKB_XD4_dq XD1.XDFFM.CLKB XD4.dq 1.8151e-17
* device instance cc_XD1_XDFFM_CLKB_XD4_nm r0 *1 0,0
Ccc_XD1_XDFFM_CLKB_XD4_nm XD1.XDFFM.CLKB XD4.nm 1.21e-17
* device instance cc_XD1_XDFFM_CLKB_XD4_nt r0 *1 0,0
Ccc_XD1_XDFFM_CLKB_XD4_nt XD1.XDFFM.CLKB XD4.nt 1.21e-17
* device instance cc_XD1_XDFFM_CLKB_XD4_t1 r0 *1 0,0
Ccc_XD1_XDFFM_CLKB_XD4_t1 XD1.XDFFM.CLKB XD4.t1 1.21e-17
* device instance cc_XD1_XDFFM_CLKB_XD5_XDFFM_CLKB r0 *1 0,0
Ccc_XD1_XDFFM_CLKB_XD5_XDFFM_CLKB XD1.XDFFM.CLKB XD5.XDFFM.CLKB 1.8151e-17
* device instance cc_XD1_XDFFM_CLKB_XD5_XDFFM_M r0 *1 0,0
Ccc_XD1_XDFFM_CLKB_XD5_XDFFM_M XD1.XDFFM.CLKB XD5.XDFFM.M 2.4201e-17
* device instance cc_XD1_XDFFM_CLKB_XD5_XDFFM_MB r0 *1 0,0
Ccc_XD1_XDFFM_CLKB_XD5_XDFFM_MB XD1.XDFFM.CLKB XD5.XDFFM.MB 1.21e-17
* device instance cc_XD1_XDFFM_CLKB_XD5_XDFFM_S r0 *1 0,0
Ccc_XD1_XDFFM_CLKB_XD5_XDFFM_S XD1.XDFFM.CLKB XD5.XDFFM.S 1.8151e-17
* device instance cc_XD1_XDFFM_CLKB_XD5_XDFFM_SB r0 *1 0,0
Ccc_XD1_XDFFM_CLKB_XD5_XDFFM_SB XD1.XDFFM.CLKB XD5.XDFFM.SB 1.8151e-17
* device instance cc_XD1_XDFFM_CLKB_XD5_XDFFQ_CLKB r0 *1 0,0
Ccc_XD1_XDFFM_CLKB_XD5_XDFFQ_CLKB XD1.XDFFM.CLKB XD5.XDFFQ.CLKB 1.8151e-17
* device instance cc_XD1_XDFFM_CLKB_XD5_XDFFQ_M r0 *1 0,0
Ccc_XD1_XDFFM_CLKB_XD5_XDFFQ_M XD1.XDFFM.CLKB XD5.XDFFQ.M 2.4201e-17
* device instance cc_XD1_XDFFM_CLKB_XD5_XDFFQ_MB r0 *1 0,0
Ccc_XD1_XDFFM_CLKB_XD5_XDFFQ_MB XD1.XDFFM.CLKB XD5.XDFFQ.MB 1.21e-17
* device instance cc_XD1_XDFFM_CLKB_XD5_XDFFQ_S r0 *1 0,0
Ccc_XD1_XDFFM_CLKB_XD5_XDFFQ_S XD1.XDFFM.CLKB XD5.XDFFQ.S 1.8151e-17
* device instance cc_XD1_XDFFM_CLKB_XD5_XDFFQ_SB r0 *1 0,0
Ccc_XD1_XDFFM_CLKB_XD5_XDFFQ_SB XD1.XDFFM.CLKB XD5.XDFFQ.SB 1.8151e-17
* device instance cc_XD1_XDFFM_CLKB_XD5_XN2_mid1 r0 *1 0,0
Ccc_XD1_XDFFM_CLKB_XD5_XN2_mid1 XD1.XDFFM.CLKB XD5.XN2.mid1 1.21e-17
* device instance cc_XD1_XDFFM_CLKB_XD5_XN3_mid1 r0 *1 0,0
Ccc_XD1_XDFFM_CLKB_XD5_XN3_mid1 XD1.XDFFM.CLKB XD5.XN3.mid1 1.21e-17
* device instance cc_XD1_XDFFM_CLKB_XD5_XN3_mid2 r0 *1 0,0
Ccc_XD1_XDFFM_CLKB_XD5_XN3_mid2 XD1.XDFFM.CLKB XD5.XN3.mid2 1.21e-17
* device instance cc_XD1_XDFFM_CLKB_XD5_dmodout r0 *1 0,0
Ccc_XD1_XDFFM_CLKB_XD5_dmodout XD1.XDFFM.CLKB XD5.dmodout 1.21e-17
* device instance cc_XD1_XDFFM_CLKB_XD5_dq r0 *1 0,0
Ccc_XD1_XDFFM_CLKB_XD5_dq XD1.XDFFM.CLKB XD5.dq 1.8151e-17
* device instance cc_XD1_XDFFM_CLKB_XD5_nm r0 *1 0,0
Ccc_XD1_XDFFM_CLKB_XD5_nm XD1.XDFFM.CLKB XD5.nm 1.21e-17
* device instance cc_XD1_XDFFM_CLKB_XD5_nt r0 *1 0,0
Ccc_XD1_XDFFM_CLKB_XD5_nt XD1.XDFFM.CLKB XD5.nt 1.21e-17
* device instance cc_XD1_XDFFM_CLKB_XD5_t1 r0 *1 0,0
Ccc_XD1_XDFFM_CLKB_XD5_t1 XD1.XDFFM.CLKB XD5.t1 1.21e-17
* device instance cc_XD1_XDFFM_CLKB_XFRT_CLKB r0 *1 0,0
Ccc_XD1_XDFFM_CLKB_XFRT_CLKB XD1.XDFFM.CLKB XFRT.CLKB 1.8151e-17
* device instance cc_XD1_XDFFM_CLKB_XFRT_M r0 *1 0,0
Ccc_XD1_XDFFM_CLKB_XFRT_M XD1.XDFFM.CLKB XFRT.M 2.4201e-17
* device instance cc_XD1_XDFFM_CLKB_XFRT_MB r0 *1 0,0
Ccc_XD1_XDFFM_CLKB_XFRT_MB XD1.XDFFM.CLKB XFRT.MB 1.21e-17
* device instance cc_XD1_XDFFM_CLKB_XFRT_S r0 *1 0,0
Ccc_XD1_XDFFM_CLKB_XFRT_S XD1.XDFFM.CLKB XFRT.S 1.8151e-17
* device instance cc_XD1_XDFFM_CLKB_XFRT_SB r0 *1 0,0
Ccc_XD1_XDFFM_CLKB_XFRT_SB XD1.XDFFM.CLKB XFRT.SB 1.8151e-17
* device instance cc_XD1_XDFFM_CLKB_ck1 r0 *1 0,0
Ccc_XD1_XDFFM_CLKB_ck1 XD1.XDFFM.CLKB ck1 6.0502e-17
* device instance cc_XD1_XDFFM_CLKB_ck2 r0 *1 0,0
Ccc_XD1_XDFFM_CLKB_ck2 XD1.XDFFM.CLKB ck2 5.4452e-17
* device instance cc_XD1_XDFFM_CLKB_ck3 r0 *1 0,0
Ccc_XD1_XDFFM_CLKB_ck3 XD1.XDFFM.CLKB ck3 5.4452e-17
* device instance cc_XD1_XDFFM_CLKB_ck4 r0 *1 0,0
Ccc_XD1_XDFFM_CLKB_ck4 XD1.XDFFM.CLKB ck4 5.4452e-17
* device instance cc_XD1_XDFFM_CLKB_ck5 r0 *1 0,0
Ccc_XD1_XDFFM_CLKB_ck5 XD1.XDFFM.CLKB ck5 5.4452e-17
* device instance cc_XD1_XDFFM_CLKB_mod0 r0 *1 0,0
Ccc_XD1_XDFFM_CLKB_mod0 XD1.XDFFM.CLKB mod0 2.4201e-17
* device instance cc_XD1_XDFFM_CLKB_mod1 r0 *1 0,0
Ccc_XD1_XDFFM_CLKB_mod1 XD1.XDFFM.CLKB mod1 2.4201e-17
* device instance cc_XD1_XDFFM_CLKB_mod2 r0 *1 0,0
Ccc_XD1_XDFFM_CLKB_mod2 XD1.XDFFM.CLKB mod2 2.4201e-17
* device instance cc_XD1_XDFFM_CLKB_mod3 r0 *1 0,0
Ccc_XD1_XDFFM_CLKB_mod3 XD1.XDFFM.CLKB mod3 2.4201e-17
* device instance cc_XD1_XDFFM_CLKB_mod4 r0 *1 0,0
Ccc_XD1_XDFFM_CLKB_mod4 XD1.XDFFM.CLKB mod4 2.4201e-17
* device instance cc_XD1_XDFFM_CLKB_net1 r0 *1 0,0
Ccc_XD1_XDFFM_CLKB_net1 XD1.XDFFM.CLKB net1 1.21e-17
* device instance cc_XD1_XDFFM_M_XD1_XDFFM_MB r0 *1 0,0
Ccc_XD1_XDFFM_M_XD1_XDFFM_MB XD1.XDFFM.M XD1.XDFFM.MB 3.4688e-17
* device instance cc_XD1_XDFFM_M_XD1_XDFFM_S r0 *1 0,0
Ccc_XD1_XDFFM_M_XD1_XDFFM_S XD1.XDFFM.M XD1.XDFFM.S 2.8638e-17
* device instance cc_XD1_XDFFM_M_XD1_XDFFM_SB r0 *1 0,0
Ccc_XD1_XDFFM_M_XD1_XDFFM_SB XD1.XDFFM.M XD1.XDFFM.SB 1.8151e-17
* device instance cc_XD1_XDFFM_M_XD1_XDFFQ_CLKB r0 *1 0,0
Ccc_XD1_XDFFM_M_XD1_XDFFQ_CLKB XD1.XDFFM.M XD1.XDFFQ.CLKB 1.8151e-17
* device instance cc_XD1_XDFFM_M_XD1_XDFFQ_M r0 *1 0,0
Ccc_XD1_XDFFM_M_XD1_XDFFQ_M XD1.XDFFM.M XD1.XDFFQ.M 2.4201e-17
* device instance cc_XD1_XDFFM_M_XD1_XDFFQ_MB r0 *1 0,0
Ccc_XD1_XDFFM_M_XD1_XDFFQ_MB XD1.XDFFM.M XD1.XDFFQ.MB 1.21e-17
* device instance cc_XD1_XDFFM_M_XD1_XDFFQ_S r0 *1 0,0
Ccc_XD1_XDFFM_M_XD1_XDFFQ_S XD1.XDFFM.M XD1.XDFFQ.S 1.8151e-17
* device instance cc_XD1_XDFFM_M_XD1_XDFFQ_SB r0 *1 0,0
Ccc_XD1_XDFFM_M_XD1_XDFFQ_SB XD1.XDFFM.M XD1.XDFFQ.SB 1.8151e-17
* device instance cc_XD1_XDFFM_M_XD1_XNOR_midp r0 *1 0,0
Ccc_XD1_XDFFM_M_XD1_XNOR_midp XD1.XDFFM.M XD1.XNOR.midp 1.21e-17
* device instance cc_XD1_XDFFM_M_XD1_dmodout r0 *1 0,0
Ccc_XD1_XDFFM_M_XD1_dmodout XD1.XDFFM.M XD1.dmodout 2.8638e-17
* device instance cc_XD1_XDFFM_M_XD1_dq r0 *1 0,0
Ccc_XD1_XDFFM_M_XD1_dq XD1.XDFFM.M XD1.dq 1.21e-17
* device instance cc_XD1_XDFFM_M_XD1_nm r0 *1 0,0
Ccc_XD1_XDFFM_M_XD1_nm XD1.XDFFM.M XD1.nm 1.8151e-17
* device instance cc_XD1_XDFFM_M_XD1_nt r0 *1 0,0
Ccc_XD1_XDFFM_M_XD1_nt XD1.XDFFM.M XD1.nt 2.4201e-17
* device instance cc_XD1_XDFFM_M_XD1_t1 r0 *1 0,0
Ccc_XD1_XDFFM_M_XD1_t1 XD1.XDFFM.M XD1.t1 1.21e-17
* device instance cc_XD1_XDFFM_M_XD2_XDFFM_CLKB r0 *1 0,0
Ccc_XD1_XDFFM_M_XD2_XDFFM_CLKB XD1.XDFFM.M XD2.XDFFM.CLKB 1.8151e-17
* device instance cc_XD1_XDFFM_M_XD2_XDFFM_M r0 *1 0,0
Ccc_XD1_XDFFM_M_XD2_XDFFM_M XD1.XDFFM.M XD2.XDFFM.M 2.4201e-17
* device instance cc_XD1_XDFFM_M_XD2_XDFFM_MB r0 *1 0,0
Ccc_XD1_XDFFM_M_XD2_XDFFM_MB XD1.XDFFM.M XD2.XDFFM.MB 1.21e-17
* device instance cc_XD1_XDFFM_M_XD2_XDFFM_S r0 *1 0,0
Ccc_XD1_XDFFM_M_XD2_XDFFM_S XD1.XDFFM.M XD2.XDFFM.S 1.8151e-17
* device instance cc_XD1_XDFFM_M_XD2_XDFFM_SB r0 *1 0,0
Ccc_XD1_XDFFM_M_XD2_XDFFM_SB XD1.XDFFM.M XD2.XDFFM.SB 1.8151e-17
* device instance cc_XD1_XDFFM_M_XD2_XDFFQ_CLKB r0 *1 0,0
Ccc_XD1_XDFFM_M_XD2_XDFFQ_CLKB XD1.XDFFM.M XD2.XDFFQ.CLKB 1.8151e-17
* device instance cc_XD1_XDFFM_M_XD2_XDFFQ_M r0 *1 0,0
Ccc_XD1_XDFFM_M_XD2_XDFFQ_M XD1.XDFFM.M XD2.XDFFQ.M 2.4201e-17
* device instance cc_XD1_XDFFM_M_XD2_XDFFQ_MB r0 *1 0,0
Ccc_XD1_XDFFM_M_XD2_XDFFQ_MB XD1.XDFFM.M XD2.XDFFQ.MB 1.21e-17
* device instance cc_XD1_XDFFM_M_XD2_XDFFQ_S r0 *1 0,0
Ccc_XD1_XDFFM_M_XD2_XDFFQ_S XD1.XDFFM.M XD2.XDFFQ.S 1.8151e-17
* device instance cc_XD1_XDFFM_M_XD2_XDFFQ_SB r0 *1 0,0
Ccc_XD1_XDFFM_M_XD2_XDFFQ_SB XD1.XDFFM.M XD2.XDFFQ.SB 1.8151e-17
* device instance cc_XD1_XDFFM_M_XD2_XN2_mid1 r0 *1 0,0
Ccc_XD1_XDFFM_M_XD2_XN2_mid1 XD1.XDFFM.M XD2.XN2.mid1 1.21e-17
* device instance cc_XD1_XDFFM_M_XD2_XN3_mid1 r0 *1 0,0
Ccc_XD1_XDFFM_M_XD2_XN3_mid1 XD1.XDFFM.M XD2.XN3.mid1 1.21e-17
* device instance cc_XD1_XDFFM_M_XD2_XN3_mid2 r0 *1 0,0
Ccc_XD1_XDFFM_M_XD2_XN3_mid2 XD1.XDFFM.M XD2.XN3.mid2 1.21e-17
* device instance cc_XD1_XDFFM_M_XD2_dmodout r0 *1 0,0
Ccc_XD1_XDFFM_M_XD2_dmodout XD1.XDFFM.M XD2.dmodout 1.21e-17
* device instance cc_XD1_XDFFM_M_XD2_dq r0 *1 0,0
Ccc_XD1_XDFFM_M_XD2_dq XD1.XDFFM.M XD2.dq 1.8151e-17
* device instance cc_XD1_XDFFM_M_XD2_nm r0 *1 0,0
Ccc_XD1_XDFFM_M_XD2_nm XD1.XDFFM.M XD2.nm 1.21e-17
* device instance cc_XD1_XDFFM_M_XD2_nt r0 *1 0,0
Ccc_XD1_XDFFM_M_XD2_nt XD1.XDFFM.M XD2.nt 1.21e-17
* device instance cc_XD1_XDFFM_M_XD2_t1 r0 *1 0,0
Ccc_XD1_XDFFM_M_XD2_t1 XD1.XDFFM.M XD2.t1 1.21e-17
* device instance cc_XD1_XDFFM_M_XD3_XDFFM_CLKB r0 *1 0,0
Ccc_XD1_XDFFM_M_XD3_XDFFM_CLKB XD1.XDFFM.M XD3.XDFFM.CLKB 1.8151e-17
* device instance cc_XD1_XDFFM_M_XD3_XDFFM_M r0 *1 0,0
Ccc_XD1_XDFFM_M_XD3_XDFFM_M XD1.XDFFM.M XD3.XDFFM.M 2.4201e-17
* device instance cc_XD1_XDFFM_M_XD3_XDFFM_MB r0 *1 0,0
Ccc_XD1_XDFFM_M_XD3_XDFFM_MB XD1.XDFFM.M XD3.XDFFM.MB 1.21e-17
* device instance cc_XD1_XDFFM_M_XD3_XDFFM_S r0 *1 0,0
Ccc_XD1_XDFFM_M_XD3_XDFFM_S XD1.XDFFM.M XD3.XDFFM.S 1.8151e-17
* device instance cc_XD1_XDFFM_M_XD3_XDFFM_SB r0 *1 0,0
Ccc_XD1_XDFFM_M_XD3_XDFFM_SB XD1.XDFFM.M XD3.XDFFM.SB 1.8151e-17
* device instance cc_XD1_XDFFM_M_XD3_XDFFQ_CLKB r0 *1 0,0
Ccc_XD1_XDFFM_M_XD3_XDFFQ_CLKB XD1.XDFFM.M XD3.XDFFQ.CLKB 1.8151e-17
* device instance cc_XD1_XDFFM_M_XD3_XDFFQ_M r0 *1 0,0
Ccc_XD1_XDFFM_M_XD3_XDFFQ_M XD1.XDFFM.M XD3.XDFFQ.M 2.4201e-17
* device instance cc_XD1_XDFFM_M_XD3_XDFFQ_MB r0 *1 0,0
Ccc_XD1_XDFFM_M_XD3_XDFFQ_MB XD1.XDFFM.M XD3.XDFFQ.MB 1.21e-17
* device instance cc_XD1_XDFFM_M_XD3_XDFFQ_S r0 *1 0,0
Ccc_XD1_XDFFM_M_XD3_XDFFQ_S XD1.XDFFM.M XD3.XDFFQ.S 1.8151e-17
* device instance cc_XD1_XDFFM_M_XD3_XDFFQ_SB r0 *1 0,0
Ccc_XD1_XDFFM_M_XD3_XDFFQ_SB XD1.XDFFM.M XD3.XDFFQ.SB 1.8151e-17
* device instance cc_XD1_XDFFM_M_XD3_XN2_mid1 r0 *1 0,0
Ccc_XD1_XDFFM_M_XD3_XN2_mid1 XD1.XDFFM.M XD3.XN2.mid1 1.21e-17
* device instance cc_XD1_XDFFM_M_XD3_XN3_mid1 r0 *1 0,0
Ccc_XD1_XDFFM_M_XD3_XN3_mid1 XD1.XDFFM.M XD3.XN3.mid1 1.21e-17
* device instance cc_XD1_XDFFM_M_XD3_XN3_mid2 r0 *1 0,0
Ccc_XD1_XDFFM_M_XD3_XN3_mid2 XD1.XDFFM.M XD3.XN3.mid2 1.21e-17
* device instance cc_XD1_XDFFM_M_XD3_dmodout r0 *1 0,0
Ccc_XD1_XDFFM_M_XD3_dmodout XD1.XDFFM.M XD3.dmodout 1.21e-17
* device instance cc_XD1_XDFFM_M_XD3_dq r0 *1 0,0
Ccc_XD1_XDFFM_M_XD3_dq XD1.XDFFM.M XD3.dq 1.8151e-17
* device instance cc_XD1_XDFFM_M_XD3_nm r0 *1 0,0
Ccc_XD1_XDFFM_M_XD3_nm XD1.XDFFM.M XD3.nm 1.21e-17
* device instance cc_XD1_XDFFM_M_XD3_nt r0 *1 0,0
Ccc_XD1_XDFFM_M_XD3_nt XD1.XDFFM.M XD3.nt 1.21e-17
* device instance cc_XD1_XDFFM_M_XD3_t1 r0 *1 0,0
Ccc_XD1_XDFFM_M_XD3_t1 XD1.XDFFM.M XD3.t1 1.21e-17
* device instance cc_XD1_XDFFM_M_XD4_XDFFM_CLKB r0 *1 0,0
Ccc_XD1_XDFFM_M_XD4_XDFFM_CLKB XD1.XDFFM.M XD4.XDFFM.CLKB 1.8151e-17
* device instance cc_XD1_XDFFM_M_XD4_XDFFM_M r0 *1 0,0
Ccc_XD1_XDFFM_M_XD4_XDFFM_M XD1.XDFFM.M XD4.XDFFM.M 2.4201e-17
* device instance cc_XD1_XDFFM_M_XD4_XDFFM_MB r0 *1 0,0
Ccc_XD1_XDFFM_M_XD4_XDFFM_MB XD1.XDFFM.M XD4.XDFFM.MB 1.21e-17
* device instance cc_XD1_XDFFM_M_XD4_XDFFM_S r0 *1 0,0
Ccc_XD1_XDFFM_M_XD4_XDFFM_S XD1.XDFFM.M XD4.XDFFM.S 1.8151e-17
* device instance cc_XD1_XDFFM_M_XD4_XDFFM_SB r0 *1 0,0
Ccc_XD1_XDFFM_M_XD4_XDFFM_SB XD1.XDFFM.M XD4.XDFFM.SB 1.8151e-17
* device instance cc_XD1_XDFFM_M_XD4_XDFFQ_CLKB r0 *1 0,0
Ccc_XD1_XDFFM_M_XD4_XDFFQ_CLKB XD1.XDFFM.M XD4.XDFFQ.CLKB 1.8151e-17
* device instance cc_XD1_XDFFM_M_XD4_XDFFQ_M r0 *1 0,0
Ccc_XD1_XDFFM_M_XD4_XDFFQ_M XD1.XDFFM.M XD4.XDFFQ.M 2.4201e-17
* device instance cc_XD1_XDFFM_M_XD4_XDFFQ_MB r0 *1 0,0
Ccc_XD1_XDFFM_M_XD4_XDFFQ_MB XD1.XDFFM.M XD4.XDFFQ.MB 1.21e-17
* device instance cc_XD1_XDFFM_M_XD4_XDFFQ_S r0 *1 0,0
Ccc_XD1_XDFFM_M_XD4_XDFFQ_S XD1.XDFFM.M XD4.XDFFQ.S 1.8151e-17
* device instance cc_XD1_XDFFM_M_XD4_XDFFQ_SB r0 *1 0,0
Ccc_XD1_XDFFM_M_XD4_XDFFQ_SB XD1.XDFFM.M XD4.XDFFQ.SB 1.8151e-17
* device instance cc_XD1_XDFFM_M_XD4_XN2_mid1 r0 *1 0,0
Ccc_XD1_XDFFM_M_XD4_XN2_mid1 XD1.XDFFM.M XD4.XN2.mid1 1.21e-17
* device instance cc_XD1_XDFFM_M_XD4_XN3_mid1 r0 *1 0,0
Ccc_XD1_XDFFM_M_XD4_XN3_mid1 XD1.XDFFM.M XD4.XN3.mid1 1.21e-17
* device instance cc_XD1_XDFFM_M_XD4_XN3_mid2 r0 *1 0,0
Ccc_XD1_XDFFM_M_XD4_XN3_mid2 XD1.XDFFM.M XD4.XN3.mid2 1.21e-17
* device instance cc_XD1_XDFFM_M_XD4_dmodout r0 *1 0,0
Ccc_XD1_XDFFM_M_XD4_dmodout XD1.XDFFM.M XD4.dmodout 1.21e-17
* device instance cc_XD1_XDFFM_M_XD4_dq r0 *1 0,0
Ccc_XD1_XDFFM_M_XD4_dq XD1.XDFFM.M XD4.dq 1.8151e-17
* device instance cc_XD1_XDFFM_M_XD4_nm r0 *1 0,0
Ccc_XD1_XDFFM_M_XD4_nm XD1.XDFFM.M XD4.nm 1.21e-17
* device instance cc_XD1_XDFFM_M_XD4_nt r0 *1 0,0
Ccc_XD1_XDFFM_M_XD4_nt XD1.XDFFM.M XD4.nt 1.21e-17
* device instance cc_XD1_XDFFM_M_XD4_t1 r0 *1 0,0
Ccc_XD1_XDFFM_M_XD4_t1 XD1.XDFFM.M XD4.t1 1.21e-17
* device instance cc_XD1_XDFFM_M_XD5_XDFFM_CLKB r0 *1 0,0
Ccc_XD1_XDFFM_M_XD5_XDFFM_CLKB XD1.XDFFM.M XD5.XDFFM.CLKB 1.8151e-17
* device instance cc_XD1_XDFFM_M_XD5_XDFFM_M r0 *1 0,0
Ccc_XD1_XDFFM_M_XD5_XDFFM_M XD1.XDFFM.M XD5.XDFFM.M 2.4201e-17
* device instance cc_XD1_XDFFM_M_XD5_XDFFM_MB r0 *1 0,0
Ccc_XD1_XDFFM_M_XD5_XDFFM_MB XD1.XDFFM.M XD5.XDFFM.MB 1.21e-17
* device instance cc_XD1_XDFFM_M_XD5_XDFFM_S r0 *1 0,0
Ccc_XD1_XDFFM_M_XD5_XDFFM_S XD1.XDFFM.M XD5.XDFFM.S 1.8151e-17
* device instance cc_XD1_XDFFM_M_XD5_XDFFM_SB r0 *1 0,0
Ccc_XD1_XDFFM_M_XD5_XDFFM_SB XD1.XDFFM.M XD5.XDFFM.SB 1.8151e-17
* device instance cc_XD1_XDFFM_M_XD5_XDFFQ_CLKB r0 *1 0,0
Ccc_XD1_XDFFM_M_XD5_XDFFQ_CLKB XD1.XDFFM.M XD5.XDFFQ.CLKB 1.8151e-17
* device instance cc_XD1_XDFFM_M_XD5_XDFFQ_M r0 *1 0,0
Ccc_XD1_XDFFM_M_XD5_XDFFQ_M XD1.XDFFM.M XD5.XDFFQ.M 2.4201e-17
* device instance cc_XD1_XDFFM_M_XD5_XDFFQ_MB r0 *1 0,0
Ccc_XD1_XDFFM_M_XD5_XDFFQ_MB XD1.XDFFM.M XD5.XDFFQ.MB 1.21e-17
* device instance cc_XD1_XDFFM_M_XD5_XDFFQ_S r0 *1 0,0
Ccc_XD1_XDFFM_M_XD5_XDFFQ_S XD1.XDFFM.M XD5.XDFFQ.S 1.8151e-17
* device instance cc_XD1_XDFFM_M_XD5_XDFFQ_SB r0 *1 0,0
Ccc_XD1_XDFFM_M_XD5_XDFFQ_SB XD1.XDFFM.M XD5.XDFFQ.SB 1.8151e-17
* device instance cc_XD1_XDFFM_M_XD5_XN2_mid1 r0 *1 0,0
Ccc_XD1_XDFFM_M_XD5_XN2_mid1 XD1.XDFFM.M XD5.XN2.mid1 1.21e-17
* device instance cc_XD1_XDFFM_M_XD5_XN3_mid1 r0 *1 0,0
Ccc_XD1_XDFFM_M_XD5_XN3_mid1 XD1.XDFFM.M XD5.XN3.mid1 1.21e-17
* device instance cc_XD1_XDFFM_M_XD5_XN3_mid2 r0 *1 0,0
Ccc_XD1_XDFFM_M_XD5_XN3_mid2 XD1.XDFFM.M XD5.XN3.mid2 1.21e-17
* device instance cc_XD1_XDFFM_M_XD5_dmodout r0 *1 0,0
Ccc_XD1_XDFFM_M_XD5_dmodout XD1.XDFFM.M XD5.dmodout 1.21e-17
* device instance cc_XD1_XDFFM_M_XD5_dq r0 *1 0,0
Ccc_XD1_XDFFM_M_XD5_dq XD1.XDFFM.M XD5.dq 1.8151e-17
* device instance cc_XD1_XDFFM_M_XD5_nm r0 *1 0,0
Ccc_XD1_XDFFM_M_XD5_nm XD1.XDFFM.M XD5.nm 1.21e-17
* device instance cc_XD1_XDFFM_M_XD5_nt r0 *1 0,0
Ccc_XD1_XDFFM_M_XD5_nt XD1.XDFFM.M XD5.nt 1.21e-17
* device instance cc_XD1_XDFFM_M_XD5_t1 r0 *1 0,0
Ccc_XD1_XDFFM_M_XD5_t1 XD1.XDFFM.M XD5.t1 1.21e-17
* device instance cc_XD1_XDFFM_M_XFRT_CLKB r0 *1 0,0
Ccc_XD1_XDFFM_M_XFRT_CLKB XD1.XDFFM.M XFRT.CLKB 1.8151e-17
* device instance cc_XD1_XDFFM_M_XFRT_M r0 *1 0,0
Ccc_XD1_XDFFM_M_XFRT_M XD1.XDFFM.M XFRT.M 2.4201e-17
* device instance cc_XD1_XDFFM_M_XFRT_MB r0 *1 0,0
Ccc_XD1_XDFFM_M_XFRT_MB XD1.XDFFM.M XFRT.MB 1.21e-17
* device instance cc_XD1_XDFFM_M_XFRT_S r0 *1 0,0
Ccc_XD1_XDFFM_M_XFRT_S XD1.XDFFM.M XFRT.S 1.8151e-17
* device instance cc_XD1_XDFFM_M_XFRT_SB r0 *1 0,0
Ccc_XD1_XDFFM_M_XFRT_SB XD1.XDFFM.M XFRT.SB 1.8151e-17
* device instance cc_XD1_XDFFM_M_ck1 r0 *1 0,0
Ccc_XD1_XDFFM_M_ck1 XD1.XDFFM.M ck1 6.0502e-17
* device instance cc_XD1_XDFFM_M_ck2 r0 *1 0,0
Ccc_XD1_XDFFM_M_ck2 XD1.XDFFM.M ck2 5.4452e-17
* device instance cc_XD1_XDFFM_M_ck3 r0 *1 0,0
Ccc_XD1_XDFFM_M_ck3 XD1.XDFFM.M ck3 5.4452e-17
* device instance cc_XD1_XDFFM_M_ck4 r0 *1 0,0
Ccc_XD1_XDFFM_M_ck4 XD1.XDFFM.M ck4 5.4452e-17
* device instance cc_XD1_XDFFM_M_ck5 r0 *1 0,0
Ccc_XD1_XDFFM_M_ck5 XD1.XDFFM.M ck5 5.4452e-17
* device instance cc_XD1_XDFFM_M_mod0 r0 *1 0,0
Ccc_XD1_XDFFM_M_mod0 XD1.XDFFM.M mod0 2.4201e-17
* device instance cc_XD1_XDFFM_M_mod1 r0 *1 0,0
Ccc_XD1_XDFFM_M_mod1 XD1.XDFFM.M mod1 2.4201e-17
* device instance cc_XD1_XDFFM_M_mod2 r0 *1 0,0
Ccc_XD1_XDFFM_M_mod2 XD1.XDFFM.M mod2 2.4201e-17
* device instance cc_XD1_XDFFM_M_mod3 r0 *1 0,0
Ccc_XD1_XDFFM_M_mod3 XD1.XDFFM.M mod3 2.4201e-17
* device instance cc_XD1_XDFFM_M_mod4 r0 *1 0,0
Ccc_XD1_XDFFM_M_mod4 XD1.XDFFM.M mod4 2.4201e-17
* device instance cc_XD1_XDFFM_M_net1 r0 *1 0,0
Ccc_XD1_XDFFM_M_net1 XD1.XDFFM.M net1 1.21e-17
* device instance cc_XD1_XDFFM_MB_XD1_XDFFM_S r0 *1 0,0
Ccc_XD1_XDFFM_MB_XD1_XDFFM_S XD1.XDFFM.MB XD1.XDFFM.S 1.8151e-17
* device instance cc_XD1_XDFFM_MB_XD1_XDFFM_SB r0 *1 0,0
Ccc_XD1_XDFFM_MB_XD1_XDFFM_SB XD1.XDFFM.MB XD1.XDFFM.SB 1.8151e-17
* device instance cc_XD1_XDFFM_MB_XD1_XDFFQ_CLKB r0 *1 0,0
Ccc_XD1_XDFFM_MB_XD1_XDFFQ_CLKB XD1.XDFFM.MB XD1.XDFFQ.CLKB 1.8151e-17
* device instance cc_XD1_XDFFM_MB_XD1_XDFFQ_M r0 *1 0,0
Ccc_XD1_XDFFM_MB_XD1_XDFFQ_M XD1.XDFFM.MB XD1.XDFFQ.M 2.4201e-17
* device instance cc_XD1_XDFFM_MB_XD1_XDFFQ_MB r0 *1 0,0
Ccc_XD1_XDFFM_MB_XD1_XDFFQ_MB XD1.XDFFM.MB XD1.XDFFQ.MB 1.21e-17
* device instance cc_XD1_XDFFM_MB_XD1_XDFFQ_S r0 *1 0,0
Ccc_XD1_XDFFM_MB_XD1_XDFFQ_S XD1.XDFFM.MB XD1.XDFFQ.S 1.8151e-17
* device instance cc_XD1_XDFFM_MB_XD1_XDFFQ_SB r0 *1 0,0
Ccc_XD1_XDFFM_MB_XD1_XDFFQ_SB XD1.XDFFM.MB XD1.XDFFQ.SB 1.8151e-17
* device instance cc_XD1_XDFFM_MB_XD1_XNOR_midp r0 *1 0,0
Ccc_XD1_XDFFM_MB_XD1_XNOR_midp XD1.XDFFM.MB XD1.XNOR.midp 1.21e-17
* device instance cc_XD1_XDFFM_MB_XD1_dmodout r0 *1 0,0
Ccc_XD1_XDFFM_MB_XD1_dmodout XD1.XDFFM.MB XD1.dmodout 1.21e-17
* device instance cc_XD1_XDFFM_MB_XD1_dq r0 *1 0,0
Ccc_XD1_XDFFM_MB_XD1_dq XD1.XDFFM.MB XD1.dq 1.21e-17
* device instance cc_XD1_XDFFM_MB_XD1_nm r0 *1 0,0
Ccc_XD1_XDFFM_MB_XD1_nm XD1.XDFFM.MB XD1.nm 1.8151e-17
* device instance cc_XD1_XDFFM_MB_XD1_nt r0 *1 0,0
Ccc_XD1_XDFFM_MB_XD1_nt XD1.XDFFM.MB XD1.nt 2.4201e-17
* device instance cc_XD1_XDFFM_MB_XD1_t1 r0 *1 0,0
Ccc_XD1_XDFFM_MB_XD1_t1 XD1.XDFFM.MB XD1.t1 1.21e-17
* device instance cc_XD1_XDFFM_MB_XD2_XDFFM_CLKB r0 *1 0,0
Ccc_XD1_XDFFM_MB_XD2_XDFFM_CLKB XD1.XDFFM.MB XD2.XDFFM.CLKB 1.8151e-17
* device instance cc_XD1_XDFFM_MB_XD2_XDFFM_M r0 *1 0,0
Ccc_XD1_XDFFM_MB_XD2_XDFFM_M XD1.XDFFM.MB XD2.XDFFM.M 2.4201e-17
* device instance cc_XD1_XDFFM_MB_XD2_XDFFM_MB r0 *1 0,0
Ccc_XD1_XDFFM_MB_XD2_XDFFM_MB XD1.XDFFM.MB XD2.XDFFM.MB 1.21e-17
* device instance cc_XD1_XDFFM_MB_XD2_XDFFM_S r0 *1 0,0
Ccc_XD1_XDFFM_MB_XD2_XDFFM_S XD1.XDFFM.MB XD2.XDFFM.S 1.8151e-17
* device instance cc_XD1_XDFFM_MB_XD2_XDFFM_SB r0 *1 0,0
Ccc_XD1_XDFFM_MB_XD2_XDFFM_SB XD1.XDFFM.MB XD2.XDFFM.SB 1.8151e-17
* device instance cc_XD1_XDFFM_MB_XD2_XDFFQ_CLKB r0 *1 0,0
Ccc_XD1_XDFFM_MB_XD2_XDFFQ_CLKB XD1.XDFFM.MB XD2.XDFFQ.CLKB 1.8151e-17
* device instance cc_XD1_XDFFM_MB_XD2_XDFFQ_M r0 *1 0,0
Ccc_XD1_XDFFM_MB_XD2_XDFFQ_M XD1.XDFFM.MB XD2.XDFFQ.M 2.4201e-17
* device instance cc_XD1_XDFFM_MB_XD2_XDFFQ_MB r0 *1 0,0
Ccc_XD1_XDFFM_MB_XD2_XDFFQ_MB XD1.XDFFM.MB XD2.XDFFQ.MB 1.21e-17
* device instance cc_XD1_XDFFM_MB_XD2_XDFFQ_S r0 *1 0,0
Ccc_XD1_XDFFM_MB_XD2_XDFFQ_S XD1.XDFFM.MB XD2.XDFFQ.S 1.8151e-17
* device instance cc_XD1_XDFFM_MB_XD2_XDFFQ_SB r0 *1 0,0
Ccc_XD1_XDFFM_MB_XD2_XDFFQ_SB XD1.XDFFM.MB XD2.XDFFQ.SB 1.8151e-17
* device instance cc_XD1_XDFFM_MB_XD2_XN2_mid1 r0 *1 0,0
Ccc_XD1_XDFFM_MB_XD2_XN2_mid1 XD1.XDFFM.MB XD2.XN2.mid1 1.21e-17
* device instance cc_XD1_XDFFM_MB_XD2_XN3_mid1 r0 *1 0,0
Ccc_XD1_XDFFM_MB_XD2_XN3_mid1 XD1.XDFFM.MB XD2.XN3.mid1 1.21e-17
* device instance cc_XD1_XDFFM_MB_XD2_XN3_mid2 r0 *1 0,0
Ccc_XD1_XDFFM_MB_XD2_XN3_mid2 XD1.XDFFM.MB XD2.XN3.mid2 1.21e-17
* device instance cc_XD1_XDFFM_MB_XD2_dmodout r0 *1 0,0
Ccc_XD1_XDFFM_MB_XD2_dmodout XD1.XDFFM.MB XD2.dmodout 1.21e-17
* device instance cc_XD1_XDFFM_MB_XD2_dq r0 *1 0,0
Ccc_XD1_XDFFM_MB_XD2_dq XD1.XDFFM.MB XD2.dq 1.8151e-17
* device instance cc_XD1_XDFFM_MB_XD2_nm r0 *1 0,0
Ccc_XD1_XDFFM_MB_XD2_nm XD1.XDFFM.MB XD2.nm 1.21e-17
* device instance cc_XD1_XDFFM_MB_XD2_nt r0 *1 0,0
Ccc_XD1_XDFFM_MB_XD2_nt XD1.XDFFM.MB XD2.nt 1.21e-17
* device instance cc_XD1_XDFFM_MB_XD2_t1 r0 *1 0,0
Ccc_XD1_XDFFM_MB_XD2_t1 XD1.XDFFM.MB XD2.t1 1.21e-17
* device instance cc_XD1_XDFFM_MB_XD3_XDFFM_CLKB r0 *1 0,0
Ccc_XD1_XDFFM_MB_XD3_XDFFM_CLKB XD1.XDFFM.MB XD3.XDFFM.CLKB 1.8151e-17
* device instance cc_XD1_XDFFM_MB_XD3_XDFFM_M r0 *1 0,0
Ccc_XD1_XDFFM_MB_XD3_XDFFM_M XD1.XDFFM.MB XD3.XDFFM.M 2.4201e-17
* device instance cc_XD1_XDFFM_MB_XD3_XDFFM_MB r0 *1 0,0
Ccc_XD1_XDFFM_MB_XD3_XDFFM_MB XD1.XDFFM.MB XD3.XDFFM.MB 1.21e-17
* device instance cc_XD1_XDFFM_MB_XD3_XDFFM_S r0 *1 0,0
Ccc_XD1_XDFFM_MB_XD3_XDFFM_S XD1.XDFFM.MB XD3.XDFFM.S 1.8151e-17
* device instance cc_XD1_XDFFM_MB_XD3_XDFFM_SB r0 *1 0,0
Ccc_XD1_XDFFM_MB_XD3_XDFFM_SB XD1.XDFFM.MB XD3.XDFFM.SB 1.8151e-17
* device instance cc_XD1_XDFFM_MB_XD3_XDFFQ_CLKB r0 *1 0,0
Ccc_XD1_XDFFM_MB_XD3_XDFFQ_CLKB XD1.XDFFM.MB XD3.XDFFQ.CLKB 1.8151e-17
* device instance cc_XD1_XDFFM_MB_XD3_XDFFQ_M r0 *1 0,0
Ccc_XD1_XDFFM_MB_XD3_XDFFQ_M XD1.XDFFM.MB XD3.XDFFQ.M 2.4201e-17
* device instance cc_XD1_XDFFM_MB_XD3_XDFFQ_MB r0 *1 0,0
Ccc_XD1_XDFFM_MB_XD3_XDFFQ_MB XD1.XDFFM.MB XD3.XDFFQ.MB 1.21e-17
* device instance cc_XD1_XDFFM_MB_XD3_XDFFQ_S r0 *1 0,0
Ccc_XD1_XDFFM_MB_XD3_XDFFQ_S XD1.XDFFM.MB XD3.XDFFQ.S 1.8151e-17
* device instance cc_XD1_XDFFM_MB_XD3_XDFFQ_SB r0 *1 0,0
Ccc_XD1_XDFFM_MB_XD3_XDFFQ_SB XD1.XDFFM.MB XD3.XDFFQ.SB 1.8151e-17
* device instance cc_XD1_XDFFM_MB_XD3_XN2_mid1 r0 *1 0,0
Ccc_XD1_XDFFM_MB_XD3_XN2_mid1 XD1.XDFFM.MB XD3.XN2.mid1 1.21e-17
* device instance cc_XD1_XDFFM_MB_XD3_XN3_mid1 r0 *1 0,0
Ccc_XD1_XDFFM_MB_XD3_XN3_mid1 XD1.XDFFM.MB XD3.XN3.mid1 1.21e-17
* device instance cc_XD1_XDFFM_MB_XD3_XN3_mid2 r0 *1 0,0
Ccc_XD1_XDFFM_MB_XD3_XN3_mid2 XD1.XDFFM.MB XD3.XN3.mid2 1.21e-17
* device instance cc_XD1_XDFFM_MB_XD3_dmodout r0 *1 0,0
Ccc_XD1_XDFFM_MB_XD3_dmodout XD1.XDFFM.MB XD3.dmodout 1.21e-17
* device instance cc_XD1_XDFFM_MB_XD3_dq r0 *1 0,0
Ccc_XD1_XDFFM_MB_XD3_dq XD1.XDFFM.MB XD3.dq 1.8151e-17
* device instance cc_XD1_XDFFM_MB_XD3_nm r0 *1 0,0
Ccc_XD1_XDFFM_MB_XD3_nm XD1.XDFFM.MB XD3.nm 1.21e-17
* device instance cc_XD1_XDFFM_MB_XD3_nt r0 *1 0,0
Ccc_XD1_XDFFM_MB_XD3_nt XD1.XDFFM.MB XD3.nt 1.21e-17
* device instance cc_XD1_XDFFM_MB_XD3_t1 r0 *1 0,0
Ccc_XD1_XDFFM_MB_XD3_t1 XD1.XDFFM.MB XD3.t1 1.21e-17
* device instance cc_XD1_XDFFM_MB_XD4_XDFFM_CLKB r0 *1 0,0
Ccc_XD1_XDFFM_MB_XD4_XDFFM_CLKB XD1.XDFFM.MB XD4.XDFFM.CLKB 1.8151e-17
* device instance cc_XD1_XDFFM_MB_XD4_XDFFM_M r0 *1 0,0
Ccc_XD1_XDFFM_MB_XD4_XDFFM_M XD1.XDFFM.MB XD4.XDFFM.M 2.4201e-17
* device instance cc_XD1_XDFFM_MB_XD4_XDFFM_MB r0 *1 0,0
Ccc_XD1_XDFFM_MB_XD4_XDFFM_MB XD1.XDFFM.MB XD4.XDFFM.MB 1.21e-17
* device instance cc_XD1_XDFFM_MB_XD4_XDFFM_S r0 *1 0,0
Ccc_XD1_XDFFM_MB_XD4_XDFFM_S XD1.XDFFM.MB XD4.XDFFM.S 1.8151e-17
* device instance cc_XD1_XDFFM_MB_XD4_XDFFM_SB r0 *1 0,0
Ccc_XD1_XDFFM_MB_XD4_XDFFM_SB XD1.XDFFM.MB XD4.XDFFM.SB 1.8151e-17
* device instance cc_XD1_XDFFM_MB_XD4_XDFFQ_CLKB r0 *1 0,0
Ccc_XD1_XDFFM_MB_XD4_XDFFQ_CLKB XD1.XDFFM.MB XD4.XDFFQ.CLKB 1.8151e-17
* device instance cc_XD1_XDFFM_MB_XD4_XDFFQ_M r0 *1 0,0
Ccc_XD1_XDFFM_MB_XD4_XDFFQ_M XD1.XDFFM.MB XD4.XDFFQ.M 2.4201e-17
* device instance cc_XD1_XDFFM_MB_XD4_XDFFQ_MB r0 *1 0,0
Ccc_XD1_XDFFM_MB_XD4_XDFFQ_MB XD1.XDFFM.MB XD4.XDFFQ.MB 1.21e-17
* device instance cc_XD1_XDFFM_MB_XD4_XDFFQ_S r0 *1 0,0
Ccc_XD1_XDFFM_MB_XD4_XDFFQ_S XD1.XDFFM.MB XD4.XDFFQ.S 1.8151e-17
* device instance cc_XD1_XDFFM_MB_XD4_XDFFQ_SB r0 *1 0,0
Ccc_XD1_XDFFM_MB_XD4_XDFFQ_SB XD1.XDFFM.MB XD4.XDFFQ.SB 1.8151e-17
* device instance cc_XD1_XDFFM_MB_XD4_XN2_mid1 r0 *1 0,0
Ccc_XD1_XDFFM_MB_XD4_XN2_mid1 XD1.XDFFM.MB XD4.XN2.mid1 1.21e-17
* device instance cc_XD1_XDFFM_MB_XD4_XN3_mid1 r0 *1 0,0
Ccc_XD1_XDFFM_MB_XD4_XN3_mid1 XD1.XDFFM.MB XD4.XN3.mid1 1.21e-17
* device instance cc_XD1_XDFFM_MB_XD4_XN3_mid2 r0 *1 0,0
Ccc_XD1_XDFFM_MB_XD4_XN3_mid2 XD1.XDFFM.MB XD4.XN3.mid2 1.21e-17
* device instance cc_XD1_XDFFM_MB_XD4_dmodout r0 *1 0,0
Ccc_XD1_XDFFM_MB_XD4_dmodout XD1.XDFFM.MB XD4.dmodout 1.21e-17
* device instance cc_XD1_XDFFM_MB_XD4_dq r0 *1 0,0
Ccc_XD1_XDFFM_MB_XD4_dq XD1.XDFFM.MB XD4.dq 1.8151e-17
* device instance cc_XD1_XDFFM_MB_XD4_nm r0 *1 0,0
Ccc_XD1_XDFFM_MB_XD4_nm XD1.XDFFM.MB XD4.nm 1.21e-17
* device instance cc_XD1_XDFFM_MB_XD4_nt r0 *1 0,0
Ccc_XD1_XDFFM_MB_XD4_nt XD1.XDFFM.MB XD4.nt 1.21e-17
* device instance cc_XD1_XDFFM_MB_XD4_t1 r0 *1 0,0
Ccc_XD1_XDFFM_MB_XD4_t1 XD1.XDFFM.MB XD4.t1 1.21e-17
* device instance cc_XD1_XDFFM_MB_XD5_XDFFM_CLKB r0 *1 0,0
Ccc_XD1_XDFFM_MB_XD5_XDFFM_CLKB XD1.XDFFM.MB XD5.XDFFM.CLKB 1.8151e-17
* device instance cc_XD1_XDFFM_MB_XD5_XDFFM_M r0 *1 0,0
Ccc_XD1_XDFFM_MB_XD5_XDFFM_M XD1.XDFFM.MB XD5.XDFFM.M 2.4201e-17
* device instance cc_XD1_XDFFM_MB_XD5_XDFFM_MB r0 *1 0,0
Ccc_XD1_XDFFM_MB_XD5_XDFFM_MB XD1.XDFFM.MB XD5.XDFFM.MB 1.21e-17
* device instance cc_XD1_XDFFM_MB_XD5_XDFFM_S r0 *1 0,0
Ccc_XD1_XDFFM_MB_XD5_XDFFM_S XD1.XDFFM.MB XD5.XDFFM.S 1.8151e-17
* device instance cc_XD1_XDFFM_MB_XD5_XDFFM_SB r0 *1 0,0
Ccc_XD1_XDFFM_MB_XD5_XDFFM_SB XD1.XDFFM.MB XD5.XDFFM.SB 1.8151e-17
* device instance cc_XD1_XDFFM_MB_XD5_XDFFQ_CLKB r0 *1 0,0
Ccc_XD1_XDFFM_MB_XD5_XDFFQ_CLKB XD1.XDFFM.MB XD5.XDFFQ.CLKB 1.8151e-17
* device instance cc_XD1_XDFFM_MB_XD5_XDFFQ_M r0 *1 0,0
Ccc_XD1_XDFFM_MB_XD5_XDFFQ_M XD1.XDFFM.MB XD5.XDFFQ.M 2.4201e-17
* device instance cc_XD1_XDFFM_MB_XD5_XDFFQ_MB r0 *1 0,0
Ccc_XD1_XDFFM_MB_XD5_XDFFQ_MB XD1.XDFFM.MB XD5.XDFFQ.MB 1.21e-17
* device instance cc_XD1_XDFFM_MB_XD5_XDFFQ_S r0 *1 0,0
Ccc_XD1_XDFFM_MB_XD5_XDFFQ_S XD1.XDFFM.MB XD5.XDFFQ.S 1.8151e-17
* device instance cc_XD1_XDFFM_MB_XD5_XDFFQ_SB r0 *1 0,0
Ccc_XD1_XDFFM_MB_XD5_XDFFQ_SB XD1.XDFFM.MB XD5.XDFFQ.SB 1.8151e-17
* device instance cc_XD1_XDFFM_MB_XD5_XN2_mid1 r0 *1 0,0
Ccc_XD1_XDFFM_MB_XD5_XN2_mid1 XD1.XDFFM.MB XD5.XN2.mid1 1.21e-17
* device instance cc_XD1_XDFFM_MB_XD5_XN3_mid1 r0 *1 0,0
Ccc_XD1_XDFFM_MB_XD5_XN3_mid1 XD1.XDFFM.MB XD5.XN3.mid1 1.21e-17
* device instance cc_XD1_XDFFM_MB_XD5_XN3_mid2 r0 *1 0,0
Ccc_XD1_XDFFM_MB_XD5_XN3_mid2 XD1.XDFFM.MB XD5.XN3.mid2 1.21e-17
* device instance cc_XD1_XDFFM_MB_XD5_dmodout r0 *1 0,0
Ccc_XD1_XDFFM_MB_XD5_dmodout XD1.XDFFM.MB XD5.dmodout 1.21e-17
* device instance cc_XD1_XDFFM_MB_XD5_dq r0 *1 0,0
Ccc_XD1_XDFFM_MB_XD5_dq XD1.XDFFM.MB XD5.dq 1.8151e-17
* device instance cc_XD1_XDFFM_MB_XD5_nm r0 *1 0,0
Ccc_XD1_XDFFM_MB_XD5_nm XD1.XDFFM.MB XD5.nm 1.21e-17
* device instance cc_XD1_XDFFM_MB_XD5_nt r0 *1 0,0
Ccc_XD1_XDFFM_MB_XD5_nt XD1.XDFFM.MB XD5.nt 1.21e-17
* device instance cc_XD1_XDFFM_MB_XD5_t1 r0 *1 0,0
Ccc_XD1_XDFFM_MB_XD5_t1 XD1.XDFFM.MB XD5.t1 1.21e-17
* device instance cc_XD1_XDFFM_MB_XFRT_CLKB r0 *1 0,0
Ccc_XD1_XDFFM_MB_XFRT_CLKB XD1.XDFFM.MB XFRT.CLKB 1.8151e-17
* device instance cc_XD1_XDFFM_MB_XFRT_M r0 *1 0,0
Ccc_XD1_XDFFM_MB_XFRT_M XD1.XDFFM.MB XFRT.M 2.4201e-17
* device instance cc_XD1_XDFFM_MB_XFRT_MB r0 *1 0,0
Ccc_XD1_XDFFM_MB_XFRT_MB XD1.XDFFM.MB XFRT.MB 1.21e-17
* device instance cc_XD1_XDFFM_MB_XFRT_S r0 *1 0,0
Ccc_XD1_XDFFM_MB_XFRT_S XD1.XDFFM.MB XFRT.S 1.8151e-17
* device instance cc_XD1_XDFFM_MB_XFRT_SB r0 *1 0,0
Ccc_XD1_XDFFM_MB_XFRT_SB XD1.XDFFM.MB XFRT.SB 1.8151e-17
* device instance cc_XD1_XDFFM_MB_ck1 r0 *1 0,0
Ccc_XD1_XDFFM_MB_ck1 XD1.XDFFM.MB ck1 6.0502e-17
* device instance cc_XD1_XDFFM_MB_ck2 r0 *1 0,0
Ccc_XD1_XDFFM_MB_ck2 XD1.XDFFM.MB ck2 5.4452e-17
* device instance cc_XD1_XDFFM_MB_ck3 r0 *1 0,0
Ccc_XD1_XDFFM_MB_ck3 XD1.XDFFM.MB ck3 5.4452e-17
* device instance cc_XD1_XDFFM_MB_ck4 r0 *1 0,0
Ccc_XD1_XDFFM_MB_ck4 XD1.XDFFM.MB ck4 5.4452e-17
* device instance cc_XD1_XDFFM_MB_ck5 r0 *1 0,0
Ccc_XD1_XDFFM_MB_ck5 XD1.XDFFM.MB ck5 5.4452e-17
* device instance cc_XD1_XDFFM_MB_mod0 r0 *1 0,0
Ccc_XD1_XDFFM_MB_mod0 XD1.XDFFM.MB mod0 2.4201e-17
* device instance cc_XD1_XDFFM_MB_mod1 r0 *1 0,0
Ccc_XD1_XDFFM_MB_mod1 XD1.XDFFM.MB mod1 2.4201e-17
* device instance cc_XD1_XDFFM_MB_mod2 r0 *1 0,0
Ccc_XD1_XDFFM_MB_mod2 XD1.XDFFM.MB mod2 2.4201e-17
* device instance cc_XD1_XDFFM_MB_mod3 r0 *1 0,0
Ccc_XD1_XDFFM_MB_mod3 XD1.XDFFM.MB mod3 2.4201e-17
* device instance cc_XD1_XDFFM_MB_mod4 r0 *1 0,0
Ccc_XD1_XDFFM_MB_mod4 XD1.XDFFM.MB mod4 2.4201e-17
* device instance cc_XD1_XDFFM_MB_net1 r0 *1 0,0
Ccc_XD1_XDFFM_MB_net1 XD1.XDFFM.MB net1 1.21e-17
* device instance cc_XD1_XDFFM_S_XD1_XDFFM_SB r0 *1 0,0
Ccc_XD1_XDFFM_S_XD1_XDFFM_SB XD1.XDFFM.S XD1.XDFFM.SB 4.0738e-17
* device instance cc_XD1_XDFFM_S_XD1_XDFFQ_CLKB r0 *1 0,0
Ccc_XD1_XDFFM_S_XD1_XDFFQ_CLKB XD1.XDFFM.S XD1.XDFFQ.CLKB 1.8151e-17
* device instance cc_XD1_XDFFM_S_XD1_XDFFQ_M r0 *1 0,0
Ccc_XD1_XDFFM_S_XD1_XDFFQ_M XD1.XDFFM.S XD1.XDFFQ.M 2.4201e-17
* device instance cc_XD1_XDFFM_S_XD1_XDFFQ_MB r0 *1 0,0
Ccc_XD1_XDFFM_S_XD1_XDFFQ_MB XD1.XDFFM.S XD1.XDFFQ.MB 1.21e-17
* device instance cc_XD1_XDFFM_S_XD1_XDFFQ_S r0 *1 0,0
Ccc_XD1_XDFFM_S_XD1_XDFFQ_S XD1.XDFFM.S XD1.XDFFQ.S 1.8151e-17
* device instance cc_XD1_XDFFM_S_XD1_XDFFQ_SB r0 *1 0,0
Ccc_XD1_XDFFM_S_XD1_XDFFQ_SB XD1.XDFFM.S XD1.XDFFQ.SB 1.8151e-17
* device instance cc_XD1_XDFFM_S_XD1_XNOR_midp r0 *1 0,0
Ccc_XD1_XDFFM_S_XD1_XNOR_midp XD1.XDFFM.S XD1.XNOR.midp 1.21e-17
* device instance cc_XD1_XDFFM_S_XD1_dmodout r0 *1 0,0
Ccc_XD1_XDFFM_S_XD1_dmodout XD1.XDFFM.S XD1.dmodout 1.21e-17
* device instance cc_XD1_XDFFM_S_XD1_dq r0 *1 0,0
Ccc_XD1_XDFFM_S_XD1_dq XD1.XDFFM.S XD1.dq 1.21e-17
* device instance cc_XD1_XDFFM_S_XD1_nm r0 *1 0,0
Ccc_XD1_XDFFM_S_XD1_nm XD1.XDFFM.S XD1.nm 1.8151e-17
* device instance cc_XD1_XDFFM_S_XD1_nt r0 *1 0,0
Ccc_XD1_XDFFM_S_XD1_nt XD1.XDFFM.S XD1.nt 2.4201e-17
* device instance cc_XD1_XDFFM_S_XD1_t1 r0 *1 0,0
Ccc_XD1_XDFFM_S_XD1_t1 XD1.XDFFM.S XD1.t1 1.21e-17
* device instance cc_XD1_XDFFM_S_XD2_XDFFM_CLKB r0 *1 0,0
Ccc_XD1_XDFFM_S_XD2_XDFFM_CLKB XD1.XDFFM.S XD2.XDFFM.CLKB 1.8151e-17
* device instance cc_XD1_XDFFM_S_XD2_XDFFM_M r0 *1 0,0
Ccc_XD1_XDFFM_S_XD2_XDFFM_M XD1.XDFFM.S XD2.XDFFM.M 2.4201e-17
* device instance cc_XD1_XDFFM_S_XD2_XDFFM_MB r0 *1 0,0
Ccc_XD1_XDFFM_S_XD2_XDFFM_MB XD1.XDFFM.S XD2.XDFFM.MB 1.21e-17
* device instance cc_XD1_XDFFM_S_XD2_XDFFM_S r0 *1 0,0
Ccc_XD1_XDFFM_S_XD2_XDFFM_S XD1.XDFFM.S XD2.XDFFM.S 1.8151e-17
* device instance cc_XD1_XDFFM_S_XD2_XDFFM_SB r0 *1 0,0
Ccc_XD1_XDFFM_S_XD2_XDFFM_SB XD1.XDFFM.S XD2.XDFFM.SB 1.8151e-17
* device instance cc_XD1_XDFFM_S_XD2_XDFFQ_CLKB r0 *1 0,0
Ccc_XD1_XDFFM_S_XD2_XDFFQ_CLKB XD1.XDFFM.S XD2.XDFFQ.CLKB 1.8151e-17
* device instance cc_XD1_XDFFM_S_XD2_XDFFQ_M r0 *1 0,0
Ccc_XD1_XDFFM_S_XD2_XDFFQ_M XD1.XDFFM.S XD2.XDFFQ.M 2.4201e-17
* device instance cc_XD1_XDFFM_S_XD2_XDFFQ_MB r0 *1 0,0
Ccc_XD1_XDFFM_S_XD2_XDFFQ_MB XD1.XDFFM.S XD2.XDFFQ.MB 1.21e-17
* device instance cc_XD1_XDFFM_S_XD2_XDFFQ_S r0 *1 0,0
Ccc_XD1_XDFFM_S_XD2_XDFFQ_S XD1.XDFFM.S XD2.XDFFQ.S 1.8151e-17
* device instance cc_XD1_XDFFM_S_XD2_XDFFQ_SB r0 *1 0,0
Ccc_XD1_XDFFM_S_XD2_XDFFQ_SB XD1.XDFFM.S XD2.XDFFQ.SB 1.8151e-17
* device instance cc_XD1_XDFFM_S_XD2_XN2_mid1 r0 *1 0,0
Ccc_XD1_XDFFM_S_XD2_XN2_mid1 XD1.XDFFM.S XD2.XN2.mid1 1.21e-17
* device instance cc_XD1_XDFFM_S_XD2_XN3_mid1 r0 *1 0,0
Ccc_XD1_XDFFM_S_XD2_XN3_mid1 XD1.XDFFM.S XD2.XN3.mid1 1.21e-17
* device instance cc_XD1_XDFFM_S_XD2_XN3_mid2 r0 *1 0,0
Ccc_XD1_XDFFM_S_XD2_XN3_mid2 XD1.XDFFM.S XD2.XN3.mid2 1.21e-17
* device instance cc_XD1_XDFFM_S_XD2_dmodout r0 *1 0,0
Ccc_XD1_XDFFM_S_XD2_dmodout XD1.XDFFM.S XD2.dmodout 1.21e-17
* device instance cc_XD1_XDFFM_S_XD2_dq r0 *1 0,0
Ccc_XD1_XDFFM_S_XD2_dq XD1.XDFFM.S XD2.dq 1.8151e-17
* device instance cc_XD1_XDFFM_S_XD2_nm r0 *1 0,0
Ccc_XD1_XDFFM_S_XD2_nm XD1.XDFFM.S XD2.nm 1.21e-17
* device instance cc_XD1_XDFFM_S_XD2_nt r0 *1 0,0
Ccc_XD1_XDFFM_S_XD2_nt XD1.XDFFM.S XD2.nt 1.21e-17
* device instance cc_XD1_XDFFM_S_XD2_t1 r0 *1 0,0
Ccc_XD1_XDFFM_S_XD2_t1 XD1.XDFFM.S XD2.t1 1.21e-17
* device instance cc_XD1_XDFFM_S_XD3_XDFFM_CLKB r0 *1 0,0
Ccc_XD1_XDFFM_S_XD3_XDFFM_CLKB XD1.XDFFM.S XD3.XDFFM.CLKB 1.8151e-17
* device instance cc_XD1_XDFFM_S_XD3_XDFFM_M r0 *1 0,0
Ccc_XD1_XDFFM_S_XD3_XDFFM_M XD1.XDFFM.S XD3.XDFFM.M 2.4201e-17
* device instance cc_XD1_XDFFM_S_XD3_XDFFM_MB r0 *1 0,0
Ccc_XD1_XDFFM_S_XD3_XDFFM_MB XD1.XDFFM.S XD3.XDFFM.MB 1.21e-17
* device instance cc_XD1_XDFFM_S_XD3_XDFFM_S r0 *1 0,0
Ccc_XD1_XDFFM_S_XD3_XDFFM_S XD1.XDFFM.S XD3.XDFFM.S 1.8151e-17
* device instance cc_XD1_XDFFM_S_XD3_XDFFM_SB r0 *1 0,0
Ccc_XD1_XDFFM_S_XD3_XDFFM_SB XD1.XDFFM.S XD3.XDFFM.SB 1.8151e-17
* device instance cc_XD1_XDFFM_S_XD3_XDFFQ_CLKB r0 *1 0,0
Ccc_XD1_XDFFM_S_XD3_XDFFQ_CLKB XD1.XDFFM.S XD3.XDFFQ.CLKB 1.8151e-17
* device instance cc_XD1_XDFFM_S_XD3_XDFFQ_M r0 *1 0,0
Ccc_XD1_XDFFM_S_XD3_XDFFQ_M XD1.XDFFM.S XD3.XDFFQ.M 2.4201e-17
* device instance cc_XD1_XDFFM_S_XD3_XDFFQ_MB r0 *1 0,0
Ccc_XD1_XDFFM_S_XD3_XDFFQ_MB XD1.XDFFM.S XD3.XDFFQ.MB 1.21e-17
* device instance cc_XD1_XDFFM_S_XD3_XDFFQ_S r0 *1 0,0
Ccc_XD1_XDFFM_S_XD3_XDFFQ_S XD1.XDFFM.S XD3.XDFFQ.S 1.8151e-17
* device instance cc_XD1_XDFFM_S_XD3_XDFFQ_SB r0 *1 0,0
Ccc_XD1_XDFFM_S_XD3_XDFFQ_SB XD1.XDFFM.S XD3.XDFFQ.SB 1.8151e-17
* device instance cc_XD1_XDFFM_S_XD3_XN2_mid1 r0 *1 0,0
Ccc_XD1_XDFFM_S_XD3_XN2_mid1 XD1.XDFFM.S XD3.XN2.mid1 1.21e-17
* device instance cc_XD1_XDFFM_S_XD3_XN3_mid1 r0 *1 0,0
Ccc_XD1_XDFFM_S_XD3_XN3_mid1 XD1.XDFFM.S XD3.XN3.mid1 1.21e-17
* device instance cc_XD1_XDFFM_S_XD3_XN3_mid2 r0 *1 0,0
Ccc_XD1_XDFFM_S_XD3_XN3_mid2 XD1.XDFFM.S XD3.XN3.mid2 1.21e-17
* device instance cc_XD1_XDFFM_S_XD3_dmodout r0 *1 0,0
Ccc_XD1_XDFFM_S_XD3_dmodout XD1.XDFFM.S XD3.dmodout 1.21e-17
* device instance cc_XD1_XDFFM_S_XD3_dq r0 *1 0,0
Ccc_XD1_XDFFM_S_XD3_dq XD1.XDFFM.S XD3.dq 1.8151e-17
* device instance cc_XD1_XDFFM_S_XD3_nm r0 *1 0,0
Ccc_XD1_XDFFM_S_XD3_nm XD1.XDFFM.S XD3.nm 1.21e-17
* device instance cc_XD1_XDFFM_S_XD3_nt r0 *1 0,0
Ccc_XD1_XDFFM_S_XD3_nt XD1.XDFFM.S XD3.nt 1.21e-17
* device instance cc_XD1_XDFFM_S_XD3_t1 r0 *1 0,0
Ccc_XD1_XDFFM_S_XD3_t1 XD1.XDFFM.S XD3.t1 1.21e-17
* device instance cc_XD1_XDFFM_S_XD4_XDFFM_CLKB r0 *1 0,0
Ccc_XD1_XDFFM_S_XD4_XDFFM_CLKB XD1.XDFFM.S XD4.XDFFM.CLKB 1.8151e-17
* device instance cc_XD1_XDFFM_S_XD4_XDFFM_M r0 *1 0,0
Ccc_XD1_XDFFM_S_XD4_XDFFM_M XD1.XDFFM.S XD4.XDFFM.M 2.4201e-17
* device instance cc_XD1_XDFFM_S_XD4_XDFFM_MB r0 *1 0,0
Ccc_XD1_XDFFM_S_XD4_XDFFM_MB XD1.XDFFM.S XD4.XDFFM.MB 1.21e-17
* device instance cc_XD1_XDFFM_S_XD4_XDFFM_S r0 *1 0,0
Ccc_XD1_XDFFM_S_XD4_XDFFM_S XD1.XDFFM.S XD4.XDFFM.S 1.8151e-17
* device instance cc_XD1_XDFFM_S_XD4_XDFFM_SB r0 *1 0,0
Ccc_XD1_XDFFM_S_XD4_XDFFM_SB XD1.XDFFM.S XD4.XDFFM.SB 1.8151e-17
* device instance cc_XD1_XDFFM_S_XD4_XDFFQ_CLKB r0 *1 0,0
Ccc_XD1_XDFFM_S_XD4_XDFFQ_CLKB XD1.XDFFM.S XD4.XDFFQ.CLKB 1.8151e-17
* device instance cc_XD1_XDFFM_S_XD4_XDFFQ_M r0 *1 0,0
Ccc_XD1_XDFFM_S_XD4_XDFFQ_M XD1.XDFFM.S XD4.XDFFQ.M 2.4201e-17
* device instance cc_XD1_XDFFM_S_XD4_XDFFQ_MB r0 *1 0,0
Ccc_XD1_XDFFM_S_XD4_XDFFQ_MB XD1.XDFFM.S XD4.XDFFQ.MB 1.21e-17
* device instance cc_XD1_XDFFM_S_XD4_XDFFQ_S r0 *1 0,0
Ccc_XD1_XDFFM_S_XD4_XDFFQ_S XD1.XDFFM.S XD4.XDFFQ.S 1.8151e-17
* device instance cc_XD1_XDFFM_S_XD4_XDFFQ_SB r0 *1 0,0
Ccc_XD1_XDFFM_S_XD4_XDFFQ_SB XD1.XDFFM.S XD4.XDFFQ.SB 1.8151e-17
* device instance cc_XD1_XDFFM_S_XD4_XN2_mid1 r0 *1 0,0
Ccc_XD1_XDFFM_S_XD4_XN2_mid1 XD1.XDFFM.S XD4.XN2.mid1 1.21e-17
* device instance cc_XD1_XDFFM_S_XD4_XN3_mid1 r0 *1 0,0
Ccc_XD1_XDFFM_S_XD4_XN3_mid1 XD1.XDFFM.S XD4.XN3.mid1 1.21e-17
* device instance cc_XD1_XDFFM_S_XD4_XN3_mid2 r0 *1 0,0
Ccc_XD1_XDFFM_S_XD4_XN3_mid2 XD1.XDFFM.S XD4.XN3.mid2 1.21e-17
* device instance cc_XD1_XDFFM_S_XD4_dmodout r0 *1 0,0
Ccc_XD1_XDFFM_S_XD4_dmodout XD1.XDFFM.S XD4.dmodout 1.21e-17
* device instance cc_XD1_XDFFM_S_XD4_dq r0 *1 0,0
Ccc_XD1_XDFFM_S_XD4_dq XD1.XDFFM.S XD4.dq 1.8151e-17
* device instance cc_XD1_XDFFM_S_XD4_nm r0 *1 0,0
Ccc_XD1_XDFFM_S_XD4_nm XD1.XDFFM.S XD4.nm 1.21e-17
* device instance cc_XD1_XDFFM_S_XD4_nt r0 *1 0,0
Ccc_XD1_XDFFM_S_XD4_nt XD1.XDFFM.S XD4.nt 1.21e-17
* device instance cc_XD1_XDFFM_S_XD4_t1 r0 *1 0,0
Ccc_XD1_XDFFM_S_XD4_t1 XD1.XDFFM.S XD4.t1 1.21e-17
* device instance cc_XD1_XDFFM_S_XD5_XDFFM_CLKB r0 *1 0,0
Ccc_XD1_XDFFM_S_XD5_XDFFM_CLKB XD1.XDFFM.S XD5.XDFFM.CLKB 1.8151e-17
* device instance cc_XD1_XDFFM_S_XD5_XDFFM_M r0 *1 0,0
Ccc_XD1_XDFFM_S_XD5_XDFFM_M XD1.XDFFM.S XD5.XDFFM.M 2.4201e-17
* device instance cc_XD1_XDFFM_S_XD5_XDFFM_MB r0 *1 0,0
Ccc_XD1_XDFFM_S_XD5_XDFFM_MB XD1.XDFFM.S XD5.XDFFM.MB 1.21e-17
* device instance cc_XD1_XDFFM_S_XD5_XDFFM_S r0 *1 0,0
Ccc_XD1_XDFFM_S_XD5_XDFFM_S XD1.XDFFM.S XD5.XDFFM.S 1.8151e-17
* device instance cc_XD1_XDFFM_S_XD5_XDFFM_SB r0 *1 0,0
Ccc_XD1_XDFFM_S_XD5_XDFFM_SB XD1.XDFFM.S XD5.XDFFM.SB 1.8151e-17
* device instance cc_XD1_XDFFM_S_XD5_XDFFQ_CLKB r0 *1 0,0
Ccc_XD1_XDFFM_S_XD5_XDFFQ_CLKB XD1.XDFFM.S XD5.XDFFQ.CLKB 1.8151e-17
* device instance cc_XD1_XDFFM_S_XD5_XDFFQ_M r0 *1 0,0
Ccc_XD1_XDFFM_S_XD5_XDFFQ_M XD1.XDFFM.S XD5.XDFFQ.M 2.4201e-17
* device instance cc_XD1_XDFFM_S_XD5_XDFFQ_MB r0 *1 0,0
Ccc_XD1_XDFFM_S_XD5_XDFFQ_MB XD1.XDFFM.S XD5.XDFFQ.MB 1.21e-17
* device instance cc_XD1_XDFFM_S_XD5_XDFFQ_S r0 *1 0,0
Ccc_XD1_XDFFM_S_XD5_XDFFQ_S XD1.XDFFM.S XD5.XDFFQ.S 1.8151e-17
* device instance cc_XD1_XDFFM_S_XD5_XDFFQ_SB r0 *1 0,0
Ccc_XD1_XDFFM_S_XD5_XDFFQ_SB XD1.XDFFM.S XD5.XDFFQ.SB 1.8151e-17
* device instance cc_XD1_XDFFM_S_XD5_XN2_mid1 r0 *1 0,0
Ccc_XD1_XDFFM_S_XD5_XN2_mid1 XD1.XDFFM.S XD5.XN2.mid1 1.21e-17
* device instance cc_XD1_XDFFM_S_XD5_XN3_mid1 r0 *1 0,0
Ccc_XD1_XDFFM_S_XD5_XN3_mid1 XD1.XDFFM.S XD5.XN3.mid1 1.21e-17
* device instance cc_XD1_XDFFM_S_XD5_XN3_mid2 r0 *1 0,0
Ccc_XD1_XDFFM_S_XD5_XN3_mid2 XD1.XDFFM.S XD5.XN3.mid2 1.21e-17
* device instance cc_XD1_XDFFM_S_XD5_dmodout r0 *1 0,0
Ccc_XD1_XDFFM_S_XD5_dmodout XD1.XDFFM.S XD5.dmodout 1.21e-17
* device instance cc_XD1_XDFFM_S_XD5_dq r0 *1 0,0
Ccc_XD1_XDFFM_S_XD5_dq XD1.XDFFM.S XD5.dq 1.8151e-17
* device instance cc_XD1_XDFFM_S_XD5_nm r0 *1 0,0
Ccc_XD1_XDFFM_S_XD5_nm XD1.XDFFM.S XD5.nm 1.21e-17
* device instance cc_XD1_XDFFM_S_XD5_nt r0 *1 0,0
Ccc_XD1_XDFFM_S_XD5_nt XD1.XDFFM.S XD5.nt 1.21e-17
* device instance cc_XD1_XDFFM_S_XD5_t1 r0 *1 0,0
Ccc_XD1_XDFFM_S_XD5_t1 XD1.XDFFM.S XD5.t1 1.21e-17
* device instance cc_XD1_XDFFM_S_XFRT_CLKB r0 *1 0,0
Ccc_XD1_XDFFM_S_XFRT_CLKB XD1.XDFFM.S XFRT.CLKB 1.8151e-17
* device instance cc_XD1_XDFFM_S_XFRT_M r0 *1 0,0
Ccc_XD1_XDFFM_S_XFRT_M XD1.XDFFM.S XFRT.M 2.4201e-17
* device instance cc_XD1_XDFFM_S_XFRT_MB r0 *1 0,0
Ccc_XD1_XDFFM_S_XFRT_MB XD1.XDFFM.S XFRT.MB 1.21e-17
* device instance cc_XD1_XDFFM_S_XFRT_S r0 *1 0,0
Ccc_XD1_XDFFM_S_XFRT_S XD1.XDFFM.S XFRT.S 1.8151e-17
* device instance cc_XD1_XDFFM_S_XFRT_SB r0 *1 0,0
Ccc_XD1_XDFFM_S_XFRT_SB XD1.XDFFM.S XFRT.SB 1.8151e-17
* device instance cc_XD1_XDFFM_S_ck1 r0 *1 0,0
Ccc_XD1_XDFFM_S_ck1 XD1.XDFFM.S ck1 5.4452e-17
* device instance cc_XD1_XDFFM_S_ck2 r0 *1 0,0
Ccc_XD1_XDFFM_S_ck2 XD1.XDFFM.S ck2 5.4452e-17
* device instance cc_XD1_XDFFM_S_ck3 r0 *1 0,0
Ccc_XD1_XDFFM_S_ck3 XD1.XDFFM.S ck3 5.4452e-17
* device instance cc_XD1_XDFFM_S_ck4 r0 *1 0,0
Ccc_XD1_XDFFM_S_ck4 XD1.XDFFM.S ck4 5.4452e-17
* device instance cc_XD1_XDFFM_S_ck5 r0 *1 0,0
Ccc_XD1_XDFFM_S_ck5 XD1.XDFFM.S ck5 5.4452e-17
* device instance cc_XD1_XDFFM_S_mod0 r0 *1 0,0
Ccc_XD1_XDFFM_S_mod0 XD1.XDFFM.S mod0 2.4201e-17
* device instance cc_XD1_XDFFM_S_mod1 r0 *1 0,0
Ccc_XD1_XDFFM_S_mod1 XD1.XDFFM.S mod1 2.4201e-17
* device instance cc_XD1_XDFFM_S_mod2 r0 *1 0,0
Ccc_XD1_XDFFM_S_mod2 XD1.XDFFM.S mod2 2.4201e-17
* device instance cc_XD1_XDFFM_S_mod3 r0 *1 0,0
Ccc_XD1_XDFFM_S_mod3 XD1.XDFFM.S mod3 2.4201e-17
* device instance cc_XD1_XDFFM_S_mod4 r0 *1 0,0
Ccc_XD1_XDFFM_S_mod4 XD1.XDFFM.S mod4 2.4201e-17
* device instance cc_XD1_XDFFM_S_net1 r0 *1 0,0
Ccc_XD1_XDFFM_S_net1 XD1.XDFFM.S net1 1.21e-17
* device instance cc_XD1_XDFFM_SB_XD1_XDFFQ_CLKB r0 *1 0,0
Ccc_XD1_XDFFM_SB_XD1_XDFFQ_CLKB XD1.XDFFM.SB XD1.XDFFQ.CLKB 1.8151e-17
* device instance cc_XD1_XDFFM_SB_XD1_XDFFQ_M r0 *1 0,0
Ccc_XD1_XDFFM_SB_XD1_XDFFQ_M XD1.XDFFM.SB XD1.XDFFQ.M 2.4201e-17
* device instance cc_XD1_XDFFM_SB_XD1_XDFFQ_MB r0 *1 0,0
Ccc_XD1_XDFFM_SB_XD1_XDFFQ_MB XD1.XDFFM.SB XD1.XDFFQ.MB 1.21e-17
* device instance cc_XD1_XDFFM_SB_XD1_XDFFQ_S r0 *1 0,0
Ccc_XD1_XDFFM_SB_XD1_XDFFQ_S XD1.XDFFM.SB XD1.XDFFQ.S 1.8151e-17
* device instance cc_XD1_XDFFM_SB_XD1_XDFFQ_SB r0 *1 0,0
Ccc_XD1_XDFFM_SB_XD1_XDFFQ_SB XD1.XDFFM.SB XD1.XDFFQ.SB 1.8151e-17
* device instance cc_XD1_XDFFM_SB_XD1_XNOR_midp r0 *1 0,0
Ccc_XD1_XDFFM_SB_XD1_XNOR_midp XD1.XDFFM.SB XD1.XNOR.midp 1.21e-17
* device instance cc_XD1_XDFFM_SB_XD1_dmodout r0 *1 0,0
Ccc_XD1_XDFFM_SB_XD1_dmodout XD1.XDFFM.SB XD1.dmodout 1.21e-17
* device instance cc_XD1_XDFFM_SB_XD1_dq r0 *1 0,0
Ccc_XD1_XDFFM_SB_XD1_dq XD1.XDFFM.SB XD1.dq 1.21e-17
* device instance cc_XD1_XDFFM_SB_XD1_nm r0 *1 0,0
Ccc_XD1_XDFFM_SB_XD1_nm XD1.XDFFM.SB XD1.nm 1.8151e-17
* device instance cc_XD1_XDFFM_SB_XD1_nt r0 *1 0,0
Ccc_XD1_XDFFM_SB_XD1_nt XD1.XDFFM.SB XD1.nt 2.4201e-17
* device instance cc_XD1_XDFFM_SB_XD1_t1 r0 *1 0,0
Ccc_XD1_XDFFM_SB_XD1_t1 XD1.XDFFM.SB XD1.t1 1.21e-17
* device instance cc_XD1_XDFFM_SB_XD2_XDFFM_CLKB r0 *1 0,0
Ccc_XD1_XDFFM_SB_XD2_XDFFM_CLKB XD1.XDFFM.SB XD2.XDFFM.CLKB 1.8151e-17
* device instance cc_XD1_XDFFM_SB_XD2_XDFFM_M r0 *1 0,0
Ccc_XD1_XDFFM_SB_XD2_XDFFM_M XD1.XDFFM.SB XD2.XDFFM.M 2.4201e-17
* device instance cc_XD1_XDFFM_SB_XD2_XDFFM_MB r0 *1 0,0
Ccc_XD1_XDFFM_SB_XD2_XDFFM_MB XD1.XDFFM.SB XD2.XDFFM.MB 1.21e-17
* device instance cc_XD1_XDFFM_SB_XD2_XDFFM_S r0 *1 0,0
Ccc_XD1_XDFFM_SB_XD2_XDFFM_S XD1.XDFFM.SB XD2.XDFFM.S 1.8151e-17
* device instance cc_XD1_XDFFM_SB_XD2_XDFFM_SB r0 *1 0,0
Ccc_XD1_XDFFM_SB_XD2_XDFFM_SB XD1.XDFFM.SB XD2.XDFFM.SB 1.8151e-17
* device instance cc_XD1_XDFFM_SB_XD2_XDFFQ_CLKB r0 *1 0,0
Ccc_XD1_XDFFM_SB_XD2_XDFFQ_CLKB XD1.XDFFM.SB XD2.XDFFQ.CLKB 1.8151e-17
* device instance cc_XD1_XDFFM_SB_XD2_XDFFQ_M r0 *1 0,0
Ccc_XD1_XDFFM_SB_XD2_XDFFQ_M XD1.XDFFM.SB XD2.XDFFQ.M 2.4201e-17
* device instance cc_XD1_XDFFM_SB_XD2_XDFFQ_MB r0 *1 0,0
Ccc_XD1_XDFFM_SB_XD2_XDFFQ_MB XD1.XDFFM.SB XD2.XDFFQ.MB 1.21e-17
* device instance cc_XD1_XDFFM_SB_XD2_XDFFQ_S r0 *1 0,0
Ccc_XD1_XDFFM_SB_XD2_XDFFQ_S XD1.XDFFM.SB XD2.XDFFQ.S 1.8151e-17
* device instance cc_XD1_XDFFM_SB_XD2_XDFFQ_SB r0 *1 0,0
Ccc_XD1_XDFFM_SB_XD2_XDFFQ_SB XD1.XDFFM.SB XD2.XDFFQ.SB 1.8151e-17
* device instance cc_XD1_XDFFM_SB_XD2_XN2_mid1 r0 *1 0,0
Ccc_XD1_XDFFM_SB_XD2_XN2_mid1 XD1.XDFFM.SB XD2.XN2.mid1 1.21e-17
* device instance cc_XD1_XDFFM_SB_XD2_XN3_mid1 r0 *1 0,0
Ccc_XD1_XDFFM_SB_XD2_XN3_mid1 XD1.XDFFM.SB XD2.XN3.mid1 1.21e-17
* device instance cc_XD1_XDFFM_SB_XD2_XN3_mid2 r0 *1 0,0
Ccc_XD1_XDFFM_SB_XD2_XN3_mid2 XD1.XDFFM.SB XD2.XN3.mid2 1.21e-17
* device instance cc_XD1_XDFFM_SB_XD2_dmodout r0 *1 0,0
Ccc_XD1_XDFFM_SB_XD2_dmodout XD1.XDFFM.SB XD2.dmodout 1.21e-17
* device instance cc_XD1_XDFFM_SB_XD2_dq r0 *1 0,0
Ccc_XD1_XDFFM_SB_XD2_dq XD1.XDFFM.SB XD2.dq 1.8151e-17
* device instance cc_XD1_XDFFM_SB_XD2_nm r0 *1 0,0
Ccc_XD1_XDFFM_SB_XD2_nm XD1.XDFFM.SB XD2.nm 1.21e-17
* device instance cc_XD1_XDFFM_SB_XD2_nt r0 *1 0,0
Ccc_XD1_XDFFM_SB_XD2_nt XD1.XDFFM.SB XD2.nt 1.21e-17
* device instance cc_XD1_XDFFM_SB_XD2_t1 r0 *1 0,0
Ccc_XD1_XDFFM_SB_XD2_t1 XD1.XDFFM.SB XD2.t1 1.21e-17
* device instance cc_XD1_XDFFM_SB_XD3_XDFFM_CLKB r0 *1 0,0
Ccc_XD1_XDFFM_SB_XD3_XDFFM_CLKB XD1.XDFFM.SB XD3.XDFFM.CLKB 1.8151e-17
* device instance cc_XD1_XDFFM_SB_XD3_XDFFM_M r0 *1 0,0
Ccc_XD1_XDFFM_SB_XD3_XDFFM_M XD1.XDFFM.SB XD3.XDFFM.M 2.4201e-17
* device instance cc_XD1_XDFFM_SB_XD3_XDFFM_MB r0 *1 0,0
Ccc_XD1_XDFFM_SB_XD3_XDFFM_MB XD1.XDFFM.SB XD3.XDFFM.MB 1.21e-17
* device instance cc_XD1_XDFFM_SB_XD3_XDFFM_S r0 *1 0,0
Ccc_XD1_XDFFM_SB_XD3_XDFFM_S XD1.XDFFM.SB XD3.XDFFM.S 1.8151e-17
* device instance cc_XD1_XDFFM_SB_XD3_XDFFM_SB r0 *1 0,0
Ccc_XD1_XDFFM_SB_XD3_XDFFM_SB XD1.XDFFM.SB XD3.XDFFM.SB 1.8151e-17
* device instance cc_XD1_XDFFM_SB_XD3_XDFFQ_CLKB r0 *1 0,0
Ccc_XD1_XDFFM_SB_XD3_XDFFQ_CLKB XD1.XDFFM.SB XD3.XDFFQ.CLKB 1.8151e-17
* device instance cc_XD1_XDFFM_SB_XD3_XDFFQ_M r0 *1 0,0
Ccc_XD1_XDFFM_SB_XD3_XDFFQ_M XD1.XDFFM.SB XD3.XDFFQ.M 2.4201e-17
* device instance cc_XD1_XDFFM_SB_XD3_XDFFQ_MB r0 *1 0,0
Ccc_XD1_XDFFM_SB_XD3_XDFFQ_MB XD1.XDFFM.SB XD3.XDFFQ.MB 1.21e-17
* device instance cc_XD1_XDFFM_SB_XD3_XDFFQ_S r0 *1 0,0
Ccc_XD1_XDFFM_SB_XD3_XDFFQ_S XD1.XDFFM.SB XD3.XDFFQ.S 1.8151e-17
* device instance cc_XD1_XDFFM_SB_XD3_XDFFQ_SB r0 *1 0,0
Ccc_XD1_XDFFM_SB_XD3_XDFFQ_SB XD1.XDFFM.SB XD3.XDFFQ.SB 1.8151e-17
* device instance cc_XD1_XDFFM_SB_XD3_XN2_mid1 r0 *1 0,0
Ccc_XD1_XDFFM_SB_XD3_XN2_mid1 XD1.XDFFM.SB XD3.XN2.mid1 1.21e-17
* device instance cc_XD1_XDFFM_SB_XD3_XN3_mid1 r0 *1 0,0
Ccc_XD1_XDFFM_SB_XD3_XN3_mid1 XD1.XDFFM.SB XD3.XN3.mid1 1.21e-17
* device instance cc_XD1_XDFFM_SB_XD3_XN3_mid2 r0 *1 0,0
Ccc_XD1_XDFFM_SB_XD3_XN3_mid2 XD1.XDFFM.SB XD3.XN3.mid2 1.21e-17
* device instance cc_XD1_XDFFM_SB_XD3_dmodout r0 *1 0,0
Ccc_XD1_XDFFM_SB_XD3_dmodout XD1.XDFFM.SB XD3.dmodout 1.21e-17
* device instance cc_XD1_XDFFM_SB_XD3_dq r0 *1 0,0
Ccc_XD1_XDFFM_SB_XD3_dq XD1.XDFFM.SB XD3.dq 1.8151e-17
* device instance cc_XD1_XDFFM_SB_XD3_nm r0 *1 0,0
Ccc_XD1_XDFFM_SB_XD3_nm XD1.XDFFM.SB XD3.nm 1.21e-17
* device instance cc_XD1_XDFFM_SB_XD3_nt r0 *1 0,0
Ccc_XD1_XDFFM_SB_XD3_nt XD1.XDFFM.SB XD3.nt 1.21e-17
* device instance cc_XD1_XDFFM_SB_XD3_t1 r0 *1 0,0
Ccc_XD1_XDFFM_SB_XD3_t1 XD1.XDFFM.SB XD3.t1 1.21e-17
* device instance cc_XD1_XDFFM_SB_XD4_XDFFM_CLKB r0 *1 0,0
Ccc_XD1_XDFFM_SB_XD4_XDFFM_CLKB XD1.XDFFM.SB XD4.XDFFM.CLKB 1.8151e-17
* device instance cc_XD1_XDFFM_SB_XD4_XDFFM_M r0 *1 0,0
Ccc_XD1_XDFFM_SB_XD4_XDFFM_M XD1.XDFFM.SB XD4.XDFFM.M 2.4201e-17
* device instance cc_XD1_XDFFM_SB_XD4_XDFFM_MB r0 *1 0,0
Ccc_XD1_XDFFM_SB_XD4_XDFFM_MB XD1.XDFFM.SB XD4.XDFFM.MB 1.21e-17
* device instance cc_XD1_XDFFM_SB_XD4_XDFFM_S r0 *1 0,0
Ccc_XD1_XDFFM_SB_XD4_XDFFM_S XD1.XDFFM.SB XD4.XDFFM.S 1.8151e-17
* device instance cc_XD1_XDFFM_SB_XD4_XDFFM_SB r0 *1 0,0
Ccc_XD1_XDFFM_SB_XD4_XDFFM_SB XD1.XDFFM.SB XD4.XDFFM.SB 1.8151e-17
* device instance cc_XD1_XDFFM_SB_XD4_XDFFQ_CLKB r0 *1 0,0
Ccc_XD1_XDFFM_SB_XD4_XDFFQ_CLKB XD1.XDFFM.SB XD4.XDFFQ.CLKB 1.8151e-17
* device instance cc_XD1_XDFFM_SB_XD4_XDFFQ_M r0 *1 0,0
Ccc_XD1_XDFFM_SB_XD4_XDFFQ_M XD1.XDFFM.SB XD4.XDFFQ.M 2.4201e-17
* device instance cc_XD1_XDFFM_SB_XD4_XDFFQ_MB r0 *1 0,0
Ccc_XD1_XDFFM_SB_XD4_XDFFQ_MB XD1.XDFFM.SB XD4.XDFFQ.MB 1.21e-17
* device instance cc_XD1_XDFFM_SB_XD4_XDFFQ_S r0 *1 0,0
Ccc_XD1_XDFFM_SB_XD4_XDFFQ_S XD1.XDFFM.SB XD4.XDFFQ.S 1.8151e-17
* device instance cc_XD1_XDFFM_SB_XD4_XDFFQ_SB r0 *1 0,0
Ccc_XD1_XDFFM_SB_XD4_XDFFQ_SB XD1.XDFFM.SB XD4.XDFFQ.SB 1.8151e-17
* device instance cc_XD1_XDFFM_SB_XD4_XN2_mid1 r0 *1 0,0
Ccc_XD1_XDFFM_SB_XD4_XN2_mid1 XD1.XDFFM.SB XD4.XN2.mid1 1.21e-17
* device instance cc_XD1_XDFFM_SB_XD4_XN3_mid1 r0 *1 0,0
Ccc_XD1_XDFFM_SB_XD4_XN3_mid1 XD1.XDFFM.SB XD4.XN3.mid1 1.21e-17
* device instance cc_XD1_XDFFM_SB_XD4_XN3_mid2 r0 *1 0,0
Ccc_XD1_XDFFM_SB_XD4_XN3_mid2 XD1.XDFFM.SB XD4.XN3.mid2 1.21e-17
* device instance cc_XD1_XDFFM_SB_XD4_dmodout r0 *1 0,0
Ccc_XD1_XDFFM_SB_XD4_dmodout XD1.XDFFM.SB XD4.dmodout 1.21e-17
* device instance cc_XD1_XDFFM_SB_XD4_dq r0 *1 0,0
Ccc_XD1_XDFFM_SB_XD4_dq XD1.XDFFM.SB XD4.dq 1.8151e-17
* device instance cc_XD1_XDFFM_SB_XD4_nm r0 *1 0,0
Ccc_XD1_XDFFM_SB_XD4_nm XD1.XDFFM.SB XD4.nm 1.21e-17
* device instance cc_XD1_XDFFM_SB_XD4_nt r0 *1 0,0
Ccc_XD1_XDFFM_SB_XD4_nt XD1.XDFFM.SB XD4.nt 1.21e-17
* device instance cc_XD1_XDFFM_SB_XD4_t1 r0 *1 0,0
Ccc_XD1_XDFFM_SB_XD4_t1 XD1.XDFFM.SB XD4.t1 1.21e-17
* device instance cc_XD1_XDFFM_SB_XD5_XDFFM_CLKB r0 *1 0,0
Ccc_XD1_XDFFM_SB_XD5_XDFFM_CLKB XD1.XDFFM.SB XD5.XDFFM.CLKB 1.8151e-17
* device instance cc_XD1_XDFFM_SB_XD5_XDFFM_M r0 *1 0,0
Ccc_XD1_XDFFM_SB_XD5_XDFFM_M XD1.XDFFM.SB XD5.XDFFM.M 2.4201e-17
* device instance cc_XD1_XDFFM_SB_XD5_XDFFM_MB r0 *1 0,0
Ccc_XD1_XDFFM_SB_XD5_XDFFM_MB XD1.XDFFM.SB XD5.XDFFM.MB 1.21e-17
* device instance cc_XD1_XDFFM_SB_XD5_XDFFM_S r0 *1 0,0
Ccc_XD1_XDFFM_SB_XD5_XDFFM_S XD1.XDFFM.SB XD5.XDFFM.S 1.8151e-17
* device instance cc_XD1_XDFFM_SB_XD5_XDFFM_SB r0 *1 0,0
Ccc_XD1_XDFFM_SB_XD5_XDFFM_SB XD1.XDFFM.SB XD5.XDFFM.SB 1.8151e-17
* device instance cc_XD1_XDFFM_SB_XD5_XDFFQ_CLKB r0 *1 0,0
Ccc_XD1_XDFFM_SB_XD5_XDFFQ_CLKB XD1.XDFFM.SB XD5.XDFFQ.CLKB 1.8151e-17
* device instance cc_XD1_XDFFM_SB_XD5_XDFFQ_M r0 *1 0,0
Ccc_XD1_XDFFM_SB_XD5_XDFFQ_M XD1.XDFFM.SB XD5.XDFFQ.M 2.4201e-17
* device instance cc_XD1_XDFFM_SB_XD5_XDFFQ_MB r0 *1 0,0
Ccc_XD1_XDFFM_SB_XD5_XDFFQ_MB XD1.XDFFM.SB XD5.XDFFQ.MB 1.21e-17
* device instance cc_XD1_XDFFM_SB_XD5_XDFFQ_S r0 *1 0,0
Ccc_XD1_XDFFM_SB_XD5_XDFFQ_S XD1.XDFFM.SB XD5.XDFFQ.S 1.8151e-17
* device instance cc_XD1_XDFFM_SB_XD5_XDFFQ_SB r0 *1 0,0
Ccc_XD1_XDFFM_SB_XD5_XDFFQ_SB XD1.XDFFM.SB XD5.XDFFQ.SB 1.8151e-17
* device instance cc_XD1_XDFFM_SB_XD5_XN2_mid1 r0 *1 0,0
Ccc_XD1_XDFFM_SB_XD5_XN2_mid1 XD1.XDFFM.SB XD5.XN2.mid1 1.21e-17
* device instance cc_XD1_XDFFM_SB_XD5_XN3_mid1 r0 *1 0,0
Ccc_XD1_XDFFM_SB_XD5_XN3_mid1 XD1.XDFFM.SB XD5.XN3.mid1 1.21e-17
* device instance cc_XD1_XDFFM_SB_XD5_XN3_mid2 r0 *1 0,0
Ccc_XD1_XDFFM_SB_XD5_XN3_mid2 XD1.XDFFM.SB XD5.XN3.mid2 1.21e-17
* device instance cc_XD1_XDFFM_SB_XD5_dmodout r0 *1 0,0
Ccc_XD1_XDFFM_SB_XD5_dmodout XD1.XDFFM.SB XD5.dmodout 1.21e-17
* device instance cc_XD1_XDFFM_SB_XD5_dq r0 *1 0,0
Ccc_XD1_XDFFM_SB_XD5_dq XD1.XDFFM.SB XD5.dq 1.8151e-17
* device instance cc_XD1_XDFFM_SB_XD5_nm r0 *1 0,0
Ccc_XD1_XDFFM_SB_XD5_nm XD1.XDFFM.SB XD5.nm 1.21e-17
* device instance cc_XD1_XDFFM_SB_XD5_nt r0 *1 0,0
Ccc_XD1_XDFFM_SB_XD5_nt XD1.XDFFM.SB XD5.nt 1.21e-17
* device instance cc_XD1_XDFFM_SB_XD5_t1 r0 *1 0,0
Ccc_XD1_XDFFM_SB_XD5_t1 XD1.XDFFM.SB XD5.t1 1.21e-17
* device instance cc_XD1_XDFFM_SB_XFRT_CLKB r0 *1 0,0
Ccc_XD1_XDFFM_SB_XFRT_CLKB XD1.XDFFM.SB XFRT.CLKB 1.8151e-17
* device instance cc_XD1_XDFFM_SB_XFRT_M r0 *1 0,0
Ccc_XD1_XDFFM_SB_XFRT_M XD1.XDFFM.SB XFRT.M 2.4201e-17
* device instance cc_XD1_XDFFM_SB_XFRT_MB r0 *1 0,0
Ccc_XD1_XDFFM_SB_XFRT_MB XD1.XDFFM.SB XFRT.MB 1.21e-17
* device instance cc_XD1_XDFFM_SB_XFRT_S r0 *1 0,0
Ccc_XD1_XDFFM_SB_XFRT_S XD1.XDFFM.SB XFRT.S 1.8151e-17
* device instance cc_XD1_XDFFM_SB_XFRT_SB r0 *1 0,0
Ccc_XD1_XDFFM_SB_XFRT_SB XD1.XDFFM.SB XFRT.SB 1.8151e-17
* device instance cc_XD1_XDFFM_SB_ck1 r0 *1 0,0
Ccc_XD1_XDFFM_SB_ck1 XD1.XDFFM.SB ck1 5.4452e-17
* device instance cc_XD1_XDFFM_SB_ck2 r0 *1 0,0
Ccc_XD1_XDFFM_SB_ck2 XD1.XDFFM.SB ck2 5.4452e-17
* device instance cc_XD1_XDFFM_SB_ck3 r0 *1 0,0
Ccc_XD1_XDFFM_SB_ck3 XD1.XDFFM.SB ck3 5.4452e-17
* device instance cc_XD1_XDFFM_SB_ck4 r0 *1 0,0
Ccc_XD1_XDFFM_SB_ck4 XD1.XDFFM.SB ck4 5.4452e-17
* device instance cc_XD1_XDFFM_SB_ck5 r0 *1 0,0
Ccc_XD1_XDFFM_SB_ck5 XD1.XDFFM.SB ck5 5.4452e-17
* device instance cc_XD1_XDFFM_SB_mod0 r0 *1 0,0
Ccc_XD1_XDFFM_SB_mod0 XD1.XDFFM.SB mod0 2.4201e-17
* device instance cc_XD1_XDFFM_SB_mod1 r0 *1 0,0
Ccc_XD1_XDFFM_SB_mod1 XD1.XDFFM.SB mod1 2.4201e-17
* device instance cc_XD1_XDFFM_SB_mod2 r0 *1 0,0
Ccc_XD1_XDFFM_SB_mod2 XD1.XDFFM.SB mod2 2.4201e-17
* device instance cc_XD1_XDFFM_SB_mod3 r0 *1 0,0
Ccc_XD1_XDFFM_SB_mod3 XD1.XDFFM.SB mod3 2.4201e-17
* device instance cc_XD1_XDFFM_SB_mod4 r0 *1 0,0
Ccc_XD1_XDFFM_SB_mod4 XD1.XDFFM.SB mod4 2.4201e-17
* device instance cc_XD1_XDFFM_SB_net1 r0 *1 0,0
Ccc_XD1_XDFFM_SB_net1 XD1.XDFFM.SB net1 1.21e-17
* device instance cc_XD1_XDFFQ_CLKB_XD1_XDFFQ_M r0 *1 0,0
Ccc_XD1_XDFFQ_CLKB_XD1_XDFFQ_M XD1.XDFFQ.CLKB XD1.XDFFQ.M 4.2352e-17
* device instance cc_XD1_XDFFQ_CLKB_XD1_XDFFQ_MB r0 *1 0,0
Ccc_XD1_XDFFQ_CLKB_XD1_XDFFQ_MB XD1.XDFFQ.CLKB XD1.XDFFQ.MB 2.4201e-17
* device instance cc_XD1_XDFFQ_CLKB_XD1_XDFFQ_S r0 *1 0,0
Ccc_XD1_XDFFQ_CLKB_XD1_XDFFQ_S XD1.XDFFQ.CLKB XD1.XDFFQ.S 1.8151e-17
* device instance cc_XD1_XDFFQ_CLKB_XD1_XDFFQ_SB r0 *1 0,0
Ccc_XD1_XDFFQ_CLKB_XD1_XDFFQ_SB XD1.XDFFQ.CLKB XD1.XDFFQ.SB 1.8151e-17
* device instance cc_XD1_XDFFQ_CLKB_XD1_XN2_mid1 r0 *1 0,0
Ccc_XD1_XDFFQ_CLKB_XD1_XN2_mid1 XD1.XDFFQ.CLKB XD1.XN2.mid1 1.21e-17
* device instance cc_XD1_XDFFQ_CLKB_XD1_XNOR_midp r0 *1 0,0
Ccc_XD1_XDFFQ_CLKB_XD1_XNOR_midp XD1.XDFFQ.CLKB XD1.XNOR.midp 1.21e-17
* device instance cc_XD1_XDFFQ_CLKB_XD1_dmodout r0 *1 0,0
Ccc_XD1_XDFFQ_CLKB_XD1_dmodout XD1.XDFFQ.CLKB XD1.dmodout 1.21e-17
* device instance cc_XD1_XDFFQ_CLKB_XD1_dq r0 *1 0,0
Ccc_XD1_XDFFQ_CLKB_XD1_dq XD1.XDFFQ.CLKB XD1.dq 1.8151e-17
* device instance cc_XD1_XDFFQ_CLKB_XD1_nm r0 *1 0,0
Ccc_XD1_XDFFQ_CLKB_XD1_nm XD1.XDFFQ.CLKB XD1.nm 1.21e-17
* device instance cc_XD1_XDFFQ_CLKB_XD1_nt r0 *1 0,0
Ccc_XD1_XDFFQ_CLKB_XD1_nt XD1.XDFFQ.CLKB XD1.nt 2.4201e-17
* device instance cc_XD1_XDFFQ_CLKB_XD1_t1 r0 *1 0,0
Ccc_XD1_XDFFQ_CLKB_XD1_t1 XD1.XDFFQ.CLKB XD1.t1 1.21e-17
* device instance cc_XD1_XDFFQ_CLKB_XD2_XDFFM_CLKB r0 *1 0,0
Ccc_XD1_XDFFQ_CLKB_XD2_XDFFM_CLKB XD1.XDFFQ.CLKB XD2.XDFFM.CLKB 1.8151e-17
* device instance cc_XD1_XDFFQ_CLKB_XD2_XDFFM_M r0 *1 0,0
Ccc_XD1_XDFFQ_CLKB_XD2_XDFFM_M XD1.XDFFQ.CLKB XD2.XDFFM.M 2.4201e-17
* device instance cc_XD1_XDFFQ_CLKB_XD2_XDFFM_MB r0 *1 0,0
Ccc_XD1_XDFFQ_CLKB_XD2_XDFFM_MB XD1.XDFFQ.CLKB XD2.XDFFM.MB 1.21e-17
* device instance cc_XD1_XDFFQ_CLKB_XD2_XDFFM_S r0 *1 0,0
Ccc_XD1_XDFFQ_CLKB_XD2_XDFFM_S XD1.XDFFQ.CLKB XD2.XDFFM.S 1.8151e-17
* device instance cc_XD1_XDFFQ_CLKB_XD2_XDFFM_SB r0 *1 0,0
Ccc_XD1_XDFFQ_CLKB_XD2_XDFFM_SB XD1.XDFFQ.CLKB XD2.XDFFM.SB 1.8151e-17
* device instance cc_XD1_XDFFQ_CLKB_XD2_XDFFQ_CLKB r0 *1 0,0
Ccc_XD1_XDFFQ_CLKB_XD2_XDFFQ_CLKB XD1.XDFFQ.CLKB XD2.XDFFQ.CLKB 1.8151e-17
* device instance cc_XD1_XDFFQ_CLKB_XD2_XDFFQ_M r0 *1 0,0
Ccc_XD1_XDFFQ_CLKB_XD2_XDFFQ_M XD1.XDFFQ.CLKB XD2.XDFFQ.M 2.4201e-17
* device instance cc_XD1_XDFFQ_CLKB_XD2_XDFFQ_MB r0 *1 0,0
Ccc_XD1_XDFFQ_CLKB_XD2_XDFFQ_MB XD1.XDFFQ.CLKB XD2.XDFFQ.MB 1.21e-17
* device instance cc_XD1_XDFFQ_CLKB_XD2_XDFFQ_S r0 *1 0,0
Ccc_XD1_XDFFQ_CLKB_XD2_XDFFQ_S XD1.XDFFQ.CLKB XD2.XDFFQ.S 1.8151e-17
* device instance cc_XD1_XDFFQ_CLKB_XD2_XDFFQ_SB r0 *1 0,0
Ccc_XD1_XDFFQ_CLKB_XD2_XDFFQ_SB XD1.XDFFQ.CLKB XD2.XDFFQ.SB 1.8151e-17
* device instance cc_XD1_XDFFQ_CLKB_XD2_XN2_mid1 r0 *1 0,0
Ccc_XD1_XDFFQ_CLKB_XD2_XN2_mid1 XD1.XDFFQ.CLKB XD2.XN2.mid1 1.21e-17
* device instance cc_XD1_XDFFQ_CLKB_XD2_XN3_mid1 r0 *1 0,0
Ccc_XD1_XDFFQ_CLKB_XD2_XN3_mid1 XD1.XDFFQ.CLKB XD2.XN3.mid1 1.21e-17
* device instance cc_XD1_XDFFQ_CLKB_XD2_XN3_mid2 r0 *1 0,0
Ccc_XD1_XDFFQ_CLKB_XD2_XN3_mid2 XD1.XDFFQ.CLKB XD2.XN3.mid2 1.21e-17
* device instance cc_XD1_XDFFQ_CLKB_XD2_dmodout r0 *1 0,0
Ccc_XD1_XDFFQ_CLKB_XD2_dmodout XD1.XDFFQ.CLKB XD2.dmodout 1.21e-17
* device instance cc_XD1_XDFFQ_CLKB_XD2_dq r0 *1 0,0
Ccc_XD1_XDFFQ_CLKB_XD2_dq XD1.XDFFQ.CLKB XD2.dq 1.8151e-17
* device instance cc_XD1_XDFFQ_CLKB_XD2_nm r0 *1 0,0
Ccc_XD1_XDFFQ_CLKB_XD2_nm XD1.XDFFQ.CLKB XD2.nm 1.21e-17
* device instance cc_XD1_XDFFQ_CLKB_XD2_nt r0 *1 0,0
Ccc_XD1_XDFFQ_CLKB_XD2_nt XD1.XDFFQ.CLKB XD2.nt 1.21e-17
* device instance cc_XD1_XDFFQ_CLKB_XD2_t1 r0 *1 0,0
Ccc_XD1_XDFFQ_CLKB_XD2_t1 XD1.XDFFQ.CLKB XD2.t1 1.21e-17
* device instance cc_XD1_XDFFQ_CLKB_XD3_XDFFM_CLKB r0 *1 0,0
Ccc_XD1_XDFFQ_CLKB_XD3_XDFFM_CLKB XD1.XDFFQ.CLKB XD3.XDFFM.CLKB 1.8151e-17
* device instance cc_XD1_XDFFQ_CLKB_XD3_XDFFM_M r0 *1 0,0
Ccc_XD1_XDFFQ_CLKB_XD3_XDFFM_M XD1.XDFFQ.CLKB XD3.XDFFM.M 2.4201e-17
* device instance cc_XD1_XDFFQ_CLKB_XD3_XDFFM_MB r0 *1 0,0
Ccc_XD1_XDFFQ_CLKB_XD3_XDFFM_MB XD1.XDFFQ.CLKB XD3.XDFFM.MB 1.21e-17
* device instance cc_XD1_XDFFQ_CLKB_XD3_XDFFM_S r0 *1 0,0
Ccc_XD1_XDFFQ_CLKB_XD3_XDFFM_S XD1.XDFFQ.CLKB XD3.XDFFM.S 1.8151e-17
* device instance cc_XD1_XDFFQ_CLKB_XD3_XDFFM_SB r0 *1 0,0
Ccc_XD1_XDFFQ_CLKB_XD3_XDFFM_SB XD1.XDFFQ.CLKB XD3.XDFFM.SB 1.8151e-17
* device instance cc_XD1_XDFFQ_CLKB_XD3_XDFFQ_CLKB r0 *1 0,0
Ccc_XD1_XDFFQ_CLKB_XD3_XDFFQ_CLKB XD1.XDFFQ.CLKB XD3.XDFFQ.CLKB 1.8151e-17
* device instance cc_XD1_XDFFQ_CLKB_XD3_XDFFQ_M r0 *1 0,0
Ccc_XD1_XDFFQ_CLKB_XD3_XDFFQ_M XD1.XDFFQ.CLKB XD3.XDFFQ.M 2.4201e-17
* device instance cc_XD1_XDFFQ_CLKB_XD3_XDFFQ_MB r0 *1 0,0
Ccc_XD1_XDFFQ_CLKB_XD3_XDFFQ_MB XD1.XDFFQ.CLKB XD3.XDFFQ.MB 1.21e-17
* device instance cc_XD1_XDFFQ_CLKB_XD3_XDFFQ_S r0 *1 0,0
Ccc_XD1_XDFFQ_CLKB_XD3_XDFFQ_S XD1.XDFFQ.CLKB XD3.XDFFQ.S 1.8151e-17
* device instance cc_XD1_XDFFQ_CLKB_XD3_XDFFQ_SB r0 *1 0,0
Ccc_XD1_XDFFQ_CLKB_XD3_XDFFQ_SB XD1.XDFFQ.CLKB XD3.XDFFQ.SB 1.8151e-17
* device instance cc_XD1_XDFFQ_CLKB_XD3_XN2_mid1 r0 *1 0,0
Ccc_XD1_XDFFQ_CLKB_XD3_XN2_mid1 XD1.XDFFQ.CLKB XD3.XN2.mid1 1.21e-17
* device instance cc_XD1_XDFFQ_CLKB_XD3_XN3_mid1 r0 *1 0,0
Ccc_XD1_XDFFQ_CLKB_XD3_XN3_mid1 XD1.XDFFQ.CLKB XD3.XN3.mid1 1.21e-17
* device instance cc_XD1_XDFFQ_CLKB_XD3_XN3_mid2 r0 *1 0,0
Ccc_XD1_XDFFQ_CLKB_XD3_XN3_mid2 XD1.XDFFQ.CLKB XD3.XN3.mid2 1.21e-17
* device instance cc_XD1_XDFFQ_CLKB_XD3_dmodout r0 *1 0,0
Ccc_XD1_XDFFQ_CLKB_XD3_dmodout XD1.XDFFQ.CLKB XD3.dmodout 1.21e-17
* device instance cc_XD1_XDFFQ_CLKB_XD3_dq r0 *1 0,0
Ccc_XD1_XDFFQ_CLKB_XD3_dq XD1.XDFFQ.CLKB XD3.dq 1.8151e-17
* device instance cc_XD1_XDFFQ_CLKB_XD3_nm r0 *1 0,0
Ccc_XD1_XDFFQ_CLKB_XD3_nm XD1.XDFFQ.CLKB XD3.nm 1.21e-17
* device instance cc_XD1_XDFFQ_CLKB_XD3_nt r0 *1 0,0
Ccc_XD1_XDFFQ_CLKB_XD3_nt XD1.XDFFQ.CLKB XD3.nt 1.21e-17
* device instance cc_XD1_XDFFQ_CLKB_XD3_t1 r0 *1 0,0
Ccc_XD1_XDFFQ_CLKB_XD3_t1 XD1.XDFFQ.CLKB XD3.t1 1.21e-17
* device instance cc_XD1_XDFFQ_CLKB_XD4_XDFFM_CLKB r0 *1 0,0
Ccc_XD1_XDFFQ_CLKB_XD4_XDFFM_CLKB XD1.XDFFQ.CLKB XD4.XDFFM.CLKB 1.8151e-17
* device instance cc_XD1_XDFFQ_CLKB_XD4_XDFFM_M r0 *1 0,0
Ccc_XD1_XDFFQ_CLKB_XD4_XDFFM_M XD1.XDFFQ.CLKB XD4.XDFFM.M 2.4201e-17
* device instance cc_XD1_XDFFQ_CLKB_XD4_XDFFM_MB r0 *1 0,0
Ccc_XD1_XDFFQ_CLKB_XD4_XDFFM_MB XD1.XDFFQ.CLKB XD4.XDFFM.MB 1.21e-17
* device instance cc_XD1_XDFFQ_CLKB_XD4_XDFFM_S r0 *1 0,0
Ccc_XD1_XDFFQ_CLKB_XD4_XDFFM_S XD1.XDFFQ.CLKB XD4.XDFFM.S 1.8151e-17
* device instance cc_XD1_XDFFQ_CLKB_XD4_XDFFM_SB r0 *1 0,0
Ccc_XD1_XDFFQ_CLKB_XD4_XDFFM_SB XD1.XDFFQ.CLKB XD4.XDFFM.SB 1.8151e-17
* device instance cc_XD1_XDFFQ_CLKB_XD4_XDFFQ_CLKB r0 *1 0,0
Ccc_XD1_XDFFQ_CLKB_XD4_XDFFQ_CLKB XD1.XDFFQ.CLKB XD4.XDFFQ.CLKB 1.8151e-17
* device instance cc_XD1_XDFFQ_CLKB_XD4_XDFFQ_M r0 *1 0,0
Ccc_XD1_XDFFQ_CLKB_XD4_XDFFQ_M XD1.XDFFQ.CLKB XD4.XDFFQ.M 2.4201e-17
* device instance cc_XD1_XDFFQ_CLKB_XD4_XDFFQ_MB r0 *1 0,0
Ccc_XD1_XDFFQ_CLKB_XD4_XDFFQ_MB XD1.XDFFQ.CLKB XD4.XDFFQ.MB 1.21e-17
* device instance cc_XD1_XDFFQ_CLKB_XD4_XDFFQ_S r0 *1 0,0
Ccc_XD1_XDFFQ_CLKB_XD4_XDFFQ_S XD1.XDFFQ.CLKB XD4.XDFFQ.S 1.8151e-17
* device instance cc_XD1_XDFFQ_CLKB_XD4_XDFFQ_SB r0 *1 0,0
Ccc_XD1_XDFFQ_CLKB_XD4_XDFFQ_SB XD1.XDFFQ.CLKB XD4.XDFFQ.SB 1.8151e-17
* device instance cc_XD1_XDFFQ_CLKB_XD4_XN2_mid1 r0 *1 0,0
Ccc_XD1_XDFFQ_CLKB_XD4_XN2_mid1 XD1.XDFFQ.CLKB XD4.XN2.mid1 1.21e-17
* device instance cc_XD1_XDFFQ_CLKB_XD4_XN3_mid1 r0 *1 0,0
Ccc_XD1_XDFFQ_CLKB_XD4_XN3_mid1 XD1.XDFFQ.CLKB XD4.XN3.mid1 1.21e-17
* device instance cc_XD1_XDFFQ_CLKB_XD4_XN3_mid2 r0 *1 0,0
Ccc_XD1_XDFFQ_CLKB_XD4_XN3_mid2 XD1.XDFFQ.CLKB XD4.XN3.mid2 1.21e-17
* device instance cc_XD1_XDFFQ_CLKB_XD4_dmodout r0 *1 0,0
Ccc_XD1_XDFFQ_CLKB_XD4_dmodout XD1.XDFFQ.CLKB XD4.dmodout 1.21e-17
* device instance cc_XD1_XDFFQ_CLKB_XD4_dq r0 *1 0,0
Ccc_XD1_XDFFQ_CLKB_XD4_dq XD1.XDFFQ.CLKB XD4.dq 1.8151e-17
* device instance cc_XD1_XDFFQ_CLKB_XD4_nm r0 *1 0,0
Ccc_XD1_XDFFQ_CLKB_XD4_nm XD1.XDFFQ.CLKB XD4.nm 1.21e-17
* device instance cc_XD1_XDFFQ_CLKB_XD4_nt r0 *1 0,0
Ccc_XD1_XDFFQ_CLKB_XD4_nt XD1.XDFFQ.CLKB XD4.nt 1.21e-17
* device instance cc_XD1_XDFFQ_CLKB_XD4_t1 r0 *1 0,0
Ccc_XD1_XDFFQ_CLKB_XD4_t1 XD1.XDFFQ.CLKB XD4.t1 1.21e-17
* device instance cc_XD1_XDFFQ_CLKB_XD5_XDFFM_CLKB r0 *1 0,0
Ccc_XD1_XDFFQ_CLKB_XD5_XDFFM_CLKB XD1.XDFFQ.CLKB XD5.XDFFM.CLKB 1.8151e-17
* device instance cc_XD1_XDFFQ_CLKB_XD5_XDFFM_M r0 *1 0,0
Ccc_XD1_XDFFQ_CLKB_XD5_XDFFM_M XD1.XDFFQ.CLKB XD5.XDFFM.M 2.4201e-17
* device instance cc_XD1_XDFFQ_CLKB_XD5_XDFFM_MB r0 *1 0,0
Ccc_XD1_XDFFQ_CLKB_XD5_XDFFM_MB XD1.XDFFQ.CLKB XD5.XDFFM.MB 1.21e-17
* device instance cc_XD1_XDFFQ_CLKB_XD5_XDFFM_S r0 *1 0,0
Ccc_XD1_XDFFQ_CLKB_XD5_XDFFM_S XD1.XDFFQ.CLKB XD5.XDFFM.S 1.8151e-17
* device instance cc_XD1_XDFFQ_CLKB_XD5_XDFFM_SB r0 *1 0,0
Ccc_XD1_XDFFQ_CLKB_XD5_XDFFM_SB XD1.XDFFQ.CLKB XD5.XDFFM.SB 1.8151e-17
* device instance cc_XD1_XDFFQ_CLKB_XD5_XDFFQ_CLKB r0 *1 0,0
Ccc_XD1_XDFFQ_CLKB_XD5_XDFFQ_CLKB XD1.XDFFQ.CLKB XD5.XDFFQ.CLKB 1.8151e-17
* device instance cc_XD1_XDFFQ_CLKB_XD5_XDFFQ_M r0 *1 0,0
Ccc_XD1_XDFFQ_CLKB_XD5_XDFFQ_M XD1.XDFFQ.CLKB XD5.XDFFQ.M 2.4201e-17
* device instance cc_XD1_XDFFQ_CLKB_XD5_XDFFQ_MB r0 *1 0,0
Ccc_XD1_XDFFQ_CLKB_XD5_XDFFQ_MB XD1.XDFFQ.CLKB XD5.XDFFQ.MB 1.21e-17
* device instance cc_XD1_XDFFQ_CLKB_XD5_XDFFQ_S r0 *1 0,0
Ccc_XD1_XDFFQ_CLKB_XD5_XDFFQ_S XD1.XDFFQ.CLKB XD5.XDFFQ.S 1.8151e-17
* device instance cc_XD1_XDFFQ_CLKB_XD5_XDFFQ_SB r0 *1 0,0
Ccc_XD1_XDFFQ_CLKB_XD5_XDFFQ_SB XD1.XDFFQ.CLKB XD5.XDFFQ.SB 1.8151e-17
* device instance cc_XD1_XDFFQ_CLKB_XD5_XN2_mid1 r0 *1 0,0
Ccc_XD1_XDFFQ_CLKB_XD5_XN2_mid1 XD1.XDFFQ.CLKB XD5.XN2.mid1 1.21e-17
* device instance cc_XD1_XDFFQ_CLKB_XD5_XN3_mid1 r0 *1 0,0
Ccc_XD1_XDFFQ_CLKB_XD5_XN3_mid1 XD1.XDFFQ.CLKB XD5.XN3.mid1 1.21e-17
* device instance cc_XD1_XDFFQ_CLKB_XD5_XN3_mid2 r0 *1 0,0
Ccc_XD1_XDFFQ_CLKB_XD5_XN3_mid2 XD1.XDFFQ.CLKB XD5.XN3.mid2 1.21e-17
* device instance cc_XD1_XDFFQ_CLKB_XD5_dmodout r0 *1 0,0
Ccc_XD1_XDFFQ_CLKB_XD5_dmodout XD1.XDFFQ.CLKB XD5.dmodout 1.21e-17
* device instance cc_XD1_XDFFQ_CLKB_XD5_dq r0 *1 0,0
Ccc_XD1_XDFFQ_CLKB_XD5_dq XD1.XDFFQ.CLKB XD5.dq 1.8151e-17
* device instance cc_XD1_XDFFQ_CLKB_XD5_nm r0 *1 0,0
Ccc_XD1_XDFFQ_CLKB_XD5_nm XD1.XDFFQ.CLKB XD5.nm 1.21e-17
* device instance cc_XD1_XDFFQ_CLKB_XD5_nt r0 *1 0,0
Ccc_XD1_XDFFQ_CLKB_XD5_nt XD1.XDFFQ.CLKB XD5.nt 1.21e-17
* device instance cc_XD1_XDFFQ_CLKB_XD5_t1 r0 *1 0,0
Ccc_XD1_XDFFQ_CLKB_XD5_t1 XD1.XDFFQ.CLKB XD5.t1 1.21e-17
* device instance cc_XD1_XDFFQ_CLKB_XFRT_CLKB r0 *1 0,0
Ccc_XD1_XDFFQ_CLKB_XFRT_CLKB XD1.XDFFQ.CLKB XFRT.CLKB 1.8151e-17
* device instance cc_XD1_XDFFQ_CLKB_XFRT_M r0 *1 0,0
Ccc_XD1_XDFFQ_CLKB_XFRT_M XD1.XDFFQ.CLKB XFRT.M 2.4201e-17
* device instance cc_XD1_XDFFQ_CLKB_XFRT_MB r0 *1 0,0
Ccc_XD1_XDFFQ_CLKB_XFRT_MB XD1.XDFFQ.CLKB XFRT.MB 1.21e-17
* device instance cc_XD1_XDFFQ_CLKB_XFRT_S r0 *1 0,0
Ccc_XD1_XDFFQ_CLKB_XFRT_S XD1.XDFFQ.CLKB XFRT.S 1.8151e-17
* device instance cc_XD1_XDFFQ_CLKB_XFRT_SB r0 *1 0,0
Ccc_XD1_XDFFQ_CLKB_XFRT_SB XD1.XDFFQ.CLKB XFRT.SB 1.8151e-17
* device instance cc_XD1_XDFFQ_CLKB_ck1 r0 *1 0,0
Ccc_XD1_XDFFQ_CLKB_ck1 XD1.XDFFQ.CLKB ck1 6.0502e-17
* device instance cc_XD1_XDFFQ_CLKB_ck2 r0 *1 0,0
Ccc_XD1_XDFFQ_CLKB_ck2 XD1.XDFFQ.CLKB ck2 5.4452e-17
* device instance cc_XD1_XDFFQ_CLKB_ck3 r0 *1 0,0
Ccc_XD1_XDFFQ_CLKB_ck3 XD1.XDFFQ.CLKB ck3 5.4452e-17
* device instance cc_XD1_XDFFQ_CLKB_ck4 r0 *1 0,0
Ccc_XD1_XDFFQ_CLKB_ck4 XD1.XDFFQ.CLKB ck4 5.4452e-17
* device instance cc_XD1_XDFFQ_CLKB_ck5 r0 *1 0,0
Ccc_XD1_XDFFQ_CLKB_ck5 XD1.XDFFQ.CLKB ck5 5.4452e-17
* device instance cc_XD1_XDFFQ_CLKB_mod0 r0 *1 0,0
Ccc_XD1_XDFFQ_CLKB_mod0 XD1.XDFFQ.CLKB mod0 2.4201e-17
* device instance cc_XD1_XDFFQ_CLKB_mod1 r0 *1 0,0
Ccc_XD1_XDFFQ_CLKB_mod1 XD1.XDFFQ.CLKB mod1 2.4201e-17
* device instance cc_XD1_XDFFQ_CLKB_mod2 r0 *1 0,0
Ccc_XD1_XDFFQ_CLKB_mod2 XD1.XDFFQ.CLKB mod2 2.4201e-17
* device instance cc_XD1_XDFFQ_CLKB_mod3 r0 *1 0,0
Ccc_XD1_XDFFQ_CLKB_mod3 XD1.XDFFQ.CLKB mod3 2.4201e-17
* device instance cc_XD1_XDFFQ_CLKB_mod4 r0 *1 0,0
Ccc_XD1_XDFFQ_CLKB_mod4 XD1.XDFFQ.CLKB mod4 2.4201e-17
* device instance cc_XD1_XDFFQ_CLKB_net1 r0 *1 0,0
Ccc_XD1_XDFFQ_CLKB_net1 XD1.XDFFQ.CLKB net1 1.21e-17
* device instance cc_XD1_XDFFQ_M_XD1_XDFFQ_MB r0 *1 0,0
Ccc_XD1_XDFFQ_M_XD1_XDFFQ_MB XD1.XDFFQ.M XD1.XDFFQ.MB 3.4688e-17
* device instance cc_XD1_XDFFQ_M_XD1_XDFFQ_S r0 *1 0,0
Ccc_XD1_XDFFQ_M_XD1_XDFFQ_S XD1.XDFFQ.M XD1.XDFFQ.S 2.8638e-17
* device instance cc_XD1_XDFFQ_M_XD1_XDFFQ_SB r0 *1 0,0
Ccc_XD1_XDFFQ_M_XD1_XDFFQ_SB XD1.XDFFQ.M XD1.XDFFQ.SB 1.8151e-17
* device instance cc_XD1_XDFFQ_M_XD1_XN2_mid1 r0 *1 0,0
Ccc_XD1_XDFFQ_M_XD1_XN2_mid1 XD1.XDFFQ.M XD1.XN2.mid1 1.21e-17
* device instance cc_XD1_XDFFQ_M_XD1_XNOR_midp r0 *1 0,0
Ccc_XD1_XDFFQ_M_XD1_XNOR_midp XD1.XDFFQ.M XD1.XNOR.midp 1.21e-17
* device instance cc_XD1_XDFFQ_M_XD1_dmodout r0 *1 0,0
Ccc_XD1_XDFFQ_M_XD1_dmodout XD1.XDFFQ.M XD1.dmodout 1.21e-17
* device instance cc_XD1_XDFFQ_M_XD1_dq r0 *1 0,0
Ccc_XD1_XDFFQ_M_XD1_dq XD1.XDFFQ.M XD1.dq 2.8638e-17
* device instance cc_XD1_XDFFQ_M_XD1_nm r0 *1 0,0
Ccc_XD1_XDFFQ_M_XD1_nm XD1.XDFFQ.M XD1.nm 1.21e-17
* device instance cc_XD1_XDFFQ_M_XD1_nt r0 *1 0,0
Ccc_XD1_XDFFQ_M_XD1_nt XD1.XDFFQ.M XD1.nt 2.4201e-17
* device instance cc_XD1_XDFFQ_M_XD1_t1 r0 *1 0,0
Ccc_XD1_XDFFQ_M_XD1_t1 XD1.XDFFQ.M XD1.t1 1.21e-17
* device instance cc_XD1_XDFFQ_M_XD2_XDFFM_CLKB r0 *1 0,0
Ccc_XD1_XDFFQ_M_XD2_XDFFM_CLKB XD1.XDFFQ.M XD2.XDFFM.CLKB 1.8151e-17
* device instance cc_XD1_XDFFQ_M_XD2_XDFFM_M r0 *1 0,0
Ccc_XD1_XDFFQ_M_XD2_XDFFM_M XD1.XDFFQ.M XD2.XDFFM.M 2.4201e-17
* device instance cc_XD1_XDFFQ_M_XD2_XDFFM_MB r0 *1 0,0
Ccc_XD1_XDFFQ_M_XD2_XDFFM_MB XD1.XDFFQ.M XD2.XDFFM.MB 1.21e-17
* device instance cc_XD1_XDFFQ_M_XD2_XDFFM_S r0 *1 0,0
Ccc_XD1_XDFFQ_M_XD2_XDFFM_S XD1.XDFFQ.M XD2.XDFFM.S 1.8151e-17
* device instance cc_XD1_XDFFQ_M_XD2_XDFFM_SB r0 *1 0,0
Ccc_XD1_XDFFQ_M_XD2_XDFFM_SB XD1.XDFFQ.M XD2.XDFFM.SB 1.8151e-17
* device instance cc_XD1_XDFFQ_M_XD2_XDFFQ_CLKB r0 *1 0,0
Ccc_XD1_XDFFQ_M_XD2_XDFFQ_CLKB XD1.XDFFQ.M XD2.XDFFQ.CLKB 1.8151e-17
* device instance cc_XD1_XDFFQ_M_XD2_XDFFQ_M r0 *1 0,0
Ccc_XD1_XDFFQ_M_XD2_XDFFQ_M XD1.XDFFQ.M XD2.XDFFQ.M 2.4201e-17
* device instance cc_XD1_XDFFQ_M_XD2_XDFFQ_MB r0 *1 0,0
Ccc_XD1_XDFFQ_M_XD2_XDFFQ_MB XD1.XDFFQ.M XD2.XDFFQ.MB 1.21e-17
* device instance cc_XD1_XDFFQ_M_XD2_XDFFQ_S r0 *1 0,0
Ccc_XD1_XDFFQ_M_XD2_XDFFQ_S XD1.XDFFQ.M XD2.XDFFQ.S 1.8151e-17
* device instance cc_XD1_XDFFQ_M_XD2_XDFFQ_SB r0 *1 0,0
Ccc_XD1_XDFFQ_M_XD2_XDFFQ_SB XD1.XDFFQ.M XD2.XDFFQ.SB 1.8151e-17
* device instance cc_XD1_XDFFQ_M_XD2_XN2_mid1 r0 *1 0,0
Ccc_XD1_XDFFQ_M_XD2_XN2_mid1 XD1.XDFFQ.M XD2.XN2.mid1 1.21e-17
* device instance cc_XD1_XDFFQ_M_XD2_XN3_mid1 r0 *1 0,0
Ccc_XD1_XDFFQ_M_XD2_XN3_mid1 XD1.XDFFQ.M XD2.XN3.mid1 1.21e-17
* device instance cc_XD1_XDFFQ_M_XD2_XN3_mid2 r0 *1 0,0
Ccc_XD1_XDFFQ_M_XD2_XN3_mid2 XD1.XDFFQ.M XD2.XN3.mid2 1.21e-17
* device instance cc_XD1_XDFFQ_M_XD2_dmodout r0 *1 0,0
Ccc_XD1_XDFFQ_M_XD2_dmodout XD1.XDFFQ.M XD2.dmodout 1.21e-17
* device instance cc_XD1_XDFFQ_M_XD2_dq r0 *1 0,0
Ccc_XD1_XDFFQ_M_XD2_dq XD1.XDFFQ.M XD2.dq 1.8151e-17
* device instance cc_XD1_XDFFQ_M_XD2_nm r0 *1 0,0
Ccc_XD1_XDFFQ_M_XD2_nm XD1.XDFFQ.M XD2.nm 1.21e-17
* device instance cc_XD1_XDFFQ_M_XD2_nt r0 *1 0,0
Ccc_XD1_XDFFQ_M_XD2_nt XD1.XDFFQ.M XD2.nt 1.21e-17
* device instance cc_XD1_XDFFQ_M_XD2_t1 r0 *1 0,0
Ccc_XD1_XDFFQ_M_XD2_t1 XD1.XDFFQ.M XD2.t1 1.21e-17
* device instance cc_XD1_XDFFQ_M_XD3_XDFFM_CLKB r0 *1 0,0
Ccc_XD1_XDFFQ_M_XD3_XDFFM_CLKB XD1.XDFFQ.M XD3.XDFFM.CLKB 1.8151e-17
* device instance cc_XD1_XDFFQ_M_XD3_XDFFM_M r0 *1 0,0
Ccc_XD1_XDFFQ_M_XD3_XDFFM_M XD1.XDFFQ.M XD3.XDFFM.M 2.4201e-17
* device instance cc_XD1_XDFFQ_M_XD3_XDFFM_MB r0 *1 0,0
Ccc_XD1_XDFFQ_M_XD3_XDFFM_MB XD1.XDFFQ.M XD3.XDFFM.MB 1.21e-17
* device instance cc_XD1_XDFFQ_M_XD3_XDFFM_S r0 *1 0,0
Ccc_XD1_XDFFQ_M_XD3_XDFFM_S XD1.XDFFQ.M XD3.XDFFM.S 1.8151e-17
* device instance cc_XD1_XDFFQ_M_XD3_XDFFM_SB r0 *1 0,0
Ccc_XD1_XDFFQ_M_XD3_XDFFM_SB XD1.XDFFQ.M XD3.XDFFM.SB 1.8151e-17
* device instance cc_XD1_XDFFQ_M_XD3_XDFFQ_CLKB r0 *1 0,0
Ccc_XD1_XDFFQ_M_XD3_XDFFQ_CLKB XD1.XDFFQ.M XD3.XDFFQ.CLKB 1.8151e-17
* device instance cc_XD1_XDFFQ_M_XD3_XDFFQ_M r0 *1 0,0
Ccc_XD1_XDFFQ_M_XD3_XDFFQ_M XD1.XDFFQ.M XD3.XDFFQ.M 2.4201e-17
* device instance cc_XD1_XDFFQ_M_XD3_XDFFQ_MB r0 *1 0,0
Ccc_XD1_XDFFQ_M_XD3_XDFFQ_MB XD1.XDFFQ.M XD3.XDFFQ.MB 1.21e-17
* device instance cc_XD1_XDFFQ_M_XD3_XDFFQ_S r0 *1 0,0
Ccc_XD1_XDFFQ_M_XD3_XDFFQ_S XD1.XDFFQ.M XD3.XDFFQ.S 1.8151e-17
* device instance cc_XD1_XDFFQ_M_XD3_XDFFQ_SB r0 *1 0,0
Ccc_XD1_XDFFQ_M_XD3_XDFFQ_SB XD1.XDFFQ.M XD3.XDFFQ.SB 1.8151e-17
* device instance cc_XD1_XDFFQ_M_XD3_XN2_mid1 r0 *1 0,0
Ccc_XD1_XDFFQ_M_XD3_XN2_mid1 XD1.XDFFQ.M XD3.XN2.mid1 1.21e-17
* device instance cc_XD1_XDFFQ_M_XD3_XN3_mid1 r0 *1 0,0
Ccc_XD1_XDFFQ_M_XD3_XN3_mid1 XD1.XDFFQ.M XD3.XN3.mid1 1.21e-17
* device instance cc_XD1_XDFFQ_M_XD3_XN3_mid2 r0 *1 0,0
Ccc_XD1_XDFFQ_M_XD3_XN3_mid2 XD1.XDFFQ.M XD3.XN3.mid2 1.21e-17
* device instance cc_XD1_XDFFQ_M_XD3_dmodout r0 *1 0,0
Ccc_XD1_XDFFQ_M_XD3_dmodout XD1.XDFFQ.M XD3.dmodout 1.21e-17
* device instance cc_XD1_XDFFQ_M_XD3_dq r0 *1 0,0
Ccc_XD1_XDFFQ_M_XD3_dq XD1.XDFFQ.M XD3.dq 1.8151e-17
* device instance cc_XD1_XDFFQ_M_XD3_nm r0 *1 0,0
Ccc_XD1_XDFFQ_M_XD3_nm XD1.XDFFQ.M XD3.nm 1.21e-17
* device instance cc_XD1_XDFFQ_M_XD3_nt r0 *1 0,0
Ccc_XD1_XDFFQ_M_XD3_nt XD1.XDFFQ.M XD3.nt 1.21e-17
* device instance cc_XD1_XDFFQ_M_XD3_t1 r0 *1 0,0
Ccc_XD1_XDFFQ_M_XD3_t1 XD1.XDFFQ.M XD3.t1 1.21e-17
* device instance cc_XD1_XDFFQ_M_XD4_XDFFM_CLKB r0 *1 0,0
Ccc_XD1_XDFFQ_M_XD4_XDFFM_CLKB XD1.XDFFQ.M XD4.XDFFM.CLKB 1.8151e-17
* device instance cc_XD1_XDFFQ_M_XD4_XDFFM_M r0 *1 0,0
Ccc_XD1_XDFFQ_M_XD4_XDFFM_M XD1.XDFFQ.M XD4.XDFFM.M 2.4201e-17
* device instance cc_XD1_XDFFQ_M_XD4_XDFFM_MB r0 *1 0,0
Ccc_XD1_XDFFQ_M_XD4_XDFFM_MB XD1.XDFFQ.M XD4.XDFFM.MB 1.21e-17
* device instance cc_XD1_XDFFQ_M_XD4_XDFFM_S r0 *1 0,0
Ccc_XD1_XDFFQ_M_XD4_XDFFM_S XD1.XDFFQ.M XD4.XDFFM.S 1.8151e-17
* device instance cc_XD1_XDFFQ_M_XD4_XDFFM_SB r0 *1 0,0
Ccc_XD1_XDFFQ_M_XD4_XDFFM_SB XD1.XDFFQ.M XD4.XDFFM.SB 1.8151e-17
* device instance cc_XD1_XDFFQ_M_XD4_XDFFQ_CLKB r0 *1 0,0
Ccc_XD1_XDFFQ_M_XD4_XDFFQ_CLKB XD1.XDFFQ.M XD4.XDFFQ.CLKB 1.8151e-17
* device instance cc_XD1_XDFFQ_M_XD4_XDFFQ_M r0 *1 0,0
Ccc_XD1_XDFFQ_M_XD4_XDFFQ_M XD1.XDFFQ.M XD4.XDFFQ.M 2.4201e-17
* device instance cc_XD1_XDFFQ_M_XD4_XDFFQ_MB r0 *1 0,0
Ccc_XD1_XDFFQ_M_XD4_XDFFQ_MB XD1.XDFFQ.M XD4.XDFFQ.MB 1.21e-17
* device instance cc_XD1_XDFFQ_M_XD4_XDFFQ_S r0 *1 0,0
Ccc_XD1_XDFFQ_M_XD4_XDFFQ_S XD1.XDFFQ.M XD4.XDFFQ.S 1.8151e-17
* device instance cc_XD1_XDFFQ_M_XD4_XDFFQ_SB r0 *1 0,0
Ccc_XD1_XDFFQ_M_XD4_XDFFQ_SB XD1.XDFFQ.M XD4.XDFFQ.SB 1.8151e-17
* device instance cc_XD1_XDFFQ_M_XD4_XN2_mid1 r0 *1 0,0
Ccc_XD1_XDFFQ_M_XD4_XN2_mid1 XD1.XDFFQ.M XD4.XN2.mid1 1.21e-17
* device instance cc_XD1_XDFFQ_M_XD4_XN3_mid1 r0 *1 0,0
Ccc_XD1_XDFFQ_M_XD4_XN3_mid1 XD1.XDFFQ.M XD4.XN3.mid1 1.21e-17
* device instance cc_XD1_XDFFQ_M_XD4_XN3_mid2 r0 *1 0,0
Ccc_XD1_XDFFQ_M_XD4_XN3_mid2 XD1.XDFFQ.M XD4.XN3.mid2 1.21e-17
* device instance cc_XD1_XDFFQ_M_XD4_dmodout r0 *1 0,0
Ccc_XD1_XDFFQ_M_XD4_dmodout XD1.XDFFQ.M XD4.dmodout 1.21e-17
* device instance cc_XD1_XDFFQ_M_XD4_dq r0 *1 0,0
Ccc_XD1_XDFFQ_M_XD4_dq XD1.XDFFQ.M XD4.dq 1.8151e-17
* device instance cc_XD1_XDFFQ_M_XD4_nm r0 *1 0,0
Ccc_XD1_XDFFQ_M_XD4_nm XD1.XDFFQ.M XD4.nm 1.21e-17
* device instance cc_XD1_XDFFQ_M_XD4_nt r0 *1 0,0
Ccc_XD1_XDFFQ_M_XD4_nt XD1.XDFFQ.M XD4.nt 1.21e-17
* device instance cc_XD1_XDFFQ_M_XD4_t1 r0 *1 0,0
Ccc_XD1_XDFFQ_M_XD4_t1 XD1.XDFFQ.M XD4.t1 1.21e-17
* device instance cc_XD1_XDFFQ_M_XD5_XDFFM_CLKB r0 *1 0,0
Ccc_XD1_XDFFQ_M_XD5_XDFFM_CLKB XD1.XDFFQ.M XD5.XDFFM.CLKB 1.8151e-17
* device instance cc_XD1_XDFFQ_M_XD5_XDFFM_M r0 *1 0,0
Ccc_XD1_XDFFQ_M_XD5_XDFFM_M XD1.XDFFQ.M XD5.XDFFM.M 2.4201e-17
* device instance cc_XD1_XDFFQ_M_XD5_XDFFM_MB r0 *1 0,0
Ccc_XD1_XDFFQ_M_XD5_XDFFM_MB XD1.XDFFQ.M XD5.XDFFM.MB 1.21e-17
* device instance cc_XD1_XDFFQ_M_XD5_XDFFM_S r0 *1 0,0
Ccc_XD1_XDFFQ_M_XD5_XDFFM_S XD1.XDFFQ.M XD5.XDFFM.S 1.8151e-17
* device instance cc_XD1_XDFFQ_M_XD5_XDFFM_SB r0 *1 0,0
Ccc_XD1_XDFFQ_M_XD5_XDFFM_SB XD1.XDFFQ.M XD5.XDFFM.SB 1.8151e-17
* device instance cc_XD1_XDFFQ_M_XD5_XDFFQ_CLKB r0 *1 0,0
Ccc_XD1_XDFFQ_M_XD5_XDFFQ_CLKB XD1.XDFFQ.M XD5.XDFFQ.CLKB 1.8151e-17
* device instance cc_XD1_XDFFQ_M_XD5_XDFFQ_M r0 *1 0,0
Ccc_XD1_XDFFQ_M_XD5_XDFFQ_M XD1.XDFFQ.M XD5.XDFFQ.M 2.4201e-17
* device instance cc_XD1_XDFFQ_M_XD5_XDFFQ_MB r0 *1 0,0
Ccc_XD1_XDFFQ_M_XD5_XDFFQ_MB XD1.XDFFQ.M XD5.XDFFQ.MB 1.21e-17
* device instance cc_XD1_XDFFQ_M_XD5_XDFFQ_S r0 *1 0,0
Ccc_XD1_XDFFQ_M_XD5_XDFFQ_S XD1.XDFFQ.M XD5.XDFFQ.S 1.8151e-17
* device instance cc_XD1_XDFFQ_M_XD5_XDFFQ_SB r0 *1 0,0
Ccc_XD1_XDFFQ_M_XD5_XDFFQ_SB XD1.XDFFQ.M XD5.XDFFQ.SB 1.8151e-17
* device instance cc_XD1_XDFFQ_M_XD5_XN2_mid1 r0 *1 0,0
Ccc_XD1_XDFFQ_M_XD5_XN2_mid1 XD1.XDFFQ.M XD5.XN2.mid1 1.21e-17
* device instance cc_XD1_XDFFQ_M_XD5_XN3_mid1 r0 *1 0,0
Ccc_XD1_XDFFQ_M_XD5_XN3_mid1 XD1.XDFFQ.M XD5.XN3.mid1 1.21e-17
* device instance cc_XD1_XDFFQ_M_XD5_XN3_mid2 r0 *1 0,0
Ccc_XD1_XDFFQ_M_XD5_XN3_mid2 XD1.XDFFQ.M XD5.XN3.mid2 1.21e-17
* device instance cc_XD1_XDFFQ_M_XD5_dmodout r0 *1 0,0
Ccc_XD1_XDFFQ_M_XD5_dmodout XD1.XDFFQ.M XD5.dmodout 1.21e-17
* device instance cc_XD1_XDFFQ_M_XD5_dq r0 *1 0,0
Ccc_XD1_XDFFQ_M_XD5_dq XD1.XDFFQ.M XD5.dq 1.8151e-17
* device instance cc_XD1_XDFFQ_M_XD5_nm r0 *1 0,0
Ccc_XD1_XDFFQ_M_XD5_nm XD1.XDFFQ.M XD5.nm 1.21e-17
* device instance cc_XD1_XDFFQ_M_XD5_nt r0 *1 0,0
Ccc_XD1_XDFFQ_M_XD5_nt XD1.XDFFQ.M XD5.nt 1.21e-17
* device instance cc_XD1_XDFFQ_M_XD5_t1 r0 *1 0,0
Ccc_XD1_XDFFQ_M_XD5_t1 XD1.XDFFQ.M XD5.t1 1.21e-17
* device instance cc_XD1_XDFFQ_M_XFRT_CLKB r0 *1 0,0
Ccc_XD1_XDFFQ_M_XFRT_CLKB XD1.XDFFQ.M XFRT.CLKB 1.8151e-17
* device instance cc_XD1_XDFFQ_M_XFRT_M r0 *1 0,0
Ccc_XD1_XDFFQ_M_XFRT_M XD1.XDFFQ.M XFRT.M 2.4201e-17
* device instance cc_XD1_XDFFQ_M_XFRT_MB r0 *1 0,0
Ccc_XD1_XDFFQ_M_XFRT_MB XD1.XDFFQ.M XFRT.MB 1.21e-17
* device instance cc_XD1_XDFFQ_M_XFRT_S r0 *1 0,0
Ccc_XD1_XDFFQ_M_XFRT_S XD1.XDFFQ.M XFRT.S 1.8151e-17
* device instance cc_XD1_XDFFQ_M_XFRT_SB r0 *1 0,0
Ccc_XD1_XDFFQ_M_XFRT_SB XD1.XDFFQ.M XFRT.SB 1.8151e-17
* device instance cc_XD1_XDFFQ_M_ck1 r0 *1 0,0
Ccc_XD1_XDFFQ_M_ck1 XD1.XDFFQ.M ck1 6.0502e-17
* device instance cc_XD1_XDFFQ_M_ck2 r0 *1 0,0
Ccc_XD1_XDFFQ_M_ck2 XD1.XDFFQ.M ck2 5.4452e-17
* device instance cc_XD1_XDFFQ_M_ck3 r0 *1 0,0
Ccc_XD1_XDFFQ_M_ck3 XD1.XDFFQ.M ck3 5.4452e-17
* device instance cc_XD1_XDFFQ_M_ck4 r0 *1 0,0
Ccc_XD1_XDFFQ_M_ck4 XD1.XDFFQ.M ck4 5.4452e-17
* device instance cc_XD1_XDFFQ_M_ck5 r0 *1 0,0
Ccc_XD1_XDFFQ_M_ck5 XD1.XDFFQ.M ck5 5.4452e-17
* device instance cc_XD1_XDFFQ_M_mod0 r0 *1 0,0
Ccc_XD1_XDFFQ_M_mod0 XD1.XDFFQ.M mod0 2.4201e-17
* device instance cc_XD1_XDFFQ_M_mod1 r0 *1 0,0
Ccc_XD1_XDFFQ_M_mod1 XD1.XDFFQ.M mod1 2.4201e-17
* device instance cc_XD1_XDFFQ_M_mod2 r0 *1 0,0
Ccc_XD1_XDFFQ_M_mod2 XD1.XDFFQ.M mod2 2.4201e-17
* device instance cc_XD1_XDFFQ_M_mod3 r0 *1 0,0
Ccc_XD1_XDFFQ_M_mod3 XD1.XDFFQ.M mod3 2.4201e-17
* device instance cc_XD1_XDFFQ_M_mod4 r0 *1 0,0
Ccc_XD1_XDFFQ_M_mod4 XD1.XDFFQ.M mod4 2.4201e-17
* device instance cc_XD1_XDFFQ_M_net1 r0 *1 0,0
Ccc_XD1_XDFFQ_M_net1 XD1.XDFFQ.M net1 1.21e-17
* device instance cc_XD1_XDFFQ_MB_XD1_XDFFQ_S r0 *1 0,0
Ccc_XD1_XDFFQ_MB_XD1_XDFFQ_S XD1.XDFFQ.MB XD1.XDFFQ.S 1.8151e-17
* device instance cc_XD1_XDFFQ_MB_XD1_XDFFQ_SB r0 *1 0,0
Ccc_XD1_XDFFQ_MB_XD1_XDFFQ_SB XD1.XDFFQ.MB XD1.XDFFQ.SB 1.8151e-17
* device instance cc_XD1_XDFFQ_MB_XD1_XN2_mid1 r0 *1 0,0
Ccc_XD1_XDFFQ_MB_XD1_XN2_mid1 XD1.XDFFQ.MB XD1.XN2.mid1 1.21e-17
* device instance cc_XD1_XDFFQ_MB_XD1_XNOR_midp r0 *1 0,0
Ccc_XD1_XDFFQ_MB_XD1_XNOR_midp XD1.XDFFQ.MB XD1.XNOR.midp 1.21e-17
* device instance cc_XD1_XDFFQ_MB_XD1_dmodout r0 *1 0,0
Ccc_XD1_XDFFQ_MB_XD1_dmodout XD1.XDFFQ.MB XD1.dmodout 1.21e-17
* device instance cc_XD1_XDFFQ_MB_XD1_dq r0 *1 0,0
Ccc_XD1_XDFFQ_MB_XD1_dq XD1.XDFFQ.MB XD1.dq 1.21e-17
* device instance cc_XD1_XDFFQ_MB_XD1_nm r0 *1 0,0
Ccc_XD1_XDFFQ_MB_XD1_nm XD1.XDFFQ.MB XD1.nm 1.21e-17
* device instance cc_XD1_XDFFQ_MB_XD1_nt r0 *1 0,0
Ccc_XD1_XDFFQ_MB_XD1_nt XD1.XDFFQ.MB XD1.nt 2.4201e-17
* device instance cc_XD1_XDFFQ_MB_XD1_t1 r0 *1 0,0
Ccc_XD1_XDFFQ_MB_XD1_t1 XD1.XDFFQ.MB XD1.t1 1.21e-17
* device instance cc_XD1_XDFFQ_MB_XD2_XDFFM_CLKB r0 *1 0,0
Ccc_XD1_XDFFQ_MB_XD2_XDFFM_CLKB XD1.XDFFQ.MB XD2.XDFFM.CLKB 1.8151e-17
* device instance cc_XD1_XDFFQ_MB_XD2_XDFFM_M r0 *1 0,0
Ccc_XD1_XDFFQ_MB_XD2_XDFFM_M XD1.XDFFQ.MB XD2.XDFFM.M 2.4201e-17
* device instance cc_XD1_XDFFQ_MB_XD2_XDFFM_MB r0 *1 0,0
Ccc_XD1_XDFFQ_MB_XD2_XDFFM_MB XD1.XDFFQ.MB XD2.XDFFM.MB 1.21e-17
* device instance cc_XD1_XDFFQ_MB_XD2_XDFFM_S r0 *1 0,0
Ccc_XD1_XDFFQ_MB_XD2_XDFFM_S XD1.XDFFQ.MB XD2.XDFFM.S 1.8151e-17
* device instance cc_XD1_XDFFQ_MB_XD2_XDFFM_SB r0 *1 0,0
Ccc_XD1_XDFFQ_MB_XD2_XDFFM_SB XD1.XDFFQ.MB XD2.XDFFM.SB 1.8151e-17
* device instance cc_XD1_XDFFQ_MB_XD2_XDFFQ_CLKB r0 *1 0,0
Ccc_XD1_XDFFQ_MB_XD2_XDFFQ_CLKB XD1.XDFFQ.MB XD2.XDFFQ.CLKB 1.8151e-17
* device instance cc_XD1_XDFFQ_MB_XD2_XDFFQ_M r0 *1 0,0
Ccc_XD1_XDFFQ_MB_XD2_XDFFQ_M XD1.XDFFQ.MB XD2.XDFFQ.M 2.4201e-17
* device instance cc_XD1_XDFFQ_MB_XD2_XDFFQ_MB r0 *1 0,0
Ccc_XD1_XDFFQ_MB_XD2_XDFFQ_MB XD1.XDFFQ.MB XD2.XDFFQ.MB 1.21e-17
* device instance cc_XD1_XDFFQ_MB_XD2_XDFFQ_S r0 *1 0,0
Ccc_XD1_XDFFQ_MB_XD2_XDFFQ_S XD1.XDFFQ.MB XD2.XDFFQ.S 1.8151e-17
* device instance cc_XD1_XDFFQ_MB_XD2_XDFFQ_SB r0 *1 0,0
Ccc_XD1_XDFFQ_MB_XD2_XDFFQ_SB XD1.XDFFQ.MB XD2.XDFFQ.SB 1.8151e-17
* device instance cc_XD1_XDFFQ_MB_XD2_XN2_mid1 r0 *1 0,0
Ccc_XD1_XDFFQ_MB_XD2_XN2_mid1 XD1.XDFFQ.MB XD2.XN2.mid1 1.21e-17
* device instance cc_XD1_XDFFQ_MB_XD2_XN3_mid1 r0 *1 0,0
Ccc_XD1_XDFFQ_MB_XD2_XN3_mid1 XD1.XDFFQ.MB XD2.XN3.mid1 1.21e-17
* device instance cc_XD1_XDFFQ_MB_XD2_XN3_mid2 r0 *1 0,0
Ccc_XD1_XDFFQ_MB_XD2_XN3_mid2 XD1.XDFFQ.MB XD2.XN3.mid2 1.21e-17
* device instance cc_XD1_XDFFQ_MB_XD2_dmodout r0 *1 0,0
Ccc_XD1_XDFFQ_MB_XD2_dmodout XD1.XDFFQ.MB XD2.dmodout 1.21e-17
* device instance cc_XD1_XDFFQ_MB_XD2_dq r0 *1 0,0
Ccc_XD1_XDFFQ_MB_XD2_dq XD1.XDFFQ.MB XD2.dq 1.8151e-17
* device instance cc_XD1_XDFFQ_MB_XD2_nm r0 *1 0,0
Ccc_XD1_XDFFQ_MB_XD2_nm XD1.XDFFQ.MB XD2.nm 1.21e-17
* device instance cc_XD1_XDFFQ_MB_XD2_nt r0 *1 0,0
Ccc_XD1_XDFFQ_MB_XD2_nt XD1.XDFFQ.MB XD2.nt 1.21e-17
* device instance cc_XD1_XDFFQ_MB_XD2_t1 r0 *1 0,0
Ccc_XD1_XDFFQ_MB_XD2_t1 XD1.XDFFQ.MB XD2.t1 1.21e-17
* device instance cc_XD1_XDFFQ_MB_XD3_XDFFM_CLKB r0 *1 0,0
Ccc_XD1_XDFFQ_MB_XD3_XDFFM_CLKB XD1.XDFFQ.MB XD3.XDFFM.CLKB 1.8151e-17
* device instance cc_XD1_XDFFQ_MB_XD3_XDFFM_M r0 *1 0,0
Ccc_XD1_XDFFQ_MB_XD3_XDFFM_M XD1.XDFFQ.MB XD3.XDFFM.M 2.4201e-17
* device instance cc_XD1_XDFFQ_MB_XD3_XDFFM_MB r0 *1 0,0
Ccc_XD1_XDFFQ_MB_XD3_XDFFM_MB XD1.XDFFQ.MB XD3.XDFFM.MB 1.21e-17
* device instance cc_XD1_XDFFQ_MB_XD3_XDFFM_S r0 *1 0,0
Ccc_XD1_XDFFQ_MB_XD3_XDFFM_S XD1.XDFFQ.MB XD3.XDFFM.S 1.8151e-17
* device instance cc_XD1_XDFFQ_MB_XD3_XDFFM_SB r0 *1 0,0
Ccc_XD1_XDFFQ_MB_XD3_XDFFM_SB XD1.XDFFQ.MB XD3.XDFFM.SB 1.8151e-17
* device instance cc_XD1_XDFFQ_MB_XD3_XDFFQ_CLKB r0 *1 0,0
Ccc_XD1_XDFFQ_MB_XD3_XDFFQ_CLKB XD1.XDFFQ.MB XD3.XDFFQ.CLKB 1.8151e-17
* device instance cc_XD1_XDFFQ_MB_XD3_XDFFQ_M r0 *1 0,0
Ccc_XD1_XDFFQ_MB_XD3_XDFFQ_M XD1.XDFFQ.MB XD3.XDFFQ.M 2.4201e-17
* device instance cc_XD1_XDFFQ_MB_XD3_XDFFQ_MB r0 *1 0,0
Ccc_XD1_XDFFQ_MB_XD3_XDFFQ_MB XD1.XDFFQ.MB XD3.XDFFQ.MB 1.21e-17
* device instance cc_XD1_XDFFQ_MB_XD3_XDFFQ_S r0 *1 0,0
Ccc_XD1_XDFFQ_MB_XD3_XDFFQ_S XD1.XDFFQ.MB XD3.XDFFQ.S 1.8151e-17
* device instance cc_XD1_XDFFQ_MB_XD3_XDFFQ_SB r0 *1 0,0
Ccc_XD1_XDFFQ_MB_XD3_XDFFQ_SB XD1.XDFFQ.MB XD3.XDFFQ.SB 1.8151e-17
* device instance cc_XD1_XDFFQ_MB_XD3_XN2_mid1 r0 *1 0,0
Ccc_XD1_XDFFQ_MB_XD3_XN2_mid1 XD1.XDFFQ.MB XD3.XN2.mid1 1.21e-17
* device instance cc_XD1_XDFFQ_MB_XD3_XN3_mid1 r0 *1 0,0
Ccc_XD1_XDFFQ_MB_XD3_XN3_mid1 XD1.XDFFQ.MB XD3.XN3.mid1 1.21e-17
* device instance cc_XD1_XDFFQ_MB_XD3_XN3_mid2 r0 *1 0,0
Ccc_XD1_XDFFQ_MB_XD3_XN3_mid2 XD1.XDFFQ.MB XD3.XN3.mid2 1.21e-17
* device instance cc_XD1_XDFFQ_MB_XD3_dmodout r0 *1 0,0
Ccc_XD1_XDFFQ_MB_XD3_dmodout XD1.XDFFQ.MB XD3.dmodout 1.21e-17
* device instance cc_XD1_XDFFQ_MB_XD3_dq r0 *1 0,0
Ccc_XD1_XDFFQ_MB_XD3_dq XD1.XDFFQ.MB XD3.dq 1.8151e-17
* device instance cc_XD1_XDFFQ_MB_XD3_nm r0 *1 0,0
Ccc_XD1_XDFFQ_MB_XD3_nm XD1.XDFFQ.MB XD3.nm 1.21e-17
* device instance cc_XD1_XDFFQ_MB_XD3_nt r0 *1 0,0
Ccc_XD1_XDFFQ_MB_XD3_nt XD1.XDFFQ.MB XD3.nt 1.21e-17
* device instance cc_XD1_XDFFQ_MB_XD3_t1 r0 *1 0,0
Ccc_XD1_XDFFQ_MB_XD3_t1 XD1.XDFFQ.MB XD3.t1 1.21e-17
* device instance cc_XD1_XDFFQ_MB_XD4_XDFFM_CLKB r0 *1 0,0
Ccc_XD1_XDFFQ_MB_XD4_XDFFM_CLKB XD1.XDFFQ.MB XD4.XDFFM.CLKB 1.8151e-17
* device instance cc_XD1_XDFFQ_MB_XD4_XDFFM_M r0 *1 0,0
Ccc_XD1_XDFFQ_MB_XD4_XDFFM_M XD1.XDFFQ.MB XD4.XDFFM.M 2.4201e-17
* device instance cc_XD1_XDFFQ_MB_XD4_XDFFM_MB r0 *1 0,0
Ccc_XD1_XDFFQ_MB_XD4_XDFFM_MB XD1.XDFFQ.MB XD4.XDFFM.MB 1.21e-17
* device instance cc_XD1_XDFFQ_MB_XD4_XDFFM_S r0 *1 0,0
Ccc_XD1_XDFFQ_MB_XD4_XDFFM_S XD1.XDFFQ.MB XD4.XDFFM.S 1.8151e-17
* device instance cc_XD1_XDFFQ_MB_XD4_XDFFM_SB r0 *1 0,0
Ccc_XD1_XDFFQ_MB_XD4_XDFFM_SB XD1.XDFFQ.MB XD4.XDFFM.SB 1.8151e-17
* device instance cc_XD1_XDFFQ_MB_XD4_XDFFQ_CLKB r0 *1 0,0
Ccc_XD1_XDFFQ_MB_XD4_XDFFQ_CLKB XD1.XDFFQ.MB XD4.XDFFQ.CLKB 1.8151e-17
* device instance cc_XD1_XDFFQ_MB_XD4_XDFFQ_M r0 *1 0,0
Ccc_XD1_XDFFQ_MB_XD4_XDFFQ_M XD1.XDFFQ.MB XD4.XDFFQ.M 2.4201e-17
* device instance cc_XD1_XDFFQ_MB_XD4_XDFFQ_MB r0 *1 0,0
Ccc_XD1_XDFFQ_MB_XD4_XDFFQ_MB XD1.XDFFQ.MB XD4.XDFFQ.MB 1.21e-17
* device instance cc_XD1_XDFFQ_MB_XD4_XDFFQ_S r0 *1 0,0
Ccc_XD1_XDFFQ_MB_XD4_XDFFQ_S XD1.XDFFQ.MB XD4.XDFFQ.S 1.8151e-17
* device instance cc_XD1_XDFFQ_MB_XD4_XDFFQ_SB r0 *1 0,0
Ccc_XD1_XDFFQ_MB_XD4_XDFFQ_SB XD1.XDFFQ.MB XD4.XDFFQ.SB 1.8151e-17
* device instance cc_XD1_XDFFQ_MB_XD4_XN2_mid1 r0 *1 0,0
Ccc_XD1_XDFFQ_MB_XD4_XN2_mid1 XD1.XDFFQ.MB XD4.XN2.mid1 1.21e-17
* device instance cc_XD1_XDFFQ_MB_XD4_XN3_mid1 r0 *1 0,0
Ccc_XD1_XDFFQ_MB_XD4_XN3_mid1 XD1.XDFFQ.MB XD4.XN3.mid1 1.21e-17
* device instance cc_XD1_XDFFQ_MB_XD4_XN3_mid2 r0 *1 0,0
Ccc_XD1_XDFFQ_MB_XD4_XN3_mid2 XD1.XDFFQ.MB XD4.XN3.mid2 1.21e-17
* device instance cc_XD1_XDFFQ_MB_XD4_dmodout r0 *1 0,0
Ccc_XD1_XDFFQ_MB_XD4_dmodout XD1.XDFFQ.MB XD4.dmodout 1.21e-17
* device instance cc_XD1_XDFFQ_MB_XD4_dq r0 *1 0,0
Ccc_XD1_XDFFQ_MB_XD4_dq XD1.XDFFQ.MB XD4.dq 1.8151e-17
* device instance cc_XD1_XDFFQ_MB_XD4_nm r0 *1 0,0
Ccc_XD1_XDFFQ_MB_XD4_nm XD1.XDFFQ.MB XD4.nm 1.21e-17
* device instance cc_XD1_XDFFQ_MB_XD4_nt r0 *1 0,0
Ccc_XD1_XDFFQ_MB_XD4_nt XD1.XDFFQ.MB XD4.nt 1.21e-17
* device instance cc_XD1_XDFFQ_MB_XD4_t1 r0 *1 0,0
Ccc_XD1_XDFFQ_MB_XD4_t1 XD1.XDFFQ.MB XD4.t1 1.21e-17
* device instance cc_XD1_XDFFQ_MB_XD5_XDFFM_CLKB r0 *1 0,0
Ccc_XD1_XDFFQ_MB_XD5_XDFFM_CLKB XD1.XDFFQ.MB XD5.XDFFM.CLKB 1.8151e-17
* device instance cc_XD1_XDFFQ_MB_XD5_XDFFM_M r0 *1 0,0
Ccc_XD1_XDFFQ_MB_XD5_XDFFM_M XD1.XDFFQ.MB XD5.XDFFM.M 2.4201e-17
* device instance cc_XD1_XDFFQ_MB_XD5_XDFFM_MB r0 *1 0,0
Ccc_XD1_XDFFQ_MB_XD5_XDFFM_MB XD1.XDFFQ.MB XD5.XDFFM.MB 1.21e-17
* device instance cc_XD1_XDFFQ_MB_XD5_XDFFM_S r0 *1 0,0
Ccc_XD1_XDFFQ_MB_XD5_XDFFM_S XD1.XDFFQ.MB XD5.XDFFM.S 1.8151e-17
* device instance cc_XD1_XDFFQ_MB_XD5_XDFFM_SB r0 *1 0,0
Ccc_XD1_XDFFQ_MB_XD5_XDFFM_SB XD1.XDFFQ.MB XD5.XDFFM.SB 1.8151e-17
* device instance cc_XD1_XDFFQ_MB_XD5_XDFFQ_CLKB r0 *1 0,0
Ccc_XD1_XDFFQ_MB_XD5_XDFFQ_CLKB XD1.XDFFQ.MB XD5.XDFFQ.CLKB 1.8151e-17
* device instance cc_XD1_XDFFQ_MB_XD5_XDFFQ_M r0 *1 0,0
Ccc_XD1_XDFFQ_MB_XD5_XDFFQ_M XD1.XDFFQ.MB XD5.XDFFQ.M 2.4201e-17
* device instance cc_XD1_XDFFQ_MB_XD5_XDFFQ_MB r0 *1 0,0
Ccc_XD1_XDFFQ_MB_XD5_XDFFQ_MB XD1.XDFFQ.MB XD5.XDFFQ.MB 1.21e-17
* device instance cc_XD1_XDFFQ_MB_XD5_XDFFQ_S r0 *1 0,0
Ccc_XD1_XDFFQ_MB_XD5_XDFFQ_S XD1.XDFFQ.MB XD5.XDFFQ.S 1.8151e-17
* device instance cc_XD1_XDFFQ_MB_XD5_XDFFQ_SB r0 *1 0,0
Ccc_XD1_XDFFQ_MB_XD5_XDFFQ_SB XD1.XDFFQ.MB XD5.XDFFQ.SB 1.8151e-17
* device instance cc_XD1_XDFFQ_MB_XD5_XN2_mid1 r0 *1 0,0
Ccc_XD1_XDFFQ_MB_XD5_XN2_mid1 XD1.XDFFQ.MB XD5.XN2.mid1 1.21e-17
* device instance cc_XD1_XDFFQ_MB_XD5_XN3_mid1 r0 *1 0,0
Ccc_XD1_XDFFQ_MB_XD5_XN3_mid1 XD1.XDFFQ.MB XD5.XN3.mid1 1.21e-17
* device instance cc_XD1_XDFFQ_MB_XD5_XN3_mid2 r0 *1 0,0
Ccc_XD1_XDFFQ_MB_XD5_XN3_mid2 XD1.XDFFQ.MB XD5.XN3.mid2 1.21e-17
* device instance cc_XD1_XDFFQ_MB_XD5_dmodout r0 *1 0,0
Ccc_XD1_XDFFQ_MB_XD5_dmodout XD1.XDFFQ.MB XD5.dmodout 1.21e-17
* device instance cc_XD1_XDFFQ_MB_XD5_dq r0 *1 0,0
Ccc_XD1_XDFFQ_MB_XD5_dq XD1.XDFFQ.MB XD5.dq 1.8151e-17
* device instance cc_XD1_XDFFQ_MB_XD5_nm r0 *1 0,0
Ccc_XD1_XDFFQ_MB_XD5_nm XD1.XDFFQ.MB XD5.nm 1.21e-17
* device instance cc_XD1_XDFFQ_MB_XD5_nt r0 *1 0,0
Ccc_XD1_XDFFQ_MB_XD5_nt XD1.XDFFQ.MB XD5.nt 1.21e-17
* device instance cc_XD1_XDFFQ_MB_XD5_t1 r0 *1 0,0
Ccc_XD1_XDFFQ_MB_XD5_t1 XD1.XDFFQ.MB XD5.t1 1.21e-17
* device instance cc_XD1_XDFFQ_MB_XFRT_CLKB r0 *1 0,0
Ccc_XD1_XDFFQ_MB_XFRT_CLKB XD1.XDFFQ.MB XFRT.CLKB 1.8151e-17
* device instance cc_XD1_XDFFQ_MB_XFRT_M r0 *1 0,0
Ccc_XD1_XDFFQ_MB_XFRT_M XD1.XDFFQ.MB XFRT.M 2.4201e-17
* device instance cc_XD1_XDFFQ_MB_XFRT_MB r0 *1 0,0
Ccc_XD1_XDFFQ_MB_XFRT_MB XD1.XDFFQ.MB XFRT.MB 1.21e-17
* device instance cc_XD1_XDFFQ_MB_XFRT_S r0 *1 0,0
Ccc_XD1_XDFFQ_MB_XFRT_S XD1.XDFFQ.MB XFRT.S 1.8151e-17
* device instance cc_XD1_XDFFQ_MB_XFRT_SB r0 *1 0,0
Ccc_XD1_XDFFQ_MB_XFRT_SB XD1.XDFFQ.MB XFRT.SB 1.8151e-17
* device instance cc_XD1_XDFFQ_MB_ck1 r0 *1 0,0
Ccc_XD1_XDFFQ_MB_ck1 XD1.XDFFQ.MB ck1 6.0502e-17
* device instance cc_XD1_XDFFQ_MB_ck2 r0 *1 0,0
Ccc_XD1_XDFFQ_MB_ck2 XD1.XDFFQ.MB ck2 5.4452e-17
* device instance cc_XD1_XDFFQ_MB_ck3 r0 *1 0,0
Ccc_XD1_XDFFQ_MB_ck3 XD1.XDFFQ.MB ck3 5.4452e-17
* device instance cc_XD1_XDFFQ_MB_ck4 r0 *1 0,0
Ccc_XD1_XDFFQ_MB_ck4 XD1.XDFFQ.MB ck4 5.4452e-17
* device instance cc_XD1_XDFFQ_MB_ck5 r0 *1 0,0
Ccc_XD1_XDFFQ_MB_ck5 XD1.XDFFQ.MB ck5 5.4452e-17
* device instance cc_XD1_XDFFQ_MB_mod0 r0 *1 0,0
Ccc_XD1_XDFFQ_MB_mod0 XD1.XDFFQ.MB mod0 2.4201e-17
* device instance cc_XD1_XDFFQ_MB_mod1 r0 *1 0,0
Ccc_XD1_XDFFQ_MB_mod1 XD1.XDFFQ.MB mod1 2.4201e-17
* device instance cc_XD1_XDFFQ_MB_mod2 r0 *1 0,0
Ccc_XD1_XDFFQ_MB_mod2 XD1.XDFFQ.MB mod2 2.4201e-17
* device instance cc_XD1_XDFFQ_MB_mod3 r0 *1 0,0
Ccc_XD1_XDFFQ_MB_mod3 XD1.XDFFQ.MB mod3 2.4201e-17
* device instance cc_XD1_XDFFQ_MB_mod4 r0 *1 0,0
Ccc_XD1_XDFFQ_MB_mod4 XD1.XDFFQ.MB mod4 2.4201e-17
* device instance cc_XD1_XDFFQ_MB_net1 r0 *1 0,0
Ccc_XD1_XDFFQ_MB_net1 XD1.XDFFQ.MB net1 1.21e-17
* device instance cc_XD1_XDFFQ_S_XD1_XDFFQ_SB r0 *1 0,0
Ccc_XD1_XDFFQ_S_XD1_XDFFQ_SB XD1.XDFFQ.S XD1.XDFFQ.SB 4.0738e-17
* device instance cc_XD1_XDFFQ_S_XD1_XN2_mid1 r0 *1 0,0
Ccc_XD1_XDFFQ_S_XD1_XN2_mid1 XD1.XDFFQ.S XD1.XN2.mid1 1.21e-17
* device instance cc_XD1_XDFFQ_S_XD1_XNOR_midp r0 *1 0,0
Ccc_XD1_XDFFQ_S_XD1_XNOR_midp XD1.XDFFQ.S XD1.XNOR.midp 1.21e-17
* device instance cc_XD1_XDFFQ_S_XD1_dmodout r0 *1 0,0
Ccc_XD1_XDFFQ_S_XD1_dmodout XD1.XDFFQ.S XD1.dmodout 1.21e-17
* device instance cc_XD1_XDFFQ_S_XD1_dq r0 *1 0,0
Ccc_XD1_XDFFQ_S_XD1_dq XD1.XDFFQ.S XD1.dq 1.21e-17
* device instance cc_XD1_XDFFQ_S_XD1_nm r0 *1 0,0
Ccc_XD1_XDFFQ_S_XD1_nm XD1.XDFFQ.S XD1.nm 1.21e-17
* device instance cc_XD1_XDFFQ_S_XD1_nt r0 *1 0,0
Ccc_XD1_XDFFQ_S_XD1_nt XD1.XDFFQ.S XD1.nt 2.4201e-17
* device instance cc_XD1_XDFFQ_S_XD1_t1 r0 *1 0,0
Ccc_XD1_XDFFQ_S_XD1_t1 XD1.XDFFQ.S XD1.t1 1.21e-17
* device instance cc_XD1_XDFFQ_S_XD2_XDFFM_CLKB r0 *1 0,0
Ccc_XD1_XDFFQ_S_XD2_XDFFM_CLKB XD1.XDFFQ.S XD2.XDFFM.CLKB 1.8151e-17
* device instance cc_XD1_XDFFQ_S_XD2_XDFFM_M r0 *1 0,0
Ccc_XD1_XDFFQ_S_XD2_XDFFM_M XD1.XDFFQ.S XD2.XDFFM.M 2.4201e-17
* device instance cc_XD1_XDFFQ_S_XD2_XDFFM_MB r0 *1 0,0
Ccc_XD1_XDFFQ_S_XD2_XDFFM_MB XD1.XDFFQ.S XD2.XDFFM.MB 1.21e-17
* device instance cc_XD1_XDFFQ_S_XD2_XDFFM_S r0 *1 0,0
Ccc_XD1_XDFFQ_S_XD2_XDFFM_S XD1.XDFFQ.S XD2.XDFFM.S 1.8151e-17
* device instance cc_XD1_XDFFQ_S_XD2_XDFFM_SB r0 *1 0,0
Ccc_XD1_XDFFQ_S_XD2_XDFFM_SB XD1.XDFFQ.S XD2.XDFFM.SB 1.8151e-17
* device instance cc_XD1_XDFFQ_S_XD2_XDFFQ_CLKB r0 *1 0,0
Ccc_XD1_XDFFQ_S_XD2_XDFFQ_CLKB XD1.XDFFQ.S XD2.XDFFQ.CLKB 1.8151e-17
* device instance cc_XD1_XDFFQ_S_XD2_XDFFQ_M r0 *1 0,0
Ccc_XD1_XDFFQ_S_XD2_XDFFQ_M XD1.XDFFQ.S XD2.XDFFQ.M 2.4201e-17
* device instance cc_XD1_XDFFQ_S_XD2_XDFFQ_MB r0 *1 0,0
Ccc_XD1_XDFFQ_S_XD2_XDFFQ_MB XD1.XDFFQ.S XD2.XDFFQ.MB 1.21e-17
* device instance cc_XD1_XDFFQ_S_XD2_XDFFQ_S r0 *1 0,0
Ccc_XD1_XDFFQ_S_XD2_XDFFQ_S XD1.XDFFQ.S XD2.XDFFQ.S 1.8151e-17
* device instance cc_XD1_XDFFQ_S_XD2_XDFFQ_SB r0 *1 0,0
Ccc_XD1_XDFFQ_S_XD2_XDFFQ_SB XD1.XDFFQ.S XD2.XDFFQ.SB 1.8151e-17
* device instance cc_XD1_XDFFQ_S_XD2_XN2_mid1 r0 *1 0,0
Ccc_XD1_XDFFQ_S_XD2_XN2_mid1 XD1.XDFFQ.S XD2.XN2.mid1 1.21e-17
* device instance cc_XD1_XDFFQ_S_XD2_XN3_mid1 r0 *1 0,0
Ccc_XD1_XDFFQ_S_XD2_XN3_mid1 XD1.XDFFQ.S XD2.XN3.mid1 1.21e-17
* device instance cc_XD1_XDFFQ_S_XD2_XN3_mid2 r0 *1 0,0
Ccc_XD1_XDFFQ_S_XD2_XN3_mid2 XD1.XDFFQ.S XD2.XN3.mid2 1.21e-17
* device instance cc_XD1_XDFFQ_S_XD2_dmodout r0 *1 0,0
Ccc_XD1_XDFFQ_S_XD2_dmodout XD1.XDFFQ.S XD2.dmodout 1.21e-17
* device instance cc_XD1_XDFFQ_S_XD2_dq r0 *1 0,0
Ccc_XD1_XDFFQ_S_XD2_dq XD1.XDFFQ.S XD2.dq 1.8151e-17
* device instance cc_XD1_XDFFQ_S_XD2_nm r0 *1 0,0
Ccc_XD1_XDFFQ_S_XD2_nm XD1.XDFFQ.S XD2.nm 1.21e-17
* device instance cc_XD1_XDFFQ_S_XD2_nt r0 *1 0,0
Ccc_XD1_XDFFQ_S_XD2_nt XD1.XDFFQ.S XD2.nt 1.21e-17
* device instance cc_XD1_XDFFQ_S_XD2_t1 r0 *1 0,0
Ccc_XD1_XDFFQ_S_XD2_t1 XD1.XDFFQ.S XD2.t1 1.21e-17
* device instance cc_XD1_XDFFQ_S_XD3_XDFFM_CLKB r0 *1 0,0
Ccc_XD1_XDFFQ_S_XD3_XDFFM_CLKB XD1.XDFFQ.S XD3.XDFFM.CLKB 1.8151e-17
* device instance cc_XD1_XDFFQ_S_XD3_XDFFM_M r0 *1 0,0
Ccc_XD1_XDFFQ_S_XD3_XDFFM_M XD1.XDFFQ.S XD3.XDFFM.M 2.4201e-17
* device instance cc_XD1_XDFFQ_S_XD3_XDFFM_MB r0 *1 0,0
Ccc_XD1_XDFFQ_S_XD3_XDFFM_MB XD1.XDFFQ.S XD3.XDFFM.MB 1.21e-17
* device instance cc_XD1_XDFFQ_S_XD3_XDFFM_S r0 *1 0,0
Ccc_XD1_XDFFQ_S_XD3_XDFFM_S XD1.XDFFQ.S XD3.XDFFM.S 1.8151e-17
* device instance cc_XD1_XDFFQ_S_XD3_XDFFM_SB r0 *1 0,0
Ccc_XD1_XDFFQ_S_XD3_XDFFM_SB XD1.XDFFQ.S XD3.XDFFM.SB 1.8151e-17
* device instance cc_XD1_XDFFQ_S_XD3_XDFFQ_CLKB r0 *1 0,0
Ccc_XD1_XDFFQ_S_XD3_XDFFQ_CLKB XD1.XDFFQ.S XD3.XDFFQ.CLKB 1.8151e-17
* device instance cc_XD1_XDFFQ_S_XD3_XDFFQ_M r0 *1 0,0
Ccc_XD1_XDFFQ_S_XD3_XDFFQ_M XD1.XDFFQ.S XD3.XDFFQ.M 2.4201e-17
* device instance cc_XD1_XDFFQ_S_XD3_XDFFQ_MB r0 *1 0,0
Ccc_XD1_XDFFQ_S_XD3_XDFFQ_MB XD1.XDFFQ.S XD3.XDFFQ.MB 1.21e-17
* device instance cc_XD1_XDFFQ_S_XD3_XDFFQ_S r0 *1 0,0
Ccc_XD1_XDFFQ_S_XD3_XDFFQ_S XD1.XDFFQ.S XD3.XDFFQ.S 1.8151e-17
* device instance cc_XD1_XDFFQ_S_XD3_XDFFQ_SB r0 *1 0,0
Ccc_XD1_XDFFQ_S_XD3_XDFFQ_SB XD1.XDFFQ.S XD3.XDFFQ.SB 1.8151e-17
* device instance cc_XD1_XDFFQ_S_XD3_XN2_mid1 r0 *1 0,0
Ccc_XD1_XDFFQ_S_XD3_XN2_mid1 XD1.XDFFQ.S XD3.XN2.mid1 1.21e-17
* device instance cc_XD1_XDFFQ_S_XD3_XN3_mid1 r0 *1 0,0
Ccc_XD1_XDFFQ_S_XD3_XN3_mid1 XD1.XDFFQ.S XD3.XN3.mid1 1.21e-17
* device instance cc_XD1_XDFFQ_S_XD3_XN3_mid2 r0 *1 0,0
Ccc_XD1_XDFFQ_S_XD3_XN3_mid2 XD1.XDFFQ.S XD3.XN3.mid2 1.21e-17
* device instance cc_XD1_XDFFQ_S_XD3_dmodout r0 *1 0,0
Ccc_XD1_XDFFQ_S_XD3_dmodout XD1.XDFFQ.S XD3.dmodout 1.21e-17
* device instance cc_XD1_XDFFQ_S_XD3_dq r0 *1 0,0
Ccc_XD1_XDFFQ_S_XD3_dq XD1.XDFFQ.S XD3.dq 1.8151e-17
* device instance cc_XD1_XDFFQ_S_XD3_nm r0 *1 0,0
Ccc_XD1_XDFFQ_S_XD3_nm XD1.XDFFQ.S XD3.nm 1.21e-17
* device instance cc_XD1_XDFFQ_S_XD3_nt r0 *1 0,0
Ccc_XD1_XDFFQ_S_XD3_nt XD1.XDFFQ.S XD3.nt 1.21e-17
* device instance cc_XD1_XDFFQ_S_XD3_t1 r0 *1 0,0
Ccc_XD1_XDFFQ_S_XD3_t1 XD1.XDFFQ.S XD3.t1 1.21e-17
* device instance cc_XD1_XDFFQ_S_XD4_XDFFM_CLKB r0 *1 0,0
Ccc_XD1_XDFFQ_S_XD4_XDFFM_CLKB XD1.XDFFQ.S XD4.XDFFM.CLKB 1.8151e-17
* device instance cc_XD1_XDFFQ_S_XD4_XDFFM_M r0 *1 0,0
Ccc_XD1_XDFFQ_S_XD4_XDFFM_M XD1.XDFFQ.S XD4.XDFFM.M 2.4201e-17
* device instance cc_XD1_XDFFQ_S_XD4_XDFFM_MB r0 *1 0,0
Ccc_XD1_XDFFQ_S_XD4_XDFFM_MB XD1.XDFFQ.S XD4.XDFFM.MB 1.21e-17
* device instance cc_XD1_XDFFQ_S_XD4_XDFFM_S r0 *1 0,0
Ccc_XD1_XDFFQ_S_XD4_XDFFM_S XD1.XDFFQ.S XD4.XDFFM.S 1.8151e-17
* device instance cc_XD1_XDFFQ_S_XD4_XDFFM_SB r0 *1 0,0
Ccc_XD1_XDFFQ_S_XD4_XDFFM_SB XD1.XDFFQ.S XD4.XDFFM.SB 1.8151e-17
* device instance cc_XD1_XDFFQ_S_XD4_XDFFQ_CLKB r0 *1 0,0
Ccc_XD1_XDFFQ_S_XD4_XDFFQ_CLKB XD1.XDFFQ.S XD4.XDFFQ.CLKB 1.8151e-17
* device instance cc_XD1_XDFFQ_S_XD4_XDFFQ_M r0 *1 0,0
Ccc_XD1_XDFFQ_S_XD4_XDFFQ_M XD1.XDFFQ.S XD4.XDFFQ.M 2.4201e-17
* device instance cc_XD1_XDFFQ_S_XD4_XDFFQ_MB r0 *1 0,0
Ccc_XD1_XDFFQ_S_XD4_XDFFQ_MB XD1.XDFFQ.S XD4.XDFFQ.MB 1.21e-17
* device instance cc_XD1_XDFFQ_S_XD4_XDFFQ_S r0 *1 0,0
Ccc_XD1_XDFFQ_S_XD4_XDFFQ_S XD1.XDFFQ.S XD4.XDFFQ.S 1.8151e-17
* device instance cc_XD1_XDFFQ_S_XD4_XDFFQ_SB r0 *1 0,0
Ccc_XD1_XDFFQ_S_XD4_XDFFQ_SB XD1.XDFFQ.S XD4.XDFFQ.SB 1.8151e-17
* device instance cc_XD1_XDFFQ_S_XD4_XN2_mid1 r0 *1 0,0
Ccc_XD1_XDFFQ_S_XD4_XN2_mid1 XD1.XDFFQ.S XD4.XN2.mid1 1.21e-17
* device instance cc_XD1_XDFFQ_S_XD4_XN3_mid1 r0 *1 0,0
Ccc_XD1_XDFFQ_S_XD4_XN3_mid1 XD1.XDFFQ.S XD4.XN3.mid1 1.21e-17
* device instance cc_XD1_XDFFQ_S_XD4_XN3_mid2 r0 *1 0,0
Ccc_XD1_XDFFQ_S_XD4_XN3_mid2 XD1.XDFFQ.S XD4.XN3.mid2 1.21e-17
* device instance cc_XD1_XDFFQ_S_XD4_dmodout r0 *1 0,0
Ccc_XD1_XDFFQ_S_XD4_dmodout XD1.XDFFQ.S XD4.dmodout 1.21e-17
* device instance cc_XD1_XDFFQ_S_XD4_dq r0 *1 0,0
Ccc_XD1_XDFFQ_S_XD4_dq XD1.XDFFQ.S XD4.dq 1.8151e-17
* device instance cc_XD1_XDFFQ_S_XD4_nm r0 *1 0,0
Ccc_XD1_XDFFQ_S_XD4_nm XD1.XDFFQ.S XD4.nm 1.21e-17
* device instance cc_XD1_XDFFQ_S_XD4_nt r0 *1 0,0
Ccc_XD1_XDFFQ_S_XD4_nt XD1.XDFFQ.S XD4.nt 1.21e-17
* device instance cc_XD1_XDFFQ_S_XD4_t1 r0 *1 0,0
Ccc_XD1_XDFFQ_S_XD4_t1 XD1.XDFFQ.S XD4.t1 1.21e-17
* device instance cc_XD1_XDFFQ_S_XD5_XDFFM_CLKB r0 *1 0,0
Ccc_XD1_XDFFQ_S_XD5_XDFFM_CLKB XD1.XDFFQ.S XD5.XDFFM.CLKB 1.8151e-17
* device instance cc_XD1_XDFFQ_S_XD5_XDFFM_M r0 *1 0,0
Ccc_XD1_XDFFQ_S_XD5_XDFFM_M XD1.XDFFQ.S XD5.XDFFM.M 2.4201e-17
* device instance cc_XD1_XDFFQ_S_XD5_XDFFM_MB r0 *1 0,0
Ccc_XD1_XDFFQ_S_XD5_XDFFM_MB XD1.XDFFQ.S XD5.XDFFM.MB 1.21e-17
* device instance cc_XD1_XDFFQ_S_XD5_XDFFM_S r0 *1 0,0
Ccc_XD1_XDFFQ_S_XD5_XDFFM_S XD1.XDFFQ.S XD5.XDFFM.S 1.8151e-17
* device instance cc_XD1_XDFFQ_S_XD5_XDFFM_SB r0 *1 0,0
Ccc_XD1_XDFFQ_S_XD5_XDFFM_SB XD1.XDFFQ.S XD5.XDFFM.SB 1.8151e-17
* device instance cc_XD1_XDFFQ_S_XD5_XDFFQ_CLKB r0 *1 0,0
Ccc_XD1_XDFFQ_S_XD5_XDFFQ_CLKB XD1.XDFFQ.S XD5.XDFFQ.CLKB 1.8151e-17
* device instance cc_XD1_XDFFQ_S_XD5_XDFFQ_M r0 *1 0,0
Ccc_XD1_XDFFQ_S_XD5_XDFFQ_M XD1.XDFFQ.S XD5.XDFFQ.M 2.4201e-17
* device instance cc_XD1_XDFFQ_S_XD5_XDFFQ_MB r0 *1 0,0
Ccc_XD1_XDFFQ_S_XD5_XDFFQ_MB XD1.XDFFQ.S XD5.XDFFQ.MB 1.21e-17
* device instance cc_XD1_XDFFQ_S_XD5_XDFFQ_S r0 *1 0,0
Ccc_XD1_XDFFQ_S_XD5_XDFFQ_S XD1.XDFFQ.S XD5.XDFFQ.S 1.8151e-17
* device instance cc_XD1_XDFFQ_S_XD5_XDFFQ_SB r0 *1 0,0
Ccc_XD1_XDFFQ_S_XD5_XDFFQ_SB XD1.XDFFQ.S XD5.XDFFQ.SB 1.8151e-17
* device instance cc_XD1_XDFFQ_S_XD5_XN2_mid1 r0 *1 0,0
Ccc_XD1_XDFFQ_S_XD5_XN2_mid1 XD1.XDFFQ.S XD5.XN2.mid1 1.21e-17
* device instance cc_XD1_XDFFQ_S_XD5_XN3_mid1 r0 *1 0,0
Ccc_XD1_XDFFQ_S_XD5_XN3_mid1 XD1.XDFFQ.S XD5.XN3.mid1 1.21e-17
* device instance cc_XD1_XDFFQ_S_XD5_XN3_mid2 r0 *1 0,0
Ccc_XD1_XDFFQ_S_XD5_XN3_mid2 XD1.XDFFQ.S XD5.XN3.mid2 1.21e-17
* device instance cc_XD1_XDFFQ_S_XD5_dmodout r0 *1 0,0
Ccc_XD1_XDFFQ_S_XD5_dmodout XD1.XDFFQ.S XD5.dmodout 1.21e-17
* device instance cc_XD1_XDFFQ_S_XD5_dq r0 *1 0,0
Ccc_XD1_XDFFQ_S_XD5_dq XD1.XDFFQ.S XD5.dq 1.8151e-17
* device instance cc_XD1_XDFFQ_S_XD5_nm r0 *1 0,0
Ccc_XD1_XDFFQ_S_XD5_nm XD1.XDFFQ.S XD5.nm 1.21e-17
* device instance cc_XD1_XDFFQ_S_XD5_nt r0 *1 0,0
Ccc_XD1_XDFFQ_S_XD5_nt XD1.XDFFQ.S XD5.nt 1.21e-17
* device instance cc_XD1_XDFFQ_S_XD5_t1 r0 *1 0,0
Ccc_XD1_XDFFQ_S_XD5_t1 XD1.XDFFQ.S XD5.t1 1.21e-17
* device instance cc_XD1_XDFFQ_S_XFRT_CLKB r0 *1 0,0
Ccc_XD1_XDFFQ_S_XFRT_CLKB XD1.XDFFQ.S XFRT.CLKB 1.8151e-17
* device instance cc_XD1_XDFFQ_S_XFRT_M r0 *1 0,0
Ccc_XD1_XDFFQ_S_XFRT_M XD1.XDFFQ.S XFRT.M 2.4201e-17
* device instance cc_XD1_XDFFQ_S_XFRT_MB r0 *1 0,0
Ccc_XD1_XDFFQ_S_XFRT_MB XD1.XDFFQ.S XFRT.MB 1.21e-17
* device instance cc_XD1_XDFFQ_S_XFRT_S r0 *1 0,0
Ccc_XD1_XDFFQ_S_XFRT_S XD1.XDFFQ.S XFRT.S 1.8151e-17
* device instance cc_XD1_XDFFQ_S_XFRT_SB r0 *1 0,0
Ccc_XD1_XDFFQ_S_XFRT_SB XD1.XDFFQ.S XFRT.SB 1.8151e-17
* device instance cc_XD1_XDFFQ_S_ck1 r0 *1 0,0
Ccc_XD1_XDFFQ_S_ck1 XD1.XDFFQ.S ck1 5.4452e-17
* device instance cc_XD1_XDFFQ_S_ck2 r0 *1 0,0
Ccc_XD1_XDFFQ_S_ck2 XD1.XDFFQ.S ck2 5.4452e-17
* device instance cc_XD1_XDFFQ_S_ck3 r0 *1 0,0
Ccc_XD1_XDFFQ_S_ck3 XD1.XDFFQ.S ck3 5.4452e-17
* device instance cc_XD1_XDFFQ_S_ck4 r0 *1 0,0
Ccc_XD1_XDFFQ_S_ck4 XD1.XDFFQ.S ck4 5.4452e-17
* device instance cc_XD1_XDFFQ_S_ck5 r0 *1 0,0
Ccc_XD1_XDFFQ_S_ck5 XD1.XDFFQ.S ck5 5.4452e-17
* device instance cc_XD1_XDFFQ_S_mod0 r0 *1 0,0
Ccc_XD1_XDFFQ_S_mod0 XD1.XDFFQ.S mod0 2.4201e-17
* device instance cc_XD1_XDFFQ_S_mod1 r0 *1 0,0
Ccc_XD1_XDFFQ_S_mod1 XD1.XDFFQ.S mod1 2.4201e-17
* device instance cc_XD1_XDFFQ_S_mod2 r0 *1 0,0
Ccc_XD1_XDFFQ_S_mod2 XD1.XDFFQ.S mod2 2.4201e-17
* device instance cc_XD1_XDFFQ_S_mod3 r0 *1 0,0
Ccc_XD1_XDFFQ_S_mod3 XD1.XDFFQ.S mod3 2.4201e-17
* device instance cc_XD1_XDFFQ_S_mod4 r0 *1 0,0
Ccc_XD1_XDFFQ_S_mod4 XD1.XDFFQ.S mod4 2.4201e-17
* device instance cc_XD1_XDFFQ_S_net1 r0 *1 0,0
Ccc_XD1_XDFFQ_S_net1 XD1.XDFFQ.S net1 1.21e-17
* device instance cc_XD1_XDFFQ_SB_XD1_XN2_mid1 r0 *1 0,0
Ccc_XD1_XDFFQ_SB_XD1_XN2_mid1 XD1.XDFFQ.SB XD1.XN2.mid1 1.21e-17
* device instance cc_XD1_XDFFQ_SB_XD1_XNOR_midp r0 *1 0,0
Ccc_XD1_XDFFQ_SB_XD1_XNOR_midp XD1.XDFFQ.SB XD1.XNOR.midp 1.21e-17
* device instance cc_XD1_XDFFQ_SB_XD1_dmodout r0 *1 0,0
Ccc_XD1_XDFFQ_SB_XD1_dmodout XD1.XDFFQ.SB XD1.dmodout 1.21e-17
* device instance cc_XD1_XDFFQ_SB_XD1_dq r0 *1 0,0
Ccc_XD1_XDFFQ_SB_XD1_dq XD1.XDFFQ.SB XD1.dq 1.21e-17
* device instance cc_XD1_XDFFQ_SB_XD1_nm r0 *1 0,0
Ccc_XD1_XDFFQ_SB_XD1_nm XD1.XDFFQ.SB XD1.nm 1.21e-17
* device instance cc_XD1_XDFFQ_SB_XD1_nt r0 *1 0,0
Ccc_XD1_XDFFQ_SB_XD1_nt XD1.XDFFQ.SB XD1.nt 2.4201e-17
* device instance cc_XD1_XDFFQ_SB_XD1_t1 r0 *1 0,0
Ccc_XD1_XDFFQ_SB_XD1_t1 XD1.XDFFQ.SB XD1.t1 1.21e-17
* device instance cc_XD1_XDFFQ_SB_XD2_XDFFM_CLKB r0 *1 0,0
Ccc_XD1_XDFFQ_SB_XD2_XDFFM_CLKB XD1.XDFFQ.SB XD2.XDFFM.CLKB 1.8151e-17
* device instance cc_XD1_XDFFQ_SB_XD2_XDFFM_M r0 *1 0,0
Ccc_XD1_XDFFQ_SB_XD2_XDFFM_M XD1.XDFFQ.SB XD2.XDFFM.M 2.4201e-17
* device instance cc_XD1_XDFFQ_SB_XD2_XDFFM_MB r0 *1 0,0
Ccc_XD1_XDFFQ_SB_XD2_XDFFM_MB XD1.XDFFQ.SB XD2.XDFFM.MB 1.21e-17
* device instance cc_XD1_XDFFQ_SB_XD2_XDFFM_S r0 *1 0,0
Ccc_XD1_XDFFQ_SB_XD2_XDFFM_S XD1.XDFFQ.SB XD2.XDFFM.S 1.8151e-17
* device instance cc_XD1_XDFFQ_SB_XD2_XDFFM_SB r0 *1 0,0
Ccc_XD1_XDFFQ_SB_XD2_XDFFM_SB XD1.XDFFQ.SB XD2.XDFFM.SB 1.8151e-17
* device instance cc_XD1_XDFFQ_SB_XD2_XDFFQ_CLKB r0 *1 0,0
Ccc_XD1_XDFFQ_SB_XD2_XDFFQ_CLKB XD1.XDFFQ.SB XD2.XDFFQ.CLKB 1.8151e-17
* device instance cc_XD1_XDFFQ_SB_XD2_XDFFQ_M r0 *1 0,0
Ccc_XD1_XDFFQ_SB_XD2_XDFFQ_M XD1.XDFFQ.SB XD2.XDFFQ.M 2.4201e-17
* device instance cc_XD1_XDFFQ_SB_XD2_XDFFQ_MB r0 *1 0,0
Ccc_XD1_XDFFQ_SB_XD2_XDFFQ_MB XD1.XDFFQ.SB XD2.XDFFQ.MB 1.21e-17
* device instance cc_XD1_XDFFQ_SB_XD2_XDFFQ_S r0 *1 0,0
Ccc_XD1_XDFFQ_SB_XD2_XDFFQ_S XD1.XDFFQ.SB XD2.XDFFQ.S 1.8151e-17
* device instance cc_XD1_XDFFQ_SB_XD2_XDFFQ_SB r0 *1 0,0
Ccc_XD1_XDFFQ_SB_XD2_XDFFQ_SB XD1.XDFFQ.SB XD2.XDFFQ.SB 1.8151e-17
* device instance cc_XD1_XDFFQ_SB_XD2_XN2_mid1 r0 *1 0,0
Ccc_XD1_XDFFQ_SB_XD2_XN2_mid1 XD1.XDFFQ.SB XD2.XN2.mid1 1.21e-17
* device instance cc_XD1_XDFFQ_SB_XD2_XN3_mid1 r0 *1 0,0
Ccc_XD1_XDFFQ_SB_XD2_XN3_mid1 XD1.XDFFQ.SB XD2.XN3.mid1 1.21e-17
* device instance cc_XD1_XDFFQ_SB_XD2_XN3_mid2 r0 *1 0,0
Ccc_XD1_XDFFQ_SB_XD2_XN3_mid2 XD1.XDFFQ.SB XD2.XN3.mid2 1.21e-17
* device instance cc_XD1_XDFFQ_SB_XD2_dmodout r0 *1 0,0
Ccc_XD1_XDFFQ_SB_XD2_dmodout XD1.XDFFQ.SB XD2.dmodout 1.21e-17
* device instance cc_XD1_XDFFQ_SB_XD2_dq r0 *1 0,0
Ccc_XD1_XDFFQ_SB_XD2_dq XD1.XDFFQ.SB XD2.dq 1.8151e-17
* device instance cc_XD1_XDFFQ_SB_XD2_nm r0 *1 0,0
Ccc_XD1_XDFFQ_SB_XD2_nm XD1.XDFFQ.SB XD2.nm 1.21e-17
* device instance cc_XD1_XDFFQ_SB_XD2_nt r0 *1 0,0
Ccc_XD1_XDFFQ_SB_XD2_nt XD1.XDFFQ.SB XD2.nt 1.21e-17
* device instance cc_XD1_XDFFQ_SB_XD2_t1 r0 *1 0,0
Ccc_XD1_XDFFQ_SB_XD2_t1 XD1.XDFFQ.SB XD2.t1 1.21e-17
* device instance cc_XD1_XDFFQ_SB_XD3_XDFFM_CLKB r0 *1 0,0
Ccc_XD1_XDFFQ_SB_XD3_XDFFM_CLKB XD1.XDFFQ.SB XD3.XDFFM.CLKB 1.8151e-17
* device instance cc_XD1_XDFFQ_SB_XD3_XDFFM_M r0 *1 0,0
Ccc_XD1_XDFFQ_SB_XD3_XDFFM_M XD1.XDFFQ.SB XD3.XDFFM.M 2.4201e-17
* device instance cc_XD1_XDFFQ_SB_XD3_XDFFM_MB r0 *1 0,0
Ccc_XD1_XDFFQ_SB_XD3_XDFFM_MB XD1.XDFFQ.SB XD3.XDFFM.MB 1.21e-17
* device instance cc_XD1_XDFFQ_SB_XD3_XDFFM_S r0 *1 0,0
Ccc_XD1_XDFFQ_SB_XD3_XDFFM_S XD1.XDFFQ.SB XD3.XDFFM.S 1.8151e-17
* device instance cc_XD1_XDFFQ_SB_XD3_XDFFM_SB r0 *1 0,0
Ccc_XD1_XDFFQ_SB_XD3_XDFFM_SB XD1.XDFFQ.SB XD3.XDFFM.SB 1.8151e-17
* device instance cc_XD1_XDFFQ_SB_XD3_XDFFQ_CLKB r0 *1 0,0
Ccc_XD1_XDFFQ_SB_XD3_XDFFQ_CLKB XD1.XDFFQ.SB XD3.XDFFQ.CLKB 1.8151e-17
* device instance cc_XD1_XDFFQ_SB_XD3_XDFFQ_M r0 *1 0,0
Ccc_XD1_XDFFQ_SB_XD3_XDFFQ_M XD1.XDFFQ.SB XD3.XDFFQ.M 2.4201e-17
* device instance cc_XD1_XDFFQ_SB_XD3_XDFFQ_MB r0 *1 0,0
Ccc_XD1_XDFFQ_SB_XD3_XDFFQ_MB XD1.XDFFQ.SB XD3.XDFFQ.MB 1.21e-17
* device instance cc_XD1_XDFFQ_SB_XD3_XDFFQ_S r0 *1 0,0
Ccc_XD1_XDFFQ_SB_XD3_XDFFQ_S XD1.XDFFQ.SB XD3.XDFFQ.S 1.8151e-17
* device instance cc_XD1_XDFFQ_SB_XD3_XDFFQ_SB r0 *1 0,0
Ccc_XD1_XDFFQ_SB_XD3_XDFFQ_SB XD1.XDFFQ.SB XD3.XDFFQ.SB 1.8151e-17
* device instance cc_XD1_XDFFQ_SB_XD3_XN2_mid1 r0 *1 0,0
Ccc_XD1_XDFFQ_SB_XD3_XN2_mid1 XD1.XDFFQ.SB XD3.XN2.mid1 1.21e-17
* device instance cc_XD1_XDFFQ_SB_XD3_XN3_mid1 r0 *1 0,0
Ccc_XD1_XDFFQ_SB_XD3_XN3_mid1 XD1.XDFFQ.SB XD3.XN3.mid1 1.21e-17
* device instance cc_XD1_XDFFQ_SB_XD3_XN3_mid2 r0 *1 0,0
Ccc_XD1_XDFFQ_SB_XD3_XN3_mid2 XD1.XDFFQ.SB XD3.XN3.mid2 1.21e-17
* device instance cc_XD1_XDFFQ_SB_XD3_dmodout r0 *1 0,0
Ccc_XD1_XDFFQ_SB_XD3_dmodout XD1.XDFFQ.SB XD3.dmodout 1.21e-17
* device instance cc_XD1_XDFFQ_SB_XD3_dq r0 *1 0,0
Ccc_XD1_XDFFQ_SB_XD3_dq XD1.XDFFQ.SB XD3.dq 1.8151e-17
* device instance cc_XD1_XDFFQ_SB_XD3_nm r0 *1 0,0
Ccc_XD1_XDFFQ_SB_XD3_nm XD1.XDFFQ.SB XD3.nm 1.21e-17
* device instance cc_XD1_XDFFQ_SB_XD3_nt r0 *1 0,0
Ccc_XD1_XDFFQ_SB_XD3_nt XD1.XDFFQ.SB XD3.nt 1.21e-17
* device instance cc_XD1_XDFFQ_SB_XD3_t1 r0 *1 0,0
Ccc_XD1_XDFFQ_SB_XD3_t1 XD1.XDFFQ.SB XD3.t1 1.21e-17
* device instance cc_XD1_XDFFQ_SB_XD4_XDFFM_CLKB r0 *1 0,0
Ccc_XD1_XDFFQ_SB_XD4_XDFFM_CLKB XD1.XDFFQ.SB XD4.XDFFM.CLKB 1.8151e-17
* device instance cc_XD1_XDFFQ_SB_XD4_XDFFM_M r0 *1 0,0
Ccc_XD1_XDFFQ_SB_XD4_XDFFM_M XD1.XDFFQ.SB XD4.XDFFM.M 2.4201e-17
* device instance cc_XD1_XDFFQ_SB_XD4_XDFFM_MB r0 *1 0,0
Ccc_XD1_XDFFQ_SB_XD4_XDFFM_MB XD1.XDFFQ.SB XD4.XDFFM.MB 1.21e-17
* device instance cc_XD1_XDFFQ_SB_XD4_XDFFM_S r0 *1 0,0
Ccc_XD1_XDFFQ_SB_XD4_XDFFM_S XD1.XDFFQ.SB XD4.XDFFM.S 1.8151e-17
* device instance cc_XD1_XDFFQ_SB_XD4_XDFFM_SB r0 *1 0,0
Ccc_XD1_XDFFQ_SB_XD4_XDFFM_SB XD1.XDFFQ.SB XD4.XDFFM.SB 1.8151e-17
* device instance cc_XD1_XDFFQ_SB_XD4_XDFFQ_CLKB r0 *1 0,0
Ccc_XD1_XDFFQ_SB_XD4_XDFFQ_CLKB XD1.XDFFQ.SB XD4.XDFFQ.CLKB 1.8151e-17
* device instance cc_XD1_XDFFQ_SB_XD4_XDFFQ_M r0 *1 0,0
Ccc_XD1_XDFFQ_SB_XD4_XDFFQ_M XD1.XDFFQ.SB XD4.XDFFQ.M 2.4201e-17
* device instance cc_XD1_XDFFQ_SB_XD4_XDFFQ_MB r0 *1 0,0
Ccc_XD1_XDFFQ_SB_XD4_XDFFQ_MB XD1.XDFFQ.SB XD4.XDFFQ.MB 1.21e-17
* device instance cc_XD1_XDFFQ_SB_XD4_XDFFQ_S r0 *1 0,0
Ccc_XD1_XDFFQ_SB_XD4_XDFFQ_S XD1.XDFFQ.SB XD4.XDFFQ.S 1.8151e-17
* device instance cc_XD1_XDFFQ_SB_XD4_XDFFQ_SB r0 *1 0,0
Ccc_XD1_XDFFQ_SB_XD4_XDFFQ_SB XD1.XDFFQ.SB XD4.XDFFQ.SB 1.8151e-17
* device instance cc_XD1_XDFFQ_SB_XD4_XN2_mid1 r0 *1 0,0
Ccc_XD1_XDFFQ_SB_XD4_XN2_mid1 XD1.XDFFQ.SB XD4.XN2.mid1 1.21e-17
* device instance cc_XD1_XDFFQ_SB_XD4_XN3_mid1 r0 *1 0,0
Ccc_XD1_XDFFQ_SB_XD4_XN3_mid1 XD1.XDFFQ.SB XD4.XN3.mid1 1.21e-17
* device instance cc_XD1_XDFFQ_SB_XD4_XN3_mid2 r0 *1 0,0
Ccc_XD1_XDFFQ_SB_XD4_XN3_mid2 XD1.XDFFQ.SB XD4.XN3.mid2 1.21e-17
* device instance cc_XD1_XDFFQ_SB_XD4_dmodout r0 *1 0,0
Ccc_XD1_XDFFQ_SB_XD4_dmodout XD1.XDFFQ.SB XD4.dmodout 1.21e-17
* device instance cc_XD1_XDFFQ_SB_XD4_dq r0 *1 0,0
Ccc_XD1_XDFFQ_SB_XD4_dq XD1.XDFFQ.SB XD4.dq 1.8151e-17
* device instance cc_XD1_XDFFQ_SB_XD4_nm r0 *1 0,0
Ccc_XD1_XDFFQ_SB_XD4_nm XD1.XDFFQ.SB XD4.nm 1.21e-17
* device instance cc_XD1_XDFFQ_SB_XD4_nt r0 *1 0,0
Ccc_XD1_XDFFQ_SB_XD4_nt XD1.XDFFQ.SB XD4.nt 1.21e-17
* device instance cc_XD1_XDFFQ_SB_XD4_t1 r0 *1 0,0
Ccc_XD1_XDFFQ_SB_XD4_t1 XD1.XDFFQ.SB XD4.t1 1.21e-17
* device instance cc_XD1_XDFFQ_SB_XD5_XDFFM_CLKB r0 *1 0,0
Ccc_XD1_XDFFQ_SB_XD5_XDFFM_CLKB XD1.XDFFQ.SB XD5.XDFFM.CLKB 1.8151e-17
* device instance cc_XD1_XDFFQ_SB_XD5_XDFFM_M r0 *1 0,0
Ccc_XD1_XDFFQ_SB_XD5_XDFFM_M XD1.XDFFQ.SB XD5.XDFFM.M 2.4201e-17
* device instance cc_XD1_XDFFQ_SB_XD5_XDFFM_MB r0 *1 0,0
Ccc_XD1_XDFFQ_SB_XD5_XDFFM_MB XD1.XDFFQ.SB XD5.XDFFM.MB 1.21e-17
* device instance cc_XD1_XDFFQ_SB_XD5_XDFFM_S r0 *1 0,0
Ccc_XD1_XDFFQ_SB_XD5_XDFFM_S XD1.XDFFQ.SB XD5.XDFFM.S 1.8151e-17
* device instance cc_XD1_XDFFQ_SB_XD5_XDFFM_SB r0 *1 0,0
Ccc_XD1_XDFFQ_SB_XD5_XDFFM_SB XD1.XDFFQ.SB XD5.XDFFM.SB 1.8151e-17
* device instance cc_XD1_XDFFQ_SB_XD5_XDFFQ_CLKB r0 *1 0,0
Ccc_XD1_XDFFQ_SB_XD5_XDFFQ_CLKB XD1.XDFFQ.SB XD5.XDFFQ.CLKB 1.8151e-17
* device instance cc_XD1_XDFFQ_SB_XD5_XDFFQ_M r0 *1 0,0
Ccc_XD1_XDFFQ_SB_XD5_XDFFQ_M XD1.XDFFQ.SB XD5.XDFFQ.M 2.4201e-17
* device instance cc_XD1_XDFFQ_SB_XD5_XDFFQ_MB r0 *1 0,0
Ccc_XD1_XDFFQ_SB_XD5_XDFFQ_MB XD1.XDFFQ.SB XD5.XDFFQ.MB 1.21e-17
* device instance cc_XD1_XDFFQ_SB_XD5_XDFFQ_S r0 *1 0,0
Ccc_XD1_XDFFQ_SB_XD5_XDFFQ_S XD1.XDFFQ.SB XD5.XDFFQ.S 1.8151e-17
* device instance cc_XD1_XDFFQ_SB_XD5_XDFFQ_SB r0 *1 0,0
Ccc_XD1_XDFFQ_SB_XD5_XDFFQ_SB XD1.XDFFQ.SB XD5.XDFFQ.SB 1.8151e-17
* device instance cc_XD1_XDFFQ_SB_XD5_XN2_mid1 r0 *1 0,0
Ccc_XD1_XDFFQ_SB_XD5_XN2_mid1 XD1.XDFFQ.SB XD5.XN2.mid1 1.21e-17
* device instance cc_XD1_XDFFQ_SB_XD5_XN3_mid1 r0 *1 0,0
Ccc_XD1_XDFFQ_SB_XD5_XN3_mid1 XD1.XDFFQ.SB XD5.XN3.mid1 1.21e-17
* device instance cc_XD1_XDFFQ_SB_XD5_XN3_mid2 r0 *1 0,0
Ccc_XD1_XDFFQ_SB_XD5_XN3_mid2 XD1.XDFFQ.SB XD5.XN3.mid2 1.21e-17
* device instance cc_XD1_XDFFQ_SB_XD5_dmodout r0 *1 0,0
Ccc_XD1_XDFFQ_SB_XD5_dmodout XD1.XDFFQ.SB XD5.dmodout 1.21e-17
* device instance cc_XD1_XDFFQ_SB_XD5_dq r0 *1 0,0
Ccc_XD1_XDFFQ_SB_XD5_dq XD1.XDFFQ.SB XD5.dq 1.8151e-17
* device instance cc_XD1_XDFFQ_SB_XD5_nm r0 *1 0,0
Ccc_XD1_XDFFQ_SB_XD5_nm XD1.XDFFQ.SB XD5.nm 1.21e-17
* device instance cc_XD1_XDFFQ_SB_XD5_nt r0 *1 0,0
Ccc_XD1_XDFFQ_SB_XD5_nt XD1.XDFFQ.SB XD5.nt 1.21e-17
* device instance cc_XD1_XDFFQ_SB_XD5_t1 r0 *1 0,0
Ccc_XD1_XDFFQ_SB_XD5_t1 XD1.XDFFQ.SB XD5.t1 1.21e-17
* device instance cc_XD1_XDFFQ_SB_XFRT_CLKB r0 *1 0,0
Ccc_XD1_XDFFQ_SB_XFRT_CLKB XD1.XDFFQ.SB XFRT.CLKB 1.8151e-17
* device instance cc_XD1_XDFFQ_SB_XFRT_M r0 *1 0,0
Ccc_XD1_XDFFQ_SB_XFRT_M XD1.XDFFQ.SB XFRT.M 2.4201e-17
* device instance cc_XD1_XDFFQ_SB_XFRT_MB r0 *1 0,0
Ccc_XD1_XDFFQ_SB_XFRT_MB XD1.XDFFQ.SB XFRT.MB 1.21e-17
* device instance cc_XD1_XDFFQ_SB_XFRT_S r0 *1 0,0
Ccc_XD1_XDFFQ_SB_XFRT_S XD1.XDFFQ.SB XFRT.S 1.8151e-17
* device instance cc_XD1_XDFFQ_SB_XFRT_SB r0 *1 0,0
Ccc_XD1_XDFFQ_SB_XFRT_SB XD1.XDFFQ.SB XFRT.SB 1.8151e-17
* device instance cc_XD1_XDFFQ_SB_ck1 r0 *1 0,0
Ccc_XD1_XDFFQ_SB_ck1 XD1.XDFFQ.SB ck1 5.4452e-17
* device instance cc_XD1_XDFFQ_SB_ck2 r0 *1 0,0
Ccc_XD1_XDFFQ_SB_ck2 XD1.XDFFQ.SB ck2 5.4452e-17
* device instance cc_XD1_XDFFQ_SB_ck3 r0 *1 0,0
Ccc_XD1_XDFFQ_SB_ck3 XD1.XDFFQ.SB ck3 5.4452e-17
* device instance cc_XD1_XDFFQ_SB_ck4 r0 *1 0,0
Ccc_XD1_XDFFQ_SB_ck4 XD1.XDFFQ.SB ck4 5.4452e-17
* device instance cc_XD1_XDFFQ_SB_ck5 r0 *1 0,0
Ccc_XD1_XDFFQ_SB_ck5 XD1.XDFFQ.SB ck5 5.4452e-17
* device instance cc_XD1_XDFFQ_SB_mod0 r0 *1 0,0
Ccc_XD1_XDFFQ_SB_mod0 XD1.XDFFQ.SB mod0 2.4201e-17
* device instance cc_XD1_XDFFQ_SB_mod1 r0 *1 0,0
Ccc_XD1_XDFFQ_SB_mod1 XD1.XDFFQ.SB mod1 2.4201e-17
* device instance cc_XD1_XDFFQ_SB_mod2 r0 *1 0,0
Ccc_XD1_XDFFQ_SB_mod2 XD1.XDFFQ.SB mod2 2.4201e-17
* device instance cc_XD1_XDFFQ_SB_mod3 r0 *1 0,0
Ccc_XD1_XDFFQ_SB_mod3 XD1.XDFFQ.SB mod3 2.4201e-17
* device instance cc_XD1_XDFFQ_SB_mod4 r0 *1 0,0
Ccc_XD1_XDFFQ_SB_mod4 XD1.XDFFQ.SB mod4 2.4201e-17
* device instance cc_XD1_XDFFQ_SB_net1 r0 *1 0,0
Ccc_XD1_XDFFQ_SB_net1 XD1.XDFFQ.SB net1 1.21e-17
* device instance cc_XD1_XN2_mid1_XD1_nm r0 *1 0,0
Ccc_XD1_XN2_mid1_XD1_nm XD1.XN2.mid1 XD1.nm 1.1294e-17
* device instance cc_XD1_XN2_mid1_ck2 r0 *1 0,0
Ccc_XD1_XN2_mid1_ck2 XD1.XN2.mid1 ck2 6.05e-18
* device instance cc_XD1_XN3_mid1_XD1_XN3_mid2 r0 *1 0,0
Ccc_XD1_XN3_mid1_XD1_XN3_mid2 XD1.XN3.mid1 XD1.XN3.mid2 1.1294e-17
* device instance cc_XD1_XN3_mid1_XD1_nt r0 *1 0,0
Ccc_XD1_XN3_mid1_XD1_nt XD1.XN3.mid1 XD1.nt 1.1294e-17
* device instance cc_XD1_XN3_mid2_mod0 r0 *1 0,0
Ccc_XD1_XN3_mid2_mod0 XD1.XN3.mid2 mod0 6.05e-18
* device instance cc_XD1_XNOR_midp_XD1_dq r0 *1 0,0
Ccc_XD1_XNOR_midp_XD1_dq XD1.XNOR.midp XD1.dq 5.244e-18
* device instance cc_XD1_XNOR_midp_XD1_t1 r0 *1 0,0
Ccc_XD1_XNOR_midp_XD1_t1 XD1.XNOR.midp XD1.t1 6.05e-18
* device instance cc_XD1_dmodout_XD1_dq r0 *1 0,0
Ccc_XD1_dmodout_XD1_dq XD1.dmodout XD1.dq 1.21e-17
* device instance cc_XD1_dmodout_XD1_nm r0 *1 0,0
Ccc_XD1_dmodout_XD1_nm XD1.dmodout XD1.nm 1.8151e-17
* device instance cc_XD1_dmodout_XD1_nt r0 *1 0,0
Ccc_XD1_dmodout_XD1_nt XD1.dmodout XD1.nt 2.4201e-17
* device instance cc_XD1_dmodout_XD1_t1 r0 *1 0,0
Ccc_XD1_dmodout_XD1_t1 XD1.dmodout XD1.t1 1.21e-17
* device instance cc_XD1_dmodout_XD2_XDFFM_CLKB r0 *1 0,0
Ccc_XD1_dmodout_XD2_XDFFM_CLKB XD1.dmodout XD2.XDFFM.CLKB 1.8151e-17
* device instance cc_XD1_dmodout_XD2_XDFFM_M r0 *1 0,0
Ccc_XD1_dmodout_XD2_XDFFM_M XD1.dmodout XD2.XDFFM.M 2.4201e-17
* device instance cc_XD1_dmodout_XD2_XDFFM_MB r0 *1 0,0
Ccc_XD1_dmodout_XD2_XDFFM_MB XD1.dmodout XD2.XDFFM.MB 1.21e-17
* device instance cc_XD1_dmodout_XD2_XDFFM_S r0 *1 0,0
Ccc_XD1_dmodout_XD2_XDFFM_S XD1.dmodout XD2.XDFFM.S 1.8151e-17
* device instance cc_XD1_dmodout_XD2_XDFFM_SB r0 *1 0,0
Ccc_XD1_dmodout_XD2_XDFFM_SB XD1.dmodout XD2.XDFFM.SB 1.8151e-17
* device instance cc_XD1_dmodout_XD2_XDFFQ_CLKB r0 *1 0,0
Ccc_XD1_dmodout_XD2_XDFFQ_CLKB XD1.dmodout XD2.XDFFQ.CLKB 1.8151e-17
* device instance cc_XD1_dmodout_XD2_XDFFQ_M r0 *1 0,0
Ccc_XD1_dmodout_XD2_XDFFQ_M XD1.dmodout XD2.XDFFQ.M 2.4201e-17
* device instance cc_XD1_dmodout_XD2_XDFFQ_MB r0 *1 0,0
Ccc_XD1_dmodout_XD2_XDFFQ_MB XD1.dmodout XD2.XDFFQ.MB 1.21e-17
* device instance cc_XD1_dmodout_XD2_XDFFQ_S r0 *1 0,0
Ccc_XD1_dmodout_XD2_XDFFQ_S XD1.dmodout XD2.XDFFQ.S 1.8151e-17
* device instance cc_XD1_dmodout_XD2_XDFFQ_SB r0 *1 0,0
Ccc_XD1_dmodout_XD2_XDFFQ_SB XD1.dmodout XD2.XDFFQ.SB 1.8151e-17
* device instance cc_XD1_dmodout_XD2_XN2_mid1 r0 *1 0,0
Ccc_XD1_dmodout_XD2_XN2_mid1 XD1.dmodout XD2.XN2.mid1 1.21e-17
* device instance cc_XD1_dmodout_XD2_XN3_mid1 r0 *1 0,0
Ccc_XD1_dmodout_XD2_XN3_mid1 XD1.dmodout XD2.XN3.mid1 1.21e-17
* device instance cc_XD1_dmodout_XD2_XN3_mid2 r0 *1 0,0
Ccc_XD1_dmodout_XD2_XN3_mid2 XD1.dmodout XD2.XN3.mid2 1.21e-17
* device instance cc_XD1_dmodout_XD2_dmodout r0 *1 0,0
Ccc_XD1_dmodout_XD2_dmodout XD1.dmodout XD2.dmodout 1.21e-17
* device instance cc_XD1_dmodout_XD2_dq r0 *1 0,0
Ccc_XD1_dmodout_XD2_dq XD1.dmodout XD2.dq 1.8151e-17
* device instance cc_XD1_dmodout_XD2_nm r0 *1 0,0
Ccc_XD1_dmodout_XD2_nm XD1.dmodout XD2.nm 1.21e-17
* device instance cc_XD1_dmodout_XD2_nt r0 *1 0,0
Ccc_XD1_dmodout_XD2_nt XD1.dmodout XD2.nt 1.21e-17
* device instance cc_XD1_dmodout_XD2_t1 r0 *1 0,0
Ccc_XD1_dmodout_XD2_t1 XD1.dmodout XD2.t1 1.21e-17
* device instance cc_XD1_dmodout_XD3_XDFFM_CLKB r0 *1 0,0
Ccc_XD1_dmodout_XD3_XDFFM_CLKB XD1.dmodout XD3.XDFFM.CLKB 1.8151e-17
* device instance cc_XD1_dmodout_XD3_XDFFM_M r0 *1 0,0
Ccc_XD1_dmodout_XD3_XDFFM_M XD1.dmodout XD3.XDFFM.M 2.4201e-17
* device instance cc_XD1_dmodout_XD3_XDFFM_MB r0 *1 0,0
Ccc_XD1_dmodout_XD3_XDFFM_MB XD1.dmodout XD3.XDFFM.MB 1.21e-17
* device instance cc_XD1_dmodout_XD3_XDFFM_S r0 *1 0,0
Ccc_XD1_dmodout_XD3_XDFFM_S XD1.dmodout XD3.XDFFM.S 1.8151e-17
* device instance cc_XD1_dmodout_XD3_XDFFM_SB r0 *1 0,0
Ccc_XD1_dmodout_XD3_XDFFM_SB XD1.dmodout XD3.XDFFM.SB 1.8151e-17
* device instance cc_XD1_dmodout_XD3_XDFFQ_CLKB r0 *1 0,0
Ccc_XD1_dmodout_XD3_XDFFQ_CLKB XD1.dmodout XD3.XDFFQ.CLKB 1.8151e-17
* device instance cc_XD1_dmodout_XD3_XDFFQ_M r0 *1 0,0
Ccc_XD1_dmodout_XD3_XDFFQ_M XD1.dmodout XD3.XDFFQ.M 2.4201e-17
* device instance cc_XD1_dmodout_XD3_XDFFQ_MB r0 *1 0,0
Ccc_XD1_dmodout_XD3_XDFFQ_MB XD1.dmodout XD3.XDFFQ.MB 1.21e-17
* device instance cc_XD1_dmodout_XD3_XDFFQ_S r0 *1 0,0
Ccc_XD1_dmodout_XD3_XDFFQ_S XD1.dmodout XD3.XDFFQ.S 1.8151e-17
* device instance cc_XD1_dmodout_XD3_XDFFQ_SB r0 *1 0,0
Ccc_XD1_dmodout_XD3_XDFFQ_SB XD1.dmodout XD3.XDFFQ.SB 1.8151e-17
* device instance cc_XD1_dmodout_XD3_XN2_mid1 r0 *1 0,0
Ccc_XD1_dmodout_XD3_XN2_mid1 XD1.dmodout XD3.XN2.mid1 1.21e-17
* device instance cc_XD1_dmodout_XD3_XN3_mid1 r0 *1 0,0
Ccc_XD1_dmodout_XD3_XN3_mid1 XD1.dmodout XD3.XN3.mid1 1.21e-17
* device instance cc_XD1_dmodout_XD3_XN3_mid2 r0 *1 0,0
Ccc_XD1_dmodout_XD3_XN3_mid2 XD1.dmodout XD3.XN3.mid2 1.21e-17
* device instance cc_XD1_dmodout_XD3_dmodout r0 *1 0,0
Ccc_XD1_dmodout_XD3_dmodout XD1.dmodout XD3.dmodout 1.21e-17
* device instance cc_XD1_dmodout_XD3_dq r0 *1 0,0
Ccc_XD1_dmodout_XD3_dq XD1.dmodout XD3.dq 1.8151e-17
* device instance cc_XD1_dmodout_XD3_nm r0 *1 0,0
Ccc_XD1_dmodout_XD3_nm XD1.dmodout XD3.nm 1.21e-17
* device instance cc_XD1_dmodout_XD3_nt r0 *1 0,0
Ccc_XD1_dmodout_XD3_nt XD1.dmodout XD3.nt 1.21e-17
* device instance cc_XD1_dmodout_XD3_t1 r0 *1 0,0
Ccc_XD1_dmodout_XD3_t1 XD1.dmodout XD3.t1 1.21e-17
* device instance cc_XD1_dmodout_XD4_XDFFM_CLKB r0 *1 0,0
Ccc_XD1_dmodout_XD4_XDFFM_CLKB XD1.dmodout XD4.XDFFM.CLKB 1.8151e-17
* device instance cc_XD1_dmodout_XD4_XDFFM_M r0 *1 0,0
Ccc_XD1_dmodout_XD4_XDFFM_M XD1.dmodout XD4.XDFFM.M 2.4201e-17
* device instance cc_XD1_dmodout_XD4_XDFFM_MB r0 *1 0,0
Ccc_XD1_dmodout_XD4_XDFFM_MB XD1.dmodout XD4.XDFFM.MB 1.21e-17
* device instance cc_XD1_dmodout_XD4_XDFFM_S r0 *1 0,0
Ccc_XD1_dmodout_XD4_XDFFM_S XD1.dmodout XD4.XDFFM.S 1.8151e-17
* device instance cc_XD1_dmodout_XD4_XDFFM_SB r0 *1 0,0
Ccc_XD1_dmodout_XD4_XDFFM_SB XD1.dmodout XD4.XDFFM.SB 1.8151e-17
* device instance cc_XD1_dmodout_XD4_XDFFQ_CLKB r0 *1 0,0
Ccc_XD1_dmodout_XD4_XDFFQ_CLKB XD1.dmodout XD4.XDFFQ.CLKB 1.8151e-17
* device instance cc_XD1_dmodout_XD4_XDFFQ_M r0 *1 0,0
Ccc_XD1_dmodout_XD4_XDFFQ_M XD1.dmodout XD4.XDFFQ.M 2.4201e-17
* device instance cc_XD1_dmodout_XD4_XDFFQ_MB r0 *1 0,0
Ccc_XD1_dmodout_XD4_XDFFQ_MB XD1.dmodout XD4.XDFFQ.MB 1.21e-17
* device instance cc_XD1_dmodout_XD4_XDFFQ_S r0 *1 0,0
Ccc_XD1_dmodout_XD4_XDFFQ_S XD1.dmodout XD4.XDFFQ.S 1.8151e-17
* device instance cc_XD1_dmodout_XD4_XDFFQ_SB r0 *1 0,0
Ccc_XD1_dmodout_XD4_XDFFQ_SB XD1.dmodout XD4.XDFFQ.SB 1.8151e-17
* device instance cc_XD1_dmodout_XD4_XN2_mid1 r0 *1 0,0
Ccc_XD1_dmodout_XD4_XN2_mid1 XD1.dmodout XD4.XN2.mid1 1.21e-17
* device instance cc_XD1_dmodout_XD4_XN3_mid1 r0 *1 0,0
Ccc_XD1_dmodout_XD4_XN3_mid1 XD1.dmodout XD4.XN3.mid1 1.21e-17
* device instance cc_XD1_dmodout_XD4_XN3_mid2 r0 *1 0,0
Ccc_XD1_dmodout_XD4_XN3_mid2 XD1.dmodout XD4.XN3.mid2 1.21e-17
* device instance cc_XD1_dmodout_XD4_dmodout r0 *1 0,0
Ccc_XD1_dmodout_XD4_dmodout XD1.dmodout XD4.dmodout 1.21e-17
* device instance cc_XD1_dmodout_XD4_dq r0 *1 0,0
Ccc_XD1_dmodout_XD4_dq XD1.dmodout XD4.dq 1.8151e-17
* device instance cc_XD1_dmodout_XD4_nm r0 *1 0,0
Ccc_XD1_dmodout_XD4_nm XD1.dmodout XD4.nm 1.21e-17
* device instance cc_XD1_dmodout_XD4_nt r0 *1 0,0
Ccc_XD1_dmodout_XD4_nt XD1.dmodout XD4.nt 1.21e-17
* device instance cc_XD1_dmodout_XD4_t1 r0 *1 0,0
Ccc_XD1_dmodout_XD4_t1 XD1.dmodout XD4.t1 1.21e-17
* device instance cc_XD1_dmodout_XD5_XDFFM_CLKB r0 *1 0,0
Ccc_XD1_dmodout_XD5_XDFFM_CLKB XD1.dmodout XD5.XDFFM.CLKB 1.8151e-17
* device instance cc_XD1_dmodout_XD5_XDFFM_M r0 *1 0,0
Ccc_XD1_dmodout_XD5_XDFFM_M XD1.dmodout XD5.XDFFM.M 2.4201e-17
* device instance cc_XD1_dmodout_XD5_XDFFM_MB r0 *1 0,0
Ccc_XD1_dmodout_XD5_XDFFM_MB XD1.dmodout XD5.XDFFM.MB 1.21e-17
* device instance cc_XD1_dmodout_XD5_XDFFM_S r0 *1 0,0
Ccc_XD1_dmodout_XD5_XDFFM_S XD1.dmodout XD5.XDFFM.S 1.8151e-17
* device instance cc_XD1_dmodout_XD5_XDFFM_SB r0 *1 0,0
Ccc_XD1_dmodout_XD5_XDFFM_SB XD1.dmodout XD5.XDFFM.SB 1.8151e-17
* device instance cc_XD1_dmodout_XD5_XDFFQ_CLKB r0 *1 0,0
Ccc_XD1_dmodout_XD5_XDFFQ_CLKB XD1.dmodout XD5.XDFFQ.CLKB 1.8151e-17
* device instance cc_XD1_dmodout_XD5_XDFFQ_M r0 *1 0,0
Ccc_XD1_dmodout_XD5_XDFFQ_M XD1.dmodout XD5.XDFFQ.M 2.4201e-17
* device instance cc_XD1_dmodout_XD5_XDFFQ_MB r0 *1 0,0
Ccc_XD1_dmodout_XD5_XDFFQ_MB XD1.dmodout XD5.XDFFQ.MB 1.21e-17
* device instance cc_XD1_dmodout_XD5_XDFFQ_S r0 *1 0,0
Ccc_XD1_dmodout_XD5_XDFFQ_S XD1.dmodout XD5.XDFFQ.S 1.8151e-17
* device instance cc_XD1_dmodout_XD5_XDFFQ_SB r0 *1 0,0
Ccc_XD1_dmodout_XD5_XDFFQ_SB XD1.dmodout XD5.XDFFQ.SB 1.8151e-17
* device instance cc_XD1_dmodout_XD5_XN2_mid1 r0 *1 0,0
Ccc_XD1_dmodout_XD5_XN2_mid1 XD1.dmodout XD5.XN2.mid1 1.21e-17
* device instance cc_XD1_dmodout_XD5_XN3_mid1 r0 *1 0,0
Ccc_XD1_dmodout_XD5_XN3_mid1 XD1.dmodout XD5.XN3.mid1 1.21e-17
* device instance cc_XD1_dmodout_XD5_XN3_mid2 r0 *1 0,0
Ccc_XD1_dmodout_XD5_XN3_mid2 XD1.dmodout XD5.XN3.mid2 1.21e-17
* device instance cc_XD1_dmodout_XD5_dmodout r0 *1 0,0
Ccc_XD1_dmodout_XD5_dmodout XD1.dmodout XD5.dmodout 1.21e-17
* device instance cc_XD1_dmodout_XD5_dq r0 *1 0,0
Ccc_XD1_dmodout_XD5_dq XD1.dmodout XD5.dq 1.8151e-17
* device instance cc_XD1_dmodout_XD5_nm r0 *1 0,0
Ccc_XD1_dmodout_XD5_nm XD1.dmodout XD5.nm 1.21e-17
* device instance cc_XD1_dmodout_XD5_nt r0 *1 0,0
Ccc_XD1_dmodout_XD5_nt XD1.dmodout XD5.nt 1.21e-17
* device instance cc_XD1_dmodout_XD5_t1 r0 *1 0,0
Ccc_XD1_dmodout_XD5_t1 XD1.dmodout XD5.t1 1.21e-17
* device instance cc_XD1_dmodout_XFRT_CLKB r0 *1 0,0
Ccc_XD1_dmodout_XFRT_CLKB XD1.dmodout XFRT.CLKB 1.8151e-17
* device instance cc_XD1_dmodout_XFRT_M r0 *1 0,0
Ccc_XD1_dmodout_XFRT_M XD1.dmodout XFRT.M 2.4201e-17
* device instance cc_XD1_dmodout_XFRT_MB r0 *1 0,0
Ccc_XD1_dmodout_XFRT_MB XD1.dmodout XFRT.MB 1.21e-17
* device instance cc_XD1_dmodout_XFRT_S r0 *1 0,0
Ccc_XD1_dmodout_XFRT_S XD1.dmodout XFRT.S 1.8151e-17
* device instance cc_XD1_dmodout_XFRT_SB r0 *1 0,0
Ccc_XD1_dmodout_XFRT_SB XD1.dmodout XFRT.SB 1.8151e-17
* device instance cc_XD1_dmodout_ck1 r0 *1 0,0
Ccc_XD1_dmodout_ck1 XD1.dmodout ck1 6.6553e-17
* device instance cc_XD1_dmodout_ck2 r0 *1 0,0
Ccc_XD1_dmodout_ck2 XD1.dmodout ck2 5.4452e-17
* device instance cc_XD1_dmodout_ck3 r0 *1 0,0
Ccc_XD1_dmodout_ck3 XD1.dmodout ck3 5.4452e-17
* device instance cc_XD1_dmodout_ck4 r0 *1 0,0
Ccc_XD1_dmodout_ck4 XD1.dmodout ck4 5.4452e-17
* device instance cc_XD1_dmodout_ck5 r0 *1 0,0
Ccc_XD1_dmodout_ck5 XD1.dmodout ck5 5.4452e-17
* device instance cc_XD1_dmodout_mod0 r0 *1 0,0
Ccc_XD1_dmodout_mod0 XD1.dmodout mod0 2.4201e-17
* device instance cc_XD1_dmodout_mod1 r0 *1 0,0
Ccc_XD1_dmodout_mod1 XD1.dmodout mod1 2.4201e-17
* device instance cc_XD1_dmodout_mod2 r0 *1 0,0
Ccc_XD1_dmodout_mod2 XD1.dmodout mod2 2.4201e-17
* device instance cc_XD1_dmodout_mod3 r0 *1 0,0
Ccc_XD1_dmodout_mod3 XD1.dmodout mod3 2.4201e-17
* device instance cc_XD1_dmodout_mod4 r0 *1 0,0
Ccc_XD1_dmodout_mod4 XD1.dmodout mod4 2.4201e-17
* device instance cc_XD1_dmodout_net1 r0 *1 0,0
Ccc_XD1_dmodout_net1 XD1.dmodout net1 1.21e-17
* device instance cc_XD1_dq_XD1_nm r0 *1 0,0
Ccc_XD1_dq_XD1_nm XD1.dq XD1.nm 1.21e-17
* device instance cc_XD1_dq_XD1_nt r0 *1 0,0
Ccc_XD1_dq_XD1_nt XD1.dq XD1.nt 2.4201e-17
* device instance cc_XD1_dq_XD1_t1 r0 *1 0,0
Ccc_XD1_dq_XD1_t1 XD1.dq XD1.t1 1.8151e-17
* device instance cc_XD1_dq_XD2_XDFFM_CLKB r0 *1 0,0
Ccc_XD1_dq_XD2_XDFFM_CLKB XD1.dq XD2.XDFFM.CLKB 1.8151e-17
* device instance cc_XD1_dq_XD2_XDFFM_M r0 *1 0,0
Ccc_XD1_dq_XD2_XDFFM_M XD1.dq XD2.XDFFM.M 2.4201e-17
* device instance cc_XD1_dq_XD2_XDFFM_MB r0 *1 0,0
Ccc_XD1_dq_XD2_XDFFM_MB XD1.dq XD2.XDFFM.MB 1.21e-17
* device instance cc_XD1_dq_XD2_XDFFM_S r0 *1 0,0
Ccc_XD1_dq_XD2_XDFFM_S XD1.dq XD2.XDFFM.S 1.8151e-17
* device instance cc_XD1_dq_XD2_XDFFM_SB r0 *1 0,0
Ccc_XD1_dq_XD2_XDFFM_SB XD1.dq XD2.XDFFM.SB 1.8151e-17
* device instance cc_XD1_dq_XD2_XDFFQ_CLKB r0 *1 0,0
Ccc_XD1_dq_XD2_XDFFQ_CLKB XD1.dq XD2.XDFFQ.CLKB 1.8151e-17
* device instance cc_XD1_dq_XD2_XDFFQ_M r0 *1 0,0
Ccc_XD1_dq_XD2_XDFFQ_M XD1.dq XD2.XDFFQ.M 2.4201e-17
* device instance cc_XD1_dq_XD2_XDFFQ_MB r0 *1 0,0
Ccc_XD1_dq_XD2_XDFFQ_MB XD1.dq XD2.XDFFQ.MB 1.21e-17
* device instance cc_XD1_dq_XD2_XDFFQ_S r0 *1 0,0
Ccc_XD1_dq_XD2_XDFFQ_S XD1.dq XD2.XDFFQ.S 1.8151e-17
* device instance cc_XD1_dq_XD2_XDFFQ_SB r0 *1 0,0
Ccc_XD1_dq_XD2_XDFFQ_SB XD1.dq XD2.XDFFQ.SB 1.8151e-17
* device instance cc_XD1_dq_XD2_XN2_mid1 r0 *1 0,0
Ccc_XD1_dq_XD2_XN2_mid1 XD1.dq XD2.XN2.mid1 1.21e-17
* device instance cc_XD1_dq_XD2_XN3_mid1 r0 *1 0,0
Ccc_XD1_dq_XD2_XN3_mid1 XD1.dq XD2.XN3.mid1 1.21e-17
* device instance cc_XD1_dq_XD2_XN3_mid2 r0 *1 0,0
Ccc_XD1_dq_XD2_XN3_mid2 XD1.dq XD2.XN3.mid2 1.21e-17
* device instance cc_XD1_dq_XD2_dmodout r0 *1 0,0
Ccc_XD1_dq_XD2_dmodout XD1.dq XD2.dmodout 1.21e-17
* device instance cc_XD1_dq_XD2_dq r0 *1 0,0
Ccc_XD1_dq_XD2_dq XD1.dq XD2.dq 1.8151e-17
* device instance cc_XD1_dq_XD2_nm r0 *1 0,0
Ccc_XD1_dq_XD2_nm XD1.dq XD2.nm 1.21e-17
* device instance cc_XD1_dq_XD2_nt r0 *1 0,0
Ccc_XD1_dq_XD2_nt XD1.dq XD2.nt 1.21e-17
* device instance cc_XD1_dq_XD2_t1 r0 *1 0,0
Ccc_XD1_dq_XD2_t1 XD1.dq XD2.t1 1.21e-17
* device instance cc_XD1_dq_XD3_XDFFM_CLKB r0 *1 0,0
Ccc_XD1_dq_XD3_XDFFM_CLKB XD1.dq XD3.XDFFM.CLKB 1.8151e-17
* device instance cc_XD1_dq_XD3_XDFFM_M r0 *1 0,0
Ccc_XD1_dq_XD3_XDFFM_M XD1.dq XD3.XDFFM.M 2.4201e-17
* device instance cc_XD1_dq_XD3_XDFFM_MB r0 *1 0,0
Ccc_XD1_dq_XD3_XDFFM_MB XD1.dq XD3.XDFFM.MB 1.21e-17
* device instance cc_XD1_dq_XD3_XDFFM_S r0 *1 0,0
Ccc_XD1_dq_XD3_XDFFM_S XD1.dq XD3.XDFFM.S 1.8151e-17
* device instance cc_XD1_dq_XD3_XDFFM_SB r0 *1 0,0
Ccc_XD1_dq_XD3_XDFFM_SB XD1.dq XD3.XDFFM.SB 1.8151e-17
* device instance cc_XD1_dq_XD3_XDFFQ_CLKB r0 *1 0,0
Ccc_XD1_dq_XD3_XDFFQ_CLKB XD1.dq XD3.XDFFQ.CLKB 1.8151e-17
* device instance cc_XD1_dq_XD3_XDFFQ_M r0 *1 0,0
Ccc_XD1_dq_XD3_XDFFQ_M XD1.dq XD3.XDFFQ.M 2.4201e-17
* device instance cc_XD1_dq_XD3_XDFFQ_MB r0 *1 0,0
Ccc_XD1_dq_XD3_XDFFQ_MB XD1.dq XD3.XDFFQ.MB 1.21e-17
* device instance cc_XD1_dq_XD3_XDFFQ_S r0 *1 0,0
Ccc_XD1_dq_XD3_XDFFQ_S XD1.dq XD3.XDFFQ.S 1.8151e-17
* device instance cc_XD1_dq_XD3_XDFFQ_SB r0 *1 0,0
Ccc_XD1_dq_XD3_XDFFQ_SB XD1.dq XD3.XDFFQ.SB 1.8151e-17
* device instance cc_XD1_dq_XD3_XN2_mid1 r0 *1 0,0
Ccc_XD1_dq_XD3_XN2_mid1 XD1.dq XD3.XN2.mid1 1.21e-17
* device instance cc_XD1_dq_XD3_XN3_mid1 r0 *1 0,0
Ccc_XD1_dq_XD3_XN3_mid1 XD1.dq XD3.XN3.mid1 1.21e-17
* device instance cc_XD1_dq_XD3_XN3_mid2 r0 *1 0,0
Ccc_XD1_dq_XD3_XN3_mid2 XD1.dq XD3.XN3.mid2 1.21e-17
* device instance cc_XD1_dq_XD3_dmodout r0 *1 0,0
Ccc_XD1_dq_XD3_dmodout XD1.dq XD3.dmodout 1.21e-17
* device instance cc_XD1_dq_XD3_dq r0 *1 0,0
Ccc_XD1_dq_XD3_dq XD1.dq XD3.dq 1.8151e-17
* device instance cc_XD1_dq_XD3_nm r0 *1 0,0
Ccc_XD1_dq_XD3_nm XD1.dq XD3.nm 1.21e-17
* device instance cc_XD1_dq_XD3_nt r0 *1 0,0
Ccc_XD1_dq_XD3_nt XD1.dq XD3.nt 1.21e-17
* device instance cc_XD1_dq_XD3_t1 r0 *1 0,0
Ccc_XD1_dq_XD3_t1 XD1.dq XD3.t1 1.21e-17
* device instance cc_XD1_dq_XD4_XDFFM_CLKB r0 *1 0,0
Ccc_XD1_dq_XD4_XDFFM_CLKB XD1.dq XD4.XDFFM.CLKB 1.8151e-17
* device instance cc_XD1_dq_XD4_XDFFM_M r0 *1 0,0
Ccc_XD1_dq_XD4_XDFFM_M XD1.dq XD4.XDFFM.M 2.4201e-17
* device instance cc_XD1_dq_XD4_XDFFM_MB r0 *1 0,0
Ccc_XD1_dq_XD4_XDFFM_MB XD1.dq XD4.XDFFM.MB 1.21e-17
* device instance cc_XD1_dq_XD4_XDFFM_S r0 *1 0,0
Ccc_XD1_dq_XD4_XDFFM_S XD1.dq XD4.XDFFM.S 1.8151e-17
* device instance cc_XD1_dq_XD4_XDFFM_SB r0 *1 0,0
Ccc_XD1_dq_XD4_XDFFM_SB XD1.dq XD4.XDFFM.SB 1.8151e-17
* device instance cc_XD1_dq_XD4_XDFFQ_CLKB r0 *1 0,0
Ccc_XD1_dq_XD4_XDFFQ_CLKB XD1.dq XD4.XDFFQ.CLKB 1.8151e-17
* device instance cc_XD1_dq_XD4_XDFFQ_M r0 *1 0,0
Ccc_XD1_dq_XD4_XDFFQ_M XD1.dq XD4.XDFFQ.M 2.4201e-17
* device instance cc_XD1_dq_XD4_XDFFQ_MB r0 *1 0,0
Ccc_XD1_dq_XD4_XDFFQ_MB XD1.dq XD4.XDFFQ.MB 1.21e-17
* device instance cc_XD1_dq_XD4_XDFFQ_S r0 *1 0,0
Ccc_XD1_dq_XD4_XDFFQ_S XD1.dq XD4.XDFFQ.S 1.8151e-17
* device instance cc_XD1_dq_XD4_XDFFQ_SB r0 *1 0,0
Ccc_XD1_dq_XD4_XDFFQ_SB XD1.dq XD4.XDFFQ.SB 1.8151e-17
* device instance cc_XD1_dq_XD4_XN2_mid1 r0 *1 0,0
Ccc_XD1_dq_XD4_XN2_mid1 XD1.dq XD4.XN2.mid1 1.21e-17
* device instance cc_XD1_dq_XD4_XN3_mid1 r0 *1 0,0
Ccc_XD1_dq_XD4_XN3_mid1 XD1.dq XD4.XN3.mid1 1.21e-17
* device instance cc_XD1_dq_XD4_XN3_mid2 r0 *1 0,0
Ccc_XD1_dq_XD4_XN3_mid2 XD1.dq XD4.XN3.mid2 1.21e-17
* device instance cc_XD1_dq_XD4_dmodout r0 *1 0,0
Ccc_XD1_dq_XD4_dmodout XD1.dq XD4.dmodout 1.21e-17
* device instance cc_XD1_dq_XD4_dq r0 *1 0,0
Ccc_XD1_dq_XD4_dq XD1.dq XD4.dq 1.8151e-17
* device instance cc_XD1_dq_XD4_nm r0 *1 0,0
Ccc_XD1_dq_XD4_nm XD1.dq XD4.nm 1.21e-17
* device instance cc_XD1_dq_XD4_nt r0 *1 0,0
Ccc_XD1_dq_XD4_nt XD1.dq XD4.nt 1.21e-17
* device instance cc_XD1_dq_XD4_t1 r0 *1 0,0
Ccc_XD1_dq_XD4_t1 XD1.dq XD4.t1 1.21e-17
* device instance cc_XD1_dq_XD5_XDFFM_CLKB r0 *1 0,0
Ccc_XD1_dq_XD5_XDFFM_CLKB XD1.dq XD5.XDFFM.CLKB 1.8151e-17
* device instance cc_XD1_dq_XD5_XDFFM_M r0 *1 0,0
Ccc_XD1_dq_XD5_XDFFM_M XD1.dq XD5.XDFFM.M 2.4201e-17
* device instance cc_XD1_dq_XD5_XDFFM_MB r0 *1 0,0
Ccc_XD1_dq_XD5_XDFFM_MB XD1.dq XD5.XDFFM.MB 1.21e-17
* device instance cc_XD1_dq_XD5_XDFFM_S r0 *1 0,0
Ccc_XD1_dq_XD5_XDFFM_S XD1.dq XD5.XDFFM.S 1.8151e-17
* device instance cc_XD1_dq_XD5_XDFFM_SB r0 *1 0,0
Ccc_XD1_dq_XD5_XDFFM_SB XD1.dq XD5.XDFFM.SB 1.8151e-17
* device instance cc_XD1_dq_XD5_XDFFQ_CLKB r0 *1 0,0
Ccc_XD1_dq_XD5_XDFFQ_CLKB XD1.dq XD5.XDFFQ.CLKB 1.8151e-17
* device instance cc_XD1_dq_XD5_XDFFQ_M r0 *1 0,0
Ccc_XD1_dq_XD5_XDFFQ_M XD1.dq XD5.XDFFQ.M 2.4201e-17
* device instance cc_XD1_dq_XD5_XDFFQ_MB r0 *1 0,0
Ccc_XD1_dq_XD5_XDFFQ_MB XD1.dq XD5.XDFFQ.MB 1.21e-17
* device instance cc_XD1_dq_XD5_XDFFQ_S r0 *1 0,0
Ccc_XD1_dq_XD5_XDFFQ_S XD1.dq XD5.XDFFQ.S 1.8151e-17
* device instance cc_XD1_dq_XD5_XDFFQ_SB r0 *1 0,0
Ccc_XD1_dq_XD5_XDFFQ_SB XD1.dq XD5.XDFFQ.SB 1.8151e-17
* device instance cc_XD1_dq_XD5_XN2_mid1 r0 *1 0,0
Ccc_XD1_dq_XD5_XN2_mid1 XD1.dq XD5.XN2.mid1 1.21e-17
* device instance cc_XD1_dq_XD5_XN3_mid1 r0 *1 0,0
Ccc_XD1_dq_XD5_XN3_mid1 XD1.dq XD5.XN3.mid1 1.21e-17
* device instance cc_XD1_dq_XD5_XN3_mid2 r0 *1 0,0
Ccc_XD1_dq_XD5_XN3_mid2 XD1.dq XD5.XN3.mid2 1.21e-17
* device instance cc_XD1_dq_XD5_dmodout r0 *1 0,0
Ccc_XD1_dq_XD5_dmodout XD1.dq XD5.dmodout 1.21e-17
* device instance cc_XD1_dq_XD5_dq r0 *1 0,0
Ccc_XD1_dq_XD5_dq XD1.dq XD5.dq 1.8151e-17
* device instance cc_XD1_dq_XD5_nm r0 *1 0,0
Ccc_XD1_dq_XD5_nm XD1.dq XD5.nm 1.21e-17
* device instance cc_XD1_dq_XD5_nt r0 *1 0,0
Ccc_XD1_dq_XD5_nt XD1.dq XD5.nt 1.21e-17
* device instance cc_XD1_dq_XD5_t1 r0 *1 0,0
Ccc_XD1_dq_XD5_t1 XD1.dq XD5.t1 1.21e-17
* device instance cc_XD1_dq_XFRT_CLKB r0 *1 0,0
Ccc_XD1_dq_XFRT_CLKB XD1.dq XFRT.CLKB 1.8151e-17
* device instance cc_XD1_dq_XFRT_M r0 *1 0,0
Ccc_XD1_dq_XFRT_M XD1.dq XFRT.M 2.4201e-17
* device instance cc_XD1_dq_XFRT_MB r0 *1 0,0
Ccc_XD1_dq_XFRT_MB XD1.dq XFRT.MB 1.21e-17
* device instance cc_XD1_dq_XFRT_S r0 *1 0,0
Ccc_XD1_dq_XFRT_S XD1.dq XFRT.S 1.8151e-17
* device instance cc_XD1_dq_XFRT_SB r0 *1 0,0
Ccc_XD1_dq_XFRT_SB XD1.dq XFRT.SB 1.8151e-17
* device instance cc_XD1_dq_ck1 r0 *1 0,0
Ccc_XD1_dq_ck1 XD1.dq ck1 6.6553e-17
* device instance cc_XD1_dq_ck2 r0 *1 0,0
Ccc_XD1_dq_ck2 XD1.dq ck2 5.4452e-17
* device instance cc_XD1_dq_ck3 r0 *1 0,0
Ccc_XD1_dq_ck3 XD1.dq ck3 5.4452e-17
* device instance cc_XD1_dq_ck4 r0 *1 0,0
Ccc_XD1_dq_ck4 XD1.dq ck4 5.4452e-17
* device instance cc_XD1_dq_ck5 r0 *1 0,0
Ccc_XD1_dq_ck5 XD1.dq ck5 5.4452e-17
* device instance cc_XD1_dq_mod0 r0 *1 0,0
Ccc_XD1_dq_mod0 XD1.dq mod0 2.4201e-17
* device instance cc_XD1_dq_mod1 r0 *1 0,0
Ccc_XD1_dq_mod1 XD1.dq mod1 2.4201e-17
* device instance cc_XD1_dq_mod2 r0 *1 0,0
Ccc_XD1_dq_mod2 XD1.dq mod2 2.4201e-17
* device instance cc_XD1_dq_mod3 r0 *1 0,0
Ccc_XD1_dq_mod3 XD1.dq mod3 2.4201e-17
* device instance cc_XD1_dq_mod4 r0 *1 0,0
Ccc_XD1_dq_mod4 XD1.dq mod4 2.4201e-17
* device instance cc_XD1_dq_net1 r0 *1 0,0
Ccc_XD1_dq_net1 XD1.dq net1 1.21e-17
* device instance cc_XD1_nm_XD1_nt r0 *1 0,0
Ccc_XD1_nm_XD1_nt XD1.nm XD1.nt 2.4201e-17
* device instance cc_XD1_nm_XD1_t1 r0 *1 0,0
Ccc_XD1_nm_XD1_t1 XD1.nm XD1.t1 1.21e-17
* device instance cc_XD1_nm_XD2_XDFFM_CLKB r0 *1 0,0
Ccc_XD1_nm_XD2_XDFFM_CLKB XD1.nm XD2.XDFFM.CLKB 1.8151e-17
* device instance cc_XD1_nm_XD2_XDFFM_M r0 *1 0,0
Ccc_XD1_nm_XD2_XDFFM_M XD1.nm XD2.XDFFM.M 2.4201e-17
* device instance cc_XD1_nm_XD2_XDFFM_MB r0 *1 0,0
Ccc_XD1_nm_XD2_XDFFM_MB XD1.nm XD2.XDFFM.MB 1.21e-17
* device instance cc_XD1_nm_XD2_XDFFM_S r0 *1 0,0
Ccc_XD1_nm_XD2_XDFFM_S XD1.nm XD2.XDFFM.S 1.8151e-17
* device instance cc_XD1_nm_XD2_XDFFM_SB r0 *1 0,0
Ccc_XD1_nm_XD2_XDFFM_SB XD1.nm XD2.XDFFM.SB 1.8151e-17
* device instance cc_XD1_nm_XD2_XDFFQ_CLKB r0 *1 0,0
Ccc_XD1_nm_XD2_XDFFQ_CLKB XD1.nm XD2.XDFFQ.CLKB 1.8151e-17
* device instance cc_XD1_nm_XD2_XDFFQ_M r0 *1 0,0
Ccc_XD1_nm_XD2_XDFFQ_M XD1.nm XD2.XDFFQ.M 2.4201e-17
* device instance cc_XD1_nm_XD2_XDFFQ_MB r0 *1 0,0
Ccc_XD1_nm_XD2_XDFFQ_MB XD1.nm XD2.XDFFQ.MB 1.21e-17
* device instance cc_XD1_nm_XD2_XDFFQ_S r0 *1 0,0
Ccc_XD1_nm_XD2_XDFFQ_S XD1.nm XD2.XDFFQ.S 1.8151e-17
* device instance cc_XD1_nm_XD2_XDFFQ_SB r0 *1 0,0
Ccc_XD1_nm_XD2_XDFFQ_SB XD1.nm XD2.XDFFQ.SB 1.8151e-17
* device instance cc_XD1_nm_XD2_XN2_mid1 r0 *1 0,0
Ccc_XD1_nm_XD2_XN2_mid1 XD1.nm XD2.XN2.mid1 1.21e-17
* device instance cc_XD1_nm_XD2_XN3_mid1 r0 *1 0,0
Ccc_XD1_nm_XD2_XN3_mid1 XD1.nm XD2.XN3.mid1 1.21e-17
* device instance cc_XD1_nm_XD2_XN3_mid2 r0 *1 0,0
Ccc_XD1_nm_XD2_XN3_mid2 XD1.nm XD2.XN3.mid2 1.21e-17
* device instance cc_XD1_nm_XD2_dmodout r0 *1 0,0
Ccc_XD1_nm_XD2_dmodout XD1.nm XD2.dmodout 1.21e-17
* device instance cc_XD1_nm_XD2_dq r0 *1 0,0
Ccc_XD1_nm_XD2_dq XD1.nm XD2.dq 1.8151e-17
* device instance cc_XD1_nm_XD2_nm r0 *1 0,0
Ccc_XD1_nm_XD2_nm XD1.nm XD2.nm 1.21e-17
* device instance cc_XD1_nm_XD2_nt r0 *1 0,0
Ccc_XD1_nm_XD2_nt XD1.nm XD2.nt 1.21e-17
* device instance cc_XD1_nm_XD2_t1 r0 *1 0,0
Ccc_XD1_nm_XD2_t1 XD1.nm XD2.t1 1.21e-17
* device instance cc_XD1_nm_XD3_XDFFM_CLKB r0 *1 0,0
Ccc_XD1_nm_XD3_XDFFM_CLKB XD1.nm XD3.XDFFM.CLKB 1.8151e-17
* device instance cc_XD1_nm_XD3_XDFFM_M r0 *1 0,0
Ccc_XD1_nm_XD3_XDFFM_M XD1.nm XD3.XDFFM.M 2.4201e-17
* device instance cc_XD1_nm_XD3_XDFFM_MB r0 *1 0,0
Ccc_XD1_nm_XD3_XDFFM_MB XD1.nm XD3.XDFFM.MB 1.21e-17
* device instance cc_XD1_nm_XD3_XDFFM_S r0 *1 0,0
Ccc_XD1_nm_XD3_XDFFM_S XD1.nm XD3.XDFFM.S 1.8151e-17
* device instance cc_XD1_nm_XD3_XDFFM_SB r0 *1 0,0
Ccc_XD1_nm_XD3_XDFFM_SB XD1.nm XD3.XDFFM.SB 1.8151e-17
* device instance cc_XD1_nm_XD3_XDFFQ_CLKB r0 *1 0,0
Ccc_XD1_nm_XD3_XDFFQ_CLKB XD1.nm XD3.XDFFQ.CLKB 1.8151e-17
* device instance cc_XD1_nm_XD3_XDFFQ_M r0 *1 0,0
Ccc_XD1_nm_XD3_XDFFQ_M XD1.nm XD3.XDFFQ.M 2.4201e-17
* device instance cc_XD1_nm_XD3_XDFFQ_MB r0 *1 0,0
Ccc_XD1_nm_XD3_XDFFQ_MB XD1.nm XD3.XDFFQ.MB 1.21e-17
* device instance cc_XD1_nm_XD3_XDFFQ_S r0 *1 0,0
Ccc_XD1_nm_XD3_XDFFQ_S XD1.nm XD3.XDFFQ.S 1.8151e-17
* device instance cc_XD1_nm_XD3_XDFFQ_SB r0 *1 0,0
Ccc_XD1_nm_XD3_XDFFQ_SB XD1.nm XD3.XDFFQ.SB 1.8151e-17
* device instance cc_XD1_nm_XD3_XN2_mid1 r0 *1 0,0
Ccc_XD1_nm_XD3_XN2_mid1 XD1.nm XD3.XN2.mid1 1.21e-17
* device instance cc_XD1_nm_XD3_XN3_mid1 r0 *1 0,0
Ccc_XD1_nm_XD3_XN3_mid1 XD1.nm XD3.XN3.mid1 1.21e-17
* device instance cc_XD1_nm_XD3_XN3_mid2 r0 *1 0,0
Ccc_XD1_nm_XD3_XN3_mid2 XD1.nm XD3.XN3.mid2 1.21e-17
* device instance cc_XD1_nm_XD3_dmodout r0 *1 0,0
Ccc_XD1_nm_XD3_dmodout XD1.nm XD3.dmodout 1.21e-17
* device instance cc_XD1_nm_XD3_dq r0 *1 0,0
Ccc_XD1_nm_XD3_dq XD1.nm XD3.dq 1.8151e-17
* device instance cc_XD1_nm_XD3_nm r0 *1 0,0
Ccc_XD1_nm_XD3_nm XD1.nm XD3.nm 1.21e-17
* device instance cc_XD1_nm_XD3_nt r0 *1 0,0
Ccc_XD1_nm_XD3_nt XD1.nm XD3.nt 1.21e-17
* device instance cc_XD1_nm_XD3_t1 r0 *1 0,0
Ccc_XD1_nm_XD3_t1 XD1.nm XD3.t1 1.21e-17
* device instance cc_XD1_nm_XD4_XDFFM_CLKB r0 *1 0,0
Ccc_XD1_nm_XD4_XDFFM_CLKB XD1.nm XD4.XDFFM.CLKB 1.8151e-17
* device instance cc_XD1_nm_XD4_XDFFM_M r0 *1 0,0
Ccc_XD1_nm_XD4_XDFFM_M XD1.nm XD4.XDFFM.M 2.4201e-17
* device instance cc_XD1_nm_XD4_XDFFM_MB r0 *1 0,0
Ccc_XD1_nm_XD4_XDFFM_MB XD1.nm XD4.XDFFM.MB 1.21e-17
* device instance cc_XD1_nm_XD4_XDFFM_S r0 *1 0,0
Ccc_XD1_nm_XD4_XDFFM_S XD1.nm XD4.XDFFM.S 1.8151e-17
* device instance cc_XD1_nm_XD4_XDFFM_SB r0 *1 0,0
Ccc_XD1_nm_XD4_XDFFM_SB XD1.nm XD4.XDFFM.SB 1.8151e-17
* device instance cc_XD1_nm_XD4_XDFFQ_CLKB r0 *1 0,0
Ccc_XD1_nm_XD4_XDFFQ_CLKB XD1.nm XD4.XDFFQ.CLKB 1.8151e-17
* device instance cc_XD1_nm_XD4_XDFFQ_M r0 *1 0,0
Ccc_XD1_nm_XD4_XDFFQ_M XD1.nm XD4.XDFFQ.M 2.4201e-17
* device instance cc_XD1_nm_XD4_XDFFQ_MB r0 *1 0,0
Ccc_XD1_nm_XD4_XDFFQ_MB XD1.nm XD4.XDFFQ.MB 1.21e-17
* device instance cc_XD1_nm_XD4_XDFFQ_S r0 *1 0,0
Ccc_XD1_nm_XD4_XDFFQ_S XD1.nm XD4.XDFFQ.S 1.8151e-17
* device instance cc_XD1_nm_XD4_XDFFQ_SB r0 *1 0,0
Ccc_XD1_nm_XD4_XDFFQ_SB XD1.nm XD4.XDFFQ.SB 1.8151e-17
* device instance cc_XD1_nm_XD4_XN2_mid1 r0 *1 0,0
Ccc_XD1_nm_XD4_XN2_mid1 XD1.nm XD4.XN2.mid1 1.21e-17
* device instance cc_XD1_nm_XD4_XN3_mid1 r0 *1 0,0
Ccc_XD1_nm_XD4_XN3_mid1 XD1.nm XD4.XN3.mid1 1.21e-17
* device instance cc_XD1_nm_XD4_XN3_mid2 r0 *1 0,0
Ccc_XD1_nm_XD4_XN3_mid2 XD1.nm XD4.XN3.mid2 1.21e-17
* device instance cc_XD1_nm_XD4_dmodout r0 *1 0,0
Ccc_XD1_nm_XD4_dmodout XD1.nm XD4.dmodout 1.21e-17
* device instance cc_XD1_nm_XD4_dq r0 *1 0,0
Ccc_XD1_nm_XD4_dq XD1.nm XD4.dq 1.8151e-17
* device instance cc_XD1_nm_XD4_nm r0 *1 0,0
Ccc_XD1_nm_XD4_nm XD1.nm XD4.nm 1.21e-17
* device instance cc_XD1_nm_XD4_nt r0 *1 0,0
Ccc_XD1_nm_XD4_nt XD1.nm XD4.nt 1.21e-17
* device instance cc_XD1_nm_XD4_t1 r0 *1 0,0
Ccc_XD1_nm_XD4_t1 XD1.nm XD4.t1 1.21e-17
* device instance cc_XD1_nm_XD5_XDFFM_CLKB r0 *1 0,0
Ccc_XD1_nm_XD5_XDFFM_CLKB XD1.nm XD5.XDFFM.CLKB 1.8151e-17
* device instance cc_XD1_nm_XD5_XDFFM_M r0 *1 0,0
Ccc_XD1_nm_XD5_XDFFM_M XD1.nm XD5.XDFFM.M 2.4201e-17
* device instance cc_XD1_nm_XD5_XDFFM_MB r0 *1 0,0
Ccc_XD1_nm_XD5_XDFFM_MB XD1.nm XD5.XDFFM.MB 1.21e-17
* device instance cc_XD1_nm_XD5_XDFFM_S r0 *1 0,0
Ccc_XD1_nm_XD5_XDFFM_S XD1.nm XD5.XDFFM.S 1.8151e-17
* device instance cc_XD1_nm_XD5_XDFFM_SB r0 *1 0,0
Ccc_XD1_nm_XD5_XDFFM_SB XD1.nm XD5.XDFFM.SB 1.8151e-17
* device instance cc_XD1_nm_XD5_XDFFQ_CLKB r0 *1 0,0
Ccc_XD1_nm_XD5_XDFFQ_CLKB XD1.nm XD5.XDFFQ.CLKB 1.8151e-17
* device instance cc_XD1_nm_XD5_XDFFQ_M r0 *1 0,0
Ccc_XD1_nm_XD5_XDFFQ_M XD1.nm XD5.XDFFQ.M 2.4201e-17
* device instance cc_XD1_nm_XD5_XDFFQ_MB r0 *1 0,0
Ccc_XD1_nm_XD5_XDFFQ_MB XD1.nm XD5.XDFFQ.MB 1.21e-17
* device instance cc_XD1_nm_XD5_XDFFQ_S r0 *1 0,0
Ccc_XD1_nm_XD5_XDFFQ_S XD1.nm XD5.XDFFQ.S 1.8151e-17
* device instance cc_XD1_nm_XD5_XDFFQ_SB r0 *1 0,0
Ccc_XD1_nm_XD5_XDFFQ_SB XD1.nm XD5.XDFFQ.SB 1.8151e-17
* device instance cc_XD1_nm_XD5_XN2_mid1 r0 *1 0,0
Ccc_XD1_nm_XD5_XN2_mid1 XD1.nm XD5.XN2.mid1 1.21e-17
* device instance cc_XD1_nm_XD5_XN3_mid1 r0 *1 0,0
Ccc_XD1_nm_XD5_XN3_mid1 XD1.nm XD5.XN3.mid1 1.21e-17
* device instance cc_XD1_nm_XD5_XN3_mid2 r0 *1 0,0
Ccc_XD1_nm_XD5_XN3_mid2 XD1.nm XD5.XN3.mid2 1.21e-17
* device instance cc_XD1_nm_XD5_dmodout r0 *1 0,0
Ccc_XD1_nm_XD5_dmodout XD1.nm XD5.dmodout 1.21e-17
* device instance cc_XD1_nm_XD5_dq r0 *1 0,0
Ccc_XD1_nm_XD5_dq XD1.nm XD5.dq 1.8151e-17
* device instance cc_XD1_nm_XD5_nm r0 *1 0,0
Ccc_XD1_nm_XD5_nm XD1.nm XD5.nm 1.21e-17
* device instance cc_XD1_nm_XD5_nt r0 *1 0,0
Ccc_XD1_nm_XD5_nt XD1.nm XD5.nt 1.21e-17
* device instance cc_XD1_nm_XD5_t1 r0 *1 0,0
Ccc_XD1_nm_XD5_t1 XD1.nm XD5.t1 1.21e-17
* device instance cc_XD1_nm_XFRT_CLKB r0 *1 0,0
Ccc_XD1_nm_XFRT_CLKB XD1.nm XFRT.CLKB 1.8151e-17
* device instance cc_XD1_nm_XFRT_M r0 *1 0,0
Ccc_XD1_nm_XFRT_M XD1.nm XFRT.M 2.4201e-17
* device instance cc_XD1_nm_XFRT_MB r0 *1 0,0
Ccc_XD1_nm_XFRT_MB XD1.nm XFRT.MB 1.21e-17
* device instance cc_XD1_nm_XFRT_S r0 *1 0,0
Ccc_XD1_nm_XFRT_S XD1.nm XFRT.S 1.8151e-17
* device instance cc_XD1_nm_XFRT_SB r0 *1 0,0
Ccc_XD1_nm_XFRT_SB XD1.nm XFRT.SB 1.8151e-17
* device instance cc_XD1_nm_ck1 r0 *1 0,0
Ccc_XD1_nm_ck1 XD1.nm ck1 5.4452e-17
* device instance cc_XD1_nm_ck2 r0 *1 0,0
Ccc_XD1_nm_ck2 XD1.nm ck2 6.0502e-17
* device instance cc_XD1_nm_ck3 r0 *1 0,0
Ccc_XD1_nm_ck3 XD1.nm ck3 5.4452e-17
* device instance cc_XD1_nm_ck4 r0 *1 0,0
Ccc_XD1_nm_ck4 XD1.nm ck4 5.4452e-17
* device instance cc_XD1_nm_ck5 r0 *1 0,0
Ccc_XD1_nm_ck5 XD1.nm ck5 5.4452e-17
* device instance cc_XD1_nm_mod0 r0 *1 0,0
Ccc_XD1_nm_mod0 XD1.nm mod0 2.4201e-17
* device instance cc_XD1_nm_mod1 r0 *1 0,0
Ccc_XD1_nm_mod1 XD1.nm mod1 2.4201e-17
* device instance cc_XD1_nm_mod2 r0 *1 0,0
Ccc_XD1_nm_mod2 XD1.nm mod2 2.4201e-17
* device instance cc_XD1_nm_mod3 r0 *1 0,0
Ccc_XD1_nm_mod3 XD1.nm mod3 2.4201e-17
* device instance cc_XD1_nm_mod4 r0 *1 0,0
Ccc_XD1_nm_mod4 XD1.nm mod4 2.4201e-17
* device instance cc_XD1_nm_net1 r0 *1 0,0
Ccc_XD1_nm_net1 XD1.nm net1 1.21e-17
* device instance cc_XD1_nt_XD1_t1 r0 *1 0,0
Ccc_XD1_nt_XD1_t1 XD1.nt XD1.t1 1.21e-17
* device instance cc_XD1_nt_XD2_XDFFM_CLKB r0 *1 0,0
Ccc_XD1_nt_XD2_XDFFM_CLKB XD1.nt XD2.XDFFM.CLKB 1.8151e-17
* device instance cc_XD1_nt_XD2_XDFFM_M r0 *1 0,0
Ccc_XD1_nt_XD2_XDFFM_M XD1.nt XD2.XDFFM.M 2.4201e-17
* device instance cc_XD1_nt_XD2_XDFFM_MB r0 *1 0,0
Ccc_XD1_nt_XD2_XDFFM_MB XD1.nt XD2.XDFFM.MB 1.21e-17
* device instance cc_XD1_nt_XD2_XDFFM_S r0 *1 0,0
Ccc_XD1_nt_XD2_XDFFM_S XD1.nt XD2.XDFFM.S 1.8151e-17
* device instance cc_XD1_nt_XD2_XDFFM_SB r0 *1 0,0
Ccc_XD1_nt_XD2_XDFFM_SB XD1.nt XD2.XDFFM.SB 1.8151e-17
* device instance cc_XD1_nt_XD2_XDFFQ_CLKB r0 *1 0,0
Ccc_XD1_nt_XD2_XDFFQ_CLKB XD1.nt XD2.XDFFQ.CLKB 1.8151e-17
* device instance cc_XD1_nt_XD2_XDFFQ_M r0 *1 0,0
Ccc_XD1_nt_XD2_XDFFQ_M XD1.nt XD2.XDFFQ.M 2.4201e-17
* device instance cc_XD1_nt_XD2_XDFFQ_MB r0 *1 0,0
Ccc_XD1_nt_XD2_XDFFQ_MB XD1.nt XD2.XDFFQ.MB 1.21e-17
* device instance cc_XD1_nt_XD2_XDFFQ_S r0 *1 0,0
Ccc_XD1_nt_XD2_XDFFQ_S XD1.nt XD2.XDFFQ.S 1.8151e-17
* device instance cc_XD1_nt_XD2_XDFFQ_SB r0 *1 0,0
Ccc_XD1_nt_XD2_XDFFQ_SB XD1.nt XD2.XDFFQ.SB 1.8151e-17
* device instance cc_XD1_nt_XD2_XN2_mid1 r0 *1 0,0
Ccc_XD1_nt_XD2_XN2_mid1 XD1.nt XD2.XN2.mid1 1.21e-17
* device instance cc_XD1_nt_XD2_XN3_mid1 r0 *1 0,0
Ccc_XD1_nt_XD2_XN3_mid1 XD1.nt XD2.XN3.mid1 1.21e-17
* device instance cc_XD1_nt_XD2_XN3_mid2 r0 *1 0,0
Ccc_XD1_nt_XD2_XN3_mid2 XD1.nt XD2.XN3.mid2 1.21e-17
* device instance cc_XD1_nt_XD2_dmodout r0 *1 0,0
Ccc_XD1_nt_XD2_dmodout XD1.nt XD2.dmodout 1.21e-17
* device instance cc_XD1_nt_XD2_dq r0 *1 0,0
Ccc_XD1_nt_XD2_dq XD1.nt XD2.dq 1.8151e-17
* device instance cc_XD1_nt_XD2_nm r0 *1 0,0
Ccc_XD1_nt_XD2_nm XD1.nt XD2.nm 1.21e-17
* device instance cc_XD1_nt_XD2_nt r0 *1 0,0
Ccc_XD1_nt_XD2_nt XD1.nt XD2.nt 1.21e-17
* device instance cc_XD1_nt_XD2_t1 r0 *1 0,0
Ccc_XD1_nt_XD2_t1 XD1.nt XD2.t1 1.21e-17
* device instance cc_XD1_nt_XD3_XDFFM_CLKB r0 *1 0,0
Ccc_XD1_nt_XD3_XDFFM_CLKB XD1.nt XD3.XDFFM.CLKB 1.8151e-17
* device instance cc_XD1_nt_XD3_XDFFM_M r0 *1 0,0
Ccc_XD1_nt_XD3_XDFFM_M XD1.nt XD3.XDFFM.M 2.4201e-17
* device instance cc_XD1_nt_XD3_XDFFM_MB r0 *1 0,0
Ccc_XD1_nt_XD3_XDFFM_MB XD1.nt XD3.XDFFM.MB 1.21e-17
* device instance cc_XD1_nt_XD3_XDFFM_S r0 *1 0,0
Ccc_XD1_nt_XD3_XDFFM_S XD1.nt XD3.XDFFM.S 1.8151e-17
* device instance cc_XD1_nt_XD3_XDFFM_SB r0 *1 0,0
Ccc_XD1_nt_XD3_XDFFM_SB XD1.nt XD3.XDFFM.SB 1.8151e-17
* device instance cc_XD1_nt_XD3_XDFFQ_CLKB r0 *1 0,0
Ccc_XD1_nt_XD3_XDFFQ_CLKB XD1.nt XD3.XDFFQ.CLKB 1.8151e-17
* device instance cc_XD1_nt_XD3_XDFFQ_M r0 *1 0,0
Ccc_XD1_nt_XD3_XDFFQ_M XD1.nt XD3.XDFFQ.M 2.4201e-17
* device instance cc_XD1_nt_XD3_XDFFQ_MB r0 *1 0,0
Ccc_XD1_nt_XD3_XDFFQ_MB XD1.nt XD3.XDFFQ.MB 1.21e-17
* device instance cc_XD1_nt_XD3_XDFFQ_S r0 *1 0,0
Ccc_XD1_nt_XD3_XDFFQ_S XD1.nt XD3.XDFFQ.S 1.8151e-17
* device instance cc_XD1_nt_XD3_XDFFQ_SB r0 *1 0,0
Ccc_XD1_nt_XD3_XDFFQ_SB XD1.nt XD3.XDFFQ.SB 1.8151e-17
* device instance cc_XD1_nt_XD3_XN2_mid1 r0 *1 0,0
Ccc_XD1_nt_XD3_XN2_mid1 XD1.nt XD3.XN2.mid1 1.21e-17
* device instance cc_XD1_nt_XD3_XN3_mid1 r0 *1 0,0
Ccc_XD1_nt_XD3_XN3_mid1 XD1.nt XD3.XN3.mid1 1.21e-17
* device instance cc_XD1_nt_XD3_XN3_mid2 r0 *1 0,0
Ccc_XD1_nt_XD3_XN3_mid2 XD1.nt XD3.XN3.mid2 1.21e-17
* device instance cc_XD1_nt_XD3_dmodout r0 *1 0,0
Ccc_XD1_nt_XD3_dmodout XD1.nt XD3.dmodout 1.21e-17
* device instance cc_XD1_nt_XD3_dq r0 *1 0,0
Ccc_XD1_nt_XD3_dq XD1.nt XD3.dq 1.8151e-17
* device instance cc_XD1_nt_XD3_nm r0 *1 0,0
Ccc_XD1_nt_XD3_nm XD1.nt XD3.nm 1.21e-17
* device instance cc_XD1_nt_XD3_nt r0 *1 0,0
Ccc_XD1_nt_XD3_nt XD1.nt XD3.nt 1.21e-17
* device instance cc_XD1_nt_XD3_t1 r0 *1 0,0
Ccc_XD1_nt_XD3_t1 XD1.nt XD3.t1 1.21e-17
* device instance cc_XD1_nt_XD4_XDFFM_CLKB r0 *1 0,0
Ccc_XD1_nt_XD4_XDFFM_CLKB XD1.nt XD4.XDFFM.CLKB 1.8151e-17
* device instance cc_XD1_nt_XD4_XDFFM_M r0 *1 0,0
Ccc_XD1_nt_XD4_XDFFM_M XD1.nt XD4.XDFFM.M 2.4201e-17
* device instance cc_XD1_nt_XD4_XDFFM_MB r0 *1 0,0
Ccc_XD1_nt_XD4_XDFFM_MB XD1.nt XD4.XDFFM.MB 1.21e-17
* device instance cc_XD1_nt_XD4_XDFFM_S r0 *1 0,0
Ccc_XD1_nt_XD4_XDFFM_S XD1.nt XD4.XDFFM.S 1.8151e-17
* device instance cc_XD1_nt_XD4_XDFFM_SB r0 *1 0,0
Ccc_XD1_nt_XD4_XDFFM_SB XD1.nt XD4.XDFFM.SB 1.8151e-17
* device instance cc_XD1_nt_XD4_XDFFQ_CLKB r0 *1 0,0
Ccc_XD1_nt_XD4_XDFFQ_CLKB XD1.nt XD4.XDFFQ.CLKB 1.8151e-17
* device instance cc_XD1_nt_XD4_XDFFQ_M r0 *1 0,0
Ccc_XD1_nt_XD4_XDFFQ_M XD1.nt XD4.XDFFQ.M 2.4201e-17
* device instance cc_XD1_nt_XD4_XDFFQ_MB r0 *1 0,0
Ccc_XD1_nt_XD4_XDFFQ_MB XD1.nt XD4.XDFFQ.MB 1.21e-17
* device instance cc_XD1_nt_XD4_XDFFQ_S r0 *1 0,0
Ccc_XD1_nt_XD4_XDFFQ_S XD1.nt XD4.XDFFQ.S 1.8151e-17
* device instance cc_XD1_nt_XD4_XDFFQ_SB r0 *1 0,0
Ccc_XD1_nt_XD4_XDFFQ_SB XD1.nt XD4.XDFFQ.SB 1.8151e-17
* device instance cc_XD1_nt_XD4_XN2_mid1 r0 *1 0,0
Ccc_XD1_nt_XD4_XN2_mid1 XD1.nt XD4.XN2.mid1 1.21e-17
* device instance cc_XD1_nt_XD4_XN3_mid1 r0 *1 0,0
Ccc_XD1_nt_XD4_XN3_mid1 XD1.nt XD4.XN3.mid1 1.21e-17
* device instance cc_XD1_nt_XD4_XN3_mid2 r0 *1 0,0
Ccc_XD1_nt_XD4_XN3_mid2 XD1.nt XD4.XN3.mid2 1.21e-17
* device instance cc_XD1_nt_XD4_dmodout r0 *1 0,0
Ccc_XD1_nt_XD4_dmodout XD1.nt XD4.dmodout 1.21e-17
* device instance cc_XD1_nt_XD4_dq r0 *1 0,0
Ccc_XD1_nt_XD4_dq XD1.nt XD4.dq 1.8151e-17
* device instance cc_XD1_nt_XD4_nm r0 *1 0,0
Ccc_XD1_nt_XD4_nm XD1.nt XD4.nm 1.21e-17
* device instance cc_XD1_nt_XD4_nt r0 *1 0,0
Ccc_XD1_nt_XD4_nt XD1.nt XD4.nt 1.21e-17
* device instance cc_XD1_nt_XD4_t1 r0 *1 0,0
Ccc_XD1_nt_XD4_t1 XD1.nt XD4.t1 1.21e-17
* device instance cc_XD1_nt_XD5_XDFFM_CLKB r0 *1 0,0
Ccc_XD1_nt_XD5_XDFFM_CLKB XD1.nt XD5.XDFFM.CLKB 1.8151e-17
* device instance cc_XD1_nt_XD5_XDFFM_M r0 *1 0,0
Ccc_XD1_nt_XD5_XDFFM_M XD1.nt XD5.XDFFM.M 2.4201e-17
* device instance cc_XD1_nt_XD5_XDFFM_MB r0 *1 0,0
Ccc_XD1_nt_XD5_XDFFM_MB XD1.nt XD5.XDFFM.MB 1.21e-17
* device instance cc_XD1_nt_XD5_XDFFM_S r0 *1 0,0
Ccc_XD1_nt_XD5_XDFFM_S XD1.nt XD5.XDFFM.S 1.8151e-17
* device instance cc_XD1_nt_XD5_XDFFM_SB r0 *1 0,0
Ccc_XD1_nt_XD5_XDFFM_SB XD1.nt XD5.XDFFM.SB 1.8151e-17
* device instance cc_XD1_nt_XD5_XDFFQ_CLKB r0 *1 0,0
Ccc_XD1_nt_XD5_XDFFQ_CLKB XD1.nt XD5.XDFFQ.CLKB 1.8151e-17
* device instance cc_XD1_nt_XD5_XDFFQ_M r0 *1 0,0
Ccc_XD1_nt_XD5_XDFFQ_M XD1.nt XD5.XDFFQ.M 2.4201e-17
* device instance cc_XD1_nt_XD5_XDFFQ_MB r0 *1 0,0
Ccc_XD1_nt_XD5_XDFFQ_MB XD1.nt XD5.XDFFQ.MB 1.21e-17
* device instance cc_XD1_nt_XD5_XDFFQ_S r0 *1 0,0
Ccc_XD1_nt_XD5_XDFFQ_S XD1.nt XD5.XDFFQ.S 1.8151e-17
* device instance cc_XD1_nt_XD5_XDFFQ_SB r0 *1 0,0
Ccc_XD1_nt_XD5_XDFFQ_SB XD1.nt XD5.XDFFQ.SB 1.8151e-17
* device instance cc_XD1_nt_XD5_XN2_mid1 r0 *1 0,0
Ccc_XD1_nt_XD5_XN2_mid1 XD1.nt XD5.XN2.mid1 1.21e-17
* device instance cc_XD1_nt_XD5_XN3_mid1 r0 *1 0,0
Ccc_XD1_nt_XD5_XN3_mid1 XD1.nt XD5.XN3.mid1 1.21e-17
* device instance cc_XD1_nt_XD5_XN3_mid2 r0 *1 0,0
Ccc_XD1_nt_XD5_XN3_mid2 XD1.nt XD5.XN3.mid2 1.21e-17
* device instance cc_XD1_nt_XD5_dmodout r0 *1 0,0
Ccc_XD1_nt_XD5_dmodout XD1.nt XD5.dmodout 1.21e-17
* device instance cc_XD1_nt_XD5_dq r0 *1 0,0
Ccc_XD1_nt_XD5_dq XD1.nt XD5.dq 1.8151e-17
* device instance cc_XD1_nt_XD5_nm r0 *1 0,0
Ccc_XD1_nt_XD5_nm XD1.nt XD5.nm 1.21e-17
* device instance cc_XD1_nt_XD5_nt r0 *1 0,0
Ccc_XD1_nt_XD5_nt XD1.nt XD5.nt 1.21e-17
* device instance cc_XD1_nt_XD5_t1 r0 *1 0,0
Ccc_XD1_nt_XD5_t1 XD1.nt XD5.t1 1.21e-17
* device instance cc_XD1_nt_XFRT_CLKB r0 *1 0,0
Ccc_XD1_nt_XFRT_CLKB XD1.nt XFRT.CLKB 1.8151e-17
* device instance cc_XD1_nt_XFRT_M r0 *1 0,0
Ccc_XD1_nt_XFRT_M XD1.nt XFRT.M 2.4201e-17
* device instance cc_XD1_nt_XFRT_MB r0 *1 0,0
Ccc_XD1_nt_XFRT_MB XD1.nt XFRT.MB 1.21e-17
* device instance cc_XD1_nt_XFRT_S r0 *1 0,0
Ccc_XD1_nt_XFRT_S XD1.nt XFRT.S 1.8151e-17
* device instance cc_XD1_nt_XFRT_SB r0 *1 0,0
Ccc_XD1_nt_XFRT_SB XD1.nt XFRT.SB 1.8151e-17
* device instance cc_XD1_nt_ck1 r0 *1 0,0
Ccc_XD1_nt_ck1 XD1.nt ck1 5.4452e-17
* device instance cc_XD1_nt_ck2 r0 *1 0,0
Ccc_XD1_nt_ck2 XD1.nt ck2 5.4452e-17
* device instance cc_XD1_nt_ck3 r0 *1 0,0
Ccc_XD1_nt_ck3 XD1.nt ck3 5.4452e-17
* device instance cc_XD1_nt_ck4 r0 *1 0,0
Ccc_XD1_nt_ck4 XD1.nt ck4 5.4452e-17
* device instance cc_XD1_nt_ck5 r0 *1 0,0
Ccc_XD1_nt_ck5 XD1.nt ck5 5.4452e-17
* device instance cc_XD1_nt_mod0 r0 *1 0,0
Ccc_XD1_nt_mod0 XD1.nt mod0 3.0251e-17
* device instance cc_XD1_nt_mod1 r0 *1 0,0
Ccc_XD1_nt_mod1 XD1.nt mod1 2.4201e-17
* device instance cc_XD1_nt_mod2 r0 *1 0,0
Ccc_XD1_nt_mod2 XD1.nt mod2 2.4201e-17
* device instance cc_XD1_nt_mod3 r0 *1 0,0
Ccc_XD1_nt_mod3 XD1.nt mod3 2.4201e-17
* device instance cc_XD1_nt_mod4 r0 *1 0,0
Ccc_XD1_nt_mod4 XD1.nt mod4 2.4201e-17
* device instance cc_XD1_nt_net1 r0 *1 0,0
Ccc_XD1_nt_net1 XD1.nt net1 1.21e-17
* device instance cc_XD1_t1_XD2_XDFFM_CLKB r0 *1 0,0
Ccc_XD1_t1_XD2_XDFFM_CLKB XD1.t1 XD2.XDFFM.CLKB 1.8151e-17
* device instance cc_XD1_t1_XD2_XDFFM_M r0 *1 0,0
Ccc_XD1_t1_XD2_XDFFM_M XD1.t1 XD2.XDFFM.M 2.4201e-17
* device instance cc_XD1_t1_XD2_XDFFM_MB r0 *1 0,0
Ccc_XD1_t1_XD2_XDFFM_MB XD1.t1 XD2.XDFFM.MB 1.21e-17
* device instance cc_XD1_t1_XD2_XDFFM_S r0 *1 0,0
Ccc_XD1_t1_XD2_XDFFM_S XD1.t1 XD2.XDFFM.S 1.8151e-17
* device instance cc_XD1_t1_XD2_XDFFM_SB r0 *1 0,0
Ccc_XD1_t1_XD2_XDFFM_SB XD1.t1 XD2.XDFFM.SB 1.8151e-17
* device instance cc_XD1_t1_XD2_XDFFQ_CLKB r0 *1 0,0
Ccc_XD1_t1_XD2_XDFFQ_CLKB XD1.t1 XD2.XDFFQ.CLKB 1.8151e-17
* device instance cc_XD1_t1_XD2_XDFFQ_M r0 *1 0,0
Ccc_XD1_t1_XD2_XDFFQ_M XD1.t1 XD2.XDFFQ.M 2.4201e-17
* device instance cc_XD1_t1_XD2_XDFFQ_MB r0 *1 0,0
Ccc_XD1_t1_XD2_XDFFQ_MB XD1.t1 XD2.XDFFQ.MB 1.21e-17
* device instance cc_XD1_t1_XD2_XDFFQ_S r0 *1 0,0
Ccc_XD1_t1_XD2_XDFFQ_S XD1.t1 XD2.XDFFQ.S 1.8151e-17
* device instance cc_XD1_t1_XD2_XDFFQ_SB r0 *1 0,0
Ccc_XD1_t1_XD2_XDFFQ_SB XD1.t1 XD2.XDFFQ.SB 1.8151e-17
* device instance cc_XD1_t1_XD2_XN2_mid1 r0 *1 0,0
Ccc_XD1_t1_XD2_XN2_mid1 XD1.t1 XD2.XN2.mid1 1.21e-17
* device instance cc_XD1_t1_XD2_XN3_mid1 r0 *1 0,0
Ccc_XD1_t1_XD2_XN3_mid1 XD1.t1 XD2.XN3.mid1 1.21e-17
* device instance cc_XD1_t1_XD2_XN3_mid2 r0 *1 0,0
Ccc_XD1_t1_XD2_XN3_mid2 XD1.t1 XD2.XN3.mid2 1.21e-17
* device instance cc_XD1_t1_XD2_dmodout r0 *1 0,0
Ccc_XD1_t1_XD2_dmodout XD1.t1 XD2.dmodout 1.21e-17
* device instance cc_XD1_t1_XD2_dq r0 *1 0,0
Ccc_XD1_t1_XD2_dq XD1.t1 XD2.dq 1.8151e-17
* device instance cc_XD1_t1_XD2_nm r0 *1 0,0
Ccc_XD1_t1_XD2_nm XD1.t1 XD2.nm 1.21e-17
* device instance cc_XD1_t1_XD2_nt r0 *1 0,0
Ccc_XD1_t1_XD2_nt XD1.t1 XD2.nt 1.21e-17
* device instance cc_XD1_t1_XD2_t1 r0 *1 0,0
Ccc_XD1_t1_XD2_t1 XD1.t1 XD2.t1 1.21e-17
* device instance cc_XD1_t1_XD3_XDFFM_CLKB r0 *1 0,0
Ccc_XD1_t1_XD3_XDFFM_CLKB XD1.t1 XD3.XDFFM.CLKB 1.8151e-17
* device instance cc_XD1_t1_XD3_XDFFM_M r0 *1 0,0
Ccc_XD1_t1_XD3_XDFFM_M XD1.t1 XD3.XDFFM.M 2.4201e-17
* device instance cc_XD1_t1_XD3_XDFFM_MB r0 *1 0,0
Ccc_XD1_t1_XD3_XDFFM_MB XD1.t1 XD3.XDFFM.MB 1.21e-17
* device instance cc_XD1_t1_XD3_XDFFM_S r0 *1 0,0
Ccc_XD1_t1_XD3_XDFFM_S XD1.t1 XD3.XDFFM.S 1.8151e-17
* device instance cc_XD1_t1_XD3_XDFFM_SB r0 *1 0,0
Ccc_XD1_t1_XD3_XDFFM_SB XD1.t1 XD3.XDFFM.SB 1.8151e-17
* device instance cc_XD1_t1_XD3_XDFFQ_CLKB r0 *1 0,0
Ccc_XD1_t1_XD3_XDFFQ_CLKB XD1.t1 XD3.XDFFQ.CLKB 1.8151e-17
* device instance cc_XD1_t1_XD3_XDFFQ_M r0 *1 0,0
Ccc_XD1_t1_XD3_XDFFQ_M XD1.t1 XD3.XDFFQ.M 2.4201e-17
* device instance cc_XD1_t1_XD3_XDFFQ_MB r0 *1 0,0
Ccc_XD1_t1_XD3_XDFFQ_MB XD1.t1 XD3.XDFFQ.MB 1.21e-17
* device instance cc_XD1_t1_XD3_XDFFQ_S r0 *1 0,0
Ccc_XD1_t1_XD3_XDFFQ_S XD1.t1 XD3.XDFFQ.S 1.8151e-17
* device instance cc_XD1_t1_XD3_XDFFQ_SB r0 *1 0,0
Ccc_XD1_t1_XD3_XDFFQ_SB XD1.t1 XD3.XDFFQ.SB 1.8151e-17
* device instance cc_XD1_t1_XD3_XN2_mid1 r0 *1 0,0
Ccc_XD1_t1_XD3_XN2_mid1 XD1.t1 XD3.XN2.mid1 1.21e-17
* device instance cc_XD1_t1_XD3_XN3_mid1 r0 *1 0,0
Ccc_XD1_t1_XD3_XN3_mid1 XD1.t1 XD3.XN3.mid1 1.21e-17
* device instance cc_XD1_t1_XD3_XN3_mid2 r0 *1 0,0
Ccc_XD1_t1_XD3_XN3_mid2 XD1.t1 XD3.XN3.mid2 1.21e-17
* device instance cc_XD1_t1_XD3_dmodout r0 *1 0,0
Ccc_XD1_t1_XD3_dmodout XD1.t1 XD3.dmodout 1.21e-17
* device instance cc_XD1_t1_XD3_dq r0 *1 0,0
Ccc_XD1_t1_XD3_dq XD1.t1 XD3.dq 1.8151e-17
* device instance cc_XD1_t1_XD3_nm r0 *1 0,0
Ccc_XD1_t1_XD3_nm XD1.t1 XD3.nm 1.21e-17
* device instance cc_XD1_t1_XD3_nt r0 *1 0,0
Ccc_XD1_t1_XD3_nt XD1.t1 XD3.nt 1.21e-17
* device instance cc_XD1_t1_XD3_t1 r0 *1 0,0
Ccc_XD1_t1_XD3_t1 XD1.t1 XD3.t1 1.21e-17
* device instance cc_XD1_t1_XD4_XDFFM_CLKB r0 *1 0,0
Ccc_XD1_t1_XD4_XDFFM_CLKB XD1.t1 XD4.XDFFM.CLKB 1.8151e-17
* device instance cc_XD1_t1_XD4_XDFFM_M r0 *1 0,0
Ccc_XD1_t1_XD4_XDFFM_M XD1.t1 XD4.XDFFM.M 2.4201e-17
* device instance cc_XD1_t1_XD4_XDFFM_MB r0 *1 0,0
Ccc_XD1_t1_XD4_XDFFM_MB XD1.t1 XD4.XDFFM.MB 1.21e-17
* device instance cc_XD1_t1_XD4_XDFFM_S r0 *1 0,0
Ccc_XD1_t1_XD4_XDFFM_S XD1.t1 XD4.XDFFM.S 1.8151e-17
* device instance cc_XD1_t1_XD4_XDFFM_SB r0 *1 0,0
Ccc_XD1_t1_XD4_XDFFM_SB XD1.t1 XD4.XDFFM.SB 1.8151e-17
* device instance cc_XD1_t1_XD4_XDFFQ_CLKB r0 *1 0,0
Ccc_XD1_t1_XD4_XDFFQ_CLKB XD1.t1 XD4.XDFFQ.CLKB 1.8151e-17
* device instance cc_XD1_t1_XD4_XDFFQ_M r0 *1 0,0
Ccc_XD1_t1_XD4_XDFFQ_M XD1.t1 XD4.XDFFQ.M 2.4201e-17
* device instance cc_XD1_t1_XD4_XDFFQ_MB r0 *1 0,0
Ccc_XD1_t1_XD4_XDFFQ_MB XD1.t1 XD4.XDFFQ.MB 1.21e-17
* device instance cc_XD1_t1_XD4_XDFFQ_S r0 *1 0,0
Ccc_XD1_t1_XD4_XDFFQ_S XD1.t1 XD4.XDFFQ.S 1.8151e-17
* device instance cc_XD1_t1_XD4_XDFFQ_SB r0 *1 0,0
Ccc_XD1_t1_XD4_XDFFQ_SB XD1.t1 XD4.XDFFQ.SB 1.8151e-17
* device instance cc_XD1_t1_XD4_XN2_mid1 r0 *1 0,0
Ccc_XD1_t1_XD4_XN2_mid1 XD1.t1 XD4.XN2.mid1 1.21e-17
* device instance cc_XD1_t1_XD4_XN3_mid1 r0 *1 0,0
Ccc_XD1_t1_XD4_XN3_mid1 XD1.t1 XD4.XN3.mid1 1.21e-17
* device instance cc_XD1_t1_XD4_XN3_mid2 r0 *1 0,0
Ccc_XD1_t1_XD4_XN3_mid2 XD1.t1 XD4.XN3.mid2 1.21e-17
* device instance cc_XD1_t1_XD4_dmodout r0 *1 0,0
Ccc_XD1_t1_XD4_dmodout XD1.t1 XD4.dmodout 1.21e-17
* device instance cc_XD1_t1_XD4_dq r0 *1 0,0
Ccc_XD1_t1_XD4_dq XD1.t1 XD4.dq 1.8151e-17
* device instance cc_XD1_t1_XD4_nm r0 *1 0,0
Ccc_XD1_t1_XD4_nm XD1.t1 XD4.nm 1.21e-17
* device instance cc_XD1_t1_XD4_nt r0 *1 0,0
Ccc_XD1_t1_XD4_nt XD1.t1 XD4.nt 1.21e-17
* device instance cc_XD1_t1_XD4_t1 r0 *1 0,0
Ccc_XD1_t1_XD4_t1 XD1.t1 XD4.t1 1.21e-17
* device instance cc_XD1_t1_XD5_XDFFM_CLKB r0 *1 0,0
Ccc_XD1_t1_XD5_XDFFM_CLKB XD1.t1 XD5.XDFFM.CLKB 1.8151e-17
* device instance cc_XD1_t1_XD5_XDFFM_M r0 *1 0,0
Ccc_XD1_t1_XD5_XDFFM_M XD1.t1 XD5.XDFFM.M 2.4201e-17
* device instance cc_XD1_t1_XD5_XDFFM_MB r0 *1 0,0
Ccc_XD1_t1_XD5_XDFFM_MB XD1.t1 XD5.XDFFM.MB 1.21e-17
* device instance cc_XD1_t1_XD5_XDFFM_S r0 *1 0,0
Ccc_XD1_t1_XD5_XDFFM_S XD1.t1 XD5.XDFFM.S 1.8151e-17
* device instance cc_XD1_t1_XD5_XDFFM_SB r0 *1 0,0
Ccc_XD1_t1_XD5_XDFFM_SB XD1.t1 XD5.XDFFM.SB 1.8151e-17
* device instance cc_XD1_t1_XD5_XDFFQ_CLKB r0 *1 0,0
Ccc_XD1_t1_XD5_XDFFQ_CLKB XD1.t1 XD5.XDFFQ.CLKB 1.8151e-17
* device instance cc_XD1_t1_XD5_XDFFQ_M r0 *1 0,0
Ccc_XD1_t1_XD5_XDFFQ_M XD1.t1 XD5.XDFFQ.M 2.4201e-17
* device instance cc_XD1_t1_XD5_XDFFQ_MB r0 *1 0,0
Ccc_XD1_t1_XD5_XDFFQ_MB XD1.t1 XD5.XDFFQ.MB 1.21e-17
* device instance cc_XD1_t1_XD5_XDFFQ_S r0 *1 0,0
Ccc_XD1_t1_XD5_XDFFQ_S XD1.t1 XD5.XDFFQ.S 1.8151e-17
* device instance cc_XD1_t1_XD5_XDFFQ_SB r0 *1 0,0
Ccc_XD1_t1_XD5_XDFFQ_SB XD1.t1 XD5.XDFFQ.SB 1.8151e-17
* device instance cc_XD1_t1_XD5_XN2_mid1 r0 *1 0,0
Ccc_XD1_t1_XD5_XN2_mid1 XD1.t1 XD5.XN2.mid1 1.21e-17
* device instance cc_XD1_t1_XD5_XN3_mid1 r0 *1 0,0
Ccc_XD1_t1_XD5_XN3_mid1 XD1.t1 XD5.XN3.mid1 1.21e-17
* device instance cc_XD1_t1_XD5_XN3_mid2 r0 *1 0,0
Ccc_XD1_t1_XD5_XN3_mid2 XD1.t1 XD5.XN3.mid2 1.21e-17
* device instance cc_XD1_t1_XD5_dmodout r0 *1 0,0
Ccc_XD1_t1_XD5_dmodout XD1.t1 XD5.dmodout 1.21e-17
* device instance cc_XD1_t1_XD5_dq r0 *1 0,0
Ccc_XD1_t1_XD5_dq XD1.t1 XD5.dq 1.8151e-17
* device instance cc_XD1_t1_XD5_nm r0 *1 0,0
Ccc_XD1_t1_XD5_nm XD1.t1 XD5.nm 1.21e-17
* device instance cc_XD1_t1_XD5_nt r0 *1 0,0
Ccc_XD1_t1_XD5_nt XD1.t1 XD5.nt 1.21e-17
* device instance cc_XD1_t1_XD5_t1 r0 *1 0,0
Ccc_XD1_t1_XD5_t1 XD1.t1 XD5.t1 1.21e-17
* device instance cc_XD1_t1_XFRT_CLKB r0 *1 0,0
Ccc_XD1_t1_XFRT_CLKB XD1.t1 XFRT.CLKB 1.8151e-17
* device instance cc_XD1_t1_XFRT_M r0 *1 0,0
Ccc_XD1_t1_XFRT_M XD1.t1 XFRT.M 2.4201e-17
* device instance cc_XD1_t1_XFRT_MB r0 *1 0,0
Ccc_XD1_t1_XFRT_MB XD1.t1 XFRT.MB 1.21e-17
* device instance cc_XD1_t1_XFRT_S r0 *1 0,0
Ccc_XD1_t1_XFRT_S XD1.t1 XFRT.S 1.8151e-17
* device instance cc_XD1_t1_XFRT_SB r0 *1 0,0
Ccc_XD1_t1_XFRT_SB XD1.t1 XFRT.SB 1.8151e-17
* device instance cc_XD1_t1_ck1 r0 *1 0,0
Ccc_XD1_t1_ck1 XD1.t1 ck1 5.4452e-17
* device instance cc_XD1_t1_ck2 r0 *1 0,0
Ccc_XD1_t1_ck2 XD1.t1 ck2 6.0502e-17
* device instance cc_XD1_t1_ck3 r0 *1 0,0
Ccc_XD1_t1_ck3 XD1.t1 ck3 5.4452e-17
* device instance cc_XD1_t1_ck4 r0 *1 0,0
Ccc_XD1_t1_ck4 XD1.t1 ck4 5.4452e-17
* device instance cc_XD1_t1_ck5 r0 *1 0,0
Ccc_XD1_t1_ck5 XD1.t1 ck5 5.4452e-17
* device instance cc_XD1_t1_mod0 r0 *1 0,0
Ccc_XD1_t1_mod0 XD1.t1 mod0 2.4201e-17
* device instance cc_XD1_t1_mod1 r0 *1 0,0
Ccc_XD1_t1_mod1 XD1.t1 mod1 2.4201e-17
* device instance cc_XD1_t1_mod2 r0 *1 0,0
Ccc_XD1_t1_mod2 XD1.t1 mod2 2.4201e-17
* device instance cc_XD1_t1_mod3 r0 *1 0,0
Ccc_XD1_t1_mod3 XD1.t1 mod3 2.4201e-17
* device instance cc_XD1_t1_mod4 r0 *1 0,0
Ccc_XD1_t1_mod4 XD1.t1 mod4 2.4201e-17
* device instance cc_XD1_t1_net1 r0 *1 0,0
Ccc_XD1_t1_net1 XD1.t1 net1 1.21e-17
* device instance cc_XD2_XDFFM_CLKB_XD2_XDFFM_M r0 *1 0,0
Ccc_XD2_XDFFM_CLKB_XD2_XDFFM_M XD2.XDFFM.CLKB XD2.XDFFM.M 4.2352e-17
* device instance cc_XD2_XDFFM_CLKB_XD2_XDFFM_MB r0 *1 0,0
Ccc_XD2_XDFFM_CLKB_XD2_XDFFM_MB XD2.XDFFM.CLKB XD2.XDFFM.MB 2.4201e-17
* device instance cc_XD2_XDFFM_CLKB_XD2_XDFFM_S r0 *1 0,0
Ccc_XD2_XDFFM_CLKB_XD2_XDFFM_S XD2.XDFFM.CLKB XD2.XDFFM.S 1.8151e-17
* device instance cc_XD2_XDFFM_CLKB_XD2_XDFFM_SB r0 *1 0,0
Ccc_XD2_XDFFM_CLKB_XD2_XDFFM_SB XD2.XDFFM.CLKB XD2.XDFFM.SB 1.8151e-17
* device instance cc_XD2_XDFFM_CLKB_XD2_XDFFQ_CLKB r0 *1 0,0
Ccc_XD2_XDFFM_CLKB_XD2_XDFFQ_CLKB XD2.XDFFM.CLKB XD2.XDFFQ.CLKB 1.8151e-17
* device instance cc_XD2_XDFFM_CLKB_XD2_XDFFQ_M r0 *1 0,0
Ccc_XD2_XDFFM_CLKB_XD2_XDFFQ_M XD2.XDFFM.CLKB XD2.XDFFQ.M 2.4201e-17
* device instance cc_XD2_XDFFM_CLKB_XD2_XDFFQ_MB r0 *1 0,0
Ccc_XD2_XDFFM_CLKB_XD2_XDFFQ_MB XD2.XDFFM.CLKB XD2.XDFFQ.MB 1.21e-17
* device instance cc_XD2_XDFFM_CLKB_XD2_XDFFQ_S r0 *1 0,0
Ccc_XD2_XDFFM_CLKB_XD2_XDFFQ_S XD2.XDFFM.CLKB XD2.XDFFQ.S 1.8151e-17
* device instance cc_XD2_XDFFM_CLKB_XD2_XDFFQ_SB r0 *1 0,0
Ccc_XD2_XDFFM_CLKB_XD2_XDFFQ_SB XD2.XDFFM.CLKB XD2.XDFFQ.SB 1.8151e-17
* device instance cc_XD2_XDFFM_CLKB_XD2_XNOR_midp r0 *1 0,0
Ccc_XD2_XDFFM_CLKB_XD2_XNOR_midp XD2.XDFFM.CLKB XD2.XNOR.midp 1.21e-17
* device instance cc_XD2_XDFFM_CLKB_XD2_dmodout r0 *1 0,0
Ccc_XD2_XDFFM_CLKB_XD2_dmodout XD2.XDFFM.CLKB XD2.dmodout 1.8151e-17
* device instance cc_XD2_XDFFM_CLKB_XD2_dq r0 *1 0,0
Ccc_XD2_XDFFM_CLKB_XD2_dq XD2.XDFFM.CLKB XD2.dq 1.21e-17
* device instance cc_XD2_XDFFM_CLKB_XD2_nm r0 *1 0,0
Ccc_XD2_XDFFM_CLKB_XD2_nm XD2.XDFFM.CLKB XD2.nm 1.8151e-17
* device instance cc_XD2_XDFFM_CLKB_XD2_nt r0 *1 0,0
Ccc_XD2_XDFFM_CLKB_XD2_nt XD2.XDFFM.CLKB XD2.nt 2.4201e-17
* device instance cc_XD2_XDFFM_CLKB_XD2_t1 r0 *1 0,0
Ccc_XD2_XDFFM_CLKB_XD2_t1 XD2.XDFFM.CLKB XD2.t1 1.21e-17
* device instance cc_XD2_XDFFM_CLKB_XD3_XDFFM_CLKB r0 *1 0,0
Ccc_XD2_XDFFM_CLKB_XD3_XDFFM_CLKB XD2.XDFFM.CLKB XD3.XDFFM.CLKB 1.8151e-17
* device instance cc_XD2_XDFFM_CLKB_XD3_XDFFM_M r0 *1 0,0
Ccc_XD2_XDFFM_CLKB_XD3_XDFFM_M XD2.XDFFM.CLKB XD3.XDFFM.M 2.4201e-17
* device instance cc_XD2_XDFFM_CLKB_XD3_XDFFM_MB r0 *1 0,0
Ccc_XD2_XDFFM_CLKB_XD3_XDFFM_MB XD2.XDFFM.CLKB XD3.XDFFM.MB 1.21e-17
* device instance cc_XD2_XDFFM_CLKB_XD3_XDFFM_S r0 *1 0,0
Ccc_XD2_XDFFM_CLKB_XD3_XDFFM_S XD2.XDFFM.CLKB XD3.XDFFM.S 1.8151e-17
* device instance cc_XD2_XDFFM_CLKB_XD3_XDFFM_SB r0 *1 0,0
Ccc_XD2_XDFFM_CLKB_XD3_XDFFM_SB XD2.XDFFM.CLKB XD3.XDFFM.SB 1.8151e-17
* device instance cc_XD2_XDFFM_CLKB_XD3_XDFFQ_CLKB r0 *1 0,0
Ccc_XD2_XDFFM_CLKB_XD3_XDFFQ_CLKB XD2.XDFFM.CLKB XD3.XDFFQ.CLKB 1.8151e-17
* device instance cc_XD2_XDFFM_CLKB_XD3_XDFFQ_M r0 *1 0,0
Ccc_XD2_XDFFM_CLKB_XD3_XDFFQ_M XD2.XDFFM.CLKB XD3.XDFFQ.M 2.4201e-17
* device instance cc_XD2_XDFFM_CLKB_XD3_XDFFQ_MB r0 *1 0,0
Ccc_XD2_XDFFM_CLKB_XD3_XDFFQ_MB XD2.XDFFM.CLKB XD3.XDFFQ.MB 1.21e-17
* device instance cc_XD2_XDFFM_CLKB_XD3_XDFFQ_S r0 *1 0,0
Ccc_XD2_XDFFM_CLKB_XD3_XDFFQ_S XD2.XDFFM.CLKB XD3.XDFFQ.S 1.8151e-17
* device instance cc_XD2_XDFFM_CLKB_XD3_XDFFQ_SB r0 *1 0,0
Ccc_XD2_XDFFM_CLKB_XD3_XDFFQ_SB XD2.XDFFM.CLKB XD3.XDFFQ.SB 1.8151e-17
* device instance cc_XD2_XDFFM_CLKB_XD3_XN2_mid1 r0 *1 0,0
Ccc_XD2_XDFFM_CLKB_XD3_XN2_mid1 XD2.XDFFM.CLKB XD3.XN2.mid1 1.21e-17
* device instance cc_XD2_XDFFM_CLKB_XD3_XN3_mid1 r0 *1 0,0
Ccc_XD2_XDFFM_CLKB_XD3_XN3_mid1 XD2.XDFFM.CLKB XD3.XN3.mid1 1.21e-17
* device instance cc_XD2_XDFFM_CLKB_XD3_XN3_mid2 r0 *1 0,0
Ccc_XD2_XDFFM_CLKB_XD3_XN3_mid2 XD2.XDFFM.CLKB XD3.XN3.mid2 1.21e-17
* device instance cc_XD2_XDFFM_CLKB_XD3_dmodout r0 *1 0,0
Ccc_XD2_XDFFM_CLKB_XD3_dmodout XD2.XDFFM.CLKB XD3.dmodout 1.21e-17
* device instance cc_XD2_XDFFM_CLKB_XD3_dq r0 *1 0,0
Ccc_XD2_XDFFM_CLKB_XD3_dq XD2.XDFFM.CLKB XD3.dq 1.8151e-17
* device instance cc_XD2_XDFFM_CLKB_XD3_nm r0 *1 0,0
Ccc_XD2_XDFFM_CLKB_XD3_nm XD2.XDFFM.CLKB XD3.nm 1.21e-17
* device instance cc_XD2_XDFFM_CLKB_XD3_nt r0 *1 0,0
Ccc_XD2_XDFFM_CLKB_XD3_nt XD2.XDFFM.CLKB XD3.nt 1.21e-17
* device instance cc_XD2_XDFFM_CLKB_XD3_t1 r0 *1 0,0
Ccc_XD2_XDFFM_CLKB_XD3_t1 XD2.XDFFM.CLKB XD3.t1 1.21e-17
* device instance cc_XD2_XDFFM_CLKB_XD4_XDFFM_CLKB r0 *1 0,0
Ccc_XD2_XDFFM_CLKB_XD4_XDFFM_CLKB XD2.XDFFM.CLKB XD4.XDFFM.CLKB 1.8151e-17
* device instance cc_XD2_XDFFM_CLKB_XD4_XDFFM_M r0 *1 0,0
Ccc_XD2_XDFFM_CLKB_XD4_XDFFM_M XD2.XDFFM.CLKB XD4.XDFFM.M 2.4201e-17
* device instance cc_XD2_XDFFM_CLKB_XD4_XDFFM_MB r0 *1 0,0
Ccc_XD2_XDFFM_CLKB_XD4_XDFFM_MB XD2.XDFFM.CLKB XD4.XDFFM.MB 1.21e-17
* device instance cc_XD2_XDFFM_CLKB_XD4_XDFFM_S r0 *1 0,0
Ccc_XD2_XDFFM_CLKB_XD4_XDFFM_S XD2.XDFFM.CLKB XD4.XDFFM.S 1.8151e-17
* device instance cc_XD2_XDFFM_CLKB_XD4_XDFFM_SB r0 *1 0,0
Ccc_XD2_XDFFM_CLKB_XD4_XDFFM_SB XD2.XDFFM.CLKB XD4.XDFFM.SB 1.8151e-17
* device instance cc_XD2_XDFFM_CLKB_XD4_XDFFQ_CLKB r0 *1 0,0
Ccc_XD2_XDFFM_CLKB_XD4_XDFFQ_CLKB XD2.XDFFM.CLKB XD4.XDFFQ.CLKB 1.8151e-17
* device instance cc_XD2_XDFFM_CLKB_XD4_XDFFQ_M r0 *1 0,0
Ccc_XD2_XDFFM_CLKB_XD4_XDFFQ_M XD2.XDFFM.CLKB XD4.XDFFQ.M 2.4201e-17
* device instance cc_XD2_XDFFM_CLKB_XD4_XDFFQ_MB r0 *1 0,0
Ccc_XD2_XDFFM_CLKB_XD4_XDFFQ_MB XD2.XDFFM.CLKB XD4.XDFFQ.MB 1.21e-17
* device instance cc_XD2_XDFFM_CLKB_XD4_XDFFQ_S r0 *1 0,0
Ccc_XD2_XDFFM_CLKB_XD4_XDFFQ_S XD2.XDFFM.CLKB XD4.XDFFQ.S 1.8151e-17
* device instance cc_XD2_XDFFM_CLKB_XD4_XDFFQ_SB r0 *1 0,0
Ccc_XD2_XDFFM_CLKB_XD4_XDFFQ_SB XD2.XDFFM.CLKB XD4.XDFFQ.SB 1.8151e-17
* device instance cc_XD2_XDFFM_CLKB_XD4_XN2_mid1 r0 *1 0,0
Ccc_XD2_XDFFM_CLKB_XD4_XN2_mid1 XD2.XDFFM.CLKB XD4.XN2.mid1 1.21e-17
* device instance cc_XD2_XDFFM_CLKB_XD4_XN3_mid1 r0 *1 0,0
Ccc_XD2_XDFFM_CLKB_XD4_XN3_mid1 XD2.XDFFM.CLKB XD4.XN3.mid1 1.21e-17
* device instance cc_XD2_XDFFM_CLKB_XD4_XN3_mid2 r0 *1 0,0
Ccc_XD2_XDFFM_CLKB_XD4_XN3_mid2 XD2.XDFFM.CLKB XD4.XN3.mid2 1.21e-17
* device instance cc_XD2_XDFFM_CLKB_XD4_dmodout r0 *1 0,0
Ccc_XD2_XDFFM_CLKB_XD4_dmodout XD2.XDFFM.CLKB XD4.dmodout 1.21e-17
* device instance cc_XD2_XDFFM_CLKB_XD4_dq r0 *1 0,0
Ccc_XD2_XDFFM_CLKB_XD4_dq XD2.XDFFM.CLKB XD4.dq 1.8151e-17
* device instance cc_XD2_XDFFM_CLKB_XD4_nm r0 *1 0,0
Ccc_XD2_XDFFM_CLKB_XD4_nm XD2.XDFFM.CLKB XD4.nm 1.21e-17
* device instance cc_XD2_XDFFM_CLKB_XD4_nt r0 *1 0,0
Ccc_XD2_XDFFM_CLKB_XD4_nt XD2.XDFFM.CLKB XD4.nt 1.21e-17
* device instance cc_XD2_XDFFM_CLKB_XD4_t1 r0 *1 0,0
Ccc_XD2_XDFFM_CLKB_XD4_t1 XD2.XDFFM.CLKB XD4.t1 1.21e-17
* device instance cc_XD2_XDFFM_CLKB_XD5_XDFFM_CLKB r0 *1 0,0
Ccc_XD2_XDFFM_CLKB_XD5_XDFFM_CLKB XD2.XDFFM.CLKB XD5.XDFFM.CLKB 1.8151e-17
* device instance cc_XD2_XDFFM_CLKB_XD5_XDFFM_M r0 *1 0,0
Ccc_XD2_XDFFM_CLKB_XD5_XDFFM_M XD2.XDFFM.CLKB XD5.XDFFM.M 2.4201e-17
* device instance cc_XD2_XDFFM_CLKB_XD5_XDFFM_MB r0 *1 0,0
Ccc_XD2_XDFFM_CLKB_XD5_XDFFM_MB XD2.XDFFM.CLKB XD5.XDFFM.MB 1.21e-17
* device instance cc_XD2_XDFFM_CLKB_XD5_XDFFM_S r0 *1 0,0
Ccc_XD2_XDFFM_CLKB_XD5_XDFFM_S XD2.XDFFM.CLKB XD5.XDFFM.S 1.8151e-17
* device instance cc_XD2_XDFFM_CLKB_XD5_XDFFM_SB r0 *1 0,0
Ccc_XD2_XDFFM_CLKB_XD5_XDFFM_SB XD2.XDFFM.CLKB XD5.XDFFM.SB 1.8151e-17
* device instance cc_XD2_XDFFM_CLKB_XD5_XDFFQ_CLKB r0 *1 0,0
Ccc_XD2_XDFFM_CLKB_XD5_XDFFQ_CLKB XD2.XDFFM.CLKB XD5.XDFFQ.CLKB 1.8151e-17
* device instance cc_XD2_XDFFM_CLKB_XD5_XDFFQ_M r0 *1 0,0
Ccc_XD2_XDFFM_CLKB_XD5_XDFFQ_M XD2.XDFFM.CLKB XD5.XDFFQ.M 2.4201e-17
* device instance cc_XD2_XDFFM_CLKB_XD5_XDFFQ_MB r0 *1 0,0
Ccc_XD2_XDFFM_CLKB_XD5_XDFFQ_MB XD2.XDFFM.CLKB XD5.XDFFQ.MB 1.21e-17
* device instance cc_XD2_XDFFM_CLKB_XD5_XDFFQ_S r0 *1 0,0
Ccc_XD2_XDFFM_CLKB_XD5_XDFFQ_S XD2.XDFFM.CLKB XD5.XDFFQ.S 1.8151e-17
* device instance cc_XD2_XDFFM_CLKB_XD5_XDFFQ_SB r0 *1 0,0
Ccc_XD2_XDFFM_CLKB_XD5_XDFFQ_SB XD2.XDFFM.CLKB XD5.XDFFQ.SB 1.8151e-17
* device instance cc_XD2_XDFFM_CLKB_XD5_XN2_mid1 r0 *1 0,0
Ccc_XD2_XDFFM_CLKB_XD5_XN2_mid1 XD2.XDFFM.CLKB XD5.XN2.mid1 1.21e-17
* device instance cc_XD2_XDFFM_CLKB_XD5_XN3_mid1 r0 *1 0,0
Ccc_XD2_XDFFM_CLKB_XD5_XN3_mid1 XD2.XDFFM.CLKB XD5.XN3.mid1 1.21e-17
* device instance cc_XD2_XDFFM_CLKB_XD5_XN3_mid2 r0 *1 0,0
Ccc_XD2_XDFFM_CLKB_XD5_XN3_mid2 XD2.XDFFM.CLKB XD5.XN3.mid2 1.21e-17
* device instance cc_XD2_XDFFM_CLKB_XD5_dmodout r0 *1 0,0
Ccc_XD2_XDFFM_CLKB_XD5_dmodout XD2.XDFFM.CLKB XD5.dmodout 1.21e-17
* device instance cc_XD2_XDFFM_CLKB_XD5_dq r0 *1 0,0
Ccc_XD2_XDFFM_CLKB_XD5_dq XD2.XDFFM.CLKB XD5.dq 1.8151e-17
* device instance cc_XD2_XDFFM_CLKB_XD5_nm r0 *1 0,0
Ccc_XD2_XDFFM_CLKB_XD5_nm XD2.XDFFM.CLKB XD5.nm 1.21e-17
* device instance cc_XD2_XDFFM_CLKB_XD5_nt r0 *1 0,0
Ccc_XD2_XDFFM_CLKB_XD5_nt XD2.XDFFM.CLKB XD5.nt 1.21e-17
* device instance cc_XD2_XDFFM_CLKB_XD5_t1 r0 *1 0,0
Ccc_XD2_XDFFM_CLKB_XD5_t1 XD2.XDFFM.CLKB XD5.t1 1.21e-17
* device instance cc_XD2_XDFFM_CLKB_XFRT_CLKB r0 *1 0,0
Ccc_XD2_XDFFM_CLKB_XFRT_CLKB XD2.XDFFM.CLKB XFRT.CLKB 1.8151e-17
* device instance cc_XD2_XDFFM_CLKB_XFRT_M r0 *1 0,0
Ccc_XD2_XDFFM_CLKB_XFRT_M XD2.XDFFM.CLKB XFRT.M 2.4201e-17
* device instance cc_XD2_XDFFM_CLKB_XFRT_MB r0 *1 0,0
Ccc_XD2_XDFFM_CLKB_XFRT_MB XD2.XDFFM.CLKB XFRT.MB 1.21e-17
* device instance cc_XD2_XDFFM_CLKB_XFRT_S r0 *1 0,0
Ccc_XD2_XDFFM_CLKB_XFRT_S XD2.XDFFM.CLKB XFRT.S 1.8151e-17
* device instance cc_XD2_XDFFM_CLKB_XFRT_SB r0 *1 0,0
Ccc_XD2_XDFFM_CLKB_XFRT_SB XD2.XDFFM.CLKB XFRT.SB 1.8151e-17
* device instance cc_XD2_XDFFM_CLKB_ck1 r0 *1 0,0
Ccc_XD2_XDFFM_CLKB_ck1 XD2.XDFFM.CLKB ck1 5.4452e-17
* device instance cc_XD2_XDFFM_CLKB_ck2 r0 *1 0,0
Ccc_XD2_XDFFM_CLKB_ck2 XD2.XDFFM.CLKB ck2 6.0502e-17
* device instance cc_XD2_XDFFM_CLKB_ck3 r0 *1 0,0
Ccc_XD2_XDFFM_CLKB_ck3 XD2.XDFFM.CLKB ck3 5.4452e-17
* device instance cc_XD2_XDFFM_CLKB_ck4 r0 *1 0,0
Ccc_XD2_XDFFM_CLKB_ck4 XD2.XDFFM.CLKB ck4 5.4452e-17
* device instance cc_XD2_XDFFM_CLKB_ck5 r0 *1 0,0
Ccc_XD2_XDFFM_CLKB_ck5 XD2.XDFFM.CLKB ck5 5.4452e-17
* device instance cc_XD2_XDFFM_CLKB_mod0 r0 *1 0,0
Ccc_XD2_XDFFM_CLKB_mod0 XD2.XDFFM.CLKB mod0 2.4201e-17
* device instance cc_XD2_XDFFM_CLKB_mod1 r0 *1 0,0
Ccc_XD2_XDFFM_CLKB_mod1 XD2.XDFFM.CLKB mod1 2.4201e-17
* device instance cc_XD2_XDFFM_CLKB_mod2 r0 *1 0,0
Ccc_XD2_XDFFM_CLKB_mod2 XD2.XDFFM.CLKB mod2 2.4201e-17
* device instance cc_XD2_XDFFM_CLKB_mod3 r0 *1 0,0
Ccc_XD2_XDFFM_CLKB_mod3 XD2.XDFFM.CLKB mod3 2.4201e-17
* device instance cc_XD2_XDFFM_CLKB_mod4 r0 *1 0,0
Ccc_XD2_XDFFM_CLKB_mod4 XD2.XDFFM.CLKB mod4 2.4201e-17
* device instance cc_XD2_XDFFM_CLKB_net1 r0 *1 0,0
Ccc_XD2_XDFFM_CLKB_net1 XD2.XDFFM.CLKB net1 1.21e-17
* device instance cc_XD2_XDFFM_M_XD2_XDFFM_MB r0 *1 0,0
Ccc_XD2_XDFFM_M_XD2_XDFFM_MB XD2.XDFFM.M XD2.XDFFM.MB 3.4688e-17
* device instance cc_XD2_XDFFM_M_XD2_XDFFM_S r0 *1 0,0
Ccc_XD2_XDFFM_M_XD2_XDFFM_S XD2.XDFFM.M XD2.XDFFM.S 2.8638e-17
* device instance cc_XD2_XDFFM_M_XD2_XDFFM_SB r0 *1 0,0
Ccc_XD2_XDFFM_M_XD2_XDFFM_SB XD2.XDFFM.M XD2.XDFFM.SB 1.8151e-17
* device instance cc_XD2_XDFFM_M_XD2_XDFFQ_CLKB r0 *1 0,0
Ccc_XD2_XDFFM_M_XD2_XDFFQ_CLKB XD2.XDFFM.M XD2.XDFFQ.CLKB 1.8151e-17
* device instance cc_XD2_XDFFM_M_XD2_XDFFQ_M r0 *1 0,0
Ccc_XD2_XDFFM_M_XD2_XDFFQ_M XD2.XDFFM.M XD2.XDFFQ.M 2.4201e-17
* device instance cc_XD2_XDFFM_M_XD2_XDFFQ_MB r0 *1 0,0
Ccc_XD2_XDFFM_M_XD2_XDFFQ_MB XD2.XDFFM.M XD2.XDFFQ.MB 1.21e-17
* device instance cc_XD2_XDFFM_M_XD2_XDFFQ_S r0 *1 0,0
Ccc_XD2_XDFFM_M_XD2_XDFFQ_S XD2.XDFFM.M XD2.XDFFQ.S 1.8151e-17
* device instance cc_XD2_XDFFM_M_XD2_XDFFQ_SB r0 *1 0,0
Ccc_XD2_XDFFM_M_XD2_XDFFQ_SB XD2.XDFFM.M XD2.XDFFQ.SB 1.8151e-17
* device instance cc_XD2_XDFFM_M_XD2_XNOR_midp r0 *1 0,0
Ccc_XD2_XDFFM_M_XD2_XNOR_midp XD2.XDFFM.M XD2.XNOR.midp 1.21e-17
* device instance cc_XD2_XDFFM_M_XD2_dmodout r0 *1 0,0
Ccc_XD2_XDFFM_M_XD2_dmodout XD2.XDFFM.M XD2.dmodout 2.8638e-17
* device instance cc_XD2_XDFFM_M_XD2_dq r0 *1 0,0
Ccc_XD2_XDFFM_M_XD2_dq XD2.XDFFM.M XD2.dq 1.21e-17
* device instance cc_XD2_XDFFM_M_XD2_nm r0 *1 0,0
Ccc_XD2_XDFFM_M_XD2_nm XD2.XDFFM.M XD2.nm 1.8151e-17
* device instance cc_XD2_XDFFM_M_XD2_nt r0 *1 0,0
Ccc_XD2_XDFFM_M_XD2_nt XD2.XDFFM.M XD2.nt 2.4201e-17
* device instance cc_XD2_XDFFM_M_XD2_t1 r0 *1 0,0
Ccc_XD2_XDFFM_M_XD2_t1 XD2.XDFFM.M XD2.t1 1.21e-17
* device instance cc_XD2_XDFFM_M_XD3_XDFFM_CLKB r0 *1 0,0
Ccc_XD2_XDFFM_M_XD3_XDFFM_CLKB XD2.XDFFM.M XD3.XDFFM.CLKB 1.8151e-17
* device instance cc_XD2_XDFFM_M_XD3_XDFFM_M r0 *1 0,0
Ccc_XD2_XDFFM_M_XD3_XDFFM_M XD2.XDFFM.M XD3.XDFFM.M 2.4201e-17
* device instance cc_XD2_XDFFM_M_XD3_XDFFM_MB r0 *1 0,0
Ccc_XD2_XDFFM_M_XD3_XDFFM_MB XD2.XDFFM.M XD3.XDFFM.MB 1.21e-17
* device instance cc_XD2_XDFFM_M_XD3_XDFFM_S r0 *1 0,0
Ccc_XD2_XDFFM_M_XD3_XDFFM_S XD2.XDFFM.M XD3.XDFFM.S 1.8151e-17
* device instance cc_XD2_XDFFM_M_XD3_XDFFM_SB r0 *1 0,0
Ccc_XD2_XDFFM_M_XD3_XDFFM_SB XD2.XDFFM.M XD3.XDFFM.SB 1.8151e-17
* device instance cc_XD2_XDFFM_M_XD3_XDFFQ_CLKB r0 *1 0,0
Ccc_XD2_XDFFM_M_XD3_XDFFQ_CLKB XD2.XDFFM.M XD3.XDFFQ.CLKB 1.8151e-17
* device instance cc_XD2_XDFFM_M_XD3_XDFFQ_M r0 *1 0,0
Ccc_XD2_XDFFM_M_XD3_XDFFQ_M XD2.XDFFM.M XD3.XDFFQ.M 2.4201e-17
* device instance cc_XD2_XDFFM_M_XD3_XDFFQ_MB r0 *1 0,0
Ccc_XD2_XDFFM_M_XD3_XDFFQ_MB XD2.XDFFM.M XD3.XDFFQ.MB 1.21e-17
* device instance cc_XD2_XDFFM_M_XD3_XDFFQ_S r0 *1 0,0
Ccc_XD2_XDFFM_M_XD3_XDFFQ_S XD2.XDFFM.M XD3.XDFFQ.S 1.8151e-17
* device instance cc_XD2_XDFFM_M_XD3_XDFFQ_SB r0 *1 0,0
Ccc_XD2_XDFFM_M_XD3_XDFFQ_SB XD2.XDFFM.M XD3.XDFFQ.SB 1.8151e-17
* device instance cc_XD2_XDFFM_M_XD3_XN2_mid1 r0 *1 0,0
Ccc_XD2_XDFFM_M_XD3_XN2_mid1 XD2.XDFFM.M XD3.XN2.mid1 1.21e-17
* device instance cc_XD2_XDFFM_M_XD3_XN3_mid1 r0 *1 0,0
Ccc_XD2_XDFFM_M_XD3_XN3_mid1 XD2.XDFFM.M XD3.XN3.mid1 1.21e-17
* device instance cc_XD2_XDFFM_M_XD3_XN3_mid2 r0 *1 0,0
Ccc_XD2_XDFFM_M_XD3_XN3_mid2 XD2.XDFFM.M XD3.XN3.mid2 1.21e-17
* device instance cc_XD2_XDFFM_M_XD3_dmodout r0 *1 0,0
Ccc_XD2_XDFFM_M_XD3_dmodout XD2.XDFFM.M XD3.dmodout 1.21e-17
* device instance cc_XD2_XDFFM_M_XD3_dq r0 *1 0,0
Ccc_XD2_XDFFM_M_XD3_dq XD2.XDFFM.M XD3.dq 1.8151e-17
* device instance cc_XD2_XDFFM_M_XD3_nm r0 *1 0,0
Ccc_XD2_XDFFM_M_XD3_nm XD2.XDFFM.M XD3.nm 1.21e-17
* device instance cc_XD2_XDFFM_M_XD3_nt r0 *1 0,0
Ccc_XD2_XDFFM_M_XD3_nt XD2.XDFFM.M XD3.nt 1.21e-17
* device instance cc_XD2_XDFFM_M_XD3_t1 r0 *1 0,0
Ccc_XD2_XDFFM_M_XD3_t1 XD2.XDFFM.M XD3.t1 1.21e-17
* device instance cc_XD2_XDFFM_M_XD4_XDFFM_CLKB r0 *1 0,0
Ccc_XD2_XDFFM_M_XD4_XDFFM_CLKB XD2.XDFFM.M XD4.XDFFM.CLKB 1.8151e-17
* device instance cc_XD2_XDFFM_M_XD4_XDFFM_M r0 *1 0,0
Ccc_XD2_XDFFM_M_XD4_XDFFM_M XD2.XDFFM.M XD4.XDFFM.M 2.4201e-17
* device instance cc_XD2_XDFFM_M_XD4_XDFFM_MB r0 *1 0,0
Ccc_XD2_XDFFM_M_XD4_XDFFM_MB XD2.XDFFM.M XD4.XDFFM.MB 1.21e-17
* device instance cc_XD2_XDFFM_M_XD4_XDFFM_S r0 *1 0,0
Ccc_XD2_XDFFM_M_XD4_XDFFM_S XD2.XDFFM.M XD4.XDFFM.S 1.8151e-17
* device instance cc_XD2_XDFFM_M_XD4_XDFFM_SB r0 *1 0,0
Ccc_XD2_XDFFM_M_XD4_XDFFM_SB XD2.XDFFM.M XD4.XDFFM.SB 1.8151e-17
* device instance cc_XD2_XDFFM_M_XD4_XDFFQ_CLKB r0 *1 0,0
Ccc_XD2_XDFFM_M_XD4_XDFFQ_CLKB XD2.XDFFM.M XD4.XDFFQ.CLKB 1.8151e-17
* device instance cc_XD2_XDFFM_M_XD4_XDFFQ_M r0 *1 0,0
Ccc_XD2_XDFFM_M_XD4_XDFFQ_M XD2.XDFFM.M XD4.XDFFQ.M 2.4201e-17
* device instance cc_XD2_XDFFM_M_XD4_XDFFQ_MB r0 *1 0,0
Ccc_XD2_XDFFM_M_XD4_XDFFQ_MB XD2.XDFFM.M XD4.XDFFQ.MB 1.21e-17
* device instance cc_XD2_XDFFM_M_XD4_XDFFQ_S r0 *1 0,0
Ccc_XD2_XDFFM_M_XD4_XDFFQ_S XD2.XDFFM.M XD4.XDFFQ.S 1.8151e-17
* device instance cc_XD2_XDFFM_M_XD4_XDFFQ_SB r0 *1 0,0
Ccc_XD2_XDFFM_M_XD4_XDFFQ_SB XD2.XDFFM.M XD4.XDFFQ.SB 1.8151e-17
* device instance cc_XD2_XDFFM_M_XD4_XN2_mid1 r0 *1 0,0
Ccc_XD2_XDFFM_M_XD4_XN2_mid1 XD2.XDFFM.M XD4.XN2.mid1 1.21e-17
* device instance cc_XD2_XDFFM_M_XD4_XN3_mid1 r0 *1 0,0
Ccc_XD2_XDFFM_M_XD4_XN3_mid1 XD2.XDFFM.M XD4.XN3.mid1 1.21e-17
* device instance cc_XD2_XDFFM_M_XD4_XN3_mid2 r0 *1 0,0
Ccc_XD2_XDFFM_M_XD4_XN3_mid2 XD2.XDFFM.M XD4.XN3.mid2 1.21e-17
* device instance cc_XD2_XDFFM_M_XD4_dmodout r0 *1 0,0
Ccc_XD2_XDFFM_M_XD4_dmodout XD2.XDFFM.M XD4.dmodout 1.21e-17
* device instance cc_XD2_XDFFM_M_XD4_dq r0 *1 0,0
Ccc_XD2_XDFFM_M_XD4_dq XD2.XDFFM.M XD4.dq 1.8151e-17
* device instance cc_XD2_XDFFM_M_XD4_nm r0 *1 0,0
Ccc_XD2_XDFFM_M_XD4_nm XD2.XDFFM.M XD4.nm 1.21e-17
* device instance cc_XD2_XDFFM_M_XD4_nt r0 *1 0,0
Ccc_XD2_XDFFM_M_XD4_nt XD2.XDFFM.M XD4.nt 1.21e-17
* device instance cc_XD2_XDFFM_M_XD4_t1 r0 *1 0,0
Ccc_XD2_XDFFM_M_XD4_t1 XD2.XDFFM.M XD4.t1 1.21e-17
* device instance cc_XD2_XDFFM_M_XD5_XDFFM_CLKB r0 *1 0,0
Ccc_XD2_XDFFM_M_XD5_XDFFM_CLKB XD2.XDFFM.M XD5.XDFFM.CLKB 1.8151e-17
* device instance cc_XD2_XDFFM_M_XD5_XDFFM_M r0 *1 0,0
Ccc_XD2_XDFFM_M_XD5_XDFFM_M XD2.XDFFM.M XD5.XDFFM.M 2.4201e-17
* device instance cc_XD2_XDFFM_M_XD5_XDFFM_MB r0 *1 0,0
Ccc_XD2_XDFFM_M_XD5_XDFFM_MB XD2.XDFFM.M XD5.XDFFM.MB 1.21e-17
* device instance cc_XD2_XDFFM_M_XD5_XDFFM_S r0 *1 0,0
Ccc_XD2_XDFFM_M_XD5_XDFFM_S XD2.XDFFM.M XD5.XDFFM.S 1.8151e-17
* device instance cc_XD2_XDFFM_M_XD5_XDFFM_SB r0 *1 0,0
Ccc_XD2_XDFFM_M_XD5_XDFFM_SB XD2.XDFFM.M XD5.XDFFM.SB 1.8151e-17
* device instance cc_XD2_XDFFM_M_XD5_XDFFQ_CLKB r0 *1 0,0
Ccc_XD2_XDFFM_M_XD5_XDFFQ_CLKB XD2.XDFFM.M XD5.XDFFQ.CLKB 1.8151e-17
* device instance cc_XD2_XDFFM_M_XD5_XDFFQ_M r0 *1 0,0
Ccc_XD2_XDFFM_M_XD5_XDFFQ_M XD2.XDFFM.M XD5.XDFFQ.M 2.4201e-17
* device instance cc_XD2_XDFFM_M_XD5_XDFFQ_MB r0 *1 0,0
Ccc_XD2_XDFFM_M_XD5_XDFFQ_MB XD2.XDFFM.M XD5.XDFFQ.MB 1.21e-17
* device instance cc_XD2_XDFFM_M_XD5_XDFFQ_S r0 *1 0,0
Ccc_XD2_XDFFM_M_XD5_XDFFQ_S XD2.XDFFM.M XD5.XDFFQ.S 1.8151e-17
* device instance cc_XD2_XDFFM_M_XD5_XDFFQ_SB r0 *1 0,0
Ccc_XD2_XDFFM_M_XD5_XDFFQ_SB XD2.XDFFM.M XD5.XDFFQ.SB 1.8151e-17
* device instance cc_XD2_XDFFM_M_XD5_XN2_mid1 r0 *1 0,0
Ccc_XD2_XDFFM_M_XD5_XN2_mid1 XD2.XDFFM.M XD5.XN2.mid1 1.21e-17
* device instance cc_XD2_XDFFM_M_XD5_XN3_mid1 r0 *1 0,0
Ccc_XD2_XDFFM_M_XD5_XN3_mid1 XD2.XDFFM.M XD5.XN3.mid1 1.21e-17
* device instance cc_XD2_XDFFM_M_XD5_XN3_mid2 r0 *1 0,0
Ccc_XD2_XDFFM_M_XD5_XN3_mid2 XD2.XDFFM.M XD5.XN3.mid2 1.21e-17
* device instance cc_XD2_XDFFM_M_XD5_dmodout r0 *1 0,0
Ccc_XD2_XDFFM_M_XD5_dmodout XD2.XDFFM.M XD5.dmodout 1.21e-17
* device instance cc_XD2_XDFFM_M_XD5_dq r0 *1 0,0
Ccc_XD2_XDFFM_M_XD5_dq XD2.XDFFM.M XD5.dq 1.8151e-17
* device instance cc_XD2_XDFFM_M_XD5_nm r0 *1 0,0
Ccc_XD2_XDFFM_M_XD5_nm XD2.XDFFM.M XD5.nm 1.21e-17
* device instance cc_XD2_XDFFM_M_XD5_nt r0 *1 0,0
Ccc_XD2_XDFFM_M_XD5_nt XD2.XDFFM.M XD5.nt 1.21e-17
* device instance cc_XD2_XDFFM_M_XD5_t1 r0 *1 0,0
Ccc_XD2_XDFFM_M_XD5_t1 XD2.XDFFM.M XD5.t1 1.21e-17
* device instance cc_XD2_XDFFM_M_XFRT_CLKB r0 *1 0,0
Ccc_XD2_XDFFM_M_XFRT_CLKB XD2.XDFFM.M XFRT.CLKB 1.8151e-17
* device instance cc_XD2_XDFFM_M_XFRT_M r0 *1 0,0
Ccc_XD2_XDFFM_M_XFRT_M XD2.XDFFM.M XFRT.M 2.4201e-17
* device instance cc_XD2_XDFFM_M_XFRT_MB r0 *1 0,0
Ccc_XD2_XDFFM_M_XFRT_MB XD2.XDFFM.M XFRT.MB 1.21e-17
* device instance cc_XD2_XDFFM_M_XFRT_S r0 *1 0,0
Ccc_XD2_XDFFM_M_XFRT_S XD2.XDFFM.M XFRT.S 1.8151e-17
* device instance cc_XD2_XDFFM_M_XFRT_SB r0 *1 0,0
Ccc_XD2_XDFFM_M_XFRT_SB XD2.XDFFM.M XFRT.SB 1.8151e-17
* device instance cc_XD2_XDFFM_M_ck1 r0 *1 0,0
Ccc_XD2_XDFFM_M_ck1 XD2.XDFFM.M ck1 5.4452e-17
* device instance cc_XD2_XDFFM_M_ck2 r0 *1 0,0
Ccc_XD2_XDFFM_M_ck2 XD2.XDFFM.M ck2 6.0502e-17
* device instance cc_XD2_XDFFM_M_ck3 r0 *1 0,0
Ccc_XD2_XDFFM_M_ck3 XD2.XDFFM.M ck3 5.4452e-17
* device instance cc_XD2_XDFFM_M_ck4 r0 *1 0,0
Ccc_XD2_XDFFM_M_ck4 XD2.XDFFM.M ck4 5.4452e-17
* device instance cc_XD2_XDFFM_M_ck5 r0 *1 0,0
Ccc_XD2_XDFFM_M_ck5 XD2.XDFFM.M ck5 5.4452e-17
* device instance cc_XD2_XDFFM_M_mod0 r0 *1 0,0
Ccc_XD2_XDFFM_M_mod0 XD2.XDFFM.M mod0 2.4201e-17
* device instance cc_XD2_XDFFM_M_mod1 r0 *1 0,0
Ccc_XD2_XDFFM_M_mod1 XD2.XDFFM.M mod1 2.4201e-17
* device instance cc_XD2_XDFFM_M_mod2 r0 *1 0,0
Ccc_XD2_XDFFM_M_mod2 XD2.XDFFM.M mod2 2.4201e-17
* device instance cc_XD2_XDFFM_M_mod3 r0 *1 0,0
Ccc_XD2_XDFFM_M_mod3 XD2.XDFFM.M mod3 2.4201e-17
* device instance cc_XD2_XDFFM_M_mod4 r0 *1 0,0
Ccc_XD2_XDFFM_M_mod4 XD2.XDFFM.M mod4 2.4201e-17
* device instance cc_XD2_XDFFM_M_net1 r0 *1 0,0
Ccc_XD2_XDFFM_M_net1 XD2.XDFFM.M net1 1.21e-17
* device instance cc_XD2_XDFFM_MB_XD2_XDFFM_S r0 *1 0,0
Ccc_XD2_XDFFM_MB_XD2_XDFFM_S XD2.XDFFM.MB XD2.XDFFM.S 1.8151e-17
* device instance cc_XD2_XDFFM_MB_XD2_XDFFM_SB r0 *1 0,0
Ccc_XD2_XDFFM_MB_XD2_XDFFM_SB XD2.XDFFM.MB XD2.XDFFM.SB 1.8151e-17
* device instance cc_XD2_XDFFM_MB_XD2_XDFFQ_CLKB r0 *1 0,0
Ccc_XD2_XDFFM_MB_XD2_XDFFQ_CLKB XD2.XDFFM.MB XD2.XDFFQ.CLKB 1.8151e-17
* device instance cc_XD2_XDFFM_MB_XD2_XDFFQ_M r0 *1 0,0
Ccc_XD2_XDFFM_MB_XD2_XDFFQ_M XD2.XDFFM.MB XD2.XDFFQ.M 2.4201e-17
* device instance cc_XD2_XDFFM_MB_XD2_XDFFQ_MB r0 *1 0,0
Ccc_XD2_XDFFM_MB_XD2_XDFFQ_MB XD2.XDFFM.MB XD2.XDFFQ.MB 1.21e-17
* device instance cc_XD2_XDFFM_MB_XD2_XDFFQ_S r0 *1 0,0
Ccc_XD2_XDFFM_MB_XD2_XDFFQ_S XD2.XDFFM.MB XD2.XDFFQ.S 1.8151e-17
* device instance cc_XD2_XDFFM_MB_XD2_XDFFQ_SB r0 *1 0,0
Ccc_XD2_XDFFM_MB_XD2_XDFFQ_SB XD2.XDFFM.MB XD2.XDFFQ.SB 1.8151e-17
* device instance cc_XD2_XDFFM_MB_XD2_XNOR_midp r0 *1 0,0
Ccc_XD2_XDFFM_MB_XD2_XNOR_midp XD2.XDFFM.MB XD2.XNOR.midp 1.21e-17
* device instance cc_XD2_XDFFM_MB_XD2_dmodout r0 *1 0,0
Ccc_XD2_XDFFM_MB_XD2_dmodout XD2.XDFFM.MB XD2.dmodout 1.21e-17
* device instance cc_XD2_XDFFM_MB_XD2_dq r0 *1 0,0
Ccc_XD2_XDFFM_MB_XD2_dq XD2.XDFFM.MB XD2.dq 1.21e-17
* device instance cc_XD2_XDFFM_MB_XD2_nm r0 *1 0,0
Ccc_XD2_XDFFM_MB_XD2_nm XD2.XDFFM.MB XD2.nm 1.8151e-17
* device instance cc_XD2_XDFFM_MB_XD2_nt r0 *1 0,0
Ccc_XD2_XDFFM_MB_XD2_nt XD2.XDFFM.MB XD2.nt 2.4201e-17
* device instance cc_XD2_XDFFM_MB_XD2_t1 r0 *1 0,0
Ccc_XD2_XDFFM_MB_XD2_t1 XD2.XDFFM.MB XD2.t1 1.21e-17
* device instance cc_XD2_XDFFM_MB_XD3_XDFFM_CLKB r0 *1 0,0
Ccc_XD2_XDFFM_MB_XD3_XDFFM_CLKB XD2.XDFFM.MB XD3.XDFFM.CLKB 1.8151e-17
* device instance cc_XD2_XDFFM_MB_XD3_XDFFM_M r0 *1 0,0
Ccc_XD2_XDFFM_MB_XD3_XDFFM_M XD2.XDFFM.MB XD3.XDFFM.M 2.4201e-17
* device instance cc_XD2_XDFFM_MB_XD3_XDFFM_MB r0 *1 0,0
Ccc_XD2_XDFFM_MB_XD3_XDFFM_MB XD2.XDFFM.MB XD3.XDFFM.MB 1.21e-17
* device instance cc_XD2_XDFFM_MB_XD3_XDFFM_S r0 *1 0,0
Ccc_XD2_XDFFM_MB_XD3_XDFFM_S XD2.XDFFM.MB XD3.XDFFM.S 1.8151e-17
* device instance cc_XD2_XDFFM_MB_XD3_XDFFM_SB r0 *1 0,0
Ccc_XD2_XDFFM_MB_XD3_XDFFM_SB XD2.XDFFM.MB XD3.XDFFM.SB 1.8151e-17
* device instance cc_XD2_XDFFM_MB_XD3_XDFFQ_CLKB r0 *1 0,0
Ccc_XD2_XDFFM_MB_XD3_XDFFQ_CLKB XD2.XDFFM.MB XD3.XDFFQ.CLKB 1.8151e-17
* device instance cc_XD2_XDFFM_MB_XD3_XDFFQ_M r0 *1 0,0
Ccc_XD2_XDFFM_MB_XD3_XDFFQ_M XD2.XDFFM.MB XD3.XDFFQ.M 2.4201e-17
* device instance cc_XD2_XDFFM_MB_XD3_XDFFQ_MB r0 *1 0,0
Ccc_XD2_XDFFM_MB_XD3_XDFFQ_MB XD2.XDFFM.MB XD3.XDFFQ.MB 1.21e-17
* device instance cc_XD2_XDFFM_MB_XD3_XDFFQ_S r0 *1 0,0
Ccc_XD2_XDFFM_MB_XD3_XDFFQ_S XD2.XDFFM.MB XD3.XDFFQ.S 1.8151e-17
* device instance cc_XD2_XDFFM_MB_XD3_XDFFQ_SB r0 *1 0,0
Ccc_XD2_XDFFM_MB_XD3_XDFFQ_SB XD2.XDFFM.MB XD3.XDFFQ.SB 1.8151e-17
* device instance cc_XD2_XDFFM_MB_XD3_XN2_mid1 r0 *1 0,0
Ccc_XD2_XDFFM_MB_XD3_XN2_mid1 XD2.XDFFM.MB XD3.XN2.mid1 1.21e-17
* device instance cc_XD2_XDFFM_MB_XD3_XN3_mid1 r0 *1 0,0
Ccc_XD2_XDFFM_MB_XD3_XN3_mid1 XD2.XDFFM.MB XD3.XN3.mid1 1.21e-17
* device instance cc_XD2_XDFFM_MB_XD3_XN3_mid2 r0 *1 0,0
Ccc_XD2_XDFFM_MB_XD3_XN3_mid2 XD2.XDFFM.MB XD3.XN3.mid2 1.21e-17
* device instance cc_XD2_XDFFM_MB_XD3_dmodout r0 *1 0,0
Ccc_XD2_XDFFM_MB_XD3_dmodout XD2.XDFFM.MB XD3.dmodout 1.21e-17
* device instance cc_XD2_XDFFM_MB_XD3_dq r0 *1 0,0
Ccc_XD2_XDFFM_MB_XD3_dq XD2.XDFFM.MB XD3.dq 1.8151e-17
* device instance cc_XD2_XDFFM_MB_XD3_nm r0 *1 0,0
Ccc_XD2_XDFFM_MB_XD3_nm XD2.XDFFM.MB XD3.nm 1.21e-17
* device instance cc_XD2_XDFFM_MB_XD3_nt r0 *1 0,0
Ccc_XD2_XDFFM_MB_XD3_nt XD2.XDFFM.MB XD3.nt 1.21e-17
* device instance cc_XD2_XDFFM_MB_XD3_t1 r0 *1 0,0
Ccc_XD2_XDFFM_MB_XD3_t1 XD2.XDFFM.MB XD3.t1 1.21e-17
* device instance cc_XD2_XDFFM_MB_XD4_XDFFM_CLKB r0 *1 0,0
Ccc_XD2_XDFFM_MB_XD4_XDFFM_CLKB XD2.XDFFM.MB XD4.XDFFM.CLKB 1.8151e-17
* device instance cc_XD2_XDFFM_MB_XD4_XDFFM_M r0 *1 0,0
Ccc_XD2_XDFFM_MB_XD4_XDFFM_M XD2.XDFFM.MB XD4.XDFFM.M 2.4201e-17
* device instance cc_XD2_XDFFM_MB_XD4_XDFFM_MB r0 *1 0,0
Ccc_XD2_XDFFM_MB_XD4_XDFFM_MB XD2.XDFFM.MB XD4.XDFFM.MB 1.21e-17
* device instance cc_XD2_XDFFM_MB_XD4_XDFFM_S r0 *1 0,0
Ccc_XD2_XDFFM_MB_XD4_XDFFM_S XD2.XDFFM.MB XD4.XDFFM.S 1.8151e-17
* device instance cc_XD2_XDFFM_MB_XD4_XDFFM_SB r0 *1 0,0
Ccc_XD2_XDFFM_MB_XD4_XDFFM_SB XD2.XDFFM.MB XD4.XDFFM.SB 1.8151e-17
* device instance cc_XD2_XDFFM_MB_XD4_XDFFQ_CLKB r0 *1 0,0
Ccc_XD2_XDFFM_MB_XD4_XDFFQ_CLKB XD2.XDFFM.MB XD4.XDFFQ.CLKB 1.8151e-17
* device instance cc_XD2_XDFFM_MB_XD4_XDFFQ_M r0 *1 0,0
Ccc_XD2_XDFFM_MB_XD4_XDFFQ_M XD2.XDFFM.MB XD4.XDFFQ.M 2.4201e-17
* device instance cc_XD2_XDFFM_MB_XD4_XDFFQ_MB r0 *1 0,0
Ccc_XD2_XDFFM_MB_XD4_XDFFQ_MB XD2.XDFFM.MB XD4.XDFFQ.MB 1.21e-17
* device instance cc_XD2_XDFFM_MB_XD4_XDFFQ_S r0 *1 0,0
Ccc_XD2_XDFFM_MB_XD4_XDFFQ_S XD2.XDFFM.MB XD4.XDFFQ.S 1.8151e-17
* device instance cc_XD2_XDFFM_MB_XD4_XDFFQ_SB r0 *1 0,0
Ccc_XD2_XDFFM_MB_XD4_XDFFQ_SB XD2.XDFFM.MB XD4.XDFFQ.SB 1.8151e-17
* device instance cc_XD2_XDFFM_MB_XD4_XN2_mid1 r0 *1 0,0
Ccc_XD2_XDFFM_MB_XD4_XN2_mid1 XD2.XDFFM.MB XD4.XN2.mid1 1.21e-17
* device instance cc_XD2_XDFFM_MB_XD4_XN3_mid1 r0 *1 0,0
Ccc_XD2_XDFFM_MB_XD4_XN3_mid1 XD2.XDFFM.MB XD4.XN3.mid1 1.21e-17
* device instance cc_XD2_XDFFM_MB_XD4_XN3_mid2 r0 *1 0,0
Ccc_XD2_XDFFM_MB_XD4_XN3_mid2 XD2.XDFFM.MB XD4.XN3.mid2 1.21e-17
* device instance cc_XD2_XDFFM_MB_XD4_dmodout r0 *1 0,0
Ccc_XD2_XDFFM_MB_XD4_dmodout XD2.XDFFM.MB XD4.dmodout 1.21e-17
* device instance cc_XD2_XDFFM_MB_XD4_dq r0 *1 0,0
Ccc_XD2_XDFFM_MB_XD4_dq XD2.XDFFM.MB XD4.dq 1.8151e-17
* device instance cc_XD2_XDFFM_MB_XD4_nm r0 *1 0,0
Ccc_XD2_XDFFM_MB_XD4_nm XD2.XDFFM.MB XD4.nm 1.21e-17
* device instance cc_XD2_XDFFM_MB_XD4_nt r0 *1 0,0
Ccc_XD2_XDFFM_MB_XD4_nt XD2.XDFFM.MB XD4.nt 1.21e-17
* device instance cc_XD2_XDFFM_MB_XD4_t1 r0 *1 0,0
Ccc_XD2_XDFFM_MB_XD4_t1 XD2.XDFFM.MB XD4.t1 1.21e-17
* device instance cc_XD2_XDFFM_MB_XD5_XDFFM_CLKB r0 *1 0,0
Ccc_XD2_XDFFM_MB_XD5_XDFFM_CLKB XD2.XDFFM.MB XD5.XDFFM.CLKB 1.8151e-17
* device instance cc_XD2_XDFFM_MB_XD5_XDFFM_M r0 *1 0,0
Ccc_XD2_XDFFM_MB_XD5_XDFFM_M XD2.XDFFM.MB XD5.XDFFM.M 2.4201e-17
* device instance cc_XD2_XDFFM_MB_XD5_XDFFM_MB r0 *1 0,0
Ccc_XD2_XDFFM_MB_XD5_XDFFM_MB XD2.XDFFM.MB XD5.XDFFM.MB 1.21e-17
* device instance cc_XD2_XDFFM_MB_XD5_XDFFM_S r0 *1 0,0
Ccc_XD2_XDFFM_MB_XD5_XDFFM_S XD2.XDFFM.MB XD5.XDFFM.S 1.8151e-17
* device instance cc_XD2_XDFFM_MB_XD5_XDFFM_SB r0 *1 0,0
Ccc_XD2_XDFFM_MB_XD5_XDFFM_SB XD2.XDFFM.MB XD5.XDFFM.SB 1.8151e-17
* device instance cc_XD2_XDFFM_MB_XD5_XDFFQ_CLKB r0 *1 0,0
Ccc_XD2_XDFFM_MB_XD5_XDFFQ_CLKB XD2.XDFFM.MB XD5.XDFFQ.CLKB 1.8151e-17
* device instance cc_XD2_XDFFM_MB_XD5_XDFFQ_M r0 *1 0,0
Ccc_XD2_XDFFM_MB_XD5_XDFFQ_M XD2.XDFFM.MB XD5.XDFFQ.M 2.4201e-17
* device instance cc_XD2_XDFFM_MB_XD5_XDFFQ_MB r0 *1 0,0
Ccc_XD2_XDFFM_MB_XD5_XDFFQ_MB XD2.XDFFM.MB XD5.XDFFQ.MB 1.21e-17
* device instance cc_XD2_XDFFM_MB_XD5_XDFFQ_S r0 *1 0,0
Ccc_XD2_XDFFM_MB_XD5_XDFFQ_S XD2.XDFFM.MB XD5.XDFFQ.S 1.8151e-17
* device instance cc_XD2_XDFFM_MB_XD5_XDFFQ_SB r0 *1 0,0
Ccc_XD2_XDFFM_MB_XD5_XDFFQ_SB XD2.XDFFM.MB XD5.XDFFQ.SB 1.8151e-17
* device instance cc_XD2_XDFFM_MB_XD5_XN2_mid1 r0 *1 0,0
Ccc_XD2_XDFFM_MB_XD5_XN2_mid1 XD2.XDFFM.MB XD5.XN2.mid1 1.21e-17
* device instance cc_XD2_XDFFM_MB_XD5_XN3_mid1 r0 *1 0,0
Ccc_XD2_XDFFM_MB_XD5_XN3_mid1 XD2.XDFFM.MB XD5.XN3.mid1 1.21e-17
* device instance cc_XD2_XDFFM_MB_XD5_XN3_mid2 r0 *1 0,0
Ccc_XD2_XDFFM_MB_XD5_XN3_mid2 XD2.XDFFM.MB XD5.XN3.mid2 1.21e-17
* device instance cc_XD2_XDFFM_MB_XD5_dmodout r0 *1 0,0
Ccc_XD2_XDFFM_MB_XD5_dmodout XD2.XDFFM.MB XD5.dmodout 1.21e-17
* device instance cc_XD2_XDFFM_MB_XD5_dq r0 *1 0,0
Ccc_XD2_XDFFM_MB_XD5_dq XD2.XDFFM.MB XD5.dq 1.8151e-17
* device instance cc_XD2_XDFFM_MB_XD5_nm r0 *1 0,0
Ccc_XD2_XDFFM_MB_XD5_nm XD2.XDFFM.MB XD5.nm 1.21e-17
* device instance cc_XD2_XDFFM_MB_XD5_nt r0 *1 0,0
Ccc_XD2_XDFFM_MB_XD5_nt XD2.XDFFM.MB XD5.nt 1.21e-17
* device instance cc_XD2_XDFFM_MB_XD5_t1 r0 *1 0,0
Ccc_XD2_XDFFM_MB_XD5_t1 XD2.XDFFM.MB XD5.t1 1.21e-17
* device instance cc_XD2_XDFFM_MB_XFRT_CLKB r0 *1 0,0
Ccc_XD2_XDFFM_MB_XFRT_CLKB XD2.XDFFM.MB XFRT.CLKB 1.8151e-17
* device instance cc_XD2_XDFFM_MB_XFRT_M r0 *1 0,0
Ccc_XD2_XDFFM_MB_XFRT_M XD2.XDFFM.MB XFRT.M 2.4201e-17
* device instance cc_XD2_XDFFM_MB_XFRT_MB r0 *1 0,0
Ccc_XD2_XDFFM_MB_XFRT_MB XD2.XDFFM.MB XFRT.MB 1.21e-17
* device instance cc_XD2_XDFFM_MB_XFRT_S r0 *1 0,0
Ccc_XD2_XDFFM_MB_XFRT_S XD2.XDFFM.MB XFRT.S 1.8151e-17
* device instance cc_XD2_XDFFM_MB_XFRT_SB r0 *1 0,0
Ccc_XD2_XDFFM_MB_XFRT_SB XD2.XDFFM.MB XFRT.SB 1.8151e-17
* device instance cc_XD2_XDFFM_MB_ck1 r0 *1 0,0
Ccc_XD2_XDFFM_MB_ck1 XD2.XDFFM.MB ck1 5.4452e-17
* device instance cc_XD2_XDFFM_MB_ck2 r0 *1 0,0
Ccc_XD2_XDFFM_MB_ck2 XD2.XDFFM.MB ck2 6.0502e-17
* device instance cc_XD2_XDFFM_MB_ck3 r0 *1 0,0
Ccc_XD2_XDFFM_MB_ck3 XD2.XDFFM.MB ck3 5.4452e-17
* device instance cc_XD2_XDFFM_MB_ck4 r0 *1 0,0
Ccc_XD2_XDFFM_MB_ck4 XD2.XDFFM.MB ck4 5.4452e-17
* device instance cc_XD2_XDFFM_MB_ck5 r0 *1 0,0
Ccc_XD2_XDFFM_MB_ck5 XD2.XDFFM.MB ck5 5.4452e-17
* device instance cc_XD2_XDFFM_MB_mod0 r0 *1 0,0
Ccc_XD2_XDFFM_MB_mod0 XD2.XDFFM.MB mod0 2.4201e-17
* device instance cc_XD2_XDFFM_MB_mod1 r0 *1 0,0
Ccc_XD2_XDFFM_MB_mod1 XD2.XDFFM.MB mod1 2.4201e-17
* device instance cc_XD2_XDFFM_MB_mod2 r0 *1 0,0
Ccc_XD2_XDFFM_MB_mod2 XD2.XDFFM.MB mod2 2.4201e-17
* device instance cc_XD2_XDFFM_MB_mod3 r0 *1 0,0
Ccc_XD2_XDFFM_MB_mod3 XD2.XDFFM.MB mod3 2.4201e-17
* device instance cc_XD2_XDFFM_MB_mod4 r0 *1 0,0
Ccc_XD2_XDFFM_MB_mod4 XD2.XDFFM.MB mod4 2.4201e-17
* device instance cc_XD2_XDFFM_MB_net1 r0 *1 0,0
Ccc_XD2_XDFFM_MB_net1 XD2.XDFFM.MB net1 1.21e-17
* device instance cc_XD2_XDFFM_S_XD2_XDFFM_SB r0 *1 0,0
Ccc_XD2_XDFFM_S_XD2_XDFFM_SB XD2.XDFFM.S XD2.XDFFM.SB 4.0738e-17
* device instance cc_XD2_XDFFM_S_XD2_XDFFQ_CLKB r0 *1 0,0
Ccc_XD2_XDFFM_S_XD2_XDFFQ_CLKB XD2.XDFFM.S XD2.XDFFQ.CLKB 1.8151e-17
* device instance cc_XD2_XDFFM_S_XD2_XDFFQ_M r0 *1 0,0
Ccc_XD2_XDFFM_S_XD2_XDFFQ_M XD2.XDFFM.S XD2.XDFFQ.M 2.4201e-17
* device instance cc_XD2_XDFFM_S_XD2_XDFFQ_MB r0 *1 0,0
Ccc_XD2_XDFFM_S_XD2_XDFFQ_MB XD2.XDFFM.S XD2.XDFFQ.MB 1.21e-17
* device instance cc_XD2_XDFFM_S_XD2_XDFFQ_S r0 *1 0,0
Ccc_XD2_XDFFM_S_XD2_XDFFQ_S XD2.XDFFM.S XD2.XDFFQ.S 1.8151e-17
* device instance cc_XD2_XDFFM_S_XD2_XDFFQ_SB r0 *1 0,0
Ccc_XD2_XDFFM_S_XD2_XDFFQ_SB XD2.XDFFM.S XD2.XDFFQ.SB 1.8151e-17
* device instance cc_XD2_XDFFM_S_XD2_XNOR_midp r0 *1 0,0
Ccc_XD2_XDFFM_S_XD2_XNOR_midp XD2.XDFFM.S XD2.XNOR.midp 1.21e-17
* device instance cc_XD2_XDFFM_S_XD2_dmodout r0 *1 0,0
Ccc_XD2_XDFFM_S_XD2_dmodout XD2.XDFFM.S XD2.dmodout 1.21e-17
* device instance cc_XD2_XDFFM_S_XD2_dq r0 *1 0,0
Ccc_XD2_XDFFM_S_XD2_dq XD2.XDFFM.S XD2.dq 1.21e-17
* device instance cc_XD2_XDFFM_S_XD2_nm r0 *1 0,0
Ccc_XD2_XDFFM_S_XD2_nm XD2.XDFFM.S XD2.nm 1.8151e-17
* device instance cc_XD2_XDFFM_S_XD2_nt r0 *1 0,0
Ccc_XD2_XDFFM_S_XD2_nt XD2.XDFFM.S XD2.nt 2.4201e-17
* device instance cc_XD2_XDFFM_S_XD2_t1 r0 *1 0,0
Ccc_XD2_XDFFM_S_XD2_t1 XD2.XDFFM.S XD2.t1 1.21e-17
* device instance cc_XD2_XDFFM_S_XD3_XDFFM_CLKB r0 *1 0,0
Ccc_XD2_XDFFM_S_XD3_XDFFM_CLKB XD2.XDFFM.S XD3.XDFFM.CLKB 1.8151e-17
* device instance cc_XD2_XDFFM_S_XD3_XDFFM_M r0 *1 0,0
Ccc_XD2_XDFFM_S_XD3_XDFFM_M XD2.XDFFM.S XD3.XDFFM.M 2.4201e-17
* device instance cc_XD2_XDFFM_S_XD3_XDFFM_MB r0 *1 0,0
Ccc_XD2_XDFFM_S_XD3_XDFFM_MB XD2.XDFFM.S XD3.XDFFM.MB 1.21e-17
* device instance cc_XD2_XDFFM_S_XD3_XDFFM_S r0 *1 0,0
Ccc_XD2_XDFFM_S_XD3_XDFFM_S XD2.XDFFM.S XD3.XDFFM.S 1.8151e-17
* device instance cc_XD2_XDFFM_S_XD3_XDFFM_SB r0 *1 0,0
Ccc_XD2_XDFFM_S_XD3_XDFFM_SB XD2.XDFFM.S XD3.XDFFM.SB 1.8151e-17
* device instance cc_XD2_XDFFM_S_XD3_XDFFQ_CLKB r0 *1 0,0
Ccc_XD2_XDFFM_S_XD3_XDFFQ_CLKB XD2.XDFFM.S XD3.XDFFQ.CLKB 1.8151e-17
* device instance cc_XD2_XDFFM_S_XD3_XDFFQ_M r0 *1 0,0
Ccc_XD2_XDFFM_S_XD3_XDFFQ_M XD2.XDFFM.S XD3.XDFFQ.M 2.4201e-17
* device instance cc_XD2_XDFFM_S_XD3_XDFFQ_MB r0 *1 0,0
Ccc_XD2_XDFFM_S_XD3_XDFFQ_MB XD2.XDFFM.S XD3.XDFFQ.MB 1.21e-17
* device instance cc_XD2_XDFFM_S_XD3_XDFFQ_S r0 *1 0,0
Ccc_XD2_XDFFM_S_XD3_XDFFQ_S XD2.XDFFM.S XD3.XDFFQ.S 1.8151e-17
* device instance cc_XD2_XDFFM_S_XD3_XDFFQ_SB r0 *1 0,0
Ccc_XD2_XDFFM_S_XD3_XDFFQ_SB XD2.XDFFM.S XD3.XDFFQ.SB 1.8151e-17
* device instance cc_XD2_XDFFM_S_XD3_XN2_mid1 r0 *1 0,0
Ccc_XD2_XDFFM_S_XD3_XN2_mid1 XD2.XDFFM.S XD3.XN2.mid1 1.21e-17
* device instance cc_XD2_XDFFM_S_XD3_XN3_mid1 r0 *1 0,0
Ccc_XD2_XDFFM_S_XD3_XN3_mid1 XD2.XDFFM.S XD3.XN3.mid1 1.21e-17
* device instance cc_XD2_XDFFM_S_XD3_XN3_mid2 r0 *1 0,0
Ccc_XD2_XDFFM_S_XD3_XN3_mid2 XD2.XDFFM.S XD3.XN3.mid2 1.21e-17
* device instance cc_XD2_XDFFM_S_XD3_dmodout r0 *1 0,0
Ccc_XD2_XDFFM_S_XD3_dmodout XD2.XDFFM.S XD3.dmodout 1.21e-17
* device instance cc_XD2_XDFFM_S_XD3_dq r0 *1 0,0
Ccc_XD2_XDFFM_S_XD3_dq XD2.XDFFM.S XD3.dq 1.8151e-17
* device instance cc_XD2_XDFFM_S_XD3_nm r0 *1 0,0
Ccc_XD2_XDFFM_S_XD3_nm XD2.XDFFM.S XD3.nm 1.21e-17
* device instance cc_XD2_XDFFM_S_XD3_nt r0 *1 0,0
Ccc_XD2_XDFFM_S_XD3_nt XD2.XDFFM.S XD3.nt 1.21e-17
* device instance cc_XD2_XDFFM_S_XD3_t1 r0 *1 0,0
Ccc_XD2_XDFFM_S_XD3_t1 XD2.XDFFM.S XD3.t1 1.21e-17
* device instance cc_XD2_XDFFM_S_XD4_XDFFM_CLKB r0 *1 0,0
Ccc_XD2_XDFFM_S_XD4_XDFFM_CLKB XD2.XDFFM.S XD4.XDFFM.CLKB 1.8151e-17
* device instance cc_XD2_XDFFM_S_XD4_XDFFM_M r0 *1 0,0
Ccc_XD2_XDFFM_S_XD4_XDFFM_M XD2.XDFFM.S XD4.XDFFM.M 2.4201e-17
* device instance cc_XD2_XDFFM_S_XD4_XDFFM_MB r0 *1 0,0
Ccc_XD2_XDFFM_S_XD4_XDFFM_MB XD2.XDFFM.S XD4.XDFFM.MB 1.21e-17
* device instance cc_XD2_XDFFM_S_XD4_XDFFM_S r0 *1 0,0
Ccc_XD2_XDFFM_S_XD4_XDFFM_S XD2.XDFFM.S XD4.XDFFM.S 1.8151e-17
* device instance cc_XD2_XDFFM_S_XD4_XDFFM_SB r0 *1 0,0
Ccc_XD2_XDFFM_S_XD4_XDFFM_SB XD2.XDFFM.S XD4.XDFFM.SB 1.8151e-17
* device instance cc_XD2_XDFFM_S_XD4_XDFFQ_CLKB r0 *1 0,0
Ccc_XD2_XDFFM_S_XD4_XDFFQ_CLKB XD2.XDFFM.S XD4.XDFFQ.CLKB 1.8151e-17
* device instance cc_XD2_XDFFM_S_XD4_XDFFQ_M r0 *1 0,0
Ccc_XD2_XDFFM_S_XD4_XDFFQ_M XD2.XDFFM.S XD4.XDFFQ.M 2.4201e-17
* device instance cc_XD2_XDFFM_S_XD4_XDFFQ_MB r0 *1 0,0
Ccc_XD2_XDFFM_S_XD4_XDFFQ_MB XD2.XDFFM.S XD4.XDFFQ.MB 1.21e-17
* device instance cc_XD2_XDFFM_S_XD4_XDFFQ_S r0 *1 0,0
Ccc_XD2_XDFFM_S_XD4_XDFFQ_S XD2.XDFFM.S XD4.XDFFQ.S 1.8151e-17
* device instance cc_XD2_XDFFM_S_XD4_XDFFQ_SB r0 *1 0,0
Ccc_XD2_XDFFM_S_XD4_XDFFQ_SB XD2.XDFFM.S XD4.XDFFQ.SB 1.8151e-17
* device instance cc_XD2_XDFFM_S_XD4_XN2_mid1 r0 *1 0,0
Ccc_XD2_XDFFM_S_XD4_XN2_mid1 XD2.XDFFM.S XD4.XN2.mid1 1.21e-17
* device instance cc_XD2_XDFFM_S_XD4_XN3_mid1 r0 *1 0,0
Ccc_XD2_XDFFM_S_XD4_XN3_mid1 XD2.XDFFM.S XD4.XN3.mid1 1.21e-17
* device instance cc_XD2_XDFFM_S_XD4_XN3_mid2 r0 *1 0,0
Ccc_XD2_XDFFM_S_XD4_XN3_mid2 XD2.XDFFM.S XD4.XN3.mid2 1.21e-17
* device instance cc_XD2_XDFFM_S_XD4_dmodout r0 *1 0,0
Ccc_XD2_XDFFM_S_XD4_dmodout XD2.XDFFM.S XD4.dmodout 1.21e-17
* device instance cc_XD2_XDFFM_S_XD4_dq r0 *1 0,0
Ccc_XD2_XDFFM_S_XD4_dq XD2.XDFFM.S XD4.dq 1.8151e-17
* device instance cc_XD2_XDFFM_S_XD4_nm r0 *1 0,0
Ccc_XD2_XDFFM_S_XD4_nm XD2.XDFFM.S XD4.nm 1.21e-17
* device instance cc_XD2_XDFFM_S_XD4_nt r0 *1 0,0
Ccc_XD2_XDFFM_S_XD4_nt XD2.XDFFM.S XD4.nt 1.21e-17
* device instance cc_XD2_XDFFM_S_XD4_t1 r0 *1 0,0
Ccc_XD2_XDFFM_S_XD4_t1 XD2.XDFFM.S XD4.t1 1.21e-17
* device instance cc_XD2_XDFFM_S_XD5_XDFFM_CLKB r0 *1 0,0
Ccc_XD2_XDFFM_S_XD5_XDFFM_CLKB XD2.XDFFM.S XD5.XDFFM.CLKB 1.8151e-17
* device instance cc_XD2_XDFFM_S_XD5_XDFFM_M r0 *1 0,0
Ccc_XD2_XDFFM_S_XD5_XDFFM_M XD2.XDFFM.S XD5.XDFFM.M 2.4201e-17
* device instance cc_XD2_XDFFM_S_XD5_XDFFM_MB r0 *1 0,0
Ccc_XD2_XDFFM_S_XD5_XDFFM_MB XD2.XDFFM.S XD5.XDFFM.MB 1.21e-17
* device instance cc_XD2_XDFFM_S_XD5_XDFFM_S r0 *1 0,0
Ccc_XD2_XDFFM_S_XD5_XDFFM_S XD2.XDFFM.S XD5.XDFFM.S 1.8151e-17
* device instance cc_XD2_XDFFM_S_XD5_XDFFM_SB r0 *1 0,0
Ccc_XD2_XDFFM_S_XD5_XDFFM_SB XD2.XDFFM.S XD5.XDFFM.SB 1.8151e-17
* device instance cc_XD2_XDFFM_S_XD5_XDFFQ_CLKB r0 *1 0,0
Ccc_XD2_XDFFM_S_XD5_XDFFQ_CLKB XD2.XDFFM.S XD5.XDFFQ.CLKB 1.8151e-17
* device instance cc_XD2_XDFFM_S_XD5_XDFFQ_M r0 *1 0,0
Ccc_XD2_XDFFM_S_XD5_XDFFQ_M XD2.XDFFM.S XD5.XDFFQ.M 2.4201e-17
* device instance cc_XD2_XDFFM_S_XD5_XDFFQ_MB r0 *1 0,0
Ccc_XD2_XDFFM_S_XD5_XDFFQ_MB XD2.XDFFM.S XD5.XDFFQ.MB 1.21e-17
* device instance cc_XD2_XDFFM_S_XD5_XDFFQ_S r0 *1 0,0
Ccc_XD2_XDFFM_S_XD5_XDFFQ_S XD2.XDFFM.S XD5.XDFFQ.S 1.8151e-17
* device instance cc_XD2_XDFFM_S_XD5_XDFFQ_SB r0 *1 0,0
Ccc_XD2_XDFFM_S_XD5_XDFFQ_SB XD2.XDFFM.S XD5.XDFFQ.SB 1.8151e-17
* device instance cc_XD2_XDFFM_S_XD5_XN2_mid1 r0 *1 0,0
Ccc_XD2_XDFFM_S_XD5_XN2_mid1 XD2.XDFFM.S XD5.XN2.mid1 1.21e-17
* device instance cc_XD2_XDFFM_S_XD5_XN3_mid1 r0 *1 0,0
Ccc_XD2_XDFFM_S_XD5_XN3_mid1 XD2.XDFFM.S XD5.XN3.mid1 1.21e-17
* device instance cc_XD2_XDFFM_S_XD5_XN3_mid2 r0 *1 0,0
Ccc_XD2_XDFFM_S_XD5_XN3_mid2 XD2.XDFFM.S XD5.XN3.mid2 1.21e-17
* device instance cc_XD2_XDFFM_S_XD5_dmodout r0 *1 0,0
Ccc_XD2_XDFFM_S_XD5_dmodout XD2.XDFFM.S XD5.dmodout 1.21e-17
* device instance cc_XD2_XDFFM_S_XD5_dq r0 *1 0,0
Ccc_XD2_XDFFM_S_XD5_dq XD2.XDFFM.S XD5.dq 1.8151e-17
* device instance cc_XD2_XDFFM_S_XD5_nm r0 *1 0,0
Ccc_XD2_XDFFM_S_XD5_nm XD2.XDFFM.S XD5.nm 1.21e-17
* device instance cc_XD2_XDFFM_S_XD5_nt r0 *1 0,0
Ccc_XD2_XDFFM_S_XD5_nt XD2.XDFFM.S XD5.nt 1.21e-17
* device instance cc_XD2_XDFFM_S_XD5_t1 r0 *1 0,0
Ccc_XD2_XDFFM_S_XD5_t1 XD2.XDFFM.S XD5.t1 1.21e-17
* device instance cc_XD2_XDFFM_S_XFRT_CLKB r0 *1 0,0
Ccc_XD2_XDFFM_S_XFRT_CLKB XD2.XDFFM.S XFRT.CLKB 1.8151e-17
* device instance cc_XD2_XDFFM_S_XFRT_M r0 *1 0,0
Ccc_XD2_XDFFM_S_XFRT_M XD2.XDFFM.S XFRT.M 2.4201e-17
* device instance cc_XD2_XDFFM_S_XFRT_MB r0 *1 0,0
Ccc_XD2_XDFFM_S_XFRT_MB XD2.XDFFM.S XFRT.MB 1.21e-17
* device instance cc_XD2_XDFFM_S_XFRT_S r0 *1 0,0
Ccc_XD2_XDFFM_S_XFRT_S XD2.XDFFM.S XFRT.S 1.8151e-17
* device instance cc_XD2_XDFFM_S_XFRT_SB r0 *1 0,0
Ccc_XD2_XDFFM_S_XFRT_SB XD2.XDFFM.S XFRT.SB 1.8151e-17
* device instance cc_XD2_XDFFM_S_ck1 r0 *1 0,0
Ccc_XD2_XDFFM_S_ck1 XD2.XDFFM.S ck1 5.4452e-17
* device instance cc_XD2_XDFFM_S_ck2 r0 *1 0,0
Ccc_XD2_XDFFM_S_ck2 XD2.XDFFM.S ck2 5.4452e-17
* device instance cc_XD2_XDFFM_S_ck3 r0 *1 0,0
Ccc_XD2_XDFFM_S_ck3 XD2.XDFFM.S ck3 5.4452e-17
* device instance cc_XD2_XDFFM_S_ck4 r0 *1 0,0
Ccc_XD2_XDFFM_S_ck4 XD2.XDFFM.S ck4 5.4452e-17
* device instance cc_XD2_XDFFM_S_ck5 r0 *1 0,0
Ccc_XD2_XDFFM_S_ck5 XD2.XDFFM.S ck5 5.4452e-17
* device instance cc_XD2_XDFFM_S_mod0 r0 *1 0,0
Ccc_XD2_XDFFM_S_mod0 XD2.XDFFM.S mod0 2.4201e-17
* device instance cc_XD2_XDFFM_S_mod1 r0 *1 0,0
Ccc_XD2_XDFFM_S_mod1 XD2.XDFFM.S mod1 2.4201e-17
* device instance cc_XD2_XDFFM_S_mod2 r0 *1 0,0
Ccc_XD2_XDFFM_S_mod2 XD2.XDFFM.S mod2 2.4201e-17
* device instance cc_XD2_XDFFM_S_mod3 r0 *1 0,0
Ccc_XD2_XDFFM_S_mod3 XD2.XDFFM.S mod3 2.4201e-17
* device instance cc_XD2_XDFFM_S_mod4 r0 *1 0,0
Ccc_XD2_XDFFM_S_mod4 XD2.XDFFM.S mod4 2.4201e-17
* device instance cc_XD2_XDFFM_S_net1 r0 *1 0,0
Ccc_XD2_XDFFM_S_net1 XD2.XDFFM.S net1 1.21e-17
* device instance cc_XD2_XDFFM_SB_XD2_XDFFQ_CLKB r0 *1 0,0
Ccc_XD2_XDFFM_SB_XD2_XDFFQ_CLKB XD2.XDFFM.SB XD2.XDFFQ.CLKB 1.8151e-17
* device instance cc_XD2_XDFFM_SB_XD2_XDFFQ_M r0 *1 0,0
Ccc_XD2_XDFFM_SB_XD2_XDFFQ_M XD2.XDFFM.SB XD2.XDFFQ.M 2.4201e-17
* device instance cc_XD2_XDFFM_SB_XD2_XDFFQ_MB r0 *1 0,0
Ccc_XD2_XDFFM_SB_XD2_XDFFQ_MB XD2.XDFFM.SB XD2.XDFFQ.MB 1.21e-17
* device instance cc_XD2_XDFFM_SB_XD2_XDFFQ_S r0 *1 0,0
Ccc_XD2_XDFFM_SB_XD2_XDFFQ_S XD2.XDFFM.SB XD2.XDFFQ.S 1.8151e-17
* device instance cc_XD2_XDFFM_SB_XD2_XDFFQ_SB r0 *1 0,0
Ccc_XD2_XDFFM_SB_XD2_XDFFQ_SB XD2.XDFFM.SB XD2.XDFFQ.SB 1.8151e-17
* device instance cc_XD2_XDFFM_SB_XD2_XNOR_midp r0 *1 0,0
Ccc_XD2_XDFFM_SB_XD2_XNOR_midp XD2.XDFFM.SB XD2.XNOR.midp 1.21e-17
* device instance cc_XD2_XDFFM_SB_XD2_dmodout r0 *1 0,0
Ccc_XD2_XDFFM_SB_XD2_dmodout XD2.XDFFM.SB XD2.dmodout 1.21e-17
* device instance cc_XD2_XDFFM_SB_XD2_dq r0 *1 0,0
Ccc_XD2_XDFFM_SB_XD2_dq XD2.XDFFM.SB XD2.dq 1.21e-17
* device instance cc_XD2_XDFFM_SB_XD2_nm r0 *1 0,0
Ccc_XD2_XDFFM_SB_XD2_nm XD2.XDFFM.SB XD2.nm 1.8151e-17
* device instance cc_XD2_XDFFM_SB_XD2_nt r0 *1 0,0
Ccc_XD2_XDFFM_SB_XD2_nt XD2.XDFFM.SB XD2.nt 2.4201e-17
* device instance cc_XD2_XDFFM_SB_XD2_t1 r0 *1 0,0
Ccc_XD2_XDFFM_SB_XD2_t1 XD2.XDFFM.SB XD2.t1 1.21e-17
* device instance cc_XD2_XDFFM_SB_XD3_XDFFM_CLKB r0 *1 0,0
Ccc_XD2_XDFFM_SB_XD3_XDFFM_CLKB XD2.XDFFM.SB XD3.XDFFM.CLKB 1.8151e-17
* device instance cc_XD2_XDFFM_SB_XD3_XDFFM_M r0 *1 0,0
Ccc_XD2_XDFFM_SB_XD3_XDFFM_M XD2.XDFFM.SB XD3.XDFFM.M 2.4201e-17
* device instance cc_XD2_XDFFM_SB_XD3_XDFFM_MB r0 *1 0,0
Ccc_XD2_XDFFM_SB_XD3_XDFFM_MB XD2.XDFFM.SB XD3.XDFFM.MB 1.21e-17
* device instance cc_XD2_XDFFM_SB_XD3_XDFFM_S r0 *1 0,0
Ccc_XD2_XDFFM_SB_XD3_XDFFM_S XD2.XDFFM.SB XD3.XDFFM.S 1.8151e-17
* device instance cc_XD2_XDFFM_SB_XD3_XDFFM_SB r0 *1 0,0
Ccc_XD2_XDFFM_SB_XD3_XDFFM_SB XD2.XDFFM.SB XD3.XDFFM.SB 1.8151e-17
* device instance cc_XD2_XDFFM_SB_XD3_XDFFQ_CLKB r0 *1 0,0
Ccc_XD2_XDFFM_SB_XD3_XDFFQ_CLKB XD2.XDFFM.SB XD3.XDFFQ.CLKB 1.8151e-17
* device instance cc_XD2_XDFFM_SB_XD3_XDFFQ_M r0 *1 0,0
Ccc_XD2_XDFFM_SB_XD3_XDFFQ_M XD2.XDFFM.SB XD3.XDFFQ.M 2.4201e-17
* device instance cc_XD2_XDFFM_SB_XD3_XDFFQ_MB r0 *1 0,0
Ccc_XD2_XDFFM_SB_XD3_XDFFQ_MB XD2.XDFFM.SB XD3.XDFFQ.MB 1.21e-17
* device instance cc_XD2_XDFFM_SB_XD3_XDFFQ_S r0 *1 0,0
Ccc_XD2_XDFFM_SB_XD3_XDFFQ_S XD2.XDFFM.SB XD3.XDFFQ.S 1.8151e-17
* device instance cc_XD2_XDFFM_SB_XD3_XDFFQ_SB r0 *1 0,0
Ccc_XD2_XDFFM_SB_XD3_XDFFQ_SB XD2.XDFFM.SB XD3.XDFFQ.SB 1.8151e-17
* device instance cc_XD2_XDFFM_SB_XD3_XN2_mid1 r0 *1 0,0
Ccc_XD2_XDFFM_SB_XD3_XN2_mid1 XD2.XDFFM.SB XD3.XN2.mid1 1.21e-17
* device instance cc_XD2_XDFFM_SB_XD3_XN3_mid1 r0 *1 0,0
Ccc_XD2_XDFFM_SB_XD3_XN3_mid1 XD2.XDFFM.SB XD3.XN3.mid1 1.21e-17
* device instance cc_XD2_XDFFM_SB_XD3_XN3_mid2 r0 *1 0,0
Ccc_XD2_XDFFM_SB_XD3_XN3_mid2 XD2.XDFFM.SB XD3.XN3.mid2 1.21e-17
* device instance cc_XD2_XDFFM_SB_XD3_dmodout r0 *1 0,0
Ccc_XD2_XDFFM_SB_XD3_dmodout XD2.XDFFM.SB XD3.dmodout 1.21e-17
* device instance cc_XD2_XDFFM_SB_XD3_dq r0 *1 0,0
Ccc_XD2_XDFFM_SB_XD3_dq XD2.XDFFM.SB XD3.dq 1.8151e-17
* device instance cc_XD2_XDFFM_SB_XD3_nm r0 *1 0,0
Ccc_XD2_XDFFM_SB_XD3_nm XD2.XDFFM.SB XD3.nm 1.21e-17
* device instance cc_XD2_XDFFM_SB_XD3_nt r0 *1 0,0
Ccc_XD2_XDFFM_SB_XD3_nt XD2.XDFFM.SB XD3.nt 1.21e-17
* device instance cc_XD2_XDFFM_SB_XD3_t1 r0 *1 0,0
Ccc_XD2_XDFFM_SB_XD3_t1 XD2.XDFFM.SB XD3.t1 1.21e-17
* device instance cc_XD2_XDFFM_SB_XD4_XDFFM_CLKB r0 *1 0,0
Ccc_XD2_XDFFM_SB_XD4_XDFFM_CLKB XD2.XDFFM.SB XD4.XDFFM.CLKB 1.8151e-17
* device instance cc_XD2_XDFFM_SB_XD4_XDFFM_M r0 *1 0,0
Ccc_XD2_XDFFM_SB_XD4_XDFFM_M XD2.XDFFM.SB XD4.XDFFM.M 2.4201e-17
* device instance cc_XD2_XDFFM_SB_XD4_XDFFM_MB r0 *1 0,0
Ccc_XD2_XDFFM_SB_XD4_XDFFM_MB XD2.XDFFM.SB XD4.XDFFM.MB 1.21e-17
* device instance cc_XD2_XDFFM_SB_XD4_XDFFM_S r0 *1 0,0
Ccc_XD2_XDFFM_SB_XD4_XDFFM_S XD2.XDFFM.SB XD4.XDFFM.S 1.8151e-17
* device instance cc_XD2_XDFFM_SB_XD4_XDFFM_SB r0 *1 0,0
Ccc_XD2_XDFFM_SB_XD4_XDFFM_SB XD2.XDFFM.SB XD4.XDFFM.SB 1.8151e-17
* device instance cc_XD2_XDFFM_SB_XD4_XDFFQ_CLKB r0 *1 0,0
Ccc_XD2_XDFFM_SB_XD4_XDFFQ_CLKB XD2.XDFFM.SB XD4.XDFFQ.CLKB 1.8151e-17
* device instance cc_XD2_XDFFM_SB_XD4_XDFFQ_M r0 *1 0,0
Ccc_XD2_XDFFM_SB_XD4_XDFFQ_M XD2.XDFFM.SB XD4.XDFFQ.M 2.4201e-17
* device instance cc_XD2_XDFFM_SB_XD4_XDFFQ_MB r0 *1 0,0
Ccc_XD2_XDFFM_SB_XD4_XDFFQ_MB XD2.XDFFM.SB XD4.XDFFQ.MB 1.21e-17
* device instance cc_XD2_XDFFM_SB_XD4_XDFFQ_S r0 *1 0,0
Ccc_XD2_XDFFM_SB_XD4_XDFFQ_S XD2.XDFFM.SB XD4.XDFFQ.S 1.8151e-17
* device instance cc_XD2_XDFFM_SB_XD4_XDFFQ_SB r0 *1 0,0
Ccc_XD2_XDFFM_SB_XD4_XDFFQ_SB XD2.XDFFM.SB XD4.XDFFQ.SB 1.8151e-17
* device instance cc_XD2_XDFFM_SB_XD4_XN2_mid1 r0 *1 0,0
Ccc_XD2_XDFFM_SB_XD4_XN2_mid1 XD2.XDFFM.SB XD4.XN2.mid1 1.21e-17
* device instance cc_XD2_XDFFM_SB_XD4_XN3_mid1 r0 *1 0,0
Ccc_XD2_XDFFM_SB_XD4_XN3_mid1 XD2.XDFFM.SB XD4.XN3.mid1 1.21e-17
* device instance cc_XD2_XDFFM_SB_XD4_XN3_mid2 r0 *1 0,0
Ccc_XD2_XDFFM_SB_XD4_XN3_mid2 XD2.XDFFM.SB XD4.XN3.mid2 1.21e-17
* device instance cc_XD2_XDFFM_SB_XD4_dmodout r0 *1 0,0
Ccc_XD2_XDFFM_SB_XD4_dmodout XD2.XDFFM.SB XD4.dmodout 1.21e-17
* device instance cc_XD2_XDFFM_SB_XD4_dq r0 *1 0,0
Ccc_XD2_XDFFM_SB_XD4_dq XD2.XDFFM.SB XD4.dq 1.8151e-17
* device instance cc_XD2_XDFFM_SB_XD4_nm r0 *1 0,0
Ccc_XD2_XDFFM_SB_XD4_nm XD2.XDFFM.SB XD4.nm 1.21e-17
* device instance cc_XD2_XDFFM_SB_XD4_nt r0 *1 0,0
Ccc_XD2_XDFFM_SB_XD4_nt XD2.XDFFM.SB XD4.nt 1.21e-17
* device instance cc_XD2_XDFFM_SB_XD4_t1 r0 *1 0,0
Ccc_XD2_XDFFM_SB_XD4_t1 XD2.XDFFM.SB XD4.t1 1.21e-17
* device instance cc_XD2_XDFFM_SB_XD5_XDFFM_CLKB r0 *1 0,0
Ccc_XD2_XDFFM_SB_XD5_XDFFM_CLKB XD2.XDFFM.SB XD5.XDFFM.CLKB 1.8151e-17
* device instance cc_XD2_XDFFM_SB_XD5_XDFFM_M r0 *1 0,0
Ccc_XD2_XDFFM_SB_XD5_XDFFM_M XD2.XDFFM.SB XD5.XDFFM.M 2.4201e-17
* device instance cc_XD2_XDFFM_SB_XD5_XDFFM_MB r0 *1 0,0
Ccc_XD2_XDFFM_SB_XD5_XDFFM_MB XD2.XDFFM.SB XD5.XDFFM.MB 1.21e-17
* device instance cc_XD2_XDFFM_SB_XD5_XDFFM_S r0 *1 0,0
Ccc_XD2_XDFFM_SB_XD5_XDFFM_S XD2.XDFFM.SB XD5.XDFFM.S 1.8151e-17
* device instance cc_XD2_XDFFM_SB_XD5_XDFFM_SB r0 *1 0,0
Ccc_XD2_XDFFM_SB_XD5_XDFFM_SB XD2.XDFFM.SB XD5.XDFFM.SB 1.8151e-17
* device instance cc_XD2_XDFFM_SB_XD5_XDFFQ_CLKB r0 *1 0,0
Ccc_XD2_XDFFM_SB_XD5_XDFFQ_CLKB XD2.XDFFM.SB XD5.XDFFQ.CLKB 1.8151e-17
* device instance cc_XD2_XDFFM_SB_XD5_XDFFQ_M r0 *1 0,0
Ccc_XD2_XDFFM_SB_XD5_XDFFQ_M XD2.XDFFM.SB XD5.XDFFQ.M 2.4201e-17
* device instance cc_XD2_XDFFM_SB_XD5_XDFFQ_MB r0 *1 0,0
Ccc_XD2_XDFFM_SB_XD5_XDFFQ_MB XD2.XDFFM.SB XD5.XDFFQ.MB 1.21e-17
* device instance cc_XD2_XDFFM_SB_XD5_XDFFQ_S r0 *1 0,0
Ccc_XD2_XDFFM_SB_XD5_XDFFQ_S XD2.XDFFM.SB XD5.XDFFQ.S 1.8151e-17
* device instance cc_XD2_XDFFM_SB_XD5_XDFFQ_SB r0 *1 0,0
Ccc_XD2_XDFFM_SB_XD5_XDFFQ_SB XD2.XDFFM.SB XD5.XDFFQ.SB 1.8151e-17
* device instance cc_XD2_XDFFM_SB_XD5_XN2_mid1 r0 *1 0,0
Ccc_XD2_XDFFM_SB_XD5_XN2_mid1 XD2.XDFFM.SB XD5.XN2.mid1 1.21e-17
* device instance cc_XD2_XDFFM_SB_XD5_XN3_mid1 r0 *1 0,0
Ccc_XD2_XDFFM_SB_XD5_XN3_mid1 XD2.XDFFM.SB XD5.XN3.mid1 1.21e-17
* device instance cc_XD2_XDFFM_SB_XD5_XN3_mid2 r0 *1 0,0
Ccc_XD2_XDFFM_SB_XD5_XN3_mid2 XD2.XDFFM.SB XD5.XN3.mid2 1.21e-17
* device instance cc_XD2_XDFFM_SB_XD5_dmodout r0 *1 0,0
Ccc_XD2_XDFFM_SB_XD5_dmodout XD2.XDFFM.SB XD5.dmodout 1.21e-17
* device instance cc_XD2_XDFFM_SB_XD5_dq r0 *1 0,0
Ccc_XD2_XDFFM_SB_XD5_dq XD2.XDFFM.SB XD5.dq 1.8151e-17
* device instance cc_XD2_XDFFM_SB_XD5_nm r0 *1 0,0
Ccc_XD2_XDFFM_SB_XD5_nm XD2.XDFFM.SB XD5.nm 1.21e-17
* device instance cc_XD2_XDFFM_SB_XD5_nt r0 *1 0,0
Ccc_XD2_XDFFM_SB_XD5_nt XD2.XDFFM.SB XD5.nt 1.21e-17
* device instance cc_XD2_XDFFM_SB_XD5_t1 r0 *1 0,0
Ccc_XD2_XDFFM_SB_XD5_t1 XD2.XDFFM.SB XD5.t1 1.21e-17
* device instance cc_XD2_XDFFM_SB_XFRT_CLKB r0 *1 0,0
Ccc_XD2_XDFFM_SB_XFRT_CLKB XD2.XDFFM.SB XFRT.CLKB 1.8151e-17
* device instance cc_XD2_XDFFM_SB_XFRT_M r0 *1 0,0
Ccc_XD2_XDFFM_SB_XFRT_M XD2.XDFFM.SB XFRT.M 2.4201e-17
* device instance cc_XD2_XDFFM_SB_XFRT_MB r0 *1 0,0
Ccc_XD2_XDFFM_SB_XFRT_MB XD2.XDFFM.SB XFRT.MB 1.21e-17
* device instance cc_XD2_XDFFM_SB_XFRT_S r0 *1 0,0
Ccc_XD2_XDFFM_SB_XFRT_S XD2.XDFFM.SB XFRT.S 1.8151e-17
* device instance cc_XD2_XDFFM_SB_XFRT_SB r0 *1 0,0
Ccc_XD2_XDFFM_SB_XFRT_SB XD2.XDFFM.SB XFRT.SB 1.8151e-17
* device instance cc_XD2_XDFFM_SB_ck1 r0 *1 0,0
Ccc_XD2_XDFFM_SB_ck1 XD2.XDFFM.SB ck1 5.4452e-17
* device instance cc_XD2_XDFFM_SB_ck2 r0 *1 0,0
Ccc_XD2_XDFFM_SB_ck2 XD2.XDFFM.SB ck2 5.4452e-17
* device instance cc_XD2_XDFFM_SB_ck3 r0 *1 0,0
Ccc_XD2_XDFFM_SB_ck3 XD2.XDFFM.SB ck3 5.4452e-17
* device instance cc_XD2_XDFFM_SB_ck4 r0 *1 0,0
Ccc_XD2_XDFFM_SB_ck4 XD2.XDFFM.SB ck4 5.4452e-17
* device instance cc_XD2_XDFFM_SB_ck5 r0 *1 0,0
Ccc_XD2_XDFFM_SB_ck5 XD2.XDFFM.SB ck5 5.4452e-17
* device instance cc_XD2_XDFFM_SB_mod0 r0 *1 0,0
Ccc_XD2_XDFFM_SB_mod0 XD2.XDFFM.SB mod0 2.4201e-17
* device instance cc_XD2_XDFFM_SB_mod1 r0 *1 0,0
Ccc_XD2_XDFFM_SB_mod1 XD2.XDFFM.SB mod1 2.4201e-17
* device instance cc_XD2_XDFFM_SB_mod2 r0 *1 0,0
Ccc_XD2_XDFFM_SB_mod2 XD2.XDFFM.SB mod2 2.4201e-17
* device instance cc_XD2_XDFFM_SB_mod3 r0 *1 0,0
Ccc_XD2_XDFFM_SB_mod3 XD2.XDFFM.SB mod3 2.4201e-17
* device instance cc_XD2_XDFFM_SB_mod4 r0 *1 0,0
Ccc_XD2_XDFFM_SB_mod4 XD2.XDFFM.SB mod4 2.4201e-17
* device instance cc_XD2_XDFFM_SB_net1 r0 *1 0,0
Ccc_XD2_XDFFM_SB_net1 XD2.XDFFM.SB net1 1.21e-17
* device instance cc_XD2_XDFFQ_CLKB_XD2_XDFFQ_M r0 *1 0,0
Ccc_XD2_XDFFQ_CLKB_XD2_XDFFQ_M XD2.XDFFQ.CLKB XD2.XDFFQ.M 4.2352e-17
* device instance cc_XD2_XDFFQ_CLKB_XD2_XDFFQ_MB r0 *1 0,0
Ccc_XD2_XDFFQ_CLKB_XD2_XDFFQ_MB XD2.XDFFQ.CLKB XD2.XDFFQ.MB 2.4201e-17
* device instance cc_XD2_XDFFQ_CLKB_XD2_XDFFQ_S r0 *1 0,0
Ccc_XD2_XDFFQ_CLKB_XD2_XDFFQ_S XD2.XDFFQ.CLKB XD2.XDFFQ.S 1.8151e-17
* device instance cc_XD2_XDFFQ_CLKB_XD2_XDFFQ_SB r0 *1 0,0
Ccc_XD2_XDFFQ_CLKB_XD2_XDFFQ_SB XD2.XDFFQ.CLKB XD2.XDFFQ.SB 1.8151e-17
* device instance cc_XD2_XDFFQ_CLKB_XD2_XN2_mid1 r0 *1 0,0
Ccc_XD2_XDFFQ_CLKB_XD2_XN2_mid1 XD2.XDFFQ.CLKB XD2.XN2.mid1 1.21e-17
* device instance cc_XD2_XDFFQ_CLKB_XD2_XNOR_midp r0 *1 0,0
Ccc_XD2_XDFFQ_CLKB_XD2_XNOR_midp XD2.XDFFQ.CLKB XD2.XNOR.midp 1.21e-17
* device instance cc_XD2_XDFFQ_CLKB_XD2_dmodout r0 *1 0,0
Ccc_XD2_XDFFQ_CLKB_XD2_dmodout XD2.XDFFQ.CLKB XD2.dmodout 1.21e-17
* device instance cc_XD2_XDFFQ_CLKB_XD2_dq r0 *1 0,0
Ccc_XD2_XDFFQ_CLKB_XD2_dq XD2.XDFFQ.CLKB XD2.dq 1.8151e-17
* device instance cc_XD2_XDFFQ_CLKB_XD2_nm r0 *1 0,0
Ccc_XD2_XDFFQ_CLKB_XD2_nm XD2.XDFFQ.CLKB XD2.nm 1.21e-17
* device instance cc_XD2_XDFFQ_CLKB_XD2_nt r0 *1 0,0
Ccc_XD2_XDFFQ_CLKB_XD2_nt XD2.XDFFQ.CLKB XD2.nt 2.4201e-17
* device instance cc_XD2_XDFFQ_CLKB_XD2_t1 r0 *1 0,0
Ccc_XD2_XDFFQ_CLKB_XD2_t1 XD2.XDFFQ.CLKB XD2.t1 1.21e-17
* device instance cc_XD2_XDFFQ_CLKB_XD3_XDFFM_CLKB r0 *1 0,0
Ccc_XD2_XDFFQ_CLKB_XD3_XDFFM_CLKB XD2.XDFFQ.CLKB XD3.XDFFM.CLKB 1.8151e-17
* device instance cc_XD2_XDFFQ_CLKB_XD3_XDFFM_M r0 *1 0,0
Ccc_XD2_XDFFQ_CLKB_XD3_XDFFM_M XD2.XDFFQ.CLKB XD3.XDFFM.M 2.4201e-17
* device instance cc_XD2_XDFFQ_CLKB_XD3_XDFFM_MB r0 *1 0,0
Ccc_XD2_XDFFQ_CLKB_XD3_XDFFM_MB XD2.XDFFQ.CLKB XD3.XDFFM.MB 1.21e-17
* device instance cc_XD2_XDFFQ_CLKB_XD3_XDFFM_S r0 *1 0,0
Ccc_XD2_XDFFQ_CLKB_XD3_XDFFM_S XD2.XDFFQ.CLKB XD3.XDFFM.S 1.8151e-17
* device instance cc_XD2_XDFFQ_CLKB_XD3_XDFFM_SB r0 *1 0,0
Ccc_XD2_XDFFQ_CLKB_XD3_XDFFM_SB XD2.XDFFQ.CLKB XD3.XDFFM.SB 1.8151e-17
* device instance cc_XD2_XDFFQ_CLKB_XD3_XDFFQ_CLKB r0 *1 0,0
Ccc_XD2_XDFFQ_CLKB_XD3_XDFFQ_CLKB XD2.XDFFQ.CLKB XD3.XDFFQ.CLKB 1.8151e-17
* device instance cc_XD2_XDFFQ_CLKB_XD3_XDFFQ_M r0 *1 0,0
Ccc_XD2_XDFFQ_CLKB_XD3_XDFFQ_M XD2.XDFFQ.CLKB XD3.XDFFQ.M 2.4201e-17
* device instance cc_XD2_XDFFQ_CLKB_XD3_XDFFQ_MB r0 *1 0,0
Ccc_XD2_XDFFQ_CLKB_XD3_XDFFQ_MB XD2.XDFFQ.CLKB XD3.XDFFQ.MB 1.21e-17
* device instance cc_XD2_XDFFQ_CLKB_XD3_XDFFQ_S r0 *1 0,0
Ccc_XD2_XDFFQ_CLKB_XD3_XDFFQ_S XD2.XDFFQ.CLKB XD3.XDFFQ.S 1.8151e-17
* device instance cc_XD2_XDFFQ_CLKB_XD3_XDFFQ_SB r0 *1 0,0
Ccc_XD2_XDFFQ_CLKB_XD3_XDFFQ_SB XD2.XDFFQ.CLKB XD3.XDFFQ.SB 1.8151e-17
* device instance cc_XD2_XDFFQ_CLKB_XD3_XN2_mid1 r0 *1 0,0
Ccc_XD2_XDFFQ_CLKB_XD3_XN2_mid1 XD2.XDFFQ.CLKB XD3.XN2.mid1 1.21e-17
* device instance cc_XD2_XDFFQ_CLKB_XD3_XN3_mid1 r0 *1 0,0
Ccc_XD2_XDFFQ_CLKB_XD3_XN3_mid1 XD2.XDFFQ.CLKB XD3.XN3.mid1 1.21e-17
* device instance cc_XD2_XDFFQ_CLKB_XD3_XN3_mid2 r0 *1 0,0
Ccc_XD2_XDFFQ_CLKB_XD3_XN3_mid2 XD2.XDFFQ.CLKB XD3.XN3.mid2 1.21e-17
* device instance cc_XD2_XDFFQ_CLKB_XD3_dmodout r0 *1 0,0
Ccc_XD2_XDFFQ_CLKB_XD3_dmodout XD2.XDFFQ.CLKB XD3.dmodout 1.21e-17
* device instance cc_XD2_XDFFQ_CLKB_XD3_dq r0 *1 0,0
Ccc_XD2_XDFFQ_CLKB_XD3_dq XD2.XDFFQ.CLKB XD3.dq 1.8151e-17
* device instance cc_XD2_XDFFQ_CLKB_XD3_nm r0 *1 0,0
Ccc_XD2_XDFFQ_CLKB_XD3_nm XD2.XDFFQ.CLKB XD3.nm 1.21e-17
* device instance cc_XD2_XDFFQ_CLKB_XD3_nt r0 *1 0,0
Ccc_XD2_XDFFQ_CLKB_XD3_nt XD2.XDFFQ.CLKB XD3.nt 1.21e-17
* device instance cc_XD2_XDFFQ_CLKB_XD3_t1 r0 *1 0,0
Ccc_XD2_XDFFQ_CLKB_XD3_t1 XD2.XDFFQ.CLKB XD3.t1 1.21e-17
* device instance cc_XD2_XDFFQ_CLKB_XD4_XDFFM_CLKB r0 *1 0,0
Ccc_XD2_XDFFQ_CLKB_XD4_XDFFM_CLKB XD2.XDFFQ.CLKB XD4.XDFFM.CLKB 1.8151e-17
* device instance cc_XD2_XDFFQ_CLKB_XD4_XDFFM_M r0 *1 0,0
Ccc_XD2_XDFFQ_CLKB_XD4_XDFFM_M XD2.XDFFQ.CLKB XD4.XDFFM.M 2.4201e-17
* device instance cc_XD2_XDFFQ_CLKB_XD4_XDFFM_MB r0 *1 0,0
Ccc_XD2_XDFFQ_CLKB_XD4_XDFFM_MB XD2.XDFFQ.CLKB XD4.XDFFM.MB 1.21e-17
* device instance cc_XD2_XDFFQ_CLKB_XD4_XDFFM_S r0 *1 0,0
Ccc_XD2_XDFFQ_CLKB_XD4_XDFFM_S XD2.XDFFQ.CLKB XD4.XDFFM.S 1.8151e-17
* device instance cc_XD2_XDFFQ_CLKB_XD4_XDFFM_SB r0 *1 0,0
Ccc_XD2_XDFFQ_CLKB_XD4_XDFFM_SB XD2.XDFFQ.CLKB XD4.XDFFM.SB 1.8151e-17
* device instance cc_XD2_XDFFQ_CLKB_XD4_XDFFQ_CLKB r0 *1 0,0
Ccc_XD2_XDFFQ_CLKB_XD4_XDFFQ_CLKB XD2.XDFFQ.CLKB XD4.XDFFQ.CLKB 1.8151e-17
* device instance cc_XD2_XDFFQ_CLKB_XD4_XDFFQ_M r0 *1 0,0
Ccc_XD2_XDFFQ_CLKB_XD4_XDFFQ_M XD2.XDFFQ.CLKB XD4.XDFFQ.M 2.4201e-17
* device instance cc_XD2_XDFFQ_CLKB_XD4_XDFFQ_MB r0 *1 0,0
Ccc_XD2_XDFFQ_CLKB_XD4_XDFFQ_MB XD2.XDFFQ.CLKB XD4.XDFFQ.MB 1.21e-17
* device instance cc_XD2_XDFFQ_CLKB_XD4_XDFFQ_S r0 *1 0,0
Ccc_XD2_XDFFQ_CLKB_XD4_XDFFQ_S XD2.XDFFQ.CLKB XD4.XDFFQ.S 1.8151e-17
* device instance cc_XD2_XDFFQ_CLKB_XD4_XDFFQ_SB r0 *1 0,0
Ccc_XD2_XDFFQ_CLKB_XD4_XDFFQ_SB XD2.XDFFQ.CLKB XD4.XDFFQ.SB 1.8151e-17
* device instance cc_XD2_XDFFQ_CLKB_XD4_XN2_mid1 r0 *1 0,0
Ccc_XD2_XDFFQ_CLKB_XD4_XN2_mid1 XD2.XDFFQ.CLKB XD4.XN2.mid1 1.21e-17
* device instance cc_XD2_XDFFQ_CLKB_XD4_XN3_mid1 r0 *1 0,0
Ccc_XD2_XDFFQ_CLKB_XD4_XN3_mid1 XD2.XDFFQ.CLKB XD4.XN3.mid1 1.21e-17
* device instance cc_XD2_XDFFQ_CLKB_XD4_XN3_mid2 r0 *1 0,0
Ccc_XD2_XDFFQ_CLKB_XD4_XN3_mid2 XD2.XDFFQ.CLKB XD4.XN3.mid2 1.21e-17
* device instance cc_XD2_XDFFQ_CLKB_XD4_dmodout r0 *1 0,0
Ccc_XD2_XDFFQ_CLKB_XD4_dmodout XD2.XDFFQ.CLKB XD4.dmodout 1.21e-17
* device instance cc_XD2_XDFFQ_CLKB_XD4_dq r0 *1 0,0
Ccc_XD2_XDFFQ_CLKB_XD4_dq XD2.XDFFQ.CLKB XD4.dq 1.8151e-17
* device instance cc_XD2_XDFFQ_CLKB_XD4_nm r0 *1 0,0
Ccc_XD2_XDFFQ_CLKB_XD4_nm XD2.XDFFQ.CLKB XD4.nm 1.21e-17
* device instance cc_XD2_XDFFQ_CLKB_XD4_nt r0 *1 0,0
Ccc_XD2_XDFFQ_CLKB_XD4_nt XD2.XDFFQ.CLKB XD4.nt 1.21e-17
* device instance cc_XD2_XDFFQ_CLKB_XD4_t1 r0 *1 0,0
Ccc_XD2_XDFFQ_CLKB_XD4_t1 XD2.XDFFQ.CLKB XD4.t1 1.21e-17
* device instance cc_XD2_XDFFQ_CLKB_XD5_XDFFM_CLKB r0 *1 0,0
Ccc_XD2_XDFFQ_CLKB_XD5_XDFFM_CLKB XD2.XDFFQ.CLKB XD5.XDFFM.CLKB 1.8151e-17
* device instance cc_XD2_XDFFQ_CLKB_XD5_XDFFM_M r0 *1 0,0
Ccc_XD2_XDFFQ_CLKB_XD5_XDFFM_M XD2.XDFFQ.CLKB XD5.XDFFM.M 2.4201e-17
* device instance cc_XD2_XDFFQ_CLKB_XD5_XDFFM_MB r0 *1 0,0
Ccc_XD2_XDFFQ_CLKB_XD5_XDFFM_MB XD2.XDFFQ.CLKB XD5.XDFFM.MB 1.21e-17
* device instance cc_XD2_XDFFQ_CLKB_XD5_XDFFM_S r0 *1 0,0
Ccc_XD2_XDFFQ_CLKB_XD5_XDFFM_S XD2.XDFFQ.CLKB XD5.XDFFM.S 1.8151e-17
* device instance cc_XD2_XDFFQ_CLKB_XD5_XDFFM_SB r0 *1 0,0
Ccc_XD2_XDFFQ_CLKB_XD5_XDFFM_SB XD2.XDFFQ.CLKB XD5.XDFFM.SB 1.8151e-17
* device instance cc_XD2_XDFFQ_CLKB_XD5_XDFFQ_CLKB r0 *1 0,0
Ccc_XD2_XDFFQ_CLKB_XD5_XDFFQ_CLKB XD2.XDFFQ.CLKB XD5.XDFFQ.CLKB 1.8151e-17
* device instance cc_XD2_XDFFQ_CLKB_XD5_XDFFQ_M r0 *1 0,0
Ccc_XD2_XDFFQ_CLKB_XD5_XDFFQ_M XD2.XDFFQ.CLKB XD5.XDFFQ.M 2.4201e-17
* device instance cc_XD2_XDFFQ_CLKB_XD5_XDFFQ_MB r0 *1 0,0
Ccc_XD2_XDFFQ_CLKB_XD5_XDFFQ_MB XD2.XDFFQ.CLKB XD5.XDFFQ.MB 1.21e-17
* device instance cc_XD2_XDFFQ_CLKB_XD5_XDFFQ_S r0 *1 0,0
Ccc_XD2_XDFFQ_CLKB_XD5_XDFFQ_S XD2.XDFFQ.CLKB XD5.XDFFQ.S 1.8151e-17
* device instance cc_XD2_XDFFQ_CLKB_XD5_XDFFQ_SB r0 *1 0,0
Ccc_XD2_XDFFQ_CLKB_XD5_XDFFQ_SB XD2.XDFFQ.CLKB XD5.XDFFQ.SB 1.8151e-17
* device instance cc_XD2_XDFFQ_CLKB_XD5_XN2_mid1 r0 *1 0,0
Ccc_XD2_XDFFQ_CLKB_XD5_XN2_mid1 XD2.XDFFQ.CLKB XD5.XN2.mid1 1.21e-17
* device instance cc_XD2_XDFFQ_CLKB_XD5_XN3_mid1 r0 *1 0,0
Ccc_XD2_XDFFQ_CLKB_XD5_XN3_mid1 XD2.XDFFQ.CLKB XD5.XN3.mid1 1.21e-17
* device instance cc_XD2_XDFFQ_CLKB_XD5_XN3_mid2 r0 *1 0,0
Ccc_XD2_XDFFQ_CLKB_XD5_XN3_mid2 XD2.XDFFQ.CLKB XD5.XN3.mid2 1.21e-17
* device instance cc_XD2_XDFFQ_CLKB_XD5_dmodout r0 *1 0,0
Ccc_XD2_XDFFQ_CLKB_XD5_dmodout XD2.XDFFQ.CLKB XD5.dmodout 1.21e-17
* device instance cc_XD2_XDFFQ_CLKB_XD5_dq r0 *1 0,0
Ccc_XD2_XDFFQ_CLKB_XD5_dq XD2.XDFFQ.CLKB XD5.dq 1.8151e-17
* device instance cc_XD2_XDFFQ_CLKB_XD5_nm r0 *1 0,0
Ccc_XD2_XDFFQ_CLKB_XD5_nm XD2.XDFFQ.CLKB XD5.nm 1.21e-17
* device instance cc_XD2_XDFFQ_CLKB_XD5_nt r0 *1 0,0
Ccc_XD2_XDFFQ_CLKB_XD5_nt XD2.XDFFQ.CLKB XD5.nt 1.21e-17
* device instance cc_XD2_XDFFQ_CLKB_XD5_t1 r0 *1 0,0
Ccc_XD2_XDFFQ_CLKB_XD5_t1 XD2.XDFFQ.CLKB XD5.t1 1.21e-17
* device instance cc_XD2_XDFFQ_CLKB_XFRT_CLKB r0 *1 0,0
Ccc_XD2_XDFFQ_CLKB_XFRT_CLKB XD2.XDFFQ.CLKB XFRT.CLKB 1.8151e-17
* device instance cc_XD2_XDFFQ_CLKB_XFRT_M r0 *1 0,0
Ccc_XD2_XDFFQ_CLKB_XFRT_M XD2.XDFFQ.CLKB XFRT.M 2.4201e-17
* device instance cc_XD2_XDFFQ_CLKB_XFRT_MB r0 *1 0,0
Ccc_XD2_XDFFQ_CLKB_XFRT_MB XD2.XDFFQ.CLKB XFRT.MB 1.21e-17
* device instance cc_XD2_XDFFQ_CLKB_XFRT_S r0 *1 0,0
Ccc_XD2_XDFFQ_CLKB_XFRT_S XD2.XDFFQ.CLKB XFRT.S 1.8151e-17
* device instance cc_XD2_XDFFQ_CLKB_XFRT_SB r0 *1 0,0
Ccc_XD2_XDFFQ_CLKB_XFRT_SB XD2.XDFFQ.CLKB XFRT.SB 1.8151e-17
* device instance cc_XD2_XDFFQ_CLKB_ck1 r0 *1 0,0
Ccc_XD2_XDFFQ_CLKB_ck1 XD2.XDFFQ.CLKB ck1 5.4452e-17
* device instance cc_XD2_XDFFQ_CLKB_ck2 r0 *1 0,0
Ccc_XD2_XDFFQ_CLKB_ck2 XD2.XDFFQ.CLKB ck2 6.0502e-17
* device instance cc_XD2_XDFFQ_CLKB_ck3 r0 *1 0,0
Ccc_XD2_XDFFQ_CLKB_ck3 XD2.XDFFQ.CLKB ck3 5.4452e-17
* device instance cc_XD2_XDFFQ_CLKB_ck4 r0 *1 0,0
Ccc_XD2_XDFFQ_CLKB_ck4 XD2.XDFFQ.CLKB ck4 5.4452e-17
* device instance cc_XD2_XDFFQ_CLKB_ck5 r0 *1 0,0
Ccc_XD2_XDFFQ_CLKB_ck5 XD2.XDFFQ.CLKB ck5 5.4452e-17
* device instance cc_XD2_XDFFQ_CLKB_mod0 r0 *1 0,0
Ccc_XD2_XDFFQ_CLKB_mod0 XD2.XDFFQ.CLKB mod0 2.4201e-17
* device instance cc_XD2_XDFFQ_CLKB_mod1 r0 *1 0,0
Ccc_XD2_XDFFQ_CLKB_mod1 XD2.XDFFQ.CLKB mod1 2.4201e-17
* device instance cc_XD2_XDFFQ_CLKB_mod2 r0 *1 0,0
Ccc_XD2_XDFFQ_CLKB_mod2 XD2.XDFFQ.CLKB mod2 2.4201e-17
* device instance cc_XD2_XDFFQ_CLKB_mod3 r0 *1 0,0
Ccc_XD2_XDFFQ_CLKB_mod3 XD2.XDFFQ.CLKB mod3 2.4201e-17
* device instance cc_XD2_XDFFQ_CLKB_mod4 r0 *1 0,0
Ccc_XD2_XDFFQ_CLKB_mod4 XD2.XDFFQ.CLKB mod4 2.4201e-17
* device instance cc_XD2_XDFFQ_CLKB_net1 r0 *1 0,0
Ccc_XD2_XDFFQ_CLKB_net1 XD2.XDFFQ.CLKB net1 1.21e-17
* device instance cc_XD2_XDFFQ_M_XD2_XDFFQ_MB r0 *1 0,0
Ccc_XD2_XDFFQ_M_XD2_XDFFQ_MB XD2.XDFFQ.M XD2.XDFFQ.MB 3.4688e-17
* device instance cc_XD2_XDFFQ_M_XD2_XDFFQ_S r0 *1 0,0
Ccc_XD2_XDFFQ_M_XD2_XDFFQ_S XD2.XDFFQ.M XD2.XDFFQ.S 2.8638e-17
* device instance cc_XD2_XDFFQ_M_XD2_XDFFQ_SB r0 *1 0,0
Ccc_XD2_XDFFQ_M_XD2_XDFFQ_SB XD2.XDFFQ.M XD2.XDFFQ.SB 1.8151e-17
* device instance cc_XD2_XDFFQ_M_XD2_XN2_mid1 r0 *1 0,0
Ccc_XD2_XDFFQ_M_XD2_XN2_mid1 XD2.XDFFQ.M XD2.XN2.mid1 1.21e-17
* device instance cc_XD2_XDFFQ_M_XD2_XNOR_midp r0 *1 0,0
Ccc_XD2_XDFFQ_M_XD2_XNOR_midp XD2.XDFFQ.M XD2.XNOR.midp 1.21e-17
* device instance cc_XD2_XDFFQ_M_XD2_dmodout r0 *1 0,0
Ccc_XD2_XDFFQ_M_XD2_dmodout XD2.XDFFQ.M XD2.dmodout 1.21e-17
* device instance cc_XD2_XDFFQ_M_XD2_dq r0 *1 0,0
Ccc_XD2_XDFFQ_M_XD2_dq XD2.XDFFQ.M XD2.dq 2.8638e-17
* device instance cc_XD2_XDFFQ_M_XD2_nm r0 *1 0,0
Ccc_XD2_XDFFQ_M_XD2_nm XD2.XDFFQ.M XD2.nm 1.21e-17
* device instance cc_XD2_XDFFQ_M_XD2_nt r0 *1 0,0
Ccc_XD2_XDFFQ_M_XD2_nt XD2.XDFFQ.M XD2.nt 2.4201e-17
* device instance cc_XD2_XDFFQ_M_XD2_t1 r0 *1 0,0
Ccc_XD2_XDFFQ_M_XD2_t1 XD2.XDFFQ.M XD2.t1 1.21e-17
* device instance cc_XD2_XDFFQ_M_XD3_XDFFM_CLKB r0 *1 0,0
Ccc_XD2_XDFFQ_M_XD3_XDFFM_CLKB XD2.XDFFQ.M XD3.XDFFM.CLKB 1.8151e-17
* device instance cc_XD2_XDFFQ_M_XD3_XDFFM_M r0 *1 0,0
Ccc_XD2_XDFFQ_M_XD3_XDFFM_M XD2.XDFFQ.M XD3.XDFFM.M 2.4201e-17
* device instance cc_XD2_XDFFQ_M_XD3_XDFFM_MB r0 *1 0,0
Ccc_XD2_XDFFQ_M_XD3_XDFFM_MB XD2.XDFFQ.M XD3.XDFFM.MB 1.21e-17
* device instance cc_XD2_XDFFQ_M_XD3_XDFFM_S r0 *1 0,0
Ccc_XD2_XDFFQ_M_XD3_XDFFM_S XD2.XDFFQ.M XD3.XDFFM.S 1.8151e-17
* device instance cc_XD2_XDFFQ_M_XD3_XDFFM_SB r0 *1 0,0
Ccc_XD2_XDFFQ_M_XD3_XDFFM_SB XD2.XDFFQ.M XD3.XDFFM.SB 1.8151e-17
* device instance cc_XD2_XDFFQ_M_XD3_XDFFQ_CLKB r0 *1 0,0
Ccc_XD2_XDFFQ_M_XD3_XDFFQ_CLKB XD2.XDFFQ.M XD3.XDFFQ.CLKB 1.8151e-17
* device instance cc_XD2_XDFFQ_M_XD3_XDFFQ_M r0 *1 0,0
Ccc_XD2_XDFFQ_M_XD3_XDFFQ_M XD2.XDFFQ.M XD3.XDFFQ.M 2.4201e-17
* device instance cc_XD2_XDFFQ_M_XD3_XDFFQ_MB r0 *1 0,0
Ccc_XD2_XDFFQ_M_XD3_XDFFQ_MB XD2.XDFFQ.M XD3.XDFFQ.MB 1.21e-17
* device instance cc_XD2_XDFFQ_M_XD3_XDFFQ_S r0 *1 0,0
Ccc_XD2_XDFFQ_M_XD3_XDFFQ_S XD2.XDFFQ.M XD3.XDFFQ.S 1.8151e-17
* device instance cc_XD2_XDFFQ_M_XD3_XDFFQ_SB r0 *1 0,0
Ccc_XD2_XDFFQ_M_XD3_XDFFQ_SB XD2.XDFFQ.M XD3.XDFFQ.SB 1.8151e-17
* device instance cc_XD2_XDFFQ_M_XD3_XN2_mid1 r0 *1 0,0
Ccc_XD2_XDFFQ_M_XD3_XN2_mid1 XD2.XDFFQ.M XD3.XN2.mid1 1.21e-17
* device instance cc_XD2_XDFFQ_M_XD3_XN3_mid1 r0 *1 0,0
Ccc_XD2_XDFFQ_M_XD3_XN3_mid1 XD2.XDFFQ.M XD3.XN3.mid1 1.21e-17
* device instance cc_XD2_XDFFQ_M_XD3_XN3_mid2 r0 *1 0,0
Ccc_XD2_XDFFQ_M_XD3_XN3_mid2 XD2.XDFFQ.M XD3.XN3.mid2 1.21e-17
* device instance cc_XD2_XDFFQ_M_XD3_dmodout r0 *1 0,0
Ccc_XD2_XDFFQ_M_XD3_dmodout XD2.XDFFQ.M XD3.dmodout 1.21e-17
* device instance cc_XD2_XDFFQ_M_XD3_dq r0 *1 0,0
Ccc_XD2_XDFFQ_M_XD3_dq XD2.XDFFQ.M XD3.dq 1.8151e-17
* device instance cc_XD2_XDFFQ_M_XD3_nm r0 *1 0,0
Ccc_XD2_XDFFQ_M_XD3_nm XD2.XDFFQ.M XD3.nm 1.21e-17
* device instance cc_XD2_XDFFQ_M_XD3_nt r0 *1 0,0
Ccc_XD2_XDFFQ_M_XD3_nt XD2.XDFFQ.M XD3.nt 1.21e-17
* device instance cc_XD2_XDFFQ_M_XD3_t1 r0 *1 0,0
Ccc_XD2_XDFFQ_M_XD3_t1 XD2.XDFFQ.M XD3.t1 1.21e-17
* device instance cc_XD2_XDFFQ_M_XD4_XDFFM_CLKB r0 *1 0,0
Ccc_XD2_XDFFQ_M_XD4_XDFFM_CLKB XD2.XDFFQ.M XD4.XDFFM.CLKB 1.8151e-17
* device instance cc_XD2_XDFFQ_M_XD4_XDFFM_M r0 *1 0,0
Ccc_XD2_XDFFQ_M_XD4_XDFFM_M XD2.XDFFQ.M XD4.XDFFM.M 2.4201e-17
* device instance cc_XD2_XDFFQ_M_XD4_XDFFM_MB r0 *1 0,0
Ccc_XD2_XDFFQ_M_XD4_XDFFM_MB XD2.XDFFQ.M XD4.XDFFM.MB 1.21e-17
* device instance cc_XD2_XDFFQ_M_XD4_XDFFM_S r0 *1 0,0
Ccc_XD2_XDFFQ_M_XD4_XDFFM_S XD2.XDFFQ.M XD4.XDFFM.S 1.8151e-17
* device instance cc_XD2_XDFFQ_M_XD4_XDFFM_SB r0 *1 0,0
Ccc_XD2_XDFFQ_M_XD4_XDFFM_SB XD2.XDFFQ.M XD4.XDFFM.SB 1.8151e-17
* device instance cc_XD2_XDFFQ_M_XD4_XDFFQ_CLKB r0 *1 0,0
Ccc_XD2_XDFFQ_M_XD4_XDFFQ_CLKB XD2.XDFFQ.M XD4.XDFFQ.CLKB 1.8151e-17
* device instance cc_XD2_XDFFQ_M_XD4_XDFFQ_M r0 *1 0,0
Ccc_XD2_XDFFQ_M_XD4_XDFFQ_M XD2.XDFFQ.M XD4.XDFFQ.M 2.4201e-17
* device instance cc_XD2_XDFFQ_M_XD4_XDFFQ_MB r0 *1 0,0
Ccc_XD2_XDFFQ_M_XD4_XDFFQ_MB XD2.XDFFQ.M XD4.XDFFQ.MB 1.21e-17
* device instance cc_XD2_XDFFQ_M_XD4_XDFFQ_S r0 *1 0,0
Ccc_XD2_XDFFQ_M_XD4_XDFFQ_S XD2.XDFFQ.M XD4.XDFFQ.S 1.8151e-17
* device instance cc_XD2_XDFFQ_M_XD4_XDFFQ_SB r0 *1 0,0
Ccc_XD2_XDFFQ_M_XD4_XDFFQ_SB XD2.XDFFQ.M XD4.XDFFQ.SB 1.8151e-17
* device instance cc_XD2_XDFFQ_M_XD4_XN2_mid1 r0 *1 0,0
Ccc_XD2_XDFFQ_M_XD4_XN2_mid1 XD2.XDFFQ.M XD4.XN2.mid1 1.21e-17
* device instance cc_XD2_XDFFQ_M_XD4_XN3_mid1 r0 *1 0,0
Ccc_XD2_XDFFQ_M_XD4_XN3_mid1 XD2.XDFFQ.M XD4.XN3.mid1 1.21e-17
* device instance cc_XD2_XDFFQ_M_XD4_XN3_mid2 r0 *1 0,0
Ccc_XD2_XDFFQ_M_XD4_XN3_mid2 XD2.XDFFQ.M XD4.XN3.mid2 1.21e-17
* device instance cc_XD2_XDFFQ_M_XD4_dmodout r0 *1 0,0
Ccc_XD2_XDFFQ_M_XD4_dmodout XD2.XDFFQ.M XD4.dmodout 1.21e-17
* device instance cc_XD2_XDFFQ_M_XD4_dq r0 *1 0,0
Ccc_XD2_XDFFQ_M_XD4_dq XD2.XDFFQ.M XD4.dq 1.8151e-17
* device instance cc_XD2_XDFFQ_M_XD4_nm r0 *1 0,0
Ccc_XD2_XDFFQ_M_XD4_nm XD2.XDFFQ.M XD4.nm 1.21e-17
* device instance cc_XD2_XDFFQ_M_XD4_nt r0 *1 0,0
Ccc_XD2_XDFFQ_M_XD4_nt XD2.XDFFQ.M XD4.nt 1.21e-17
* device instance cc_XD2_XDFFQ_M_XD4_t1 r0 *1 0,0
Ccc_XD2_XDFFQ_M_XD4_t1 XD2.XDFFQ.M XD4.t1 1.21e-17
* device instance cc_XD2_XDFFQ_M_XD5_XDFFM_CLKB r0 *1 0,0
Ccc_XD2_XDFFQ_M_XD5_XDFFM_CLKB XD2.XDFFQ.M XD5.XDFFM.CLKB 1.8151e-17
* device instance cc_XD2_XDFFQ_M_XD5_XDFFM_M r0 *1 0,0
Ccc_XD2_XDFFQ_M_XD5_XDFFM_M XD2.XDFFQ.M XD5.XDFFM.M 2.4201e-17
* device instance cc_XD2_XDFFQ_M_XD5_XDFFM_MB r0 *1 0,0
Ccc_XD2_XDFFQ_M_XD5_XDFFM_MB XD2.XDFFQ.M XD5.XDFFM.MB 1.21e-17
* device instance cc_XD2_XDFFQ_M_XD5_XDFFM_S r0 *1 0,0
Ccc_XD2_XDFFQ_M_XD5_XDFFM_S XD2.XDFFQ.M XD5.XDFFM.S 1.8151e-17
* device instance cc_XD2_XDFFQ_M_XD5_XDFFM_SB r0 *1 0,0
Ccc_XD2_XDFFQ_M_XD5_XDFFM_SB XD2.XDFFQ.M XD5.XDFFM.SB 1.8151e-17
* device instance cc_XD2_XDFFQ_M_XD5_XDFFQ_CLKB r0 *1 0,0
Ccc_XD2_XDFFQ_M_XD5_XDFFQ_CLKB XD2.XDFFQ.M XD5.XDFFQ.CLKB 1.8151e-17
* device instance cc_XD2_XDFFQ_M_XD5_XDFFQ_M r0 *1 0,0
Ccc_XD2_XDFFQ_M_XD5_XDFFQ_M XD2.XDFFQ.M XD5.XDFFQ.M 2.4201e-17
* device instance cc_XD2_XDFFQ_M_XD5_XDFFQ_MB r0 *1 0,0
Ccc_XD2_XDFFQ_M_XD5_XDFFQ_MB XD2.XDFFQ.M XD5.XDFFQ.MB 1.21e-17
* device instance cc_XD2_XDFFQ_M_XD5_XDFFQ_S r0 *1 0,0
Ccc_XD2_XDFFQ_M_XD5_XDFFQ_S XD2.XDFFQ.M XD5.XDFFQ.S 1.8151e-17
* device instance cc_XD2_XDFFQ_M_XD5_XDFFQ_SB r0 *1 0,0
Ccc_XD2_XDFFQ_M_XD5_XDFFQ_SB XD2.XDFFQ.M XD5.XDFFQ.SB 1.8151e-17
* device instance cc_XD2_XDFFQ_M_XD5_XN2_mid1 r0 *1 0,0
Ccc_XD2_XDFFQ_M_XD5_XN2_mid1 XD2.XDFFQ.M XD5.XN2.mid1 1.21e-17
* device instance cc_XD2_XDFFQ_M_XD5_XN3_mid1 r0 *1 0,0
Ccc_XD2_XDFFQ_M_XD5_XN3_mid1 XD2.XDFFQ.M XD5.XN3.mid1 1.21e-17
* device instance cc_XD2_XDFFQ_M_XD5_XN3_mid2 r0 *1 0,0
Ccc_XD2_XDFFQ_M_XD5_XN3_mid2 XD2.XDFFQ.M XD5.XN3.mid2 1.21e-17
* device instance cc_XD2_XDFFQ_M_XD5_dmodout r0 *1 0,0
Ccc_XD2_XDFFQ_M_XD5_dmodout XD2.XDFFQ.M XD5.dmodout 1.21e-17
* device instance cc_XD2_XDFFQ_M_XD5_dq r0 *1 0,0
Ccc_XD2_XDFFQ_M_XD5_dq XD2.XDFFQ.M XD5.dq 1.8151e-17
* device instance cc_XD2_XDFFQ_M_XD5_nm r0 *1 0,0
Ccc_XD2_XDFFQ_M_XD5_nm XD2.XDFFQ.M XD5.nm 1.21e-17
* device instance cc_XD2_XDFFQ_M_XD5_nt r0 *1 0,0
Ccc_XD2_XDFFQ_M_XD5_nt XD2.XDFFQ.M XD5.nt 1.21e-17
* device instance cc_XD2_XDFFQ_M_XD5_t1 r0 *1 0,0
Ccc_XD2_XDFFQ_M_XD5_t1 XD2.XDFFQ.M XD5.t1 1.21e-17
* device instance cc_XD2_XDFFQ_M_XFRT_CLKB r0 *1 0,0
Ccc_XD2_XDFFQ_M_XFRT_CLKB XD2.XDFFQ.M XFRT.CLKB 1.8151e-17
* device instance cc_XD2_XDFFQ_M_XFRT_M r0 *1 0,0
Ccc_XD2_XDFFQ_M_XFRT_M XD2.XDFFQ.M XFRT.M 2.4201e-17
* device instance cc_XD2_XDFFQ_M_XFRT_MB r0 *1 0,0
Ccc_XD2_XDFFQ_M_XFRT_MB XD2.XDFFQ.M XFRT.MB 1.21e-17
* device instance cc_XD2_XDFFQ_M_XFRT_S r0 *1 0,0
Ccc_XD2_XDFFQ_M_XFRT_S XD2.XDFFQ.M XFRT.S 1.8151e-17
* device instance cc_XD2_XDFFQ_M_XFRT_SB r0 *1 0,0
Ccc_XD2_XDFFQ_M_XFRT_SB XD2.XDFFQ.M XFRT.SB 1.8151e-17
* device instance cc_XD2_XDFFQ_M_ck1 r0 *1 0,0
Ccc_XD2_XDFFQ_M_ck1 XD2.XDFFQ.M ck1 5.4452e-17
* device instance cc_XD2_XDFFQ_M_ck2 r0 *1 0,0
Ccc_XD2_XDFFQ_M_ck2 XD2.XDFFQ.M ck2 6.0502e-17
* device instance cc_XD2_XDFFQ_M_ck3 r0 *1 0,0
Ccc_XD2_XDFFQ_M_ck3 XD2.XDFFQ.M ck3 5.4452e-17
* device instance cc_XD2_XDFFQ_M_ck4 r0 *1 0,0
Ccc_XD2_XDFFQ_M_ck4 XD2.XDFFQ.M ck4 5.4452e-17
* device instance cc_XD2_XDFFQ_M_ck5 r0 *1 0,0
Ccc_XD2_XDFFQ_M_ck5 XD2.XDFFQ.M ck5 5.4452e-17
* device instance cc_XD2_XDFFQ_M_mod0 r0 *1 0,0
Ccc_XD2_XDFFQ_M_mod0 XD2.XDFFQ.M mod0 2.4201e-17
* device instance cc_XD2_XDFFQ_M_mod1 r0 *1 0,0
Ccc_XD2_XDFFQ_M_mod1 XD2.XDFFQ.M mod1 2.4201e-17
* device instance cc_XD2_XDFFQ_M_mod2 r0 *1 0,0
Ccc_XD2_XDFFQ_M_mod2 XD2.XDFFQ.M mod2 2.4201e-17
* device instance cc_XD2_XDFFQ_M_mod3 r0 *1 0,0
Ccc_XD2_XDFFQ_M_mod3 XD2.XDFFQ.M mod3 2.4201e-17
* device instance cc_XD2_XDFFQ_M_mod4 r0 *1 0,0
Ccc_XD2_XDFFQ_M_mod4 XD2.XDFFQ.M mod4 2.4201e-17
* device instance cc_XD2_XDFFQ_M_net1 r0 *1 0,0
Ccc_XD2_XDFFQ_M_net1 XD2.XDFFQ.M net1 1.21e-17
* device instance cc_XD2_XDFFQ_MB_XD2_XDFFQ_S r0 *1 0,0
Ccc_XD2_XDFFQ_MB_XD2_XDFFQ_S XD2.XDFFQ.MB XD2.XDFFQ.S 1.8151e-17
* device instance cc_XD2_XDFFQ_MB_XD2_XDFFQ_SB r0 *1 0,0
Ccc_XD2_XDFFQ_MB_XD2_XDFFQ_SB XD2.XDFFQ.MB XD2.XDFFQ.SB 1.8151e-17
* device instance cc_XD2_XDFFQ_MB_XD2_XN2_mid1 r0 *1 0,0
Ccc_XD2_XDFFQ_MB_XD2_XN2_mid1 XD2.XDFFQ.MB XD2.XN2.mid1 1.21e-17
* device instance cc_XD2_XDFFQ_MB_XD2_XNOR_midp r0 *1 0,0
Ccc_XD2_XDFFQ_MB_XD2_XNOR_midp XD2.XDFFQ.MB XD2.XNOR.midp 1.21e-17
* device instance cc_XD2_XDFFQ_MB_XD2_dmodout r0 *1 0,0
Ccc_XD2_XDFFQ_MB_XD2_dmodout XD2.XDFFQ.MB XD2.dmodout 1.21e-17
* device instance cc_XD2_XDFFQ_MB_XD2_dq r0 *1 0,0
Ccc_XD2_XDFFQ_MB_XD2_dq XD2.XDFFQ.MB XD2.dq 1.21e-17
* device instance cc_XD2_XDFFQ_MB_XD2_nm r0 *1 0,0
Ccc_XD2_XDFFQ_MB_XD2_nm XD2.XDFFQ.MB XD2.nm 1.21e-17
* device instance cc_XD2_XDFFQ_MB_XD2_nt r0 *1 0,0
Ccc_XD2_XDFFQ_MB_XD2_nt XD2.XDFFQ.MB XD2.nt 2.4201e-17
* device instance cc_XD2_XDFFQ_MB_XD2_t1 r0 *1 0,0
Ccc_XD2_XDFFQ_MB_XD2_t1 XD2.XDFFQ.MB XD2.t1 1.21e-17
* device instance cc_XD2_XDFFQ_MB_XD3_XDFFM_CLKB r0 *1 0,0
Ccc_XD2_XDFFQ_MB_XD3_XDFFM_CLKB XD2.XDFFQ.MB XD3.XDFFM.CLKB 1.8151e-17
* device instance cc_XD2_XDFFQ_MB_XD3_XDFFM_M r0 *1 0,0
Ccc_XD2_XDFFQ_MB_XD3_XDFFM_M XD2.XDFFQ.MB XD3.XDFFM.M 2.4201e-17
* device instance cc_XD2_XDFFQ_MB_XD3_XDFFM_MB r0 *1 0,0
Ccc_XD2_XDFFQ_MB_XD3_XDFFM_MB XD2.XDFFQ.MB XD3.XDFFM.MB 1.21e-17
* device instance cc_XD2_XDFFQ_MB_XD3_XDFFM_S r0 *1 0,0
Ccc_XD2_XDFFQ_MB_XD3_XDFFM_S XD2.XDFFQ.MB XD3.XDFFM.S 1.8151e-17
* device instance cc_XD2_XDFFQ_MB_XD3_XDFFM_SB r0 *1 0,0
Ccc_XD2_XDFFQ_MB_XD3_XDFFM_SB XD2.XDFFQ.MB XD3.XDFFM.SB 1.8151e-17
* device instance cc_XD2_XDFFQ_MB_XD3_XDFFQ_CLKB r0 *1 0,0
Ccc_XD2_XDFFQ_MB_XD3_XDFFQ_CLKB XD2.XDFFQ.MB XD3.XDFFQ.CLKB 1.8151e-17
* device instance cc_XD2_XDFFQ_MB_XD3_XDFFQ_M r0 *1 0,0
Ccc_XD2_XDFFQ_MB_XD3_XDFFQ_M XD2.XDFFQ.MB XD3.XDFFQ.M 2.4201e-17
* device instance cc_XD2_XDFFQ_MB_XD3_XDFFQ_MB r0 *1 0,0
Ccc_XD2_XDFFQ_MB_XD3_XDFFQ_MB XD2.XDFFQ.MB XD3.XDFFQ.MB 1.21e-17
* device instance cc_XD2_XDFFQ_MB_XD3_XDFFQ_S r0 *1 0,0
Ccc_XD2_XDFFQ_MB_XD3_XDFFQ_S XD2.XDFFQ.MB XD3.XDFFQ.S 1.8151e-17
* device instance cc_XD2_XDFFQ_MB_XD3_XDFFQ_SB r0 *1 0,0
Ccc_XD2_XDFFQ_MB_XD3_XDFFQ_SB XD2.XDFFQ.MB XD3.XDFFQ.SB 1.8151e-17
* device instance cc_XD2_XDFFQ_MB_XD3_XN2_mid1 r0 *1 0,0
Ccc_XD2_XDFFQ_MB_XD3_XN2_mid1 XD2.XDFFQ.MB XD3.XN2.mid1 1.21e-17
* device instance cc_XD2_XDFFQ_MB_XD3_XN3_mid1 r0 *1 0,0
Ccc_XD2_XDFFQ_MB_XD3_XN3_mid1 XD2.XDFFQ.MB XD3.XN3.mid1 1.21e-17
* device instance cc_XD2_XDFFQ_MB_XD3_XN3_mid2 r0 *1 0,0
Ccc_XD2_XDFFQ_MB_XD3_XN3_mid2 XD2.XDFFQ.MB XD3.XN3.mid2 1.21e-17
* device instance cc_XD2_XDFFQ_MB_XD3_dmodout r0 *1 0,0
Ccc_XD2_XDFFQ_MB_XD3_dmodout XD2.XDFFQ.MB XD3.dmodout 1.21e-17
* device instance cc_XD2_XDFFQ_MB_XD3_dq r0 *1 0,0
Ccc_XD2_XDFFQ_MB_XD3_dq XD2.XDFFQ.MB XD3.dq 1.8151e-17
* device instance cc_XD2_XDFFQ_MB_XD3_nm r0 *1 0,0
Ccc_XD2_XDFFQ_MB_XD3_nm XD2.XDFFQ.MB XD3.nm 1.21e-17
* device instance cc_XD2_XDFFQ_MB_XD3_nt r0 *1 0,0
Ccc_XD2_XDFFQ_MB_XD3_nt XD2.XDFFQ.MB XD3.nt 1.21e-17
* device instance cc_XD2_XDFFQ_MB_XD3_t1 r0 *1 0,0
Ccc_XD2_XDFFQ_MB_XD3_t1 XD2.XDFFQ.MB XD3.t1 1.21e-17
* device instance cc_XD2_XDFFQ_MB_XD4_XDFFM_CLKB r0 *1 0,0
Ccc_XD2_XDFFQ_MB_XD4_XDFFM_CLKB XD2.XDFFQ.MB XD4.XDFFM.CLKB 1.8151e-17
* device instance cc_XD2_XDFFQ_MB_XD4_XDFFM_M r0 *1 0,0
Ccc_XD2_XDFFQ_MB_XD4_XDFFM_M XD2.XDFFQ.MB XD4.XDFFM.M 2.4201e-17
* device instance cc_XD2_XDFFQ_MB_XD4_XDFFM_MB r0 *1 0,0
Ccc_XD2_XDFFQ_MB_XD4_XDFFM_MB XD2.XDFFQ.MB XD4.XDFFM.MB 1.21e-17
* device instance cc_XD2_XDFFQ_MB_XD4_XDFFM_S r0 *1 0,0
Ccc_XD2_XDFFQ_MB_XD4_XDFFM_S XD2.XDFFQ.MB XD4.XDFFM.S 1.8151e-17
* device instance cc_XD2_XDFFQ_MB_XD4_XDFFM_SB r0 *1 0,0
Ccc_XD2_XDFFQ_MB_XD4_XDFFM_SB XD2.XDFFQ.MB XD4.XDFFM.SB 1.8151e-17
* device instance cc_XD2_XDFFQ_MB_XD4_XDFFQ_CLKB r0 *1 0,0
Ccc_XD2_XDFFQ_MB_XD4_XDFFQ_CLKB XD2.XDFFQ.MB XD4.XDFFQ.CLKB 1.8151e-17
* device instance cc_XD2_XDFFQ_MB_XD4_XDFFQ_M r0 *1 0,0
Ccc_XD2_XDFFQ_MB_XD4_XDFFQ_M XD2.XDFFQ.MB XD4.XDFFQ.M 2.4201e-17
* device instance cc_XD2_XDFFQ_MB_XD4_XDFFQ_MB r0 *1 0,0
Ccc_XD2_XDFFQ_MB_XD4_XDFFQ_MB XD2.XDFFQ.MB XD4.XDFFQ.MB 1.21e-17
* device instance cc_XD2_XDFFQ_MB_XD4_XDFFQ_S r0 *1 0,0
Ccc_XD2_XDFFQ_MB_XD4_XDFFQ_S XD2.XDFFQ.MB XD4.XDFFQ.S 1.8151e-17
* device instance cc_XD2_XDFFQ_MB_XD4_XDFFQ_SB r0 *1 0,0
Ccc_XD2_XDFFQ_MB_XD4_XDFFQ_SB XD2.XDFFQ.MB XD4.XDFFQ.SB 1.8151e-17
* device instance cc_XD2_XDFFQ_MB_XD4_XN2_mid1 r0 *1 0,0
Ccc_XD2_XDFFQ_MB_XD4_XN2_mid1 XD2.XDFFQ.MB XD4.XN2.mid1 1.21e-17
* device instance cc_XD2_XDFFQ_MB_XD4_XN3_mid1 r0 *1 0,0
Ccc_XD2_XDFFQ_MB_XD4_XN3_mid1 XD2.XDFFQ.MB XD4.XN3.mid1 1.21e-17
* device instance cc_XD2_XDFFQ_MB_XD4_XN3_mid2 r0 *1 0,0
Ccc_XD2_XDFFQ_MB_XD4_XN3_mid2 XD2.XDFFQ.MB XD4.XN3.mid2 1.21e-17
* device instance cc_XD2_XDFFQ_MB_XD4_dmodout r0 *1 0,0
Ccc_XD2_XDFFQ_MB_XD4_dmodout XD2.XDFFQ.MB XD4.dmodout 1.21e-17
* device instance cc_XD2_XDFFQ_MB_XD4_dq r0 *1 0,0
Ccc_XD2_XDFFQ_MB_XD4_dq XD2.XDFFQ.MB XD4.dq 1.8151e-17
* device instance cc_XD2_XDFFQ_MB_XD4_nm r0 *1 0,0
Ccc_XD2_XDFFQ_MB_XD4_nm XD2.XDFFQ.MB XD4.nm 1.21e-17
* device instance cc_XD2_XDFFQ_MB_XD4_nt r0 *1 0,0
Ccc_XD2_XDFFQ_MB_XD4_nt XD2.XDFFQ.MB XD4.nt 1.21e-17
* device instance cc_XD2_XDFFQ_MB_XD4_t1 r0 *1 0,0
Ccc_XD2_XDFFQ_MB_XD4_t1 XD2.XDFFQ.MB XD4.t1 1.21e-17
* device instance cc_XD2_XDFFQ_MB_XD5_XDFFM_CLKB r0 *1 0,0
Ccc_XD2_XDFFQ_MB_XD5_XDFFM_CLKB XD2.XDFFQ.MB XD5.XDFFM.CLKB 1.8151e-17
* device instance cc_XD2_XDFFQ_MB_XD5_XDFFM_M r0 *1 0,0
Ccc_XD2_XDFFQ_MB_XD5_XDFFM_M XD2.XDFFQ.MB XD5.XDFFM.M 2.4201e-17
* device instance cc_XD2_XDFFQ_MB_XD5_XDFFM_MB r0 *1 0,0
Ccc_XD2_XDFFQ_MB_XD5_XDFFM_MB XD2.XDFFQ.MB XD5.XDFFM.MB 1.21e-17
* device instance cc_XD2_XDFFQ_MB_XD5_XDFFM_S r0 *1 0,0
Ccc_XD2_XDFFQ_MB_XD5_XDFFM_S XD2.XDFFQ.MB XD5.XDFFM.S 1.8151e-17
* device instance cc_XD2_XDFFQ_MB_XD5_XDFFM_SB r0 *1 0,0
Ccc_XD2_XDFFQ_MB_XD5_XDFFM_SB XD2.XDFFQ.MB XD5.XDFFM.SB 1.8151e-17
* device instance cc_XD2_XDFFQ_MB_XD5_XDFFQ_CLKB r0 *1 0,0
Ccc_XD2_XDFFQ_MB_XD5_XDFFQ_CLKB XD2.XDFFQ.MB XD5.XDFFQ.CLKB 1.8151e-17
* device instance cc_XD2_XDFFQ_MB_XD5_XDFFQ_M r0 *1 0,0
Ccc_XD2_XDFFQ_MB_XD5_XDFFQ_M XD2.XDFFQ.MB XD5.XDFFQ.M 2.4201e-17
* device instance cc_XD2_XDFFQ_MB_XD5_XDFFQ_MB r0 *1 0,0
Ccc_XD2_XDFFQ_MB_XD5_XDFFQ_MB XD2.XDFFQ.MB XD5.XDFFQ.MB 1.21e-17
* device instance cc_XD2_XDFFQ_MB_XD5_XDFFQ_S r0 *1 0,0
Ccc_XD2_XDFFQ_MB_XD5_XDFFQ_S XD2.XDFFQ.MB XD5.XDFFQ.S 1.8151e-17
* device instance cc_XD2_XDFFQ_MB_XD5_XDFFQ_SB r0 *1 0,0
Ccc_XD2_XDFFQ_MB_XD5_XDFFQ_SB XD2.XDFFQ.MB XD5.XDFFQ.SB 1.8151e-17
* device instance cc_XD2_XDFFQ_MB_XD5_XN2_mid1 r0 *1 0,0
Ccc_XD2_XDFFQ_MB_XD5_XN2_mid1 XD2.XDFFQ.MB XD5.XN2.mid1 1.21e-17
* device instance cc_XD2_XDFFQ_MB_XD5_XN3_mid1 r0 *1 0,0
Ccc_XD2_XDFFQ_MB_XD5_XN3_mid1 XD2.XDFFQ.MB XD5.XN3.mid1 1.21e-17
* device instance cc_XD2_XDFFQ_MB_XD5_XN3_mid2 r0 *1 0,0
Ccc_XD2_XDFFQ_MB_XD5_XN3_mid2 XD2.XDFFQ.MB XD5.XN3.mid2 1.21e-17
* device instance cc_XD2_XDFFQ_MB_XD5_dmodout r0 *1 0,0
Ccc_XD2_XDFFQ_MB_XD5_dmodout XD2.XDFFQ.MB XD5.dmodout 1.21e-17
* device instance cc_XD2_XDFFQ_MB_XD5_dq r0 *1 0,0
Ccc_XD2_XDFFQ_MB_XD5_dq XD2.XDFFQ.MB XD5.dq 1.8151e-17
* device instance cc_XD2_XDFFQ_MB_XD5_nm r0 *1 0,0
Ccc_XD2_XDFFQ_MB_XD5_nm XD2.XDFFQ.MB XD5.nm 1.21e-17
* device instance cc_XD2_XDFFQ_MB_XD5_nt r0 *1 0,0
Ccc_XD2_XDFFQ_MB_XD5_nt XD2.XDFFQ.MB XD5.nt 1.21e-17
* device instance cc_XD2_XDFFQ_MB_XD5_t1 r0 *1 0,0
Ccc_XD2_XDFFQ_MB_XD5_t1 XD2.XDFFQ.MB XD5.t1 1.21e-17
* device instance cc_XD2_XDFFQ_MB_XFRT_CLKB r0 *1 0,0
Ccc_XD2_XDFFQ_MB_XFRT_CLKB XD2.XDFFQ.MB XFRT.CLKB 1.8151e-17
* device instance cc_XD2_XDFFQ_MB_XFRT_M r0 *1 0,0
Ccc_XD2_XDFFQ_MB_XFRT_M XD2.XDFFQ.MB XFRT.M 2.4201e-17
* device instance cc_XD2_XDFFQ_MB_XFRT_MB r0 *1 0,0
Ccc_XD2_XDFFQ_MB_XFRT_MB XD2.XDFFQ.MB XFRT.MB 1.21e-17
* device instance cc_XD2_XDFFQ_MB_XFRT_S r0 *1 0,0
Ccc_XD2_XDFFQ_MB_XFRT_S XD2.XDFFQ.MB XFRT.S 1.8151e-17
* device instance cc_XD2_XDFFQ_MB_XFRT_SB r0 *1 0,0
Ccc_XD2_XDFFQ_MB_XFRT_SB XD2.XDFFQ.MB XFRT.SB 1.8151e-17
* device instance cc_XD2_XDFFQ_MB_ck1 r0 *1 0,0
Ccc_XD2_XDFFQ_MB_ck1 XD2.XDFFQ.MB ck1 5.4452e-17
* device instance cc_XD2_XDFFQ_MB_ck2 r0 *1 0,0
Ccc_XD2_XDFFQ_MB_ck2 XD2.XDFFQ.MB ck2 6.0502e-17
* device instance cc_XD2_XDFFQ_MB_ck3 r0 *1 0,0
Ccc_XD2_XDFFQ_MB_ck3 XD2.XDFFQ.MB ck3 5.4452e-17
* device instance cc_XD2_XDFFQ_MB_ck4 r0 *1 0,0
Ccc_XD2_XDFFQ_MB_ck4 XD2.XDFFQ.MB ck4 5.4452e-17
* device instance cc_XD2_XDFFQ_MB_ck5 r0 *1 0,0
Ccc_XD2_XDFFQ_MB_ck5 XD2.XDFFQ.MB ck5 5.4452e-17
* device instance cc_XD2_XDFFQ_MB_mod0 r0 *1 0,0
Ccc_XD2_XDFFQ_MB_mod0 XD2.XDFFQ.MB mod0 2.4201e-17
* device instance cc_XD2_XDFFQ_MB_mod1 r0 *1 0,0
Ccc_XD2_XDFFQ_MB_mod1 XD2.XDFFQ.MB mod1 2.4201e-17
* device instance cc_XD2_XDFFQ_MB_mod2 r0 *1 0,0
Ccc_XD2_XDFFQ_MB_mod2 XD2.XDFFQ.MB mod2 2.4201e-17
* device instance cc_XD2_XDFFQ_MB_mod3 r0 *1 0,0
Ccc_XD2_XDFFQ_MB_mod3 XD2.XDFFQ.MB mod3 2.4201e-17
* device instance cc_XD2_XDFFQ_MB_mod4 r0 *1 0,0
Ccc_XD2_XDFFQ_MB_mod4 XD2.XDFFQ.MB mod4 2.4201e-17
* device instance cc_XD2_XDFFQ_MB_net1 r0 *1 0,0
Ccc_XD2_XDFFQ_MB_net1 XD2.XDFFQ.MB net1 1.21e-17
* device instance cc_XD2_XDFFQ_S_XD2_XDFFQ_SB r0 *1 0,0
Ccc_XD2_XDFFQ_S_XD2_XDFFQ_SB XD2.XDFFQ.S XD2.XDFFQ.SB 4.0738e-17
* device instance cc_XD2_XDFFQ_S_XD2_XN2_mid1 r0 *1 0,0
Ccc_XD2_XDFFQ_S_XD2_XN2_mid1 XD2.XDFFQ.S XD2.XN2.mid1 1.21e-17
* device instance cc_XD2_XDFFQ_S_XD2_XNOR_midp r0 *1 0,0
Ccc_XD2_XDFFQ_S_XD2_XNOR_midp XD2.XDFFQ.S XD2.XNOR.midp 1.21e-17
* device instance cc_XD2_XDFFQ_S_XD2_dmodout r0 *1 0,0
Ccc_XD2_XDFFQ_S_XD2_dmodout XD2.XDFFQ.S XD2.dmodout 1.21e-17
* device instance cc_XD2_XDFFQ_S_XD2_dq r0 *1 0,0
Ccc_XD2_XDFFQ_S_XD2_dq XD2.XDFFQ.S XD2.dq 1.21e-17
* device instance cc_XD2_XDFFQ_S_XD2_nm r0 *1 0,0
Ccc_XD2_XDFFQ_S_XD2_nm XD2.XDFFQ.S XD2.nm 1.21e-17
* device instance cc_XD2_XDFFQ_S_XD2_nt r0 *1 0,0
Ccc_XD2_XDFFQ_S_XD2_nt XD2.XDFFQ.S XD2.nt 2.4201e-17
* device instance cc_XD2_XDFFQ_S_XD2_t1 r0 *1 0,0
Ccc_XD2_XDFFQ_S_XD2_t1 XD2.XDFFQ.S XD2.t1 1.21e-17
* device instance cc_XD2_XDFFQ_S_XD3_XDFFM_CLKB r0 *1 0,0
Ccc_XD2_XDFFQ_S_XD3_XDFFM_CLKB XD2.XDFFQ.S XD3.XDFFM.CLKB 1.8151e-17
* device instance cc_XD2_XDFFQ_S_XD3_XDFFM_M r0 *1 0,0
Ccc_XD2_XDFFQ_S_XD3_XDFFM_M XD2.XDFFQ.S XD3.XDFFM.M 2.4201e-17
* device instance cc_XD2_XDFFQ_S_XD3_XDFFM_MB r0 *1 0,0
Ccc_XD2_XDFFQ_S_XD3_XDFFM_MB XD2.XDFFQ.S XD3.XDFFM.MB 1.21e-17
* device instance cc_XD2_XDFFQ_S_XD3_XDFFM_S r0 *1 0,0
Ccc_XD2_XDFFQ_S_XD3_XDFFM_S XD2.XDFFQ.S XD3.XDFFM.S 1.8151e-17
* device instance cc_XD2_XDFFQ_S_XD3_XDFFM_SB r0 *1 0,0
Ccc_XD2_XDFFQ_S_XD3_XDFFM_SB XD2.XDFFQ.S XD3.XDFFM.SB 1.8151e-17
* device instance cc_XD2_XDFFQ_S_XD3_XDFFQ_CLKB r0 *1 0,0
Ccc_XD2_XDFFQ_S_XD3_XDFFQ_CLKB XD2.XDFFQ.S XD3.XDFFQ.CLKB 1.8151e-17
* device instance cc_XD2_XDFFQ_S_XD3_XDFFQ_M r0 *1 0,0
Ccc_XD2_XDFFQ_S_XD3_XDFFQ_M XD2.XDFFQ.S XD3.XDFFQ.M 2.4201e-17
* device instance cc_XD2_XDFFQ_S_XD3_XDFFQ_MB r0 *1 0,0
Ccc_XD2_XDFFQ_S_XD3_XDFFQ_MB XD2.XDFFQ.S XD3.XDFFQ.MB 1.21e-17
* device instance cc_XD2_XDFFQ_S_XD3_XDFFQ_S r0 *1 0,0
Ccc_XD2_XDFFQ_S_XD3_XDFFQ_S XD2.XDFFQ.S XD3.XDFFQ.S 1.8151e-17
* device instance cc_XD2_XDFFQ_S_XD3_XDFFQ_SB r0 *1 0,0
Ccc_XD2_XDFFQ_S_XD3_XDFFQ_SB XD2.XDFFQ.S XD3.XDFFQ.SB 1.8151e-17
* device instance cc_XD2_XDFFQ_S_XD3_XN2_mid1 r0 *1 0,0
Ccc_XD2_XDFFQ_S_XD3_XN2_mid1 XD2.XDFFQ.S XD3.XN2.mid1 1.21e-17
* device instance cc_XD2_XDFFQ_S_XD3_XN3_mid1 r0 *1 0,0
Ccc_XD2_XDFFQ_S_XD3_XN3_mid1 XD2.XDFFQ.S XD3.XN3.mid1 1.21e-17
* device instance cc_XD2_XDFFQ_S_XD3_XN3_mid2 r0 *1 0,0
Ccc_XD2_XDFFQ_S_XD3_XN3_mid2 XD2.XDFFQ.S XD3.XN3.mid2 1.21e-17
* device instance cc_XD2_XDFFQ_S_XD3_dmodout r0 *1 0,0
Ccc_XD2_XDFFQ_S_XD3_dmodout XD2.XDFFQ.S XD3.dmodout 1.21e-17
* device instance cc_XD2_XDFFQ_S_XD3_dq r0 *1 0,0
Ccc_XD2_XDFFQ_S_XD3_dq XD2.XDFFQ.S XD3.dq 1.8151e-17
* device instance cc_XD2_XDFFQ_S_XD3_nm r0 *1 0,0
Ccc_XD2_XDFFQ_S_XD3_nm XD2.XDFFQ.S XD3.nm 1.21e-17
* device instance cc_XD2_XDFFQ_S_XD3_nt r0 *1 0,0
Ccc_XD2_XDFFQ_S_XD3_nt XD2.XDFFQ.S XD3.nt 1.21e-17
* device instance cc_XD2_XDFFQ_S_XD3_t1 r0 *1 0,0
Ccc_XD2_XDFFQ_S_XD3_t1 XD2.XDFFQ.S XD3.t1 1.21e-17
* device instance cc_XD2_XDFFQ_S_XD4_XDFFM_CLKB r0 *1 0,0
Ccc_XD2_XDFFQ_S_XD4_XDFFM_CLKB XD2.XDFFQ.S XD4.XDFFM.CLKB 1.8151e-17
* device instance cc_XD2_XDFFQ_S_XD4_XDFFM_M r0 *1 0,0
Ccc_XD2_XDFFQ_S_XD4_XDFFM_M XD2.XDFFQ.S XD4.XDFFM.M 2.4201e-17
* device instance cc_XD2_XDFFQ_S_XD4_XDFFM_MB r0 *1 0,0
Ccc_XD2_XDFFQ_S_XD4_XDFFM_MB XD2.XDFFQ.S XD4.XDFFM.MB 1.21e-17
* device instance cc_XD2_XDFFQ_S_XD4_XDFFM_S r0 *1 0,0
Ccc_XD2_XDFFQ_S_XD4_XDFFM_S XD2.XDFFQ.S XD4.XDFFM.S 1.8151e-17
* device instance cc_XD2_XDFFQ_S_XD4_XDFFM_SB r0 *1 0,0
Ccc_XD2_XDFFQ_S_XD4_XDFFM_SB XD2.XDFFQ.S XD4.XDFFM.SB 1.8151e-17
* device instance cc_XD2_XDFFQ_S_XD4_XDFFQ_CLKB r0 *1 0,0
Ccc_XD2_XDFFQ_S_XD4_XDFFQ_CLKB XD2.XDFFQ.S XD4.XDFFQ.CLKB 1.8151e-17
* device instance cc_XD2_XDFFQ_S_XD4_XDFFQ_M r0 *1 0,0
Ccc_XD2_XDFFQ_S_XD4_XDFFQ_M XD2.XDFFQ.S XD4.XDFFQ.M 2.4201e-17
* device instance cc_XD2_XDFFQ_S_XD4_XDFFQ_MB r0 *1 0,0
Ccc_XD2_XDFFQ_S_XD4_XDFFQ_MB XD2.XDFFQ.S XD4.XDFFQ.MB 1.21e-17
* device instance cc_XD2_XDFFQ_S_XD4_XDFFQ_S r0 *1 0,0
Ccc_XD2_XDFFQ_S_XD4_XDFFQ_S XD2.XDFFQ.S XD4.XDFFQ.S 1.8151e-17
* device instance cc_XD2_XDFFQ_S_XD4_XDFFQ_SB r0 *1 0,0
Ccc_XD2_XDFFQ_S_XD4_XDFFQ_SB XD2.XDFFQ.S XD4.XDFFQ.SB 1.8151e-17
* device instance cc_XD2_XDFFQ_S_XD4_XN2_mid1 r0 *1 0,0
Ccc_XD2_XDFFQ_S_XD4_XN2_mid1 XD2.XDFFQ.S XD4.XN2.mid1 1.21e-17
* device instance cc_XD2_XDFFQ_S_XD4_XN3_mid1 r0 *1 0,0
Ccc_XD2_XDFFQ_S_XD4_XN3_mid1 XD2.XDFFQ.S XD4.XN3.mid1 1.21e-17
* device instance cc_XD2_XDFFQ_S_XD4_XN3_mid2 r0 *1 0,0
Ccc_XD2_XDFFQ_S_XD4_XN3_mid2 XD2.XDFFQ.S XD4.XN3.mid2 1.21e-17
* device instance cc_XD2_XDFFQ_S_XD4_dmodout r0 *1 0,0
Ccc_XD2_XDFFQ_S_XD4_dmodout XD2.XDFFQ.S XD4.dmodout 1.21e-17
* device instance cc_XD2_XDFFQ_S_XD4_dq r0 *1 0,0
Ccc_XD2_XDFFQ_S_XD4_dq XD2.XDFFQ.S XD4.dq 1.8151e-17
* device instance cc_XD2_XDFFQ_S_XD4_nm r0 *1 0,0
Ccc_XD2_XDFFQ_S_XD4_nm XD2.XDFFQ.S XD4.nm 1.21e-17
* device instance cc_XD2_XDFFQ_S_XD4_nt r0 *1 0,0
Ccc_XD2_XDFFQ_S_XD4_nt XD2.XDFFQ.S XD4.nt 1.21e-17
* device instance cc_XD2_XDFFQ_S_XD4_t1 r0 *1 0,0
Ccc_XD2_XDFFQ_S_XD4_t1 XD2.XDFFQ.S XD4.t1 1.21e-17
* device instance cc_XD2_XDFFQ_S_XD5_XDFFM_CLKB r0 *1 0,0
Ccc_XD2_XDFFQ_S_XD5_XDFFM_CLKB XD2.XDFFQ.S XD5.XDFFM.CLKB 1.8151e-17
* device instance cc_XD2_XDFFQ_S_XD5_XDFFM_M r0 *1 0,0
Ccc_XD2_XDFFQ_S_XD5_XDFFM_M XD2.XDFFQ.S XD5.XDFFM.M 2.4201e-17
* device instance cc_XD2_XDFFQ_S_XD5_XDFFM_MB r0 *1 0,0
Ccc_XD2_XDFFQ_S_XD5_XDFFM_MB XD2.XDFFQ.S XD5.XDFFM.MB 1.21e-17
* device instance cc_XD2_XDFFQ_S_XD5_XDFFM_S r0 *1 0,0
Ccc_XD2_XDFFQ_S_XD5_XDFFM_S XD2.XDFFQ.S XD5.XDFFM.S 1.8151e-17
* device instance cc_XD2_XDFFQ_S_XD5_XDFFM_SB r0 *1 0,0
Ccc_XD2_XDFFQ_S_XD5_XDFFM_SB XD2.XDFFQ.S XD5.XDFFM.SB 1.8151e-17
* device instance cc_XD2_XDFFQ_S_XD5_XDFFQ_CLKB r0 *1 0,0
Ccc_XD2_XDFFQ_S_XD5_XDFFQ_CLKB XD2.XDFFQ.S XD5.XDFFQ.CLKB 1.8151e-17
* device instance cc_XD2_XDFFQ_S_XD5_XDFFQ_M r0 *1 0,0
Ccc_XD2_XDFFQ_S_XD5_XDFFQ_M XD2.XDFFQ.S XD5.XDFFQ.M 2.4201e-17
* device instance cc_XD2_XDFFQ_S_XD5_XDFFQ_MB r0 *1 0,0
Ccc_XD2_XDFFQ_S_XD5_XDFFQ_MB XD2.XDFFQ.S XD5.XDFFQ.MB 1.21e-17
* device instance cc_XD2_XDFFQ_S_XD5_XDFFQ_S r0 *1 0,0
Ccc_XD2_XDFFQ_S_XD5_XDFFQ_S XD2.XDFFQ.S XD5.XDFFQ.S 1.8151e-17
* device instance cc_XD2_XDFFQ_S_XD5_XDFFQ_SB r0 *1 0,0
Ccc_XD2_XDFFQ_S_XD5_XDFFQ_SB XD2.XDFFQ.S XD5.XDFFQ.SB 1.8151e-17
* device instance cc_XD2_XDFFQ_S_XD5_XN2_mid1 r0 *1 0,0
Ccc_XD2_XDFFQ_S_XD5_XN2_mid1 XD2.XDFFQ.S XD5.XN2.mid1 1.21e-17
* device instance cc_XD2_XDFFQ_S_XD5_XN3_mid1 r0 *1 0,0
Ccc_XD2_XDFFQ_S_XD5_XN3_mid1 XD2.XDFFQ.S XD5.XN3.mid1 1.21e-17
* device instance cc_XD2_XDFFQ_S_XD5_XN3_mid2 r0 *1 0,0
Ccc_XD2_XDFFQ_S_XD5_XN3_mid2 XD2.XDFFQ.S XD5.XN3.mid2 1.21e-17
* device instance cc_XD2_XDFFQ_S_XD5_dmodout r0 *1 0,0
Ccc_XD2_XDFFQ_S_XD5_dmodout XD2.XDFFQ.S XD5.dmodout 1.21e-17
* device instance cc_XD2_XDFFQ_S_XD5_dq r0 *1 0,0
Ccc_XD2_XDFFQ_S_XD5_dq XD2.XDFFQ.S XD5.dq 1.8151e-17
* device instance cc_XD2_XDFFQ_S_XD5_nm r0 *1 0,0
Ccc_XD2_XDFFQ_S_XD5_nm XD2.XDFFQ.S XD5.nm 1.21e-17
* device instance cc_XD2_XDFFQ_S_XD5_nt r0 *1 0,0
Ccc_XD2_XDFFQ_S_XD5_nt XD2.XDFFQ.S XD5.nt 1.21e-17
* device instance cc_XD2_XDFFQ_S_XD5_t1 r0 *1 0,0
Ccc_XD2_XDFFQ_S_XD5_t1 XD2.XDFFQ.S XD5.t1 1.21e-17
* device instance cc_XD2_XDFFQ_S_XFRT_CLKB r0 *1 0,0
Ccc_XD2_XDFFQ_S_XFRT_CLKB XD2.XDFFQ.S XFRT.CLKB 1.8151e-17
* device instance cc_XD2_XDFFQ_S_XFRT_M r0 *1 0,0
Ccc_XD2_XDFFQ_S_XFRT_M XD2.XDFFQ.S XFRT.M 2.4201e-17
* device instance cc_XD2_XDFFQ_S_XFRT_MB r0 *1 0,0
Ccc_XD2_XDFFQ_S_XFRT_MB XD2.XDFFQ.S XFRT.MB 1.21e-17
* device instance cc_XD2_XDFFQ_S_XFRT_S r0 *1 0,0
Ccc_XD2_XDFFQ_S_XFRT_S XD2.XDFFQ.S XFRT.S 1.8151e-17
* device instance cc_XD2_XDFFQ_S_XFRT_SB r0 *1 0,0
Ccc_XD2_XDFFQ_S_XFRT_SB XD2.XDFFQ.S XFRT.SB 1.8151e-17
* device instance cc_XD2_XDFFQ_S_ck1 r0 *1 0,0
Ccc_XD2_XDFFQ_S_ck1 XD2.XDFFQ.S ck1 5.4452e-17
* device instance cc_XD2_XDFFQ_S_ck2 r0 *1 0,0
Ccc_XD2_XDFFQ_S_ck2 XD2.XDFFQ.S ck2 5.4452e-17
* device instance cc_XD2_XDFFQ_S_ck3 r0 *1 0,0
Ccc_XD2_XDFFQ_S_ck3 XD2.XDFFQ.S ck3 5.4452e-17
* device instance cc_XD2_XDFFQ_S_ck4 r0 *1 0,0
Ccc_XD2_XDFFQ_S_ck4 XD2.XDFFQ.S ck4 5.4452e-17
* device instance cc_XD2_XDFFQ_S_ck5 r0 *1 0,0
Ccc_XD2_XDFFQ_S_ck5 XD2.XDFFQ.S ck5 5.4452e-17
* device instance cc_XD2_XDFFQ_S_mod0 r0 *1 0,0
Ccc_XD2_XDFFQ_S_mod0 XD2.XDFFQ.S mod0 2.4201e-17
* device instance cc_XD2_XDFFQ_S_mod1 r0 *1 0,0
Ccc_XD2_XDFFQ_S_mod1 XD2.XDFFQ.S mod1 2.4201e-17
* device instance cc_XD2_XDFFQ_S_mod2 r0 *1 0,0
Ccc_XD2_XDFFQ_S_mod2 XD2.XDFFQ.S mod2 2.4201e-17
* device instance cc_XD2_XDFFQ_S_mod3 r0 *1 0,0
Ccc_XD2_XDFFQ_S_mod3 XD2.XDFFQ.S mod3 2.4201e-17
* device instance cc_XD2_XDFFQ_S_mod4 r0 *1 0,0
Ccc_XD2_XDFFQ_S_mod4 XD2.XDFFQ.S mod4 2.4201e-17
* device instance cc_XD2_XDFFQ_S_net1 r0 *1 0,0
Ccc_XD2_XDFFQ_S_net1 XD2.XDFFQ.S net1 1.21e-17
* device instance cc_XD2_XDFFQ_SB_XD2_XN2_mid1 r0 *1 0,0
Ccc_XD2_XDFFQ_SB_XD2_XN2_mid1 XD2.XDFFQ.SB XD2.XN2.mid1 1.21e-17
* device instance cc_XD2_XDFFQ_SB_XD2_XNOR_midp r0 *1 0,0
Ccc_XD2_XDFFQ_SB_XD2_XNOR_midp XD2.XDFFQ.SB XD2.XNOR.midp 1.21e-17
* device instance cc_XD2_XDFFQ_SB_XD2_dmodout r0 *1 0,0
Ccc_XD2_XDFFQ_SB_XD2_dmodout XD2.XDFFQ.SB XD2.dmodout 1.21e-17
* device instance cc_XD2_XDFFQ_SB_XD2_dq r0 *1 0,0
Ccc_XD2_XDFFQ_SB_XD2_dq XD2.XDFFQ.SB XD2.dq 1.21e-17
* device instance cc_XD2_XDFFQ_SB_XD2_nm r0 *1 0,0
Ccc_XD2_XDFFQ_SB_XD2_nm XD2.XDFFQ.SB XD2.nm 1.21e-17
* device instance cc_XD2_XDFFQ_SB_XD2_nt r0 *1 0,0
Ccc_XD2_XDFFQ_SB_XD2_nt XD2.XDFFQ.SB XD2.nt 2.4201e-17
* device instance cc_XD2_XDFFQ_SB_XD2_t1 r0 *1 0,0
Ccc_XD2_XDFFQ_SB_XD2_t1 XD2.XDFFQ.SB XD2.t1 1.21e-17
* device instance cc_XD2_XDFFQ_SB_XD3_XDFFM_CLKB r0 *1 0,0
Ccc_XD2_XDFFQ_SB_XD3_XDFFM_CLKB XD2.XDFFQ.SB XD3.XDFFM.CLKB 1.8151e-17
* device instance cc_XD2_XDFFQ_SB_XD3_XDFFM_M r0 *1 0,0
Ccc_XD2_XDFFQ_SB_XD3_XDFFM_M XD2.XDFFQ.SB XD3.XDFFM.M 2.4201e-17
* device instance cc_XD2_XDFFQ_SB_XD3_XDFFM_MB r0 *1 0,0
Ccc_XD2_XDFFQ_SB_XD3_XDFFM_MB XD2.XDFFQ.SB XD3.XDFFM.MB 1.21e-17
* device instance cc_XD2_XDFFQ_SB_XD3_XDFFM_S r0 *1 0,0
Ccc_XD2_XDFFQ_SB_XD3_XDFFM_S XD2.XDFFQ.SB XD3.XDFFM.S 1.8151e-17
* device instance cc_XD2_XDFFQ_SB_XD3_XDFFM_SB r0 *1 0,0
Ccc_XD2_XDFFQ_SB_XD3_XDFFM_SB XD2.XDFFQ.SB XD3.XDFFM.SB 1.8151e-17
* device instance cc_XD2_XDFFQ_SB_XD3_XDFFQ_CLKB r0 *1 0,0
Ccc_XD2_XDFFQ_SB_XD3_XDFFQ_CLKB XD2.XDFFQ.SB XD3.XDFFQ.CLKB 1.8151e-17
* device instance cc_XD2_XDFFQ_SB_XD3_XDFFQ_M r0 *1 0,0
Ccc_XD2_XDFFQ_SB_XD3_XDFFQ_M XD2.XDFFQ.SB XD3.XDFFQ.M 2.4201e-17
* device instance cc_XD2_XDFFQ_SB_XD3_XDFFQ_MB r0 *1 0,0
Ccc_XD2_XDFFQ_SB_XD3_XDFFQ_MB XD2.XDFFQ.SB XD3.XDFFQ.MB 1.21e-17
* device instance cc_XD2_XDFFQ_SB_XD3_XDFFQ_S r0 *1 0,0
Ccc_XD2_XDFFQ_SB_XD3_XDFFQ_S XD2.XDFFQ.SB XD3.XDFFQ.S 1.8151e-17
* device instance cc_XD2_XDFFQ_SB_XD3_XDFFQ_SB r0 *1 0,0
Ccc_XD2_XDFFQ_SB_XD3_XDFFQ_SB XD2.XDFFQ.SB XD3.XDFFQ.SB 1.8151e-17
* device instance cc_XD2_XDFFQ_SB_XD3_XN2_mid1 r0 *1 0,0
Ccc_XD2_XDFFQ_SB_XD3_XN2_mid1 XD2.XDFFQ.SB XD3.XN2.mid1 1.21e-17
* device instance cc_XD2_XDFFQ_SB_XD3_XN3_mid1 r0 *1 0,0
Ccc_XD2_XDFFQ_SB_XD3_XN3_mid1 XD2.XDFFQ.SB XD3.XN3.mid1 1.21e-17
* device instance cc_XD2_XDFFQ_SB_XD3_XN3_mid2 r0 *1 0,0
Ccc_XD2_XDFFQ_SB_XD3_XN3_mid2 XD2.XDFFQ.SB XD3.XN3.mid2 1.21e-17
* device instance cc_XD2_XDFFQ_SB_XD3_dmodout r0 *1 0,0
Ccc_XD2_XDFFQ_SB_XD3_dmodout XD2.XDFFQ.SB XD3.dmodout 1.21e-17
* device instance cc_XD2_XDFFQ_SB_XD3_dq r0 *1 0,0
Ccc_XD2_XDFFQ_SB_XD3_dq XD2.XDFFQ.SB XD3.dq 1.8151e-17
* device instance cc_XD2_XDFFQ_SB_XD3_nm r0 *1 0,0
Ccc_XD2_XDFFQ_SB_XD3_nm XD2.XDFFQ.SB XD3.nm 1.21e-17
* device instance cc_XD2_XDFFQ_SB_XD3_nt r0 *1 0,0
Ccc_XD2_XDFFQ_SB_XD3_nt XD2.XDFFQ.SB XD3.nt 1.21e-17
* device instance cc_XD2_XDFFQ_SB_XD3_t1 r0 *1 0,0
Ccc_XD2_XDFFQ_SB_XD3_t1 XD2.XDFFQ.SB XD3.t1 1.21e-17
* device instance cc_XD2_XDFFQ_SB_XD4_XDFFM_CLKB r0 *1 0,0
Ccc_XD2_XDFFQ_SB_XD4_XDFFM_CLKB XD2.XDFFQ.SB XD4.XDFFM.CLKB 1.8151e-17
* device instance cc_XD2_XDFFQ_SB_XD4_XDFFM_M r0 *1 0,0
Ccc_XD2_XDFFQ_SB_XD4_XDFFM_M XD2.XDFFQ.SB XD4.XDFFM.M 2.4201e-17
* device instance cc_XD2_XDFFQ_SB_XD4_XDFFM_MB r0 *1 0,0
Ccc_XD2_XDFFQ_SB_XD4_XDFFM_MB XD2.XDFFQ.SB XD4.XDFFM.MB 1.21e-17
* device instance cc_XD2_XDFFQ_SB_XD4_XDFFM_S r0 *1 0,0
Ccc_XD2_XDFFQ_SB_XD4_XDFFM_S XD2.XDFFQ.SB XD4.XDFFM.S 1.8151e-17
* device instance cc_XD2_XDFFQ_SB_XD4_XDFFM_SB r0 *1 0,0
Ccc_XD2_XDFFQ_SB_XD4_XDFFM_SB XD2.XDFFQ.SB XD4.XDFFM.SB 1.8151e-17
* device instance cc_XD2_XDFFQ_SB_XD4_XDFFQ_CLKB r0 *1 0,0
Ccc_XD2_XDFFQ_SB_XD4_XDFFQ_CLKB XD2.XDFFQ.SB XD4.XDFFQ.CLKB 1.8151e-17
* device instance cc_XD2_XDFFQ_SB_XD4_XDFFQ_M r0 *1 0,0
Ccc_XD2_XDFFQ_SB_XD4_XDFFQ_M XD2.XDFFQ.SB XD4.XDFFQ.M 2.4201e-17
* device instance cc_XD2_XDFFQ_SB_XD4_XDFFQ_MB r0 *1 0,0
Ccc_XD2_XDFFQ_SB_XD4_XDFFQ_MB XD2.XDFFQ.SB XD4.XDFFQ.MB 1.21e-17
* device instance cc_XD2_XDFFQ_SB_XD4_XDFFQ_S r0 *1 0,0
Ccc_XD2_XDFFQ_SB_XD4_XDFFQ_S XD2.XDFFQ.SB XD4.XDFFQ.S 1.8151e-17
* device instance cc_XD2_XDFFQ_SB_XD4_XDFFQ_SB r0 *1 0,0
Ccc_XD2_XDFFQ_SB_XD4_XDFFQ_SB XD2.XDFFQ.SB XD4.XDFFQ.SB 1.8151e-17
* device instance cc_XD2_XDFFQ_SB_XD4_XN2_mid1 r0 *1 0,0
Ccc_XD2_XDFFQ_SB_XD4_XN2_mid1 XD2.XDFFQ.SB XD4.XN2.mid1 1.21e-17
* device instance cc_XD2_XDFFQ_SB_XD4_XN3_mid1 r0 *1 0,0
Ccc_XD2_XDFFQ_SB_XD4_XN3_mid1 XD2.XDFFQ.SB XD4.XN3.mid1 1.21e-17
* device instance cc_XD2_XDFFQ_SB_XD4_XN3_mid2 r0 *1 0,0
Ccc_XD2_XDFFQ_SB_XD4_XN3_mid2 XD2.XDFFQ.SB XD4.XN3.mid2 1.21e-17
* device instance cc_XD2_XDFFQ_SB_XD4_dmodout r0 *1 0,0
Ccc_XD2_XDFFQ_SB_XD4_dmodout XD2.XDFFQ.SB XD4.dmodout 1.21e-17
* device instance cc_XD2_XDFFQ_SB_XD4_dq r0 *1 0,0
Ccc_XD2_XDFFQ_SB_XD4_dq XD2.XDFFQ.SB XD4.dq 1.8151e-17
* device instance cc_XD2_XDFFQ_SB_XD4_nm r0 *1 0,0
Ccc_XD2_XDFFQ_SB_XD4_nm XD2.XDFFQ.SB XD4.nm 1.21e-17
* device instance cc_XD2_XDFFQ_SB_XD4_nt r0 *1 0,0
Ccc_XD2_XDFFQ_SB_XD4_nt XD2.XDFFQ.SB XD4.nt 1.21e-17
* device instance cc_XD2_XDFFQ_SB_XD4_t1 r0 *1 0,0
Ccc_XD2_XDFFQ_SB_XD4_t1 XD2.XDFFQ.SB XD4.t1 1.21e-17
* device instance cc_XD2_XDFFQ_SB_XD5_XDFFM_CLKB r0 *1 0,0
Ccc_XD2_XDFFQ_SB_XD5_XDFFM_CLKB XD2.XDFFQ.SB XD5.XDFFM.CLKB 1.8151e-17
* device instance cc_XD2_XDFFQ_SB_XD5_XDFFM_M r0 *1 0,0
Ccc_XD2_XDFFQ_SB_XD5_XDFFM_M XD2.XDFFQ.SB XD5.XDFFM.M 2.4201e-17
* device instance cc_XD2_XDFFQ_SB_XD5_XDFFM_MB r0 *1 0,0
Ccc_XD2_XDFFQ_SB_XD5_XDFFM_MB XD2.XDFFQ.SB XD5.XDFFM.MB 1.21e-17
* device instance cc_XD2_XDFFQ_SB_XD5_XDFFM_S r0 *1 0,0
Ccc_XD2_XDFFQ_SB_XD5_XDFFM_S XD2.XDFFQ.SB XD5.XDFFM.S 1.8151e-17
* device instance cc_XD2_XDFFQ_SB_XD5_XDFFM_SB r0 *1 0,0
Ccc_XD2_XDFFQ_SB_XD5_XDFFM_SB XD2.XDFFQ.SB XD5.XDFFM.SB 1.8151e-17
* device instance cc_XD2_XDFFQ_SB_XD5_XDFFQ_CLKB r0 *1 0,0
Ccc_XD2_XDFFQ_SB_XD5_XDFFQ_CLKB XD2.XDFFQ.SB XD5.XDFFQ.CLKB 1.8151e-17
* device instance cc_XD2_XDFFQ_SB_XD5_XDFFQ_M r0 *1 0,0
Ccc_XD2_XDFFQ_SB_XD5_XDFFQ_M XD2.XDFFQ.SB XD5.XDFFQ.M 2.4201e-17
* device instance cc_XD2_XDFFQ_SB_XD5_XDFFQ_MB r0 *1 0,0
Ccc_XD2_XDFFQ_SB_XD5_XDFFQ_MB XD2.XDFFQ.SB XD5.XDFFQ.MB 1.21e-17
* device instance cc_XD2_XDFFQ_SB_XD5_XDFFQ_S r0 *1 0,0
Ccc_XD2_XDFFQ_SB_XD5_XDFFQ_S XD2.XDFFQ.SB XD5.XDFFQ.S 1.8151e-17
* device instance cc_XD2_XDFFQ_SB_XD5_XDFFQ_SB r0 *1 0,0
Ccc_XD2_XDFFQ_SB_XD5_XDFFQ_SB XD2.XDFFQ.SB XD5.XDFFQ.SB 1.8151e-17
* device instance cc_XD2_XDFFQ_SB_XD5_XN2_mid1 r0 *1 0,0
Ccc_XD2_XDFFQ_SB_XD5_XN2_mid1 XD2.XDFFQ.SB XD5.XN2.mid1 1.21e-17
* device instance cc_XD2_XDFFQ_SB_XD5_XN3_mid1 r0 *1 0,0
Ccc_XD2_XDFFQ_SB_XD5_XN3_mid1 XD2.XDFFQ.SB XD5.XN3.mid1 1.21e-17
* device instance cc_XD2_XDFFQ_SB_XD5_XN3_mid2 r0 *1 0,0
Ccc_XD2_XDFFQ_SB_XD5_XN3_mid2 XD2.XDFFQ.SB XD5.XN3.mid2 1.21e-17
* device instance cc_XD2_XDFFQ_SB_XD5_dmodout r0 *1 0,0
Ccc_XD2_XDFFQ_SB_XD5_dmodout XD2.XDFFQ.SB XD5.dmodout 1.21e-17
* device instance cc_XD2_XDFFQ_SB_XD5_dq r0 *1 0,0
Ccc_XD2_XDFFQ_SB_XD5_dq XD2.XDFFQ.SB XD5.dq 1.8151e-17
* device instance cc_XD2_XDFFQ_SB_XD5_nm r0 *1 0,0
Ccc_XD2_XDFFQ_SB_XD5_nm XD2.XDFFQ.SB XD5.nm 1.21e-17
* device instance cc_XD2_XDFFQ_SB_XD5_nt r0 *1 0,0
Ccc_XD2_XDFFQ_SB_XD5_nt XD2.XDFFQ.SB XD5.nt 1.21e-17
* device instance cc_XD2_XDFFQ_SB_XD5_t1 r0 *1 0,0
Ccc_XD2_XDFFQ_SB_XD5_t1 XD2.XDFFQ.SB XD5.t1 1.21e-17
* device instance cc_XD2_XDFFQ_SB_XFRT_CLKB r0 *1 0,0
Ccc_XD2_XDFFQ_SB_XFRT_CLKB XD2.XDFFQ.SB XFRT.CLKB 1.8151e-17
* device instance cc_XD2_XDFFQ_SB_XFRT_M r0 *1 0,0
Ccc_XD2_XDFFQ_SB_XFRT_M XD2.XDFFQ.SB XFRT.M 2.4201e-17
* device instance cc_XD2_XDFFQ_SB_XFRT_MB r0 *1 0,0
Ccc_XD2_XDFFQ_SB_XFRT_MB XD2.XDFFQ.SB XFRT.MB 1.21e-17
* device instance cc_XD2_XDFFQ_SB_XFRT_S r0 *1 0,0
Ccc_XD2_XDFFQ_SB_XFRT_S XD2.XDFFQ.SB XFRT.S 1.8151e-17
* device instance cc_XD2_XDFFQ_SB_XFRT_SB r0 *1 0,0
Ccc_XD2_XDFFQ_SB_XFRT_SB XD2.XDFFQ.SB XFRT.SB 1.8151e-17
* device instance cc_XD2_XDFFQ_SB_ck1 r0 *1 0,0
Ccc_XD2_XDFFQ_SB_ck1 XD2.XDFFQ.SB ck1 5.4452e-17
* device instance cc_XD2_XDFFQ_SB_ck2 r0 *1 0,0
Ccc_XD2_XDFFQ_SB_ck2 XD2.XDFFQ.SB ck2 5.4452e-17
* device instance cc_XD2_XDFFQ_SB_ck3 r0 *1 0,0
Ccc_XD2_XDFFQ_SB_ck3 XD2.XDFFQ.SB ck3 5.4452e-17
* device instance cc_XD2_XDFFQ_SB_ck4 r0 *1 0,0
Ccc_XD2_XDFFQ_SB_ck4 XD2.XDFFQ.SB ck4 5.4452e-17
* device instance cc_XD2_XDFFQ_SB_ck5 r0 *1 0,0
Ccc_XD2_XDFFQ_SB_ck5 XD2.XDFFQ.SB ck5 5.4452e-17
* device instance cc_XD2_XDFFQ_SB_mod0 r0 *1 0,0
Ccc_XD2_XDFFQ_SB_mod0 XD2.XDFFQ.SB mod0 2.4201e-17
* device instance cc_XD2_XDFFQ_SB_mod1 r0 *1 0,0
Ccc_XD2_XDFFQ_SB_mod1 XD2.XDFFQ.SB mod1 2.4201e-17
* device instance cc_XD2_XDFFQ_SB_mod2 r0 *1 0,0
Ccc_XD2_XDFFQ_SB_mod2 XD2.XDFFQ.SB mod2 2.4201e-17
* device instance cc_XD2_XDFFQ_SB_mod3 r0 *1 0,0
Ccc_XD2_XDFFQ_SB_mod3 XD2.XDFFQ.SB mod3 2.4201e-17
* device instance cc_XD2_XDFFQ_SB_mod4 r0 *1 0,0
Ccc_XD2_XDFFQ_SB_mod4 XD2.XDFFQ.SB mod4 2.4201e-17
* device instance cc_XD2_XDFFQ_SB_net1 r0 *1 0,0
Ccc_XD2_XDFFQ_SB_net1 XD2.XDFFQ.SB net1 1.21e-17
* device instance cc_XD2_XN2_mid1_XD2_nm r0 *1 0,0
Ccc_XD2_XN2_mid1_XD2_nm XD2.XN2.mid1 XD2.nm 1.1294e-17
* device instance cc_XD2_XN2_mid1_ck3 r0 *1 0,0
Ccc_XD2_XN2_mid1_ck3 XD2.XN2.mid1 ck3 6.05e-18
* device instance cc_XD2_XN3_mid1_XD2_XN3_mid2 r0 *1 0,0
Ccc_XD2_XN3_mid1_XD2_XN3_mid2 XD2.XN3.mid1 XD2.XN3.mid2 1.1294e-17
* device instance cc_XD2_XN3_mid1_XD2_nt r0 *1 0,0
Ccc_XD2_XN3_mid1_XD2_nt XD2.XN3.mid1 XD2.nt 1.1294e-17
* device instance cc_XD2_XN3_mid2_mod1 r0 *1 0,0
Ccc_XD2_XN3_mid2_mod1 XD2.XN3.mid2 mod1 6.05e-18
* device instance cc_XD2_XNOR_midp_XD2_dq r0 *1 0,0
Ccc_XD2_XNOR_midp_XD2_dq XD2.XNOR.midp XD2.dq 5.244e-18
* device instance cc_XD2_XNOR_midp_XD2_t1 r0 *1 0,0
Ccc_XD2_XNOR_midp_XD2_t1 XD2.XNOR.midp XD2.t1 6.05e-18
* device instance cc_XD2_dmodout_XD2_dq r0 *1 0,0
Ccc_XD2_dmodout_XD2_dq XD2.dmodout XD2.dq 1.21e-17
* device instance cc_XD2_dmodout_XD2_nm r0 *1 0,0
Ccc_XD2_dmodout_XD2_nm XD2.dmodout XD2.nm 1.8151e-17
* device instance cc_XD2_dmodout_XD2_nt r0 *1 0,0
Ccc_XD2_dmodout_XD2_nt XD2.dmodout XD2.nt 2.4201e-17
* device instance cc_XD2_dmodout_XD2_t1 r0 *1 0,0
Ccc_XD2_dmodout_XD2_t1 XD2.dmodout XD2.t1 1.21e-17
* device instance cc_XD2_dmodout_XD3_XDFFM_CLKB r0 *1 0,0
Ccc_XD2_dmodout_XD3_XDFFM_CLKB XD2.dmodout XD3.XDFFM.CLKB 1.8151e-17
* device instance cc_XD2_dmodout_XD3_XDFFM_M r0 *1 0,0
Ccc_XD2_dmodout_XD3_XDFFM_M XD2.dmodout XD3.XDFFM.M 2.4201e-17
* device instance cc_XD2_dmodout_XD3_XDFFM_MB r0 *1 0,0
Ccc_XD2_dmodout_XD3_XDFFM_MB XD2.dmodout XD3.XDFFM.MB 1.21e-17
* device instance cc_XD2_dmodout_XD3_XDFFM_S r0 *1 0,0
Ccc_XD2_dmodout_XD3_XDFFM_S XD2.dmodout XD3.XDFFM.S 1.8151e-17
* device instance cc_XD2_dmodout_XD3_XDFFM_SB r0 *1 0,0
Ccc_XD2_dmodout_XD3_XDFFM_SB XD2.dmodout XD3.XDFFM.SB 1.8151e-17
* device instance cc_XD2_dmodout_XD3_XDFFQ_CLKB r0 *1 0,0
Ccc_XD2_dmodout_XD3_XDFFQ_CLKB XD2.dmodout XD3.XDFFQ.CLKB 1.8151e-17
* device instance cc_XD2_dmodout_XD3_XDFFQ_M r0 *1 0,0
Ccc_XD2_dmodout_XD3_XDFFQ_M XD2.dmodout XD3.XDFFQ.M 2.4201e-17
* device instance cc_XD2_dmodout_XD3_XDFFQ_MB r0 *1 0,0
Ccc_XD2_dmodout_XD3_XDFFQ_MB XD2.dmodout XD3.XDFFQ.MB 1.21e-17
* device instance cc_XD2_dmodout_XD3_XDFFQ_S r0 *1 0,0
Ccc_XD2_dmodout_XD3_XDFFQ_S XD2.dmodout XD3.XDFFQ.S 1.8151e-17
* device instance cc_XD2_dmodout_XD3_XDFFQ_SB r0 *1 0,0
Ccc_XD2_dmodout_XD3_XDFFQ_SB XD2.dmodout XD3.XDFFQ.SB 1.8151e-17
* device instance cc_XD2_dmodout_XD3_XN2_mid1 r0 *1 0,0
Ccc_XD2_dmodout_XD3_XN2_mid1 XD2.dmodout XD3.XN2.mid1 1.21e-17
* device instance cc_XD2_dmodout_XD3_XN3_mid1 r0 *1 0,0
Ccc_XD2_dmodout_XD3_XN3_mid1 XD2.dmodout XD3.XN3.mid1 1.21e-17
* device instance cc_XD2_dmodout_XD3_XN3_mid2 r0 *1 0,0
Ccc_XD2_dmodout_XD3_XN3_mid2 XD2.dmodout XD3.XN3.mid2 1.21e-17
* device instance cc_XD2_dmodout_XD3_dmodout r0 *1 0,0
Ccc_XD2_dmodout_XD3_dmodout XD2.dmodout XD3.dmodout 1.21e-17
* device instance cc_XD2_dmodout_XD3_dq r0 *1 0,0
Ccc_XD2_dmodout_XD3_dq XD2.dmodout XD3.dq 1.8151e-17
* device instance cc_XD2_dmodout_XD3_nm r0 *1 0,0
Ccc_XD2_dmodout_XD3_nm XD2.dmodout XD3.nm 1.21e-17
* device instance cc_XD2_dmodout_XD3_nt r0 *1 0,0
Ccc_XD2_dmodout_XD3_nt XD2.dmodout XD3.nt 1.21e-17
* device instance cc_XD2_dmodout_XD3_t1 r0 *1 0,0
Ccc_XD2_dmodout_XD3_t1 XD2.dmodout XD3.t1 1.21e-17
* device instance cc_XD2_dmodout_XD4_XDFFM_CLKB r0 *1 0,0
Ccc_XD2_dmodout_XD4_XDFFM_CLKB XD2.dmodout XD4.XDFFM.CLKB 1.8151e-17
* device instance cc_XD2_dmodout_XD4_XDFFM_M r0 *1 0,0
Ccc_XD2_dmodout_XD4_XDFFM_M XD2.dmodout XD4.XDFFM.M 2.4201e-17
* device instance cc_XD2_dmodout_XD4_XDFFM_MB r0 *1 0,0
Ccc_XD2_dmodout_XD4_XDFFM_MB XD2.dmodout XD4.XDFFM.MB 1.21e-17
* device instance cc_XD2_dmodout_XD4_XDFFM_S r0 *1 0,0
Ccc_XD2_dmodout_XD4_XDFFM_S XD2.dmodout XD4.XDFFM.S 1.8151e-17
* device instance cc_XD2_dmodout_XD4_XDFFM_SB r0 *1 0,0
Ccc_XD2_dmodout_XD4_XDFFM_SB XD2.dmodout XD4.XDFFM.SB 1.8151e-17
* device instance cc_XD2_dmodout_XD4_XDFFQ_CLKB r0 *1 0,0
Ccc_XD2_dmodout_XD4_XDFFQ_CLKB XD2.dmodout XD4.XDFFQ.CLKB 1.8151e-17
* device instance cc_XD2_dmodout_XD4_XDFFQ_M r0 *1 0,0
Ccc_XD2_dmodout_XD4_XDFFQ_M XD2.dmodout XD4.XDFFQ.M 2.4201e-17
* device instance cc_XD2_dmodout_XD4_XDFFQ_MB r0 *1 0,0
Ccc_XD2_dmodout_XD4_XDFFQ_MB XD2.dmodout XD4.XDFFQ.MB 1.21e-17
* device instance cc_XD2_dmodout_XD4_XDFFQ_S r0 *1 0,0
Ccc_XD2_dmodout_XD4_XDFFQ_S XD2.dmodout XD4.XDFFQ.S 1.8151e-17
* device instance cc_XD2_dmodout_XD4_XDFFQ_SB r0 *1 0,0
Ccc_XD2_dmodout_XD4_XDFFQ_SB XD2.dmodout XD4.XDFFQ.SB 1.8151e-17
* device instance cc_XD2_dmodout_XD4_XN2_mid1 r0 *1 0,0
Ccc_XD2_dmodout_XD4_XN2_mid1 XD2.dmodout XD4.XN2.mid1 1.21e-17
* device instance cc_XD2_dmodout_XD4_XN3_mid1 r0 *1 0,0
Ccc_XD2_dmodout_XD4_XN3_mid1 XD2.dmodout XD4.XN3.mid1 1.21e-17
* device instance cc_XD2_dmodout_XD4_XN3_mid2 r0 *1 0,0
Ccc_XD2_dmodout_XD4_XN3_mid2 XD2.dmodout XD4.XN3.mid2 1.21e-17
* device instance cc_XD2_dmodout_XD4_dmodout r0 *1 0,0
Ccc_XD2_dmodout_XD4_dmodout XD2.dmodout XD4.dmodout 1.21e-17
* device instance cc_XD2_dmodout_XD4_dq r0 *1 0,0
Ccc_XD2_dmodout_XD4_dq XD2.dmodout XD4.dq 1.8151e-17
* device instance cc_XD2_dmodout_XD4_nm r0 *1 0,0
Ccc_XD2_dmodout_XD4_nm XD2.dmodout XD4.nm 1.21e-17
* device instance cc_XD2_dmodout_XD4_nt r0 *1 0,0
Ccc_XD2_dmodout_XD4_nt XD2.dmodout XD4.nt 1.21e-17
* device instance cc_XD2_dmodout_XD4_t1 r0 *1 0,0
Ccc_XD2_dmodout_XD4_t1 XD2.dmodout XD4.t1 1.21e-17
* device instance cc_XD2_dmodout_XD5_XDFFM_CLKB r0 *1 0,0
Ccc_XD2_dmodout_XD5_XDFFM_CLKB XD2.dmodout XD5.XDFFM.CLKB 1.8151e-17
* device instance cc_XD2_dmodout_XD5_XDFFM_M r0 *1 0,0
Ccc_XD2_dmodout_XD5_XDFFM_M XD2.dmodout XD5.XDFFM.M 2.4201e-17
* device instance cc_XD2_dmodout_XD5_XDFFM_MB r0 *1 0,0
Ccc_XD2_dmodout_XD5_XDFFM_MB XD2.dmodout XD5.XDFFM.MB 1.21e-17
* device instance cc_XD2_dmodout_XD5_XDFFM_S r0 *1 0,0
Ccc_XD2_dmodout_XD5_XDFFM_S XD2.dmodout XD5.XDFFM.S 1.8151e-17
* device instance cc_XD2_dmodout_XD5_XDFFM_SB r0 *1 0,0
Ccc_XD2_dmodout_XD5_XDFFM_SB XD2.dmodout XD5.XDFFM.SB 1.8151e-17
* device instance cc_XD2_dmodout_XD5_XDFFQ_CLKB r0 *1 0,0
Ccc_XD2_dmodout_XD5_XDFFQ_CLKB XD2.dmodout XD5.XDFFQ.CLKB 1.8151e-17
* device instance cc_XD2_dmodout_XD5_XDFFQ_M r0 *1 0,0
Ccc_XD2_dmodout_XD5_XDFFQ_M XD2.dmodout XD5.XDFFQ.M 2.4201e-17
* device instance cc_XD2_dmodout_XD5_XDFFQ_MB r0 *1 0,0
Ccc_XD2_dmodout_XD5_XDFFQ_MB XD2.dmodout XD5.XDFFQ.MB 1.21e-17
* device instance cc_XD2_dmodout_XD5_XDFFQ_S r0 *1 0,0
Ccc_XD2_dmodout_XD5_XDFFQ_S XD2.dmodout XD5.XDFFQ.S 1.8151e-17
* device instance cc_XD2_dmodout_XD5_XDFFQ_SB r0 *1 0,0
Ccc_XD2_dmodout_XD5_XDFFQ_SB XD2.dmodout XD5.XDFFQ.SB 1.8151e-17
* device instance cc_XD2_dmodout_XD5_XN2_mid1 r0 *1 0,0
Ccc_XD2_dmodout_XD5_XN2_mid1 XD2.dmodout XD5.XN2.mid1 1.21e-17
* device instance cc_XD2_dmodout_XD5_XN3_mid1 r0 *1 0,0
Ccc_XD2_dmodout_XD5_XN3_mid1 XD2.dmodout XD5.XN3.mid1 1.21e-17
* device instance cc_XD2_dmodout_XD5_XN3_mid2 r0 *1 0,0
Ccc_XD2_dmodout_XD5_XN3_mid2 XD2.dmodout XD5.XN3.mid2 1.21e-17
* device instance cc_XD2_dmodout_XD5_dmodout r0 *1 0,0
Ccc_XD2_dmodout_XD5_dmodout XD2.dmodout XD5.dmodout 1.21e-17
* device instance cc_XD2_dmodout_XD5_dq r0 *1 0,0
Ccc_XD2_dmodout_XD5_dq XD2.dmodout XD5.dq 1.8151e-17
* device instance cc_XD2_dmodout_XD5_nm r0 *1 0,0
Ccc_XD2_dmodout_XD5_nm XD2.dmodout XD5.nm 1.21e-17
* device instance cc_XD2_dmodout_XD5_nt r0 *1 0,0
Ccc_XD2_dmodout_XD5_nt XD2.dmodout XD5.nt 1.21e-17
* device instance cc_XD2_dmodout_XD5_t1 r0 *1 0,0
Ccc_XD2_dmodout_XD5_t1 XD2.dmodout XD5.t1 1.21e-17
* device instance cc_XD2_dmodout_XFRT_CLKB r0 *1 0,0
Ccc_XD2_dmodout_XFRT_CLKB XD2.dmodout XFRT.CLKB 1.8151e-17
* device instance cc_XD2_dmodout_XFRT_M r0 *1 0,0
Ccc_XD2_dmodout_XFRT_M XD2.dmodout XFRT.M 2.4201e-17
* device instance cc_XD2_dmodout_XFRT_MB r0 *1 0,0
Ccc_XD2_dmodout_XFRT_MB XD2.dmodout XFRT.MB 1.21e-17
* device instance cc_XD2_dmodout_XFRT_S r0 *1 0,0
Ccc_XD2_dmodout_XFRT_S XD2.dmodout XFRT.S 1.8151e-17
* device instance cc_XD2_dmodout_XFRT_SB r0 *1 0,0
Ccc_XD2_dmodout_XFRT_SB XD2.dmodout XFRT.SB 1.8151e-17
* device instance cc_XD2_dmodout_ck1 r0 *1 0,0
Ccc_XD2_dmodout_ck1 XD2.dmodout ck1 5.4452e-17
* device instance cc_XD2_dmodout_ck2 r0 *1 0,0
Ccc_XD2_dmodout_ck2 XD2.dmodout ck2 6.6553e-17
* device instance cc_XD2_dmodout_ck3 r0 *1 0,0
Ccc_XD2_dmodout_ck3 XD2.dmodout ck3 5.4452e-17
* device instance cc_XD2_dmodout_ck4 r0 *1 0,0
Ccc_XD2_dmodout_ck4 XD2.dmodout ck4 5.4452e-17
* device instance cc_XD2_dmodout_ck5 r0 *1 0,0
Ccc_XD2_dmodout_ck5 XD2.dmodout ck5 5.4452e-17
* device instance cc_XD2_dmodout_mod0 r0 *1 0,0
Ccc_XD2_dmodout_mod0 XD2.dmodout mod0 2.4201e-17
* device instance cc_XD2_dmodout_mod1 r0 *1 0,0
Ccc_XD2_dmodout_mod1 XD2.dmodout mod1 2.4201e-17
* device instance cc_XD2_dmodout_mod2 r0 *1 0,0
Ccc_XD2_dmodout_mod2 XD2.dmodout mod2 2.4201e-17
* device instance cc_XD2_dmodout_mod3 r0 *1 0,0
Ccc_XD2_dmodout_mod3 XD2.dmodout mod3 2.4201e-17
* device instance cc_XD2_dmodout_mod4 r0 *1 0,0
Ccc_XD2_dmodout_mod4 XD2.dmodout mod4 2.4201e-17
* device instance cc_XD2_dmodout_net1 r0 *1 0,0
Ccc_XD2_dmodout_net1 XD2.dmodout net1 1.21e-17
* device instance cc_XD2_dq_XD2_nm r0 *1 0,0
Ccc_XD2_dq_XD2_nm XD2.dq XD2.nm 1.21e-17
* device instance cc_XD2_dq_XD2_nt r0 *1 0,0
Ccc_XD2_dq_XD2_nt XD2.dq XD2.nt 2.4201e-17
* device instance cc_XD2_dq_XD2_t1 r0 *1 0,0
Ccc_XD2_dq_XD2_t1 XD2.dq XD2.t1 1.8151e-17
* device instance cc_XD2_dq_XD3_XDFFM_CLKB r0 *1 0,0
Ccc_XD2_dq_XD3_XDFFM_CLKB XD2.dq XD3.XDFFM.CLKB 1.8151e-17
* device instance cc_XD2_dq_XD3_XDFFM_M r0 *1 0,0
Ccc_XD2_dq_XD3_XDFFM_M XD2.dq XD3.XDFFM.M 2.4201e-17
* device instance cc_XD2_dq_XD3_XDFFM_MB r0 *1 0,0
Ccc_XD2_dq_XD3_XDFFM_MB XD2.dq XD3.XDFFM.MB 1.21e-17
* device instance cc_XD2_dq_XD3_XDFFM_S r0 *1 0,0
Ccc_XD2_dq_XD3_XDFFM_S XD2.dq XD3.XDFFM.S 1.8151e-17
* device instance cc_XD2_dq_XD3_XDFFM_SB r0 *1 0,0
Ccc_XD2_dq_XD3_XDFFM_SB XD2.dq XD3.XDFFM.SB 1.8151e-17
* device instance cc_XD2_dq_XD3_XDFFQ_CLKB r0 *1 0,0
Ccc_XD2_dq_XD3_XDFFQ_CLKB XD2.dq XD3.XDFFQ.CLKB 1.8151e-17
* device instance cc_XD2_dq_XD3_XDFFQ_M r0 *1 0,0
Ccc_XD2_dq_XD3_XDFFQ_M XD2.dq XD3.XDFFQ.M 2.4201e-17
* device instance cc_XD2_dq_XD3_XDFFQ_MB r0 *1 0,0
Ccc_XD2_dq_XD3_XDFFQ_MB XD2.dq XD3.XDFFQ.MB 1.21e-17
* device instance cc_XD2_dq_XD3_XDFFQ_S r0 *1 0,0
Ccc_XD2_dq_XD3_XDFFQ_S XD2.dq XD3.XDFFQ.S 1.8151e-17
* device instance cc_XD2_dq_XD3_XDFFQ_SB r0 *1 0,0
Ccc_XD2_dq_XD3_XDFFQ_SB XD2.dq XD3.XDFFQ.SB 1.8151e-17
* device instance cc_XD2_dq_XD3_XN2_mid1 r0 *1 0,0
Ccc_XD2_dq_XD3_XN2_mid1 XD2.dq XD3.XN2.mid1 1.21e-17
* device instance cc_XD2_dq_XD3_XN3_mid1 r0 *1 0,0
Ccc_XD2_dq_XD3_XN3_mid1 XD2.dq XD3.XN3.mid1 1.21e-17
* device instance cc_XD2_dq_XD3_XN3_mid2 r0 *1 0,0
Ccc_XD2_dq_XD3_XN3_mid2 XD2.dq XD3.XN3.mid2 1.21e-17
* device instance cc_XD2_dq_XD3_dmodout r0 *1 0,0
Ccc_XD2_dq_XD3_dmodout XD2.dq XD3.dmodout 1.21e-17
* device instance cc_XD2_dq_XD3_dq r0 *1 0,0
Ccc_XD2_dq_XD3_dq XD2.dq XD3.dq 1.8151e-17
* device instance cc_XD2_dq_XD3_nm r0 *1 0,0
Ccc_XD2_dq_XD3_nm XD2.dq XD3.nm 1.21e-17
* device instance cc_XD2_dq_XD3_nt r0 *1 0,0
Ccc_XD2_dq_XD3_nt XD2.dq XD3.nt 1.21e-17
* device instance cc_XD2_dq_XD3_t1 r0 *1 0,0
Ccc_XD2_dq_XD3_t1 XD2.dq XD3.t1 1.21e-17
* device instance cc_XD2_dq_XD4_XDFFM_CLKB r0 *1 0,0
Ccc_XD2_dq_XD4_XDFFM_CLKB XD2.dq XD4.XDFFM.CLKB 1.8151e-17
* device instance cc_XD2_dq_XD4_XDFFM_M r0 *1 0,0
Ccc_XD2_dq_XD4_XDFFM_M XD2.dq XD4.XDFFM.M 2.4201e-17
* device instance cc_XD2_dq_XD4_XDFFM_MB r0 *1 0,0
Ccc_XD2_dq_XD4_XDFFM_MB XD2.dq XD4.XDFFM.MB 1.21e-17
* device instance cc_XD2_dq_XD4_XDFFM_S r0 *1 0,0
Ccc_XD2_dq_XD4_XDFFM_S XD2.dq XD4.XDFFM.S 1.8151e-17
* device instance cc_XD2_dq_XD4_XDFFM_SB r0 *1 0,0
Ccc_XD2_dq_XD4_XDFFM_SB XD2.dq XD4.XDFFM.SB 1.8151e-17
* device instance cc_XD2_dq_XD4_XDFFQ_CLKB r0 *1 0,0
Ccc_XD2_dq_XD4_XDFFQ_CLKB XD2.dq XD4.XDFFQ.CLKB 1.8151e-17
* device instance cc_XD2_dq_XD4_XDFFQ_M r0 *1 0,0
Ccc_XD2_dq_XD4_XDFFQ_M XD2.dq XD4.XDFFQ.M 2.4201e-17
* device instance cc_XD2_dq_XD4_XDFFQ_MB r0 *1 0,0
Ccc_XD2_dq_XD4_XDFFQ_MB XD2.dq XD4.XDFFQ.MB 1.21e-17
* device instance cc_XD2_dq_XD4_XDFFQ_S r0 *1 0,0
Ccc_XD2_dq_XD4_XDFFQ_S XD2.dq XD4.XDFFQ.S 1.8151e-17
* device instance cc_XD2_dq_XD4_XDFFQ_SB r0 *1 0,0
Ccc_XD2_dq_XD4_XDFFQ_SB XD2.dq XD4.XDFFQ.SB 1.8151e-17
* device instance cc_XD2_dq_XD4_XN2_mid1 r0 *1 0,0
Ccc_XD2_dq_XD4_XN2_mid1 XD2.dq XD4.XN2.mid1 1.21e-17
* device instance cc_XD2_dq_XD4_XN3_mid1 r0 *1 0,0
Ccc_XD2_dq_XD4_XN3_mid1 XD2.dq XD4.XN3.mid1 1.21e-17
* device instance cc_XD2_dq_XD4_XN3_mid2 r0 *1 0,0
Ccc_XD2_dq_XD4_XN3_mid2 XD2.dq XD4.XN3.mid2 1.21e-17
* device instance cc_XD2_dq_XD4_dmodout r0 *1 0,0
Ccc_XD2_dq_XD4_dmodout XD2.dq XD4.dmodout 1.21e-17
* device instance cc_XD2_dq_XD4_dq r0 *1 0,0
Ccc_XD2_dq_XD4_dq XD2.dq XD4.dq 1.8151e-17
* device instance cc_XD2_dq_XD4_nm r0 *1 0,0
Ccc_XD2_dq_XD4_nm XD2.dq XD4.nm 1.21e-17
* device instance cc_XD2_dq_XD4_nt r0 *1 0,0
Ccc_XD2_dq_XD4_nt XD2.dq XD4.nt 1.21e-17
* device instance cc_XD2_dq_XD4_t1 r0 *1 0,0
Ccc_XD2_dq_XD4_t1 XD2.dq XD4.t1 1.21e-17
* device instance cc_XD2_dq_XD5_XDFFM_CLKB r0 *1 0,0
Ccc_XD2_dq_XD5_XDFFM_CLKB XD2.dq XD5.XDFFM.CLKB 1.8151e-17
* device instance cc_XD2_dq_XD5_XDFFM_M r0 *1 0,0
Ccc_XD2_dq_XD5_XDFFM_M XD2.dq XD5.XDFFM.M 2.4201e-17
* device instance cc_XD2_dq_XD5_XDFFM_MB r0 *1 0,0
Ccc_XD2_dq_XD5_XDFFM_MB XD2.dq XD5.XDFFM.MB 1.21e-17
* device instance cc_XD2_dq_XD5_XDFFM_S r0 *1 0,0
Ccc_XD2_dq_XD5_XDFFM_S XD2.dq XD5.XDFFM.S 1.8151e-17
* device instance cc_XD2_dq_XD5_XDFFM_SB r0 *1 0,0
Ccc_XD2_dq_XD5_XDFFM_SB XD2.dq XD5.XDFFM.SB 1.8151e-17
* device instance cc_XD2_dq_XD5_XDFFQ_CLKB r0 *1 0,0
Ccc_XD2_dq_XD5_XDFFQ_CLKB XD2.dq XD5.XDFFQ.CLKB 1.8151e-17
* device instance cc_XD2_dq_XD5_XDFFQ_M r0 *1 0,0
Ccc_XD2_dq_XD5_XDFFQ_M XD2.dq XD5.XDFFQ.M 2.4201e-17
* device instance cc_XD2_dq_XD5_XDFFQ_MB r0 *1 0,0
Ccc_XD2_dq_XD5_XDFFQ_MB XD2.dq XD5.XDFFQ.MB 1.21e-17
* device instance cc_XD2_dq_XD5_XDFFQ_S r0 *1 0,0
Ccc_XD2_dq_XD5_XDFFQ_S XD2.dq XD5.XDFFQ.S 1.8151e-17
* device instance cc_XD2_dq_XD5_XDFFQ_SB r0 *1 0,0
Ccc_XD2_dq_XD5_XDFFQ_SB XD2.dq XD5.XDFFQ.SB 1.8151e-17
* device instance cc_XD2_dq_XD5_XN2_mid1 r0 *1 0,0
Ccc_XD2_dq_XD5_XN2_mid1 XD2.dq XD5.XN2.mid1 1.21e-17
* device instance cc_XD2_dq_XD5_XN3_mid1 r0 *1 0,0
Ccc_XD2_dq_XD5_XN3_mid1 XD2.dq XD5.XN3.mid1 1.21e-17
* device instance cc_XD2_dq_XD5_XN3_mid2 r0 *1 0,0
Ccc_XD2_dq_XD5_XN3_mid2 XD2.dq XD5.XN3.mid2 1.21e-17
* device instance cc_XD2_dq_XD5_dmodout r0 *1 0,0
Ccc_XD2_dq_XD5_dmodout XD2.dq XD5.dmodout 1.21e-17
* device instance cc_XD2_dq_XD5_dq r0 *1 0,0
Ccc_XD2_dq_XD5_dq XD2.dq XD5.dq 1.8151e-17
* device instance cc_XD2_dq_XD5_nm r0 *1 0,0
Ccc_XD2_dq_XD5_nm XD2.dq XD5.nm 1.21e-17
* device instance cc_XD2_dq_XD5_nt r0 *1 0,0
Ccc_XD2_dq_XD5_nt XD2.dq XD5.nt 1.21e-17
* device instance cc_XD2_dq_XD5_t1 r0 *1 0,0
Ccc_XD2_dq_XD5_t1 XD2.dq XD5.t1 1.21e-17
* device instance cc_XD2_dq_XFRT_CLKB r0 *1 0,0
Ccc_XD2_dq_XFRT_CLKB XD2.dq XFRT.CLKB 1.8151e-17
* device instance cc_XD2_dq_XFRT_M r0 *1 0,0
Ccc_XD2_dq_XFRT_M XD2.dq XFRT.M 2.4201e-17
* device instance cc_XD2_dq_XFRT_MB r0 *1 0,0
Ccc_XD2_dq_XFRT_MB XD2.dq XFRT.MB 1.21e-17
* device instance cc_XD2_dq_XFRT_S r0 *1 0,0
Ccc_XD2_dq_XFRT_S XD2.dq XFRT.S 1.8151e-17
* device instance cc_XD2_dq_XFRT_SB r0 *1 0,0
Ccc_XD2_dq_XFRT_SB XD2.dq XFRT.SB 1.8151e-17
* device instance cc_XD2_dq_ck1 r0 *1 0,0
Ccc_XD2_dq_ck1 XD2.dq ck1 5.4452e-17
* device instance cc_XD2_dq_ck2 r0 *1 0,0
Ccc_XD2_dq_ck2 XD2.dq ck2 6.6553e-17
* device instance cc_XD2_dq_ck3 r0 *1 0,0
Ccc_XD2_dq_ck3 XD2.dq ck3 5.4452e-17
* device instance cc_XD2_dq_ck4 r0 *1 0,0
Ccc_XD2_dq_ck4 XD2.dq ck4 5.4452e-17
* device instance cc_XD2_dq_ck5 r0 *1 0,0
Ccc_XD2_dq_ck5 XD2.dq ck5 5.4452e-17
* device instance cc_XD2_dq_mod0 r0 *1 0,0
Ccc_XD2_dq_mod0 XD2.dq mod0 2.4201e-17
* device instance cc_XD2_dq_mod1 r0 *1 0,0
Ccc_XD2_dq_mod1 XD2.dq mod1 2.4201e-17
* device instance cc_XD2_dq_mod2 r0 *1 0,0
Ccc_XD2_dq_mod2 XD2.dq mod2 2.4201e-17
* device instance cc_XD2_dq_mod3 r0 *1 0,0
Ccc_XD2_dq_mod3 XD2.dq mod3 2.4201e-17
* device instance cc_XD2_dq_mod4 r0 *1 0,0
Ccc_XD2_dq_mod4 XD2.dq mod4 2.4201e-17
* device instance cc_XD2_dq_net1 r0 *1 0,0
Ccc_XD2_dq_net1 XD2.dq net1 1.21e-17
* device instance cc_XD2_nm_XD2_nt r0 *1 0,0
Ccc_XD2_nm_XD2_nt XD2.nm XD2.nt 2.4201e-17
* device instance cc_XD2_nm_XD2_t1 r0 *1 0,0
Ccc_XD2_nm_XD2_t1 XD2.nm XD2.t1 1.21e-17
* device instance cc_XD2_nm_XD3_XDFFM_CLKB r0 *1 0,0
Ccc_XD2_nm_XD3_XDFFM_CLKB XD2.nm XD3.XDFFM.CLKB 1.8151e-17
* device instance cc_XD2_nm_XD3_XDFFM_M r0 *1 0,0
Ccc_XD2_nm_XD3_XDFFM_M XD2.nm XD3.XDFFM.M 2.4201e-17
* device instance cc_XD2_nm_XD3_XDFFM_MB r0 *1 0,0
Ccc_XD2_nm_XD3_XDFFM_MB XD2.nm XD3.XDFFM.MB 1.21e-17
* device instance cc_XD2_nm_XD3_XDFFM_S r0 *1 0,0
Ccc_XD2_nm_XD3_XDFFM_S XD2.nm XD3.XDFFM.S 1.8151e-17
* device instance cc_XD2_nm_XD3_XDFFM_SB r0 *1 0,0
Ccc_XD2_nm_XD3_XDFFM_SB XD2.nm XD3.XDFFM.SB 1.8151e-17
* device instance cc_XD2_nm_XD3_XDFFQ_CLKB r0 *1 0,0
Ccc_XD2_nm_XD3_XDFFQ_CLKB XD2.nm XD3.XDFFQ.CLKB 1.8151e-17
* device instance cc_XD2_nm_XD3_XDFFQ_M r0 *1 0,0
Ccc_XD2_nm_XD3_XDFFQ_M XD2.nm XD3.XDFFQ.M 2.4201e-17
* device instance cc_XD2_nm_XD3_XDFFQ_MB r0 *1 0,0
Ccc_XD2_nm_XD3_XDFFQ_MB XD2.nm XD3.XDFFQ.MB 1.21e-17
* device instance cc_XD2_nm_XD3_XDFFQ_S r0 *1 0,0
Ccc_XD2_nm_XD3_XDFFQ_S XD2.nm XD3.XDFFQ.S 1.8151e-17
* device instance cc_XD2_nm_XD3_XDFFQ_SB r0 *1 0,0
Ccc_XD2_nm_XD3_XDFFQ_SB XD2.nm XD3.XDFFQ.SB 1.8151e-17
* device instance cc_XD2_nm_XD3_XN2_mid1 r0 *1 0,0
Ccc_XD2_nm_XD3_XN2_mid1 XD2.nm XD3.XN2.mid1 1.21e-17
* device instance cc_XD2_nm_XD3_XN3_mid1 r0 *1 0,0
Ccc_XD2_nm_XD3_XN3_mid1 XD2.nm XD3.XN3.mid1 1.21e-17
* device instance cc_XD2_nm_XD3_XN3_mid2 r0 *1 0,0
Ccc_XD2_nm_XD3_XN3_mid2 XD2.nm XD3.XN3.mid2 1.21e-17
* device instance cc_XD2_nm_XD3_dmodout r0 *1 0,0
Ccc_XD2_nm_XD3_dmodout XD2.nm XD3.dmodout 1.21e-17
* device instance cc_XD2_nm_XD3_dq r0 *1 0,0
Ccc_XD2_nm_XD3_dq XD2.nm XD3.dq 1.8151e-17
* device instance cc_XD2_nm_XD3_nm r0 *1 0,0
Ccc_XD2_nm_XD3_nm XD2.nm XD3.nm 1.21e-17
* device instance cc_XD2_nm_XD3_nt r0 *1 0,0
Ccc_XD2_nm_XD3_nt XD2.nm XD3.nt 1.21e-17
* device instance cc_XD2_nm_XD3_t1 r0 *1 0,0
Ccc_XD2_nm_XD3_t1 XD2.nm XD3.t1 1.21e-17
* device instance cc_XD2_nm_XD4_XDFFM_CLKB r0 *1 0,0
Ccc_XD2_nm_XD4_XDFFM_CLKB XD2.nm XD4.XDFFM.CLKB 1.8151e-17
* device instance cc_XD2_nm_XD4_XDFFM_M r0 *1 0,0
Ccc_XD2_nm_XD4_XDFFM_M XD2.nm XD4.XDFFM.M 2.4201e-17
* device instance cc_XD2_nm_XD4_XDFFM_MB r0 *1 0,0
Ccc_XD2_nm_XD4_XDFFM_MB XD2.nm XD4.XDFFM.MB 1.21e-17
* device instance cc_XD2_nm_XD4_XDFFM_S r0 *1 0,0
Ccc_XD2_nm_XD4_XDFFM_S XD2.nm XD4.XDFFM.S 1.8151e-17
* device instance cc_XD2_nm_XD4_XDFFM_SB r0 *1 0,0
Ccc_XD2_nm_XD4_XDFFM_SB XD2.nm XD4.XDFFM.SB 1.8151e-17
* device instance cc_XD2_nm_XD4_XDFFQ_CLKB r0 *1 0,0
Ccc_XD2_nm_XD4_XDFFQ_CLKB XD2.nm XD4.XDFFQ.CLKB 1.8151e-17
* device instance cc_XD2_nm_XD4_XDFFQ_M r0 *1 0,0
Ccc_XD2_nm_XD4_XDFFQ_M XD2.nm XD4.XDFFQ.M 2.4201e-17
* device instance cc_XD2_nm_XD4_XDFFQ_MB r0 *1 0,0
Ccc_XD2_nm_XD4_XDFFQ_MB XD2.nm XD4.XDFFQ.MB 1.21e-17
* device instance cc_XD2_nm_XD4_XDFFQ_S r0 *1 0,0
Ccc_XD2_nm_XD4_XDFFQ_S XD2.nm XD4.XDFFQ.S 1.8151e-17
* device instance cc_XD2_nm_XD4_XDFFQ_SB r0 *1 0,0
Ccc_XD2_nm_XD4_XDFFQ_SB XD2.nm XD4.XDFFQ.SB 1.8151e-17
* device instance cc_XD2_nm_XD4_XN2_mid1 r0 *1 0,0
Ccc_XD2_nm_XD4_XN2_mid1 XD2.nm XD4.XN2.mid1 1.21e-17
* device instance cc_XD2_nm_XD4_XN3_mid1 r0 *1 0,0
Ccc_XD2_nm_XD4_XN3_mid1 XD2.nm XD4.XN3.mid1 1.21e-17
* device instance cc_XD2_nm_XD4_XN3_mid2 r0 *1 0,0
Ccc_XD2_nm_XD4_XN3_mid2 XD2.nm XD4.XN3.mid2 1.21e-17
* device instance cc_XD2_nm_XD4_dmodout r0 *1 0,0
Ccc_XD2_nm_XD4_dmodout XD2.nm XD4.dmodout 1.21e-17
* device instance cc_XD2_nm_XD4_dq r0 *1 0,0
Ccc_XD2_nm_XD4_dq XD2.nm XD4.dq 1.8151e-17
* device instance cc_XD2_nm_XD4_nm r0 *1 0,0
Ccc_XD2_nm_XD4_nm XD2.nm XD4.nm 1.21e-17
* device instance cc_XD2_nm_XD4_nt r0 *1 0,0
Ccc_XD2_nm_XD4_nt XD2.nm XD4.nt 1.21e-17
* device instance cc_XD2_nm_XD4_t1 r0 *1 0,0
Ccc_XD2_nm_XD4_t1 XD2.nm XD4.t1 1.21e-17
* device instance cc_XD2_nm_XD5_XDFFM_CLKB r0 *1 0,0
Ccc_XD2_nm_XD5_XDFFM_CLKB XD2.nm XD5.XDFFM.CLKB 1.8151e-17
* device instance cc_XD2_nm_XD5_XDFFM_M r0 *1 0,0
Ccc_XD2_nm_XD5_XDFFM_M XD2.nm XD5.XDFFM.M 2.4201e-17
* device instance cc_XD2_nm_XD5_XDFFM_MB r0 *1 0,0
Ccc_XD2_nm_XD5_XDFFM_MB XD2.nm XD5.XDFFM.MB 1.21e-17
* device instance cc_XD2_nm_XD5_XDFFM_S r0 *1 0,0
Ccc_XD2_nm_XD5_XDFFM_S XD2.nm XD5.XDFFM.S 1.8151e-17
* device instance cc_XD2_nm_XD5_XDFFM_SB r0 *1 0,0
Ccc_XD2_nm_XD5_XDFFM_SB XD2.nm XD5.XDFFM.SB 1.8151e-17
* device instance cc_XD2_nm_XD5_XDFFQ_CLKB r0 *1 0,0
Ccc_XD2_nm_XD5_XDFFQ_CLKB XD2.nm XD5.XDFFQ.CLKB 1.8151e-17
* device instance cc_XD2_nm_XD5_XDFFQ_M r0 *1 0,0
Ccc_XD2_nm_XD5_XDFFQ_M XD2.nm XD5.XDFFQ.M 2.4201e-17
* device instance cc_XD2_nm_XD5_XDFFQ_MB r0 *1 0,0
Ccc_XD2_nm_XD5_XDFFQ_MB XD2.nm XD5.XDFFQ.MB 1.21e-17
* device instance cc_XD2_nm_XD5_XDFFQ_S r0 *1 0,0
Ccc_XD2_nm_XD5_XDFFQ_S XD2.nm XD5.XDFFQ.S 1.8151e-17
* device instance cc_XD2_nm_XD5_XDFFQ_SB r0 *1 0,0
Ccc_XD2_nm_XD5_XDFFQ_SB XD2.nm XD5.XDFFQ.SB 1.8151e-17
* device instance cc_XD2_nm_XD5_XN2_mid1 r0 *1 0,0
Ccc_XD2_nm_XD5_XN2_mid1 XD2.nm XD5.XN2.mid1 1.21e-17
* device instance cc_XD2_nm_XD5_XN3_mid1 r0 *1 0,0
Ccc_XD2_nm_XD5_XN3_mid1 XD2.nm XD5.XN3.mid1 1.21e-17
* device instance cc_XD2_nm_XD5_XN3_mid2 r0 *1 0,0
Ccc_XD2_nm_XD5_XN3_mid2 XD2.nm XD5.XN3.mid2 1.21e-17
* device instance cc_XD2_nm_XD5_dmodout r0 *1 0,0
Ccc_XD2_nm_XD5_dmodout XD2.nm XD5.dmodout 1.21e-17
* device instance cc_XD2_nm_XD5_dq r0 *1 0,0
Ccc_XD2_nm_XD5_dq XD2.nm XD5.dq 1.8151e-17
* device instance cc_XD2_nm_XD5_nm r0 *1 0,0
Ccc_XD2_nm_XD5_nm XD2.nm XD5.nm 1.21e-17
* device instance cc_XD2_nm_XD5_nt r0 *1 0,0
Ccc_XD2_nm_XD5_nt XD2.nm XD5.nt 1.21e-17
* device instance cc_XD2_nm_XD5_t1 r0 *1 0,0
Ccc_XD2_nm_XD5_t1 XD2.nm XD5.t1 1.21e-17
* device instance cc_XD2_nm_XFRT_CLKB r0 *1 0,0
Ccc_XD2_nm_XFRT_CLKB XD2.nm XFRT.CLKB 1.8151e-17
* device instance cc_XD2_nm_XFRT_M r0 *1 0,0
Ccc_XD2_nm_XFRT_M XD2.nm XFRT.M 2.4201e-17
* device instance cc_XD2_nm_XFRT_MB r0 *1 0,0
Ccc_XD2_nm_XFRT_MB XD2.nm XFRT.MB 1.21e-17
* device instance cc_XD2_nm_XFRT_S r0 *1 0,0
Ccc_XD2_nm_XFRT_S XD2.nm XFRT.S 1.8151e-17
* device instance cc_XD2_nm_XFRT_SB r0 *1 0,0
Ccc_XD2_nm_XFRT_SB XD2.nm XFRT.SB 1.8151e-17
* device instance cc_XD2_nm_ck1 r0 *1 0,0
Ccc_XD2_nm_ck1 XD2.nm ck1 5.4452e-17
* device instance cc_XD2_nm_ck2 r0 *1 0,0
Ccc_XD2_nm_ck2 XD2.nm ck2 5.4452e-17
* device instance cc_XD2_nm_ck3 r0 *1 0,0
Ccc_XD2_nm_ck3 XD2.nm ck3 6.0502e-17
* device instance cc_XD2_nm_ck4 r0 *1 0,0
Ccc_XD2_nm_ck4 XD2.nm ck4 5.4452e-17
* device instance cc_XD2_nm_ck5 r0 *1 0,0
Ccc_XD2_nm_ck5 XD2.nm ck5 5.4452e-17
* device instance cc_XD2_nm_mod0 r0 *1 0,0
Ccc_XD2_nm_mod0 XD2.nm mod0 2.4201e-17
* device instance cc_XD2_nm_mod1 r0 *1 0,0
Ccc_XD2_nm_mod1 XD2.nm mod1 2.4201e-17
* device instance cc_XD2_nm_mod2 r0 *1 0,0
Ccc_XD2_nm_mod2 XD2.nm mod2 2.4201e-17
* device instance cc_XD2_nm_mod3 r0 *1 0,0
Ccc_XD2_nm_mod3 XD2.nm mod3 2.4201e-17
* device instance cc_XD2_nm_mod4 r0 *1 0,0
Ccc_XD2_nm_mod4 XD2.nm mod4 2.4201e-17
* device instance cc_XD2_nm_net1 r0 *1 0,0
Ccc_XD2_nm_net1 XD2.nm net1 1.21e-17
* device instance cc_XD2_nt_XD2_t1 r0 *1 0,0
Ccc_XD2_nt_XD2_t1 XD2.nt XD2.t1 1.21e-17
* device instance cc_XD2_nt_XD3_XDFFM_CLKB r0 *1 0,0
Ccc_XD2_nt_XD3_XDFFM_CLKB XD2.nt XD3.XDFFM.CLKB 1.8151e-17
* device instance cc_XD2_nt_XD3_XDFFM_M r0 *1 0,0
Ccc_XD2_nt_XD3_XDFFM_M XD2.nt XD3.XDFFM.M 2.4201e-17
* device instance cc_XD2_nt_XD3_XDFFM_MB r0 *1 0,0
Ccc_XD2_nt_XD3_XDFFM_MB XD2.nt XD3.XDFFM.MB 1.21e-17
* device instance cc_XD2_nt_XD3_XDFFM_S r0 *1 0,0
Ccc_XD2_nt_XD3_XDFFM_S XD2.nt XD3.XDFFM.S 1.8151e-17
* device instance cc_XD2_nt_XD3_XDFFM_SB r0 *1 0,0
Ccc_XD2_nt_XD3_XDFFM_SB XD2.nt XD3.XDFFM.SB 1.8151e-17
* device instance cc_XD2_nt_XD3_XDFFQ_CLKB r0 *1 0,0
Ccc_XD2_nt_XD3_XDFFQ_CLKB XD2.nt XD3.XDFFQ.CLKB 1.8151e-17
* device instance cc_XD2_nt_XD3_XDFFQ_M r0 *1 0,0
Ccc_XD2_nt_XD3_XDFFQ_M XD2.nt XD3.XDFFQ.M 2.4201e-17
* device instance cc_XD2_nt_XD3_XDFFQ_MB r0 *1 0,0
Ccc_XD2_nt_XD3_XDFFQ_MB XD2.nt XD3.XDFFQ.MB 1.21e-17
* device instance cc_XD2_nt_XD3_XDFFQ_S r0 *1 0,0
Ccc_XD2_nt_XD3_XDFFQ_S XD2.nt XD3.XDFFQ.S 1.8151e-17
* device instance cc_XD2_nt_XD3_XDFFQ_SB r0 *1 0,0
Ccc_XD2_nt_XD3_XDFFQ_SB XD2.nt XD3.XDFFQ.SB 1.8151e-17
* device instance cc_XD2_nt_XD3_XN2_mid1 r0 *1 0,0
Ccc_XD2_nt_XD3_XN2_mid1 XD2.nt XD3.XN2.mid1 1.21e-17
* device instance cc_XD2_nt_XD3_XN3_mid1 r0 *1 0,0
Ccc_XD2_nt_XD3_XN3_mid1 XD2.nt XD3.XN3.mid1 1.21e-17
* device instance cc_XD2_nt_XD3_XN3_mid2 r0 *1 0,0
Ccc_XD2_nt_XD3_XN3_mid2 XD2.nt XD3.XN3.mid2 1.21e-17
* device instance cc_XD2_nt_XD3_dmodout r0 *1 0,0
Ccc_XD2_nt_XD3_dmodout XD2.nt XD3.dmodout 1.21e-17
* device instance cc_XD2_nt_XD3_dq r0 *1 0,0
Ccc_XD2_nt_XD3_dq XD2.nt XD3.dq 1.8151e-17
* device instance cc_XD2_nt_XD3_nm r0 *1 0,0
Ccc_XD2_nt_XD3_nm XD2.nt XD3.nm 1.21e-17
* device instance cc_XD2_nt_XD3_nt r0 *1 0,0
Ccc_XD2_nt_XD3_nt XD2.nt XD3.nt 1.21e-17
* device instance cc_XD2_nt_XD3_t1 r0 *1 0,0
Ccc_XD2_nt_XD3_t1 XD2.nt XD3.t1 1.21e-17
* device instance cc_XD2_nt_XD4_XDFFM_CLKB r0 *1 0,0
Ccc_XD2_nt_XD4_XDFFM_CLKB XD2.nt XD4.XDFFM.CLKB 1.8151e-17
* device instance cc_XD2_nt_XD4_XDFFM_M r0 *1 0,0
Ccc_XD2_nt_XD4_XDFFM_M XD2.nt XD4.XDFFM.M 2.4201e-17
* device instance cc_XD2_nt_XD4_XDFFM_MB r0 *1 0,0
Ccc_XD2_nt_XD4_XDFFM_MB XD2.nt XD4.XDFFM.MB 1.21e-17
* device instance cc_XD2_nt_XD4_XDFFM_S r0 *1 0,0
Ccc_XD2_nt_XD4_XDFFM_S XD2.nt XD4.XDFFM.S 1.8151e-17
* device instance cc_XD2_nt_XD4_XDFFM_SB r0 *1 0,0
Ccc_XD2_nt_XD4_XDFFM_SB XD2.nt XD4.XDFFM.SB 1.8151e-17
* device instance cc_XD2_nt_XD4_XDFFQ_CLKB r0 *1 0,0
Ccc_XD2_nt_XD4_XDFFQ_CLKB XD2.nt XD4.XDFFQ.CLKB 1.8151e-17
* device instance cc_XD2_nt_XD4_XDFFQ_M r0 *1 0,0
Ccc_XD2_nt_XD4_XDFFQ_M XD2.nt XD4.XDFFQ.M 2.4201e-17
* device instance cc_XD2_nt_XD4_XDFFQ_MB r0 *1 0,0
Ccc_XD2_nt_XD4_XDFFQ_MB XD2.nt XD4.XDFFQ.MB 1.21e-17
* device instance cc_XD2_nt_XD4_XDFFQ_S r0 *1 0,0
Ccc_XD2_nt_XD4_XDFFQ_S XD2.nt XD4.XDFFQ.S 1.8151e-17
* device instance cc_XD2_nt_XD4_XDFFQ_SB r0 *1 0,0
Ccc_XD2_nt_XD4_XDFFQ_SB XD2.nt XD4.XDFFQ.SB 1.8151e-17
* device instance cc_XD2_nt_XD4_XN2_mid1 r0 *1 0,0
Ccc_XD2_nt_XD4_XN2_mid1 XD2.nt XD4.XN2.mid1 1.21e-17
* device instance cc_XD2_nt_XD4_XN3_mid1 r0 *1 0,0
Ccc_XD2_nt_XD4_XN3_mid1 XD2.nt XD4.XN3.mid1 1.21e-17
* device instance cc_XD2_nt_XD4_XN3_mid2 r0 *1 0,0
Ccc_XD2_nt_XD4_XN3_mid2 XD2.nt XD4.XN3.mid2 1.21e-17
* device instance cc_XD2_nt_XD4_dmodout r0 *1 0,0
Ccc_XD2_nt_XD4_dmodout XD2.nt XD4.dmodout 1.21e-17
* device instance cc_XD2_nt_XD4_dq r0 *1 0,0
Ccc_XD2_nt_XD4_dq XD2.nt XD4.dq 1.8151e-17
* device instance cc_XD2_nt_XD4_nm r0 *1 0,0
Ccc_XD2_nt_XD4_nm XD2.nt XD4.nm 1.21e-17
* device instance cc_XD2_nt_XD4_nt r0 *1 0,0
Ccc_XD2_nt_XD4_nt XD2.nt XD4.nt 1.21e-17
* device instance cc_XD2_nt_XD4_t1 r0 *1 0,0
Ccc_XD2_nt_XD4_t1 XD2.nt XD4.t1 1.21e-17
* device instance cc_XD2_nt_XD5_XDFFM_CLKB r0 *1 0,0
Ccc_XD2_nt_XD5_XDFFM_CLKB XD2.nt XD5.XDFFM.CLKB 1.8151e-17
* device instance cc_XD2_nt_XD5_XDFFM_M r0 *1 0,0
Ccc_XD2_nt_XD5_XDFFM_M XD2.nt XD5.XDFFM.M 2.4201e-17
* device instance cc_XD2_nt_XD5_XDFFM_MB r0 *1 0,0
Ccc_XD2_nt_XD5_XDFFM_MB XD2.nt XD5.XDFFM.MB 1.21e-17
* device instance cc_XD2_nt_XD5_XDFFM_S r0 *1 0,0
Ccc_XD2_nt_XD5_XDFFM_S XD2.nt XD5.XDFFM.S 1.8151e-17
* device instance cc_XD2_nt_XD5_XDFFM_SB r0 *1 0,0
Ccc_XD2_nt_XD5_XDFFM_SB XD2.nt XD5.XDFFM.SB 1.8151e-17
* device instance cc_XD2_nt_XD5_XDFFQ_CLKB r0 *1 0,0
Ccc_XD2_nt_XD5_XDFFQ_CLKB XD2.nt XD5.XDFFQ.CLKB 1.8151e-17
* device instance cc_XD2_nt_XD5_XDFFQ_M r0 *1 0,0
Ccc_XD2_nt_XD5_XDFFQ_M XD2.nt XD5.XDFFQ.M 2.4201e-17
* device instance cc_XD2_nt_XD5_XDFFQ_MB r0 *1 0,0
Ccc_XD2_nt_XD5_XDFFQ_MB XD2.nt XD5.XDFFQ.MB 1.21e-17
* device instance cc_XD2_nt_XD5_XDFFQ_S r0 *1 0,0
Ccc_XD2_nt_XD5_XDFFQ_S XD2.nt XD5.XDFFQ.S 1.8151e-17
* device instance cc_XD2_nt_XD5_XDFFQ_SB r0 *1 0,0
Ccc_XD2_nt_XD5_XDFFQ_SB XD2.nt XD5.XDFFQ.SB 1.8151e-17
* device instance cc_XD2_nt_XD5_XN2_mid1 r0 *1 0,0
Ccc_XD2_nt_XD5_XN2_mid1 XD2.nt XD5.XN2.mid1 1.21e-17
* device instance cc_XD2_nt_XD5_XN3_mid1 r0 *1 0,0
Ccc_XD2_nt_XD5_XN3_mid1 XD2.nt XD5.XN3.mid1 1.21e-17
* device instance cc_XD2_nt_XD5_XN3_mid2 r0 *1 0,0
Ccc_XD2_nt_XD5_XN3_mid2 XD2.nt XD5.XN3.mid2 1.21e-17
* device instance cc_XD2_nt_XD5_dmodout r0 *1 0,0
Ccc_XD2_nt_XD5_dmodout XD2.nt XD5.dmodout 1.21e-17
* device instance cc_XD2_nt_XD5_dq r0 *1 0,0
Ccc_XD2_nt_XD5_dq XD2.nt XD5.dq 1.8151e-17
* device instance cc_XD2_nt_XD5_nm r0 *1 0,0
Ccc_XD2_nt_XD5_nm XD2.nt XD5.nm 1.21e-17
* device instance cc_XD2_nt_XD5_nt r0 *1 0,0
Ccc_XD2_nt_XD5_nt XD2.nt XD5.nt 1.21e-17
* device instance cc_XD2_nt_XD5_t1 r0 *1 0,0
Ccc_XD2_nt_XD5_t1 XD2.nt XD5.t1 1.21e-17
* device instance cc_XD2_nt_XFRT_CLKB r0 *1 0,0
Ccc_XD2_nt_XFRT_CLKB XD2.nt XFRT.CLKB 1.8151e-17
* device instance cc_XD2_nt_XFRT_M r0 *1 0,0
Ccc_XD2_nt_XFRT_M XD2.nt XFRT.M 2.4201e-17
* device instance cc_XD2_nt_XFRT_MB r0 *1 0,0
Ccc_XD2_nt_XFRT_MB XD2.nt XFRT.MB 1.21e-17
* device instance cc_XD2_nt_XFRT_S r0 *1 0,0
Ccc_XD2_nt_XFRT_S XD2.nt XFRT.S 1.8151e-17
* device instance cc_XD2_nt_XFRT_SB r0 *1 0,0
Ccc_XD2_nt_XFRT_SB XD2.nt XFRT.SB 1.8151e-17
* device instance cc_XD2_nt_ck1 r0 *1 0,0
Ccc_XD2_nt_ck1 XD2.nt ck1 5.4452e-17
* device instance cc_XD2_nt_ck2 r0 *1 0,0
Ccc_XD2_nt_ck2 XD2.nt ck2 5.4452e-17
* device instance cc_XD2_nt_ck3 r0 *1 0,0
Ccc_XD2_nt_ck3 XD2.nt ck3 5.4452e-17
* device instance cc_XD2_nt_ck4 r0 *1 0,0
Ccc_XD2_nt_ck4 XD2.nt ck4 5.4452e-17
* device instance cc_XD2_nt_ck5 r0 *1 0,0
Ccc_XD2_nt_ck5 XD2.nt ck5 5.4452e-17
* device instance cc_XD2_nt_mod0 r0 *1 0,0
Ccc_XD2_nt_mod0 XD2.nt mod0 2.4201e-17
* device instance cc_XD2_nt_mod1 r0 *1 0,0
Ccc_XD2_nt_mod1 XD2.nt mod1 3.0251e-17
* device instance cc_XD2_nt_mod2 r0 *1 0,0
Ccc_XD2_nt_mod2 XD2.nt mod2 2.4201e-17
* device instance cc_XD2_nt_mod3 r0 *1 0,0
Ccc_XD2_nt_mod3 XD2.nt mod3 2.4201e-17
* device instance cc_XD2_nt_mod4 r0 *1 0,0
Ccc_XD2_nt_mod4 XD2.nt mod4 2.4201e-17
* device instance cc_XD2_nt_net1 r0 *1 0,0
Ccc_XD2_nt_net1 XD2.nt net1 1.21e-17
* device instance cc_XD2_t1_XD3_XDFFM_CLKB r0 *1 0,0
Ccc_XD2_t1_XD3_XDFFM_CLKB XD2.t1 XD3.XDFFM.CLKB 1.8151e-17
* device instance cc_XD2_t1_XD3_XDFFM_M r0 *1 0,0
Ccc_XD2_t1_XD3_XDFFM_M XD2.t1 XD3.XDFFM.M 2.4201e-17
* device instance cc_XD2_t1_XD3_XDFFM_MB r0 *1 0,0
Ccc_XD2_t1_XD3_XDFFM_MB XD2.t1 XD3.XDFFM.MB 1.21e-17
* device instance cc_XD2_t1_XD3_XDFFM_S r0 *1 0,0
Ccc_XD2_t1_XD3_XDFFM_S XD2.t1 XD3.XDFFM.S 1.8151e-17
* device instance cc_XD2_t1_XD3_XDFFM_SB r0 *1 0,0
Ccc_XD2_t1_XD3_XDFFM_SB XD2.t1 XD3.XDFFM.SB 1.8151e-17
* device instance cc_XD2_t1_XD3_XDFFQ_CLKB r0 *1 0,0
Ccc_XD2_t1_XD3_XDFFQ_CLKB XD2.t1 XD3.XDFFQ.CLKB 1.8151e-17
* device instance cc_XD2_t1_XD3_XDFFQ_M r0 *1 0,0
Ccc_XD2_t1_XD3_XDFFQ_M XD2.t1 XD3.XDFFQ.M 2.4201e-17
* device instance cc_XD2_t1_XD3_XDFFQ_MB r0 *1 0,0
Ccc_XD2_t1_XD3_XDFFQ_MB XD2.t1 XD3.XDFFQ.MB 1.21e-17
* device instance cc_XD2_t1_XD3_XDFFQ_S r0 *1 0,0
Ccc_XD2_t1_XD3_XDFFQ_S XD2.t1 XD3.XDFFQ.S 1.8151e-17
* device instance cc_XD2_t1_XD3_XDFFQ_SB r0 *1 0,0
Ccc_XD2_t1_XD3_XDFFQ_SB XD2.t1 XD3.XDFFQ.SB 1.8151e-17
* device instance cc_XD2_t1_XD3_XN2_mid1 r0 *1 0,0
Ccc_XD2_t1_XD3_XN2_mid1 XD2.t1 XD3.XN2.mid1 1.21e-17
* device instance cc_XD2_t1_XD3_XN3_mid1 r0 *1 0,0
Ccc_XD2_t1_XD3_XN3_mid1 XD2.t1 XD3.XN3.mid1 1.21e-17
* device instance cc_XD2_t1_XD3_XN3_mid2 r0 *1 0,0
Ccc_XD2_t1_XD3_XN3_mid2 XD2.t1 XD3.XN3.mid2 1.21e-17
* device instance cc_XD2_t1_XD3_dmodout r0 *1 0,0
Ccc_XD2_t1_XD3_dmodout XD2.t1 XD3.dmodout 1.21e-17
* device instance cc_XD2_t1_XD3_dq r0 *1 0,0
Ccc_XD2_t1_XD3_dq XD2.t1 XD3.dq 1.8151e-17
* device instance cc_XD2_t1_XD3_nm r0 *1 0,0
Ccc_XD2_t1_XD3_nm XD2.t1 XD3.nm 1.21e-17
* device instance cc_XD2_t1_XD3_nt r0 *1 0,0
Ccc_XD2_t1_XD3_nt XD2.t1 XD3.nt 1.21e-17
* device instance cc_XD2_t1_XD3_t1 r0 *1 0,0
Ccc_XD2_t1_XD3_t1 XD2.t1 XD3.t1 1.21e-17
* device instance cc_XD2_t1_XD4_XDFFM_CLKB r0 *1 0,0
Ccc_XD2_t1_XD4_XDFFM_CLKB XD2.t1 XD4.XDFFM.CLKB 1.8151e-17
* device instance cc_XD2_t1_XD4_XDFFM_M r0 *1 0,0
Ccc_XD2_t1_XD4_XDFFM_M XD2.t1 XD4.XDFFM.M 2.4201e-17
* device instance cc_XD2_t1_XD4_XDFFM_MB r0 *1 0,0
Ccc_XD2_t1_XD4_XDFFM_MB XD2.t1 XD4.XDFFM.MB 1.21e-17
* device instance cc_XD2_t1_XD4_XDFFM_S r0 *1 0,0
Ccc_XD2_t1_XD4_XDFFM_S XD2.t1 XD4.XDFFM.S 1.8151e-17
* device instance cc_XD2_t1_XD4_XDFFM_SB r0 *1 0,0
Ccc_XD2_t1_XD4_XDFFM_SB XD2.t1 XD4.XDFFM.SB 1.8151e-17
* device instance cc_XD2_t1_XD4_XDFFQ_CLKB r0 *1 0,0
Ccc_XD2_t1_XD4_XDFFQ_CLKB XD2.t1 XD4.XDFFQ.CLKB 1.8151e-17
* device instance cc_XD2_t1_XD4_XDFFQ_M r0 *1 0,0
Ccc_XD2_t1_XD4_XDFFQ_M XD2.t1 XD4.XDFFQ.M 2.4201e-17
* device instance cc_XD2_t1_XD4_XDFFQ_MB r0 *1 0,0
Ccc_XD2_t1_XD4_XDFFQ_MB XD2.t1 XD4.XDFFQ.MB 1.21e-17
* device instance cc_XD2_t1_XD4_XDFFQ_S r0 *1 0,0
Ccc_XD2_t1_XD4_XDFFQ_S XD2.t1 XD4.XDFFQ.S 1.8151e-17
* device instance cc_XD2_t1_XD4_XDFFQ_SB r0 *1 0,0
Ccc_XD2_t1_XD4_XDFFQ_SB XD2.t1 XD4.XDFFQ.SB 1.8151e-17
* device instance cc_XD2_t1_XD4_XN2_mid1 r0 *1 0,0
Ccc_XD2_t1_XD4_XN2_mid1 XD2.t1 XD4.XN2.mid1 1.21e-17
* device instance cc_XD2_t1_XD4_XN3_mid1 r0 *1 0,0
Ccc_XD2_t1_XD4_XN3_mid1 XD2.t1 XD4.XN3.mid1 1.21e-17
* device instance cc_XD2_t1_XD4_XN3_mid2 r0 *1 0,0
Ccc_XD2_t1_XD4_XN3_mid2 XD2.t1 XD4.XN3.mid2 1.21e-17
* device instance cc_XD2_t1_XD4_dmodout r0 *1 0,0
Ccc_XD2_t1_XD4_dmodout XD2.t1 XD4.dmodout 1.21e-17
* device instance cc_XD2_t1_XD4_dq r0 *1 0,0
Ccc_XD2_t1_XD4_dq XD2.t1 XD4.dq 1.8151e-17
* device instance cc_XD2_t1_XD4_nm r0 *1 0,0
Ccc_XD2_t1_XD4_nm XD2.t1 XD4.nm 1.21e-17
* device instance cc_XD2_t1_XD4_nt r0 *1 0,0
Ccc_XD2_t1_XD4_nt XD2.t1 XD4.nt 1.21e-17
* device instance cc_XD2_t1_XD4_t1 r0 *1 0,0
Ccc_XD2_t1_XD4_t1 XD2.t1 XD4.t1 1.21e-17
* device instance cc_XD2_t1_XD5_XDFFM_CLKB r0 *1 0,0
Ccc_XD2_t1_XD5_XDFFM_CLKB XD2.t1 XD5.XDFFM.CLKB 1.8151e-17
* device instance cc_XD2_t1_XD5_XDFFM_M r0 *1 0,0
Ccc_XD2_t1_XD5_XDFFM_M XD2.t1 XD5.XDFFM.M 2.4201e-17
* device instance cc_XD2_t1_XD5_XDFFM_MB r0 *1 0,0
Ccc_XD2_t1_XD5_XDFFM_MB XD2.t1 XD5.XDFFM.MB 1.21e-17
* device instance cc_XD2_t1_XD5_XDFFM_S r0 *1 0,0
Ccc_XD2_t1_XD5_XDFFM_S XD2.t1 XD5.XDFFM.S 1.8151e-17
* device instance cc_XD2_t1_XD5_XDFFM_SB r0 *1 0,0
Ccc_XD2_t1_XD5_XDFFM_SB XD2.t1 XD5.XDFFM.SB 1.8151e-17
* device instance cc_XD2_t1_XD5_XDFFQ_CLKB r0 *1 0,0
Ccc_XD2_t1_XD5_XDFFQ_CLKB XD2.t1 XD5.XDFFQ.CLKB 1.8151e-17
* device instance cc_XD2_t1_XD5_XDFFQ_M r0 *1 0,0
Ccc_XD2_t1_XD5_XDFFQ_M XD2.t1 XD5.XDFFQ.M 2.4201e-17
* device instance cc_XD2_t1_XD5_XDFFQ_MB r0 *1 0,0
Ccc_XD2_t1_XD5_XDFFQ_MB XD2.t1 XD5.XDFFQ.MB 1.21e-17
* device instance cc_XD2_t1_XD5_XDFFQ_S r0 *1 0,0
Ccc_XD2_t1_XD5_XDFFQ_S XD2.t1 XD5.XDFFQ.S 1.8151e-17
* device instance cc_XD2_t1_XD5_XDFFQ_SB r0 *1 0,0
Ccc_XD2_t1_XD5_XDFFQ_SB XD2.t1 XD5.XDFFQ.SB 1.8151e-17
* device instance cc_XD2_t1_XD5_XN2_mid1 r0 *1 0,0
Ccc_XD2_t1_XD5_XN2_mid1 XD2.t1 XD5.XN2.mid1 1.21e-17
* device instance cc_XD2_t1_XD5_XN3_mid1 r0 *1 0,0
Ccc_XD2_t1_XD5_XN3_mid1 XD2.t1 XD5.XN3.mid1 1.21e-17
* device instance cc_XD2_t1_XD5_XN3_mid2 r0 *1 0,0
Ccc_XD2_t1_XD5_XN3_mid2 XD2.t1 XD5.XN3.mid2 1.21e-17
* device instance cc_XD2_t1_XD5_dmodout r0 *1 0,0
Ccc_XD2_t1_XD5_dmodout XD2.t1 XD5.dmodout 1.21e-17
* device instance cc_XD2_t1_XD5_dq r0 *1 0,0
Ccc_XD2_t1_XD5_dq XD2.t1 XD5.dq 1.8151e-17
* device instance cc_XD2_t1_XD5_nm r0 *1 0,0
Ccc_XD2_t1_XD5_nm XD2.t1 XD5.nm 1.21e-17
* device instance cc_XD2_t1_XD5_nt r0 *1 0,0
Ccc_XD2_t1_XD5_nt XD2.t1 XD5.nt 1.21e-17
* device instance cc_XD2_t1_XD5_t1 r0 *1 0,0
Ccc_XD2_t1_XD5_t1 XD2.t1 XD5.t1 1.21e-17
* device instance cc_XD2_t1_XFRT_CLKB r0 *1 0,0
Ccc_XD2_t1_XFRT_CLKB XD2.t1 XFRT.CLKB 1.8151e-17
* device instance cc_XD2_t1_XFRT_M r0 *1 0,0
Ccc_XD2_t1_XFRT_M XD2.t1 XFRT.M 2.4201e-17
* device instance cc_XD2_t1_XFRT_MB r0 *1 0,0
Ccc_XD2_t1_XFRT_MB XD2.t1 XFRT.MB 1.21e-17
* device instance cc_XD2_t1_XFRT_S r0 *1 0,0
Ccc_XD2_t1_XFRT_S XD2.t1 XFRT.S 1.8151e-17
* device instance cc_XD2_t1_XFRT_SB r0 *1 0,0
Ccc_XD2_t1_XFRT_SB XD2.t1 XFRT.SB 1.8151e-17
* device instance cc_XD2_t1_ck1 r0 *1 0,0
Ccc_XD2_t1_ck1 XD2.t1 ck1 5.4452e-17
* device instance cc_XD2_t1_ck2 r0 *1 0,0
Ccc_XD2_t1_ck2 XD2.t1 ck2 5.4452e-17
* device instance cc_XD2_t1_ck3 r0 *1 0,0
Ccc_XD2_t1_ck3 XD2.t1 ck3 6.0502e-17
* device instance cc_XD2_t1_ck4 r0 *1 0,0
Ccc_XD2_t1_ck4 XD2.t1 ck4 5.4452e-17
* device instance cc_XD2_t1_ck5 r0 *1 0,0
Ccc_XD2_t1_ck5 XD2.t1 ck5 5.4452e-17
* device instance cc_XD2_t1_mod0 r0 *1 0,0
Ccc_XD2_t1_mod0 XD2.t1 mod0 2.4201e-17
* device instance cc_XD2_t1_mod1 r0 *1 0,0
Ccc_XD2_t1_mod1 XD2.t1 mod1 2.4201e-17
* device instance cc_XD2_t1_mod2 r0 *1 0,0
Ccc_XD2_t1_mod2 XD2.t1 mod2 2.4201e-17
* device instance cc_XD2_t1_mod3 r0 *1 0,0
Ccc_XD2_t1_mod3 XD2.t1 mod3 2.4201e-17
* device instance cc_XD2_t1_mod4 r0 *1 0,0
Ccc_XD2_t1_mod4 XD2.t1 mod4 2.4201e-17
* device instance cc_XD2_t1_net1 r0 *1 0,0
Ccc_XD2_t1_net1 XD2.t1 net1 1.21e-17
* device instance cc_XD3_XDFFM_CLKB_XD3_XDFFM_M r0 *1 0,0
Ccc_XD3_XDFFM_CLKB_XD3_XDFFM_M XD3.XDFFM.CLKB XD3.XDFFM.M 4.2352e-17
* device instance cc_XD3_XDFFM_CLKB_XD3_XDFFM_MB r0 *1 0,0
Ccc_XD3_XDFFM_CLKB_XD3_XDFFM_MB XD3.XDFFM.CLKB XD3.XDFFM.MB 2.4201e-17
* device instance cc_XD3_XDFFM_CLKB_XD3_XDFFM_S r0 *1 0,0
Ccc_XD3_XDFFM_CLKB_XD3_XDFFM_S XD3.XDFFM.CLKB XD3.XDFFM.S 1.8151e-17
* device instance cc_XD3_XDFFM_CLKB_XD3_XDFFM_SB r0 *1 0,0
Ccc_XD3_XDFFM_CLKB_XD3_XDFFM_SB XD3.XDFFM.CLKB XD3.XDFFM.SB 1.8151e-17
* device instance cc_XD3_XDFFM_CLKB_XD3_XDFFQ_CLKB r0 *1 0,0
Ccc_XD3_XDFFM_CLKB_XD3_XDFFQ_CLKB XD3.XDFFM.CLKB XD3.XDFFQ.CLKB 1.8151e-17
* device instance cc_XD3_XDFFM_CLKB_XD3_XDFFQ_M r0 *1 0,0
Ccc_XD3_XDFFM_CLKB_XD3_XDFFQ_M XD3.XDFFM.CLKB XD3.XDFFQ.M 2.4201e-17
* device instance cc_XD3_XDFFM_CLKB_XD3_XDFFQ_MB r0 *1 0,0
Ccc_XD3_XDFFM_CLKB_XD3_XDFFQ_MB XD3.XDFFM.CLKB XD3.XDFFQ.MB 1.21e-17
* device instance cc_XD3_XDFFM_CLKB_XD3_XDFFQ_S r0 *1 0,0
Ccc_XD3_XDFFM_CLKB_XD3_XDFFQ_S XD3.XDFFM.CLKB XD3.XDFFQ.S 1.8151e-17
* device instance cc_XD3_XDFFM_CLKB_XD3_XDFFQ_SB r0 *1 0,0
Ccc_XD3_XDFFM_CLKB_XD3_XDFFQ_SB XD3.XDFFM.CLKB XD3.XDFFQ.SB 1.8151e-17
* device instance cc_XD3_XDFFM_CLKB_XD3_XNOR_midp r0 *1 0,0
Ccc_XD3_XDFFM_CLKB_XD3_XNOR_midp XD3.XDFFM.CLKB XD3.XNOR.midp 1.21e-17
* device instance cc_XD3_XDFFM_CLKB_XD3_dmodout r0 *1 0,0
Ccc_XD3_XDFFM_CLKB_XD3_dmodout XD3.XDFFM.CLKB XD3.dmodout 1.8151e-17
* device instance cc_XD3_XDFFM_CLKB_XD3_dq r0 *1 0,0
Ccc_XD3_XDFFM_CLKB_XD3_dq XD3.XDFFM.CLKB XD3.dq 1.21e-17
* device instance cc_XD3_XDFFM_CLKB_XD3_nm r0 *1 0,0
Ccc_XD3_XDFFM_CLKB_XD3_nm XD3.XDFFM.CLKB XD3.nm 1.8151e-17
* device instance cc_XD3_XDFFM_CLKB_XD3_nt r0 *1 0,0
Ccc_XD3_XDFFM_CLKB_XD3_nt XD3.XDFFM.CLKB XD3.nt 2.4201e-17
* device instance cc_XD3_XDFFM_CLKB_XD3_t1 r0 *1 0,0
Ccc_XD3_XDFFM_CLKB_XD3_t1 XD3.XDFFM.CLKB XD3.t1 1.21e-17
* device instance cc_XD3_XDFFM_CLKB_XD4_XDFFM_CLKB r0 *1 0,0
Ccc_XD3_XDFFM_CLKB_XD4_XDFFM_CLKB XD3.XDFFM.CLKB XD4.XDFFM.CLKB 1.8151e-17
* device instance cc_XD3_XDFFM_CLKB_XD4_XDFFM_M r0 *1 0,0
Ccc_XD3_XDFFM_CLKB_XD4_XDFFM_M XD3.XDFFM.CLKB XD4.XDFFM.M 2.4201e-17
* device instance cc_XD3_XDFFM_CLKB_XD4_XDFFM_MB r0 *1 0,0
Ccc_XD3_XDFFM_CLKB_XD4_XDFFM_MB XD3.XDFFM.CLKB XD4.XDFFM.MB 1.21e-17
* device instance cc_XD3_XDFFM_CLKB_XD4_XDFFM_S r0 *1 0,0
Ccc_XD3_XDFFM_CLKB_XD4_XDFFM_S XD3.XDFFM.CLKB XD4.XDFFM.S 1.8151e-17
* device instance cc_XD3_XDFFM_CLKB_XD4_XDFFM_SB r0 *1 0,0
Ccc_XD3_XDFFM_CLKB_XD4_XDFFM_SB XD3.XDFFM.CLKB XD4.XDFFM.SB 1.8151e-17
* device instance cc_XD3_XDFFM_CLKB_XD4_XDFFQ_CLKB r0 *1 0,0
Ccc_XD3_XDFFM_CLKB_XD4_XDFFQ_CLKB XD3.XDFFM.CLKB XD4.XDFFQ.CLKB 1.8151e-17
* device instance cc_XD3_XDFFM_CLKB_XD4_XDFFQ_M r0 *1 0,0
Ccc_XD3_XDFFM_CLKB_XD4_XDFFQ_M XD3.XDFFM.CLKB XD4.XDFFQ.M 2.4201e-17
* device instance cc_XD3_XDFFM_CLKB_XD4_XDFFQ_MB r0 *1 0,0
Ccc_XD3_XDFFM_CLKB_XD4_XDFFQ_MB XD3.XDFFM.CLKB XD4.XDFFQ.MB 1.21e-17
* device instance cc_XD3_XDFFM_CLKB_XD4_XDFFQ_S r0 *1 0,0
Ccc_XD3_XDFFM_CLKB_XD4_XDFFQ_S XD3.XDFFM.CLKB XD4.XDFFQ.S 1.8151e-17
* device instance cc_XD3_XDFFM_CLKB_XD4_XDFFQ_SB r0 *1 0,0
Ccc_XD3_XDFFM_CLKB_XD4_XDFFQ_SB XD3.XDFFM.CLKB XD4.XDFFQ.SB 1.8151e-17
* device instance cc_XD3_XDFFM_CLKB_XD4_XN2_mid1 r0 *1 0,0
Ccc_XD3_XDFFM_CLKB_XD4_XN2_mid1 XD3.XDFFM.CLKB XD4.XN2.mid1 1.21e-17
* device instance cc_XD3_XDFFM_CLKB_XD4_XN3_mid1 r0 *1 0,0
Ccc_XD3_XDFFM_CLKB_XD4_XN3_mid1 XD3.XDFFM.CLKB XD4.XN3.mid1 1.21e-17
* device instance cc_XD3_XDFFM_CLKB_XD4_XN3_mid2 r0 *1 0,0
Ccc_XD3_XDFFM_CLKB_XD4_XN3_mid2 XD3.XDFFM.CLKB XD4.XN3.mid2 1.21e-17
* device instance cc_XD3_XDFFM_CLKB_XD4_dmodout r0 *1 0,0
Ccc_XD3_XDFFM_CLKB_XD4_dmodout XD3.XDFFM.CLKB XD4.dmodout 1.21e-17
* device instance cc_XD3_XDFFM_CLKB_XD4_dq r0 *1 0,0
Ccc_XD3_XDFFM_CLKB_XD4_dq XD3.XDFFM.CLKB XD4.dq 1.8151e-17
* device instance cc_XD3_XDFFM_CLKB_XD4_nm r0 *1 0,0
Ccc_XD3_XDFFM_CLKB_XD4_nm XD3.XDFFM.CLKB XD4.nm 1.21e-17
* device instance cc_XD3_XDFFM_CLKB_XD4_nt r0 *1 0,0
Ccc_XD3_XDFFM_CLKB_XD4_nt XD3.XDFFM.CLKB XD4.nt 1.21e-17
* device instance cc_XD3_XDFFM_CLKB_XD4_t1 r0 *1 0,0
Ccc_XD3_XDFFM_CLKB_XD4_t1 XD3.XDFFM.CLKB XD4.t1 1.21e-17
* device instance cc_XD3_XDFFM_CLKB_XD5_XDFFM_CLKB r0 *1 0,0
Ccc_XD3_XDFFM_CLKB_XD5_XDFFM_CLKB XD3.XDFFM.CLKB XD5.XDFFM.CLKB 1.8151e-17
* device instance cc_XD3_XDFFM_CLKB_XD5_XDFFM_M r0 *1 0,0
Ccc_XD3_XDFFM_CLKB_XD5_XDFFM_M XD3.XDFFM.CLKB XD5.XDFFM.M 2.4201e-17
* device instance cc_XD3_XDFFM_CLKB_XD5_XDFFM_MB r0 *1 0,0
Ccc_XD3_XDFFM_CLKB_XD5_XDFFM_MB XD3.XDFFM.CLKB XD5.XDFFM.MB 1.21e-17
* device instance cc_XD3_XDFFM_CLKB_XD5_XDFFM_S r0 *1 0,0
Ccc_XD3_XDFFM_CLKB_XD5_XDFFM_S XD3.XDFFM.CLKB XD5.XDFFM.S 1.8151e-17
* device instance cc_XD3_XDFFM_CLKB_XD5_XDFFM_SB r0 *1 0,0
Ccc_XD3_XDFFM_CLKB_XD5_XDFFM_SB XD3.XDFFM.CLKB XD5.XDFFM.SB 1.8151e-17
* device instance cc_XD3_XDFFM_CLKB_XD5_XDFFQ_CLKB r0 *1 0,0
Ccc_XD3_XDFFM_CLKB_XD5_XDFFQ_CLKB XD3.XDFFM.CLKB XD5.XDFFQ.CLKB 1.8151e-17
* device instance cc_XD3_XDFFM_CLKB_XD5_XDFFQ_M r0 *1 0,0
Ccc_XD3_XDFFM_CLKB_XD5_XDFFQ_M XD3.XDFFM.CLKB XD5.XDFFQ.M 2.4201e-17
* device instance cc_XD3_XDFFM_CLKB_XD5_XDFFQ_MB r0 *1 0,0
Ccc_XD3_XDFFM_CLKB_XD5_XDFFQ_MB XD3.XDFFM.CLKB XD5.XDFFQ.MB 1.21e-17
* device instance cc_XD3_XDFFM_CLKB_XD5_XDFFQ_S r0 *1 0,0
Ccc_XD3_XDFFM_CLKB_XD5_XDFFQ_S XD3.XDFFM.CLKB XD5.XDFFQ.S 1.8151e-17
* device instance cc_XD3_XDFFM_CLKB_XD5_XDFFQ_SB r0 *1 0,0
Ccc_XD3_XDFFM_CLKB_XD5_XDFFQ_SB XD3.XDFFM.CLKB XD5.XDFFQ.SB 1.8151e-17
* device instance cc_XD3_XDFFM_CLKB_XD5_XN2_mid1 r0 *1 0,0
Ccc_XD3_XDFFM_CLKB_XD5_XN2_mid1 XD3.XDFFM.CLKB XD5.XN2.mid1 1.21e-17
* device instance cc_XD3_XDFFM_CLKB_XD5_XN3_mid1 r0 *1 0,0
Ccc_XD3_XDFFM_CLKB_XD5_XN3_mid1 XD3.XDFFM.CLKB XD5.XN3.mid1 1.21e-17
* device instance cc_XD3_XDFFM_CLKB_XD5_XN3_mid2 r0 *1 0,0
Ccc_XD3_XDFFM_CLKB_XD5_XN3_mid2 XD3.XDFFM.CLKB XD5.XN3.mid2 1.21e-17
* device instance cc_XD3_XDFFM_CLKB_XD5_dmodout r0 *1 0,0
Ccc_XD3_XDFFM_CLKB_XD5_dmodout XD3.XDFFM.CLKB XD5.dmodout 1.21e-17
* device instance cc_XD3_XDFFM_CLKB_XD5_dq r0 *1 0,0
Ccc_XD3_XDFFM_CLKB_XD5_dq XD3.XDFFM.CLKB XD5.dq 1.8151e-17
* device instance cc_XD3_XDFFM_CLKB_XD5_nm r0 *1 0,0
Ccc_XD3_XDFFM_CLKB_XD5_nm XD3.XDFFM.CLKB XD5.nm 1.21e-17
* device instance cc_XD3_XDFFM_CLKB_XD5_nt r0 *1 0,0
Ccc_XD3_XDFFM_CLKB_XD5_nt XD3.XDFFM.CLKB XD5.nt 1.21e-17
* device instance cc_XD3_XDFFM_CLKB_XD5_t1 r0 *1 0,0
Ccc_XD3_XDFFM_CLKB_XD5_t1 XD3.XDFFM.CLKB XD5.t1 1.21e-17
* device instance cc_XD3_XDFFM_CLKB_XFRT_CLKB r0 *1 0,0
Ccc_XD3_XDFFM_CLKB_XFRT_CLKB XD3.XDFFM.CLKB XFRT.CLKB 1.8151e-17
* device instance cc_XD3_XDFFM_CLKB_XFRT_M r0 *1 0,0
Ccc_XD3_XDFFM_CLKB_XFRT_M XD3.XDFFM.CLKB XFRT.M 2.4201e-17
* device instance cc_XD3_XDFFM_CLKB_XFRT_MB r0 *1 0,0
Ccc_XD3_XDFFM_CLKB_XFRT_MB XD3.XDFFM.CLKB XFRT.MB 1.21e-17
* device instance cc_XD3_XDFFM_CLKB_XFRT_S r0 *1 0,0
Ccc_XD3_XDFFM_CLKB_XFRT_S XD3.XDFFM.CLKB XFRT.S 1.8151e-17
* device instance cc_XD3_XDFFM_CLKB_XFRT_SB r0 *1 0,0
Ccc_XD3_XDFFM_CLKB_XFRT_SB XD3.XDFFM.CLKB XFRT.SB 1.8151e-17
* device instance cc_XD3_XDFFM_CLKB_ck1 r0 *1 0,0
Ccc_XD3_XDFFM_CLKB_ck1 XD3.XDFFM.CLKB ck1 5.4452e-17
* device instance cc_XD3_XDFFM_CLKB_ck2 r0 *1 0,0
Ccc_XD3_XDFFM_CLKB_ck2 XD3.XDFFM.CLKB ck2 5.4452e-17
* device instance cc_XD3_XDFFM_CLKB_ck3 r0 *1 0,0
Ccc_XD3_XDFFM_CLKB_ck3 XD3.XDFFM.CLKB ck3 6.0502e-17
* device instance cc_XD3_XDFFM_CLKB_ck4 r0 *1 0,0
Ccc_XD3_XDFFM_CLKB_ck4 XD3.XDFFM.CLKB ck4 5.4452e-17
* device instance cc_XD3_XDFFM_CLKB_ck5 r0 *1 0,0
Ccc_XD3_XDFFM_CLKB_ck5 XD3.XDFFM.CLKB ck5 5.4452e-17
* device instance cc_XD3_XDFFM_CLKB_mod0 r0 *1 0,0
Ccc_XD3_XDFFM_CLKB_mod0 XD3.XDFFM.CLKB mod0 2.4201e-17
* device instance cc_XD3_XDFFM_CLKB_mod1 r0 *1 0,0
Ccc_XD3_XDFFM_CLKB_mod1 XD3.XDFFM.CLKB mod1 2.4201e-17
* device instance cc_XD3_XDFFM_CLKB_mod2 r0 *1 0,0
Ccc_XD3_XDFFM_CLKB_mod2 XD3.XDFFM.CLKB mod2 2.4201e-17
* device instance cc_XD3_XDFFM_CLKB_mod3 r0 *1 0,0
Ccc_XD3_XDFFM_CLKB_mod3 XD3.XDFFM.CLKB mod3 2.4201e-17
* device instance cc_XD3_XDFFM_CLKB_mod4 r0 *1 0,0
Ccc_XD3_XDFFM_CLKB_mod4 XD3.XDFFM.CLKB mod4 2.4201e-17
* device instance cc_XD3_XDFFM_CLKB_net1 r0 *1 0,0
Ccc_XD3_XDFFM_CLKB_net1 XD3.XDFFM.CLKB net1 1.21e-17
* device instance cc_XD3_XDFFM_M_XD3_XDFFM_MB r0 *1 0,0
Ccc_XD3_XDFFM_M_XD3_XDFFM_MB XD3.XDFFM.M XD3.XDFFM.MB 3.4688e-17
* device instance cc_XD3_XDFFM_M_XD3_XDFFM_S r0 *1 0,0
Ccc_XD3_XDFFM_M_XD3_XDFFM_S XD3.XDFFM.M XD3.XDFFM.S 2.8638e-17
* device instance cc_XD3_XDFFM_M_XD3_XDFFM_SB r0 *1 0,0
Ccc_XD3_XDFFM_M_XD3_XDFFM_SB XD3.XDFFM.M XD3.XDFFM.SB 1.8151e-17
* device instance cc_XD3_XDFFM_M_XD3_XDFFQ_CLKB r0 *1 0,0
Ccc_XD3_XDFFM_M_XD3_XDFFQ_CLKB XD3.XDFFM.M XD3.XDFFQ.CLKB 1.8151e-17
* device instance cc_XD3_XDFFM_M_XD3_XDFFQ_M r0 *1 0,0
Ccc_XD3_XDFFM_M_XD3_XDFFQ_M XD3.XDFFM.M XD3.XDFFQ.M 2.4201e-17
* device instance cc_XD3_XDFFM_M_XD3_XDFFQ_MB r0 *1 0,0
Ccc_XD3_XDFFM_M_XD3_XDFFQ_MB XD3.XDFFM.M XD3.XDFFQ.MB 1.21e-17
* device instance cc_XD3_XDFFM_M_XD3_XDFFQ_S r0 *1 0,0
Ccc_XD3_XDFFM_M_XD3_XDFFQ_S XD3.XDFFM.M XD3.XDFFQ.S 1.8151e-17
* device instance cc_XD3_XDFFM_M_XD3_XDFFQ_SB r0 *1 0,0
Ccc_XD3_XDFFM_M_XD3_XDFFQ_SB XD3.XDFFM.M XD3.XDFFQ.SB 1.8151e-17
* device instance cc_XD3_XDFFM_M_XD3_XNOR_midp r0 *1 0,0
Ccc_XD3_XDFFM_M_XD3_XNOR_midp XD3.XDFFM.M XD3.XNOR.midp 1.21e-17
* device instance cc_XD3_XDFFM_M_XD3_dmodout r0 *1 0,0
Ccc_XD3_XDFFM_M_XD3_dmodout XD3.XDFFM.M XD3.dmodout 2.8638e-17
* device instance cc_XD3_XDFFM_M_XD3_dq r0 *1 0,0
Ccc_XD3_XDFFM_M_XD3_dq XD3.XDFFM.M XD3.dq 1.21e-17
* device instance cc_XD3_XDFFM_M_XD3_nm r0 *1 0,0
Ccc_XD3_XDFFM_M_XD3_nm XD3.XDFFM.M XD3.nm 1.8151e-17
* device instance cc_XD3_XDFFM_M_XD3_nt r0 *1 0,0
Ccc_XD3_XDFFM_M_XD3_nt XD3.XDFFM.M XD3.nt 2.4201e-17
* device instance cc_XD3_XDFFM_M_XD3_t1 r0 *1 0,0
Ccc_XD3_XDFFM_M_XD3_t1 XD3.XDFFM.M XD3.t1 1.21e-17
* device instance cc_XD3_XDFFM_M_XD4_XDFFM_CLKB r0 *1 0,0
Ccc_XD3_XDFFM_M_XD4_XDFFM_CLKB XD3.XDFFM.M XD4.XDFFM.CLKB 1.8151e-17
* device instance cc_XD3_XDFFM_M_XD4_XDFFM_M r0 *1 0,0
Ccc_XD3_XDFFM_M_XD4_XDFFM_M XD3.XDFFM.M XD4.XDFFM.M 2.4201e-17
* device instance cc_XD3_XDFFM_M_XD4_XDFFM_MB r0 *1 0,0
Ccc_XD3_XDFFM_M_XD4_XDFFM_MB XD3.XDFFM.M XD4.XDFFM.MB 1.21e-17
* device instance cc_XD3_XDFFM_M_XD4_XDFFM_S r0 *1 0,0
Ccc_XD3_XDFFM_M_XD4_XDFFM_S XD3.XDFFM.M XD4.XDFFM.S 1.8151e-17
* device instance cc_XD3_XDFFM_M_XD4_XDFFM_SB r0 *1 0,0
Ccc_XD3_XDFFM_M_XD4_XDFFM_SB XD3.XDFFM.M XD4.XDFFM.SB 1.8151e-17
* device instance cc_XD3_XDFFM_M_XD4_XDFFQ_CLKB r0 *1 0,0
Ccc_XD3_XDFFM_M_XD4_XDFFQ_CLKB XD3.XDFFM.M XD4.XDFFQ.CLKB 1.8151e-17
* device instance cc_XD3_XDFFM_M_XD4_XDFFQ_M r0 *1 0,0
Ccc_XD3_XDFFM_M_XD4_XDFFQ_M XD3.XDFFM.M XD4.XDFFQ.M 2.4201e-17
* device instance cc_XD3_XDFFM_M_XD4_XDFFQ_MB r0 *1 0,0
Ccc_XD3_XDFFM_M_XD4_XDFFQ_MB XD3.XDFFM.M XD4.XDFFQ.MB 1.21e-17
* device instance cc_XD3_XDFFM_M_XD4_XDFFQ_S r0 *1 0,0
Ccc_XD3_XDFFM_M_XD4_XDFFQ_S XD3.XDFFM.M XD4.XDFFQ.S 1.8151e-17
* device instance cc_XD3_XDFFM_M_XD4_XDFFQ_SB r0 *1 0,0
Ccc_XD3_XDFFM_M_XD4_XDFFQ_SB XD3.XDFFM.M XD4.XDFFQ.SB 1.8151e-17
* device instance cc_XD3_XDFFM_M_XD4_XN2_mid1 r0 *1 0,0
Ccc_XD3_XDFFM_M_XD4_XN2_mid1 XD3.XDFFM.M XD4.XN2.mid1 1.21e-17
* device instance cc_XD3_XDFFM_M_XD4_XN3_mid1 r0 *1 0,0
Ccc_XD3_XDFFM_M_XD4_XN3_mid1 XD3.XDFFM.M XD4.XN3.mid1 1.21e-17
* device instance cc_XD3_XDFFM_M_XD4_XN3_mid2 r0 *1 0,0
Ccc_XD3_XDFFM_M_XD4_XN3_mid2 XD3.XDFFM.M XD4.XN3.mid2 1.21e-17
* device instance cc_XD3_XDFFM_M_XD4_dmodout r0 *1 0,0
Ccc_XD3_XDFFM_M_XD4_dmodout XD3.XDFFM.M XD4.dmodout 1.21e-17
* device instance cc_XD3_XDFFM_M_XD4_dq r0 *1 0,0
Ccc_XD3_XDFFM_M_XD4_dq XD3.XDFFM.M XD4.dq 1.8151e-17
* device instance cc_XD3_XDFFM_M_XD4_nm r0 *1 0,0
Ccc_XD3_XDFFM_M_XD4_nm XD3.XDFFM.M XD4.nm 1.21e-17
* device instance cc_XD3_XDFFM_M_XD4_nt r0 *1 0,0
Ccc_XD3_XDFFM_M_XD4_nt XD3.XDFFM.M XD4.nt 1.21e-17
* device instance cc_XD3_XDFFM_M_XD4_t1 r0 *1 0,0
Ccc_XD3_XDFFM_M_XD4_t1 XD3.XDFFM.M XD4.t1 1.21e-17
* device instance cc_XD3_XDFFM_M_XD5_XDFFM_CLKB r0 *1 0,0
Ccc_XD3_XDFFM_M_XD5_XDFFM_CLKB XD3.XDFFM.M XD5.XDFFM.CLKB 1.8151e-17
* device instance cc_XD3_XDFFM_M_XD5_XDFFM_M r0 *1 0,0
Ccc_XD3_XDFFM_M_XD5_XDFFM_M XD3.XDFFM.M XD5.XDFFM.M 2.4201e-17
* device instance cc_XD3_XDFFM_M_XD5_XDFFM_MB r0 *1 0,0
Ccc_XD3_XDFFM_M_XD5_XDFFM_MB XD3.XDFFM.M XD5.XDFFM.MB 1.21e-17
* device instance cc_XD3_XDFFM_M_XD5_XDFFM_S r0 *1 0,0
Ccc_XD3_XDFFM_M_XD5_XDFFM_S XD3.XDFFM.M XD5.XDFFM.S 1.8151e-17
* device instance cc_XD3_XDFFM_M_XD5_XDFFM_SB r0 *1 0,0
Ccc_XD3_XDFFM_M_XD5_XDFFM_SB XD3.XDFFM.M XD5.XDFFM.SB 1.8151e-17
* device instance cc_XD3_XDFFM_M_XD5_XDFFQ_CLKB r0 *1 0,0
Ccc_XD3_XDFFM_M_XD5_XDFFQ_CLKB XD3.XDFFM.M XD5.XDFFQ.CLKB 1.8151e-17
* device instance cc_XD3_XDFFM_M_XD5_XDFFQ_M r0 *1 0,0
Ccc_XD3_XDFFM_M_XD5_XDFFQ_M XD3.XDFFM.M XD5.XDFFQ.M 2.4201e-17
* device instance cc_XD3_XDFFM_M_XD5_XDFFQ_MB r0 *1 0,0
Ccc_XD3_XDFFM_M_XD5_XDFFQ_MB XD3.XDFFM.M XD5.XDFFQ.MB 1.21e-17
* device instance cc_XD3_XDFFM_M_XD5_XDFFQ_S r0 *1 0,0
Ccc_XD3_XDFFM_M_XD5_XDFFQ_S XD3.XDFFM.M XD5.XDFFQ.S 1.8151e-17
* device instance cc_XD3_XDFFM_M_XD5_XDFFQ_SB r0 *1 0,0
Ccc_XD3_XDFFM_M_XD5_XDFFQ_SB XD3.XDFFM.M XD5.XDFFQ.SB 1.8151e-17
* device instance cc_XD3_XDFFM_M_XD5_XN2_mid1 r0 *1 0,0
Ccc_XD3_XDFFM_M_XD5_XN2_mid1 XD3.XDFFM.M XD5.XN2.mid1 1.21e-17
* device instance cc_XD3_XDFFM_M_XD5_XN3_mid1 r0 *1 0,0
Ccc_XD3_XDFFM_M_XD5_XN3_mid1 XD3.XDFFM.M XD5.XN3.mid1 1.21e-17
* device instance cc_XD3_XDFFM_M_XD5_XN3_mid2 r0 *1 0,0
Ccc_XD3_XDFFM_M_XD5_XN3_mid2 XD3.XDFFM.M XD5.XN3.mid2 1.21e-17
* device instance cc_XD3_XDFFM_M_XD5_dmodout r0 *1 0,0
Ccc_XD3_XDFFM_M_XD5_dmodout XD3.XDFFM.M XD5.dmodout 1.21e-17
* device instance cc_XD3_XDFFM_M_XD5_dq r0 *1 0,0
Ccc_XD3_XDFFM_M_XD5_dq XD3.XDFFM.M XD5.dq 1.8151e-17
* device instance cc_XD3_XDFFM_M_XD5_nm r0 *1 0,0
Ccc_XD3_XDFFM_M_XD5_nm XD3.XDFFM.M XD5.nm 1.21e-17
* device instance cc_XD3_XDFFM_M_XD5_nt r0 *1 0,0
Ccc_XD3_XDFFM_M_XD5_nt XD3.XDFFM.M XD5.nt 1.21e-17
* device instance cc_XD3_XDFFM_M_XD5_t1 r0 *1 0,0
Ccc_XD3_XDFFM_M_XD5_t1 XD3.XDFFM.M XD5.t1 1.21e-17
* device instance cc_XD3_XDFFM_M_XFRT_CLKB r0 *1 0,0
Ccc_XD3_XDFFM_M_XFRT_CLKB XD3.XDFFM.M XFRT.CLKB 1.8151e-17
* device instance cc_XD3_XDFFM_M_XFRT_M r0 *1 0,0
Ccc_XD3_XDFFM_M_XFRT_M XD3.XDFFM.M XFRT.M 2.4201e-17
* device instance cc_XD3_XDFFM_M_XFRT_MB r0 *1 0,0
Ccc_XD3_XDFFM_M_XFRT_MB XD3.XDFFM.M XFRT.MB 1.21e-17
* device instance cc_XD3_XDFFM_M_XFRT_S r0 *1 0,0
Ccc_XD3_XDFFM_M_XFRT_S XD3.XDFFM.M XFRT.S 1.8151e-17
* device instance cc_XD3_XDFFM_M_XFRT_SB r0 *1 0,0
Ccc_XD3_XDFFM_M_XFRT_SB XD3.XDFFM.M XFRT.SB 1.8151e-17
* device instance cc_XD3_XDFFM_M_ck1 r0 *1 0,0
Ccc_XD3_XDFFM_M_ck1 XD3.XDFFM.M ck1 5.4452e-17
* device instance cc_XD3_XDFFM_M_ck2 r0 *1 0,0
Ccc_XD3_XDFFM_M_ck2 XD3.XDFFM.M ck2 5.4452e-17
* device instance cc_XD3_XDFFM_M_ck3 r0 *1 0,0
Ccc_XD3_XDFFM_M_ck3 XD3.XDFFM.M ck3 6.0502e-17
* device instance cc_XD3_XDFFM_M_ck4 r0 *1 0,0
Ccc_XD3_XDFFM_M_ck4 XD3.XDFFM.M ck4 5.4452e-17
* device instance cc_XD3_XDFFM_M_ck5 r0 *1 0,0
Ccc_XD3_XDFFM_M_ck5 XD3.XDFFM.M ck5 5.4452e-17
* device instance cc_XD3_XDFFM_M_mod0 r0 *1 0,0
Ccc_XD3_XDFFM_M_mod0 XD3.XDFFM.M mod0 2.4201e-17
* device instance cc_XD3_XDFFM_M_mod1 r0 *1 0,0
Ccc_XD3_XDFFM_M_mod1 XD3.XDFFM.M mod1 2.4201e-17
* device instance cc_XD3_XDFFM_M_mod2 r0 *1 0,0
Ccc_XD3_XDFFM_M_mod2 XD3.XDFFM.M mod2 2.4201e-17
* device instance cc_XD3_XDFFM_M_mod3 r0 *1 0,0
Ccc_XD3_XDFFM_M_mod3 XD3.XDFFM.M mod3 2.4201e-17
* device instance cc_XD3_XDFFM_M_mod4 r0 *1 0,0
Ccc_XD3_XDFFM_M_mod4 XD3.XDFFM.M mod4 2.4201e-17
* device instance cc_XD3_XDFFM_M_net1 r0 *1 0,0
Ccc_XD3_XDFFM_M_net1 XD3.XDFFM.M net1 1.21e-17
* device instance cc_XD3_XDFFM_MB_XD3_XDFFM_S r0 *1 0,0
Ccc_XD3_XDFFM_MB_XD3_XDFFM_S XD3.XDFFM.MB XD3.XDFFM.S 1.8151e-17
* device instance cc_XD3_XDFFM_MB_XD3_XDFFM_SB r0 *1 0,0
Ccc_XD3_XDFFM_MB_XD3_XDFFM_SB XD3.XDFFM.MB XD3.XDFFM.SB 1.8151e-17
* device instance cc_XD3_XDFFM_MB_XD3_XDFFQ_CLKB r0 *1 0,0
Ccc_XD3_XDFFM_MB_XD3_XDFFQ_CLKB XD3.XDFFM.MB XD3.XDFFQ.CLKB 1.8151e-17
* device instance cc_XD3_XDFFM_MB_XD3_XDFFQ_M r0 *1 0,0
Ccc_XD3_XDFFM_MB_XD3_XDFFQ_M XD3.XDFFM.MB XD3.XDFFQ.M 2.4201e-17
* device instance cc_XD3_XDFFM_MB_XD3_XDFFQ_MB r0 *1 0,0
Ccc_XD3_XDFFM_MB_XD3_XDFFQ_MB XD3.XDFFM.MB XD3.XDFFQ.MB 1.21e-17
* device instance cc_XD3_XDFFM_MB_XD3_XDFFQ_S r0 *1 0,0
Ccc_XD3_XDFFM_MB_XD3_XDFFQ_S XD3.XDFFM.MB XD3.XDFFQ.S 1.8151e-17
* device instance cc_XD3_XDFFM_MB_XD3_XDFFQ_SB r0 *1 0,0
Ccc_XD3_XDFFM_MB_XD3_XDFFQ_SB XD3.XDFFM.MB XD3.XDFFQ.SB 1.8151e-17
* device instance cc_XD3_XDFFM_MB_XD3_XNOR_midp r0 *1 0,0
Ccc_XD3_XDFFM_MB_XD3_XNOR_midp XD3.XDFFM.MB XD3.XNOR.midp 1.21e-17
* device instance cc_XD3_XDFFM_MB_XD3_dmodout r0 *1 0,0
Ccc_XD3_XDFFM_MB_XD3_dmodout XD3.XDFFM.MB XD3.dmodout 1.21e-17
* device instance cc_XD3_XDFFM_MB_XD3_dq r0 *1 0,0
Ccc_XD3_XDFFM_MB_XD3_dq XD3.XDFFM.MB XD3.dq 1.21e-17
* device instance cc_XD3_XDFFM_MB_XD3_nm r0 *1 0,0
Ccc_XD3_XDFFM_MB_XD3_nm XD3.XDFFM.MB XD3.nm 1.8151e-17
* device instance cc_XD3_XDFFM_MB_XD3_nt r0 *1 0,0
Ccc_XD3_XDFFM_MB_XD3_nt XD3.XDFFM.MB XD3.nt 2.4201e-17
* device instance cc_XD3_XDFFM_MB_XD3_t1 r0 *1 0,0
Ccc_XD3_XDFFM_MB_XD3_t1 XD3.XDFFM.MB XD3.t1 1.21e-17
* device instance cc_XD3_XDFFM_MB_XD4_XDFFM_CLKB r0 *1 0,0
Ccc_XD3_XDFFM_MB_XD4_XDFFM_CLKB XD3.XDFFM.MB XD4.XDFFM.CLKB 1.8151e-17
* device instance cc_XD3_XDFFM_MB_XD4_XDFFM_M r0 *1 0,0
Ccc_XD3_XDFFM_MB_XD4_XDFFM_M XD3.XDFFM.MB XD4.XDFFM.M 2.4201e-17
* device instance cc_XD3_XDFFM_MB_XD4_XDFFM_MB r0 *1 0,0
Ccc_XD3_XDFFM_MB_XD4_XDFFM_MB XD3.XDFFM.MB XD4.XDFFM.MB 1.21e-17
* device instance cc_XD3_XDFFM_MB_XD4_XDFFM_S r0 *1 0,0
Ccc_XD3_XDFFM_MB_XD4_XDFFM_S XD3.XDFFM.MB XD4.XDFFM.S 1.8151e-17
* device instance cc_XD3_XDFFM_MB_XD4_XDFFM_SB r0 *1 0,0
Ccc_XD3_XDFFM_MB_XD4_XDFFM_SB XD3.XDFFM.MB XD4.XDFFM.SB 1.8151e-17
* device instance cc_XD3_XDFFM_MB_XD4_XDFFQ_CLKB r0 *1 0,0
Ccc_XD3_XDFFM_MB_XD4_XDFFQ_CLKB XD3.XDFFM.MB XD4.XDFFQ.CLKB 1.8151e-17
* device instance cc_XD3_XDFFM_MB_XD4_XDFFQ_M r0 *1 0,0
Ccc_XD3_XDFFM_MB_XD4_XDFFQ_M XD3.XDFFM.MB XD4.XDFFQ.M 2.4201e-17
* device instance cc_XD3_XDFFM_MB_XD4_XDFFQ_MB r0 *1 0,0
Ccc_XD3_XDFFM_MB_XD4_XDFFQ_MB XD3.XDFFM.MB XD4.XDFFQ.MB 1.21e-17
* device instance cc_XD3_XDFFM_MB_XD4_XDFFQ_S r0 *1 0,0
Ccc_XD3_XDFFM_MB_XD4_XDFFQ_S XD3.XDFFM.MB XD4.XDFFQ.S 1.8151e-17
* device instance cc_XD3_XDFFM_MB_XD4_XDFFQ_SB r0 *1 0,0
Ccc_XD3_XDFFM_MB_XD4_XDFFQ_SB XD3.XDFFM.MB XD4.XDFFQ.SB 1.8151e-17
* device instance cc_XD3_XDFFM_MB_XD4_XN2_mid1 r0 *1 0,0
Ccc_XD3_XDFFM_MB_XD4_XN2_mid1 XD3.XDFFM.MB XD4.XN2.mid1 1.21e-17
* device instance cc_XD3_XDFFM_MB_XD4_XN3_mid1 r0 *1 0,0
Ccc_XD3_XDFFM_MB_XD4_XN3_mid1 XD3.XDFFM.MB XD4.XN3.mid1 1.21e-17
* device instance cc_XD3_XDFFM_MB_XD4_XN3_mid2 r0 *1 0,0
Ccc_XD3_XDFFM_MB_XD4_XN3_mid2 XD3.XDFFM.MB XD4.XN3.mid2 1.21e-17
* device instance cc_XD3_XDFFM_MB_XD4_dmodout r0 *1 0,0
Ccc_XD3_XDFFM_MB_XD4_dmodout XD3.XDFFM.MB XD4.dmodout 1.21e-17
* device instance cc_XD3_XDFFM_MB_XD4_dq r0 *1 0,0
Ccc_XD3_XDFFM_MB_XD4_dq XD3.XDFFM.MB XD4.dq 1.8151e-17
* device instance cc_XD3_XDFFM_MB_XD4_nm r0 *1 0,0
Ccc_XD3_XDFFM_MB_XD4_nm XD3.XDFFM.MB XD4.nm 1.21e-17
* device instance cc_XD3_XDFFM_MB_XD4_nt r0 *1 0,0
Ccc_XD3_XDFFM_MB_XD4_nt XD3.XDFFM.MB XD4.nt 1.21e-17
* device instance cc_XD3_XDFFM_MB_XD4_t1 r0 *1 0,0
Ccc_XD3_XDFFM_MB_XD4_t1 XD3.XDFFM.MB XD4.t1 1.21e-17
* device instance cc_XD3_XDFFM_MB_XD5_XDFFM_CLKB r0 *1 0,0
Ccc_XD3_XDFFM_MB_XD5_XDFFM_CLKB XD3.XDFFM.MB XD5.XDFFM.CLKB 1.8151e-17
* device instance cc_XD3_XDFFM_MB_XD5_XDFFM_M r0 *1 0,0
Ccc_XD3_XDFFM_MB_XD5_XDFFM_M XD3.XDFFM.MB XD5.XDFFM.M 2.4201e-17
* device instance cc_XD3_XDFFM_MB_XD5_XDFFM_MB r0 *1 0,0
Ccc_XD3_XDFFM_MB_XD5_XDFFM_MB XD3.XDFFM.MB XD5.XDFFM.MB 1.21e-17
* device instance cc_XD3_XDFFM_MB_XD5_XDFFM_S r0 *1 0,0
Ccc_XD3_XDFFM_MB_XD5_XDFFM_S XD3.XDFFM.MB XD5.XDFFM.S 1.8151e-17
* device instance cc_XD3_XDFFM_MB_XD5_XDFFM_SB r0 *1 0,0
Ccc_XD3_XDFFM_MB_XD5_XDFFM_SB XD3.XDFFM.MB XD5.XDFFM.SB 1.8151e-17
* device instance cc_XD3_XDFFM_MB_XD5_XDFFQ_CLKB r0 *1 0,0
Ccc_XD3_XDFFM_MB_XD5_XDFFQ_CLKB XD3.XDFFM.MB XD5.XDFFQ.CLKB 1.8151e-17
* device instance cc_XD3_XDFFM_MB_XD5_XDFFQ_M r0 *1 0,0
Ccc_XD3_XDFFM_MB_XD5_XDFFQ_M XD3.XDFFM.MB XD5.XDFFQ.M 2.4201e-17
* device instance cc_XD3_XDFFM_MB_XD5_XDFFQ_MB r0 *1 0,0
Ccc_XD3_XDFFM_MB_XD5_XDFFQ_MB XD3.XDFFM.MB XD5.XDFFQ.MB 1.21e-17
* device instance cc_XD3_XDFFM_MB_XD5_XDFFQ_S r0 *1 0,0
Ccc_XD3_XDFFM_MB_XD5_XDFFQ_S XD3.XDFFM.MB XD5.XDFFQ.S 1.8151e-17
* device instance cc_XD3_XDFFM_MB_XD5_XDFFQ_SB r0 *1 0,0
Ccc_XD3_XDFFM_MB_XD5_XDFFQ_SB XD3.XDFFM.MB XD5.XDFFQ.SB 1.8151e-17
* device instance cc_XD3_XDFFM_MB_XD5_XN2_mid1 r0 *1 0,0
Ccc_XD3_XDFFM_MB_XD5_XN2_mid1 XD3.XDFFM.MB XD5.XN2.mid1 1.21e-17
* device instance cc_XD3_XDFFM_MB_XD5_XN3_mid1 r0 *1 0,0
Ccc_XD3_XDFFM_MB_XD5_XN3_mid1 XD3.XDFFM.MB XD5.XN3.mid1 1.21e-17
* device instance cc_XD3_XDFFM_MB_XD5_XN3_mid2 r0 *1 0,0
Ccc_XD3_XDFFM_MB_XD5_XN3_mid2 XD3.XDFFM.MB XD5.XN3.mid2 1.21e-17
* device instance cc_XD3_XDFFM_MB_XD5_dmodout r0 *1 0,0
Ccc_XD3_XDFFM_MB_XD5_dmodout XD3.XDFFM.MB XD5.dmodout 1.21e-17
* device instance cc_XD3_XDFFM_MB_XD5_dq r0 *1 0,0
Ccc_XD3_XDFFM_MB_XD5_dq XD3.XDFFM.MB XD5.dq 1.8151e-17
* device instance cc_XD3_XDFFM_MB_XD5_nm r0 *1 0,0
Ccc_XD3_XDFFM_MB_XD5_nm XD3.XDFFM.MB XD5.nm 1.21e-17
* device instance cc_XD3_XDFFM_MB_XD5_nt r0 *1 0,0
Ccc_XD3_XDFFM_MB_XD5_nt XD3.XDFFM.MB XD5.nt 1.21e-17
* device instance cc_XD3_XDFFM_MB_XD5_t1 r0 *1 0,0
Ccc_XD3_XDFFM_MB_XD5_t1 XD3.XDFFM.MB XD5.t1 1.21e-17
* device instance cc_XD3_XDFFM_MB_XFRT_CLKB r0 *1 0,0
Ccc_XD3_XDFFM_MB_XFRT_CLKB XD3.XDFFM.MB XFRT.CLKB 1.8151e-17
* device instance cc_XD3_XDFFM_MB_XFRT_M r0 *1 0,0
Ccc_XD3_XDFFM_MB_XFRT_M XD3.XDFFM.MB XFRT.M 2.4201e-17
* device instance cc_XD3_XDFFM_MB_XFRT_MB r0 *1 0,0
Ccc_XD3_XDFFM_MB_XFRT_MB XD3.XDFFM.MB XFRT.MB 1.21e-17
* device instance cc_XD3_XDFFM_MB_XFRT_S r0 *1 0,0
Ccc_XD3_XDFFM_MB_XFRT_S XD3.XDFFM.MB XFRT.S 1.8151e-17
* device instance cc_XD3_XDFFM_MB_XFRT_SB r0 *1 0,0
Ccc_XD3_XDFFM_MB_XFRT_SB XD3.XDFFM.MB XFRT.SB 1.8151e-17
* device instance cc_XD3_XDFFM_MB_ck1 r0 *1 0,0
Ccc_XD3_XDFFM_MB_ck1 XD3.XDFFM.MB ck1 5.4452e-17
* device instance cc_XD3_XDFFM_MB_ck2 r0 *1 0,0
Ccc_XD3_XDFFM_MB_ck2 XD3.XDFFM.MB ck2 5.4452e-17
* device instance cc_XD3_XDFFM_MB_ck3 r0 *1 0,0
Ccc_XD3_XDFFM_MB_ck3 XD3.XDFFM.MB ck3 6.0502e-17
* device instance cc_XD3_XDFFM_MB_ck4 r0 *1 0,0
Ccc_XD3_XDFFM_MB_ck4 XD3.XDFFM.MB ck4 5.4452e-17
* device instance cc_XD3_XDFFM_MB_ck5 r0 *1 0,0
Ccc_XD3_XDFFM_MB_ck5 XD3.XDFFM.MB ck5 5.4452e-17
* device instance cc_XD3_XDFFM_MB_mod0 r0 *1 0,0
Ccc_XD3_XDFFM_MB_mod0 XD3.XDFFM.MB mod0 2.4201e-17
* device instance cc_XD3_XDFFM_MB_mod1 r0 *1 0,0
Ccc_XD3_XDFFM_MB_mod1 XD3.XDFFM.MB mod1 2.4201e-17
* device instance cc_XD3_XDFFM_MB_mod2 r0 *1 0,0
Ccc_XD3_XDFFM_MB_mod2 XD3.XDFFM.MB mod2 2.4201e-17
* device instance cc_XD3_XDFFM_MB_mod3 r0 *1 0,0
Ccc_XD3_XDFFM_MB_mod3 XD3.XDFFM.MB mod3 2.4201e-17
* device instance cc_XD3_XDFFM_MB_mod4 r0 *1 0,0
Ccc_XD3_XDFFM_MB_mod4 XD3.XDFFM.MB mod4 2.4201e-17
* device instance cc_XD3_XDFFM_MB_net1 r0 *1 0,0
Ccc_XD3_XDFFM_MB_net1 XD3.XDFFM.MB net1 1.21e-17
* device instance cc_XD3_XDFFM_S_XD3_XDFFM_SB r0 *1 0,0
Ccc_XD3_XDFFM_S_XD3_XDFFM_SB XD3.XDFFM.S XD3.XDFFM.SB 4.0738e-17
* device instance cc_XD3_XDFFM_S_XD3_XDFFQ_CLKB r0 *1 0,0
Ccc_XD3_XDFFM_S_XD3_XDFFQ_CLKB XD3.XDFFM.S XD3.XDFFQ.CLKB 1.8151e-17
* device instance cc_XD3_XDFFM_S_XD3_XDFFQ_M r0 *1 0,0
Ccc_XD3_XDFFM_S_XD3_XDFFQ_M XD3.XDFFM.S XD3.XDFFQ.M 2.4201e-17
* device instance cc_XD3_XDFFM_S_XD3_XDFFQ_MB r0 *1 0,0
Ccc_XD3_XDFFM_S_XD3_XDFFQ_MB XD3.XDFFM.S XD3.XDFFQ.MB 1.21e-17
* device instance cc_XD3_XDFFM_S_XD3_XDFFQ_S r0 *1 0,0
Ccc_XD3_XDFFM_S_XD3_XDFFQ_S XD3.XDFFM.S XD3.XDFFQ.S 1.8151e-17
* device instance cc_XD3_XDFFM_S_XD3_XDFFQ_SB r0 *1 0,0
Ccc_XD3_XDFFM_S_XD3_XDFFQ_SB XD3.XDFFM.S XD3.XDFFQ.SB 1.8151e-17
* device instance cc_XD3_XDFFM_S_XD3_XNOR_midp r0 *1 0,0
Ccc_XD3_XDFFM_S_XD3_XNOR_midp XD3.XDFFM.S XD3.XNOR.midp 1.21e-17
* device instance cc_XD3_XDFFM_S_XD3_dmodout r0 *1 0,0
Ccc_XD3_XDFFM_S_XD3_dmodout XD3.XDFFM.S XD3.dmodout 1.21e-17
* device instance cc_XD3_XDFFM_S_XD3_dq r0 *1 0,0
Ccc_XD3_XDFFM_S_XD3_dq XD3.XDFFM.S XD3.dq 1.21e-17
* device instance cc_XD3_XDFFM_S_XD3_nm r0 *1 0,0
Ccc_XD3_XDFFM_S_XD3_nm XD3.XDFFM.S XD3.nm 1.8151e-17
* device instance cc_XD3_XDFFM_S_XD3_nt r0 *1 0,0
Ccc_XD3_XDFFM_S_XD3_nt XD3.XDFFM.S XD3.nt 2.4201e-17
* device instance cc_XD3_XDFFM_S_XD3_t1 r0 *1 0,0
Ccc_XD3_XDFFM_S_XD3_t1 XD3.XDFFM.S XD3.t1 1.21e-17
* device instance cc_XD3_XDFFM_S_XD4_XDFFM_CLKB r0 *1 0,0
Ccc_XD3_XDFFM_S_XD4_XDFFM_CLKB XD3.XDFFM.S XD4.XDFFM.CLKB 1.8151e-17
* device instance cc_XD3_XDFFM_S_XD4_XDFFM_M r0 *1 0,0
Ccc_XD3_XDFFM_S_XD4_XDFFM_M XD3.XDFFM.S XD4.XDFFM.M 2.4201e-17
* device instance cc_XD3_XDFFM_S_XD4_XDFFM_MB r0 *1 0,0
Ccc_XD3_XDFFM_S_XD4_XDFFM_MB XD3.XDFFM.S XD4.XDFFM.MB 1.21e-17
* device instance cc_XD3_XDFFM_S_XD4_XDFFM_S r0 *1 0,0
Ccc_XD3_XDFFM_S_XD4_XDFFM_S XD3.XDFFM.S XD4.XDFFM.S 1.8151e-17
* device instance cc_XD3_XDFFM_S_XD4_XDFFM_SB r0 *1 0,0
Ccc_XD3_XDFFM_S_XD4_XDFFM_SB XD3.XDFFM.S XD4.XDFFM.SB 1.8151e-17
* device instance cc_XD3_XDFFM_S_XD4_XDFFQ_CLKB r0 *1 0,0
Ccc_XD3_XDFFM_S_XD4_XDFFQ_CLKB XD3.XDFFM.S XD4.XDFFQ.CLKB 1.8151e-17
* device instance cc_XD3_XDFFM_S_XD4_XDFFQ_M r0 *1 0,0
Ccc_XD3_XDFFM_S_XD4_XDFFQ_M XD3.XDFFM.S XD4.XDFFQ.M 2.4201e-17
* device instance cc_XD3_XDFFM_S_XD4_XDFFQ_MB r0 *1 0,0
Ccc_XD3_XDFFM_S_XD4_XDFFQ_MB XD3.XDFFM.S XD4.XDFFQ.MB 1.21e-17
* device instance cc_XD3_XDFFM_S_XD4_XDFFQ_S r0 *1 0,0
Ccc_XD3_XDFFM_S_XD4_XDFFQ_S XD3.XDFFM.S XD4.XDFFQ.S 1.8151e-17
* device instance cc_XD3_XDFFM_S_XD4_XDFFQ_SB r0 *1 0,0
Ccc_XD3_XDFFM_S_XD4_XDFFQ_SB XD3.XDFFM.S XD4.XDFFQ.SB 1.8151e-17
* device instance cc_XD3_XDFFM_S_XD4_XN2_mid1 r0 *1 0,0
Ccc_XD3_XDFFM_S_XD4_XN2_mid1 XD3.XDFFM.S XD4.XN2.mid1 1.21e-17
* device instance cc_XD3_XDFFM_S_XD4_XN3_mid1 r0 *1 0,0
Ccc_XD3_XDFFM_S_XD4_XN3_mid1 XD3.XDFFM.S XD4.XN3.mid1 1.21e-17
* device instance cc_XD3_XDFFM_S_XD4_XN3_mid2 r0 *1 0,0
Ccc_XD3_XDFFM_S_XD4_XN3_mid2 XD3.XDFFM.S XD4.XN3.mid2 1.21e-17
* device instance cc_XD3_XDFFM_S_XD4_dmodout r0 *1 0,0
Ccc_XD3_XDFFM_S_XD4_dmodout XD3.XDFFM.S XD4.dmodout 1.21e-17
* device instance cc_XD3_XDFFM_S_XD4_dq r0 *1 0,0
Ccc_XD3_XDFFM_S_XD4_dq XD3.XDFFM.S XD4.dq 1.8151e-17
* device instance cc_XD3_XDFFM_S_XD4_nm r0 *1 0,0
Ccc_XD3_XDFFM_S_XD4_nm XD3.XDFFM.S XD4.nm 1.21e-17
* device instance cc_XD3_XDFFM_S_XD4_nt r0 *1 0,0
Ccc_XD3_XDFFM_S_XD4_nt XD3.XDFFM.S XD4.nt 1.21e-17
* device instance cc_XD3_XDFFM_S_XD4_t1 r0 *1 0,0
Ccc_XD3_XDFFM_S_XD4_t1 XD3.XDFFM.S XD4.t1 1.21e-17
* device instance cc_XD3_XDFFM_S_XD5_XDFFM_CLKB r0 *1 0,0
Ccc_XD3_XDFFM_S_XD5_XDFFM_CLKB XD3.XDFFM.S XD5.XDFFM.CLKB 1.8151e-17
* device instance cc_XD3_XDFFM_S_XD5_XDFFM_M r0 *1 0,0
Ccc_XD3_XDFFM_S_XD5_XDFFM_M XD3.XDFFM.S XD5.XDFFM.M 2.4201e-17
* device instance cc_XD3_XDFFM_S_XD5_XDFFM_MB r0 *1 0,0
Ccc_XD3_XDFFM_S_XD5_XDFFM_MB XD3.XDFFM.S XD5.XDFFM.MB 1.21e-17
* device instance cc_XD3_XDFFM_S_XD5_XDFFM_S r0 *1 0,0
Ccc_XD3_XDFFM_S_XD5_XDFFM_S XD3.XDFFM.S XD5.XDFFM.S 1.8151e-17
* device instance cc_XD3_XDFFM_S_XD5_XDFFM_SB r0 *1 0,0
Ccc_XD3_XDFFM_S_XD5_XDFFM_SB XD3.XDFFM.S XD5.XDFFM.SB 1.8151e-17
* device instance cc_XD3_XDFFM_S_XD5_XDFFQ_CLKB r0 *1 0,0
Ccc_XD3_XDFFM_S_XD5_XDFFQ_CLKB XD3.XDFFM.S XD5.XDFFQ.CLKB 1.8151e-17
* device instance cc_XD3_XDFFM_S_XD5_XDFFQ_M r0 *1 0,0
Ccc_XD3_XDFFM_S_XD5_XDFFQ_M XD3.XDFFM.S XD5.XDFFQ.M 2.4201e-17
* device instance cc_XD3_XDFFM_S_XD5_XDFFQ_MB r0 *1 0,0
Ccc_XD3_XDFFM_S_XD5_XDFFQ_MB XD3.XDFFM.S XD5.XDFFQ.MB 1.21e-17
* device instance cc_XD3_XDFFM_S_XD5_XDFFQ_S r0 *1 0,0
Ccc_XD3_XDFFM_S_XD5_XDFFQ_S XD3.XDFFM.S XD5.XDFFQ.S 1.8151e-17
* device instance cc_XD3_XDFFM_S_XD5_XDFFQ_SB r0 *1 0,0
Ccc_XD3_XDFFM_S_XD5_XDFFQ_SB XD3.XDFFM.S XD5.XDFFQ.SB 1.8151e-17
* device instance cc_XD3_XDFFM_S_XD5_XN2_mid1 r0 *1 0,0
Ccc_XD3_XDFFM_S_XD5_XN2_mid1 XD3.XDFFM.S XD5.XN2.mid1 1.21e-17
* device instance cc_XD3_XDFFM_S_XD5_XN3_mid1 r0 *1 0,0
Ccc_XD3_XDFFM_S_XD5_XN3_mid1 XD3.XDFFM.S XD5.XN3.mid1 1.21e-17
* device instance cc_XD3_XDFFM_S_XD5_XN3_mid2 r0 *1 0,0
Ccc_XD3_XDFFM_S_XD5_XN3_mid2 XD3.XDFFM.S XD5.XN3.mid2 1.21e-17
* device instance cc_XD3_XDFFM_S_XD5_dmodout r0 *1 0,0
Ccc_XD3_XDFFM_S_XD5_dmodout XD3.XDFFM.S XD5.dmodout 1.21e-17
* device instance cc_XD3_XDFFM_S_XD5_dq r0 *1 0,0
Ccc_XD3_XDFFM_S_XD5_dq XD3.XDFFM.S XD5.dq 1.8151e-17
* device instance cc_XD3_XDFFM_S_XD5_nm r0 *1 0,0
Ccc_XD3_XDFFM_S_XD5_nm XD3.XDFFM.S XD5.nm 1.21e-17
* device instance cc_XD3_XDFFM_S_XD5_nt r0 *1 0,0
Ccc_XD3_XDFFM_S_XD5_nt XD3.XDFFM.S XD5.nt 1.21e-17
* device instance cc_XD3_XDFFM_S_XD5_t1 r0 *1 0,0
Ccc_XD3_XDFFM_S_XD5_t1 XD3.XDFFM.S XD5.t1 1.21e-17
* device instance cc_XD3_XDFFM_S_XFRT_CLKB r0 *1 0,0
Ccc_XD3_XDFFM_S_XFRT_CLKB XD3.XDFFM.S XFRT.CLKB 1.8151e-17
* device instance cc_XD3_XDFFM_S_XFRT_M r0 *1 0,0
Ccc_XD3_XDFFM_S_XFRT_M XD3.XDFFM.S XFRT.M 2.4201e-17
* device instance cc_XD3_XDFFM_S_XFRT_MB r0 *1 0,0
Ccc_XD3_XDFFM_S_XFRT_MB XD3.XDFFM.S XFRT.MB 1.21e-17
* device instance cc_XD3_XDFFM_S_XFRT_S r0 *1 0,0
Ccc_XD3_XDFFM_S_XFRT_S XD3.XDFFM.S XFRT.S 1.8151e-17
* device instance cc_XD3_XDFFM_S_XFRT_SB r0 *1 0,0
Ccc_XD3_XDFFM_S_XFRT_SB XD3.XDFFM.S XFRT.SB 1.8151e-17
* device instance cc_XD3_XDFFM_S_ck1 r0 *1 0,0
Ccc_XD3_XDFFM_S_ck1 XD3.XDFFM.S ck1 5.4452e-17
* device instance cc_XD3_XDFFM_S_ck2 r0 *1 0,0
Ccc_XD3_XDFFM_S_ck2 XD3.XDFFM.S ck2 5.4452e-17
* device instance cc_XD3_XDFFM_S_ck3 r0 *1 0,0
Ccc_XD3_XDFFM_S_ck3 XD3.XDFFM.S ck3 5.4452e-17
* device instance cc_XD3_XDFFM_S_ck4 r0 *1 0,0
Ccc_XD3_XDFFM_S_ck4 XD3.XDFFM.S ck4 5.4452e-17
* device instance cc_XD3_XDFFM_S_ck5 r0 *1 0,0
Ccc_XD3_XDFFM_S_ck5 XD3.XDFFM.S ck5 5.4452e-17
* device instance cc_XD3_XDFFM_S_mod0 r0 *1 0,0
Ccc_XD3_XDFFM_S_mod0 XD3.XDFFM.S mod0 2.4201e-17
* device instance cc_XD3_XDFFM_S_mod1 r0 *1 0,0
Ccc_XD3_XDFFM_S_mod1 XD3.XDFFM.S mod1 2.4201e-17
* device instance cc_XD3_XDFFM_S_mod2 r0 *1 0,0
Ccc_XD3_XDFFM_S_mod2 XD3.XDFFM.S mod2 2.4201e-17
* device instance cc_XD3_XDFFM_S_mod3 r0 *1 0,0
Ccc_XD3_XDFFM_S_mod3 XD3.XDFFM.S mod3 2.4201e-17
* device instance cc_XD3_XDFFM_S_mod4 r0 *1 0,0
Ccc_XD3_XDFFM_S_mod4 XD3.XDFFM.S mod4 2.4201e-17
* device instance cc_XD3_XDFFM_S_net1 r0 *1 0,0
Ccc_XD3_XDFFM_S_net1 XD3.XDFFM.S net1 1.21e-17
* device instance cc_XD3_XDFFM_SB_XD3_XDFFQ_CLKB r0 *1 0,0
Ccc_XD3_XDFFM_SB_XD3_XDFFQ_CLKB XD3.XDFFM.SB XD3.XDFFQ.CLKB 1.8151e-17
* device instance cc_XD3_XDFFM_SB_XD3_XDFFQ_M r0 *1 0,0
Ccc_XD3_XDFFM_SB_XD3_XDFFQ_M XD3.XDFFM.SB XD3.XDFFQ.M 2.4201e-17
* device instance cc_XD3_XDFFM_SB_XD3_XDFFQ_MB r0 *1 0,0
Ccc_XD3_XDFFM_SB_XD3_XDFFQ_MB XD3.XDFFM.SB XD3.XDFFQ.MB 1.21e-17
* device instance cc_XD3_XDFFM_SB_XD3_XDFFQ_S r0 *1 0,0
Ccc_XD3_XDFFM_SB_XD3_XDFFQ_S XD3.XDFFM.SB XD3.XDFFQ.S 1.8151e-17
* device instance cc_XD3_XDFFM_SB_XD3_XDFFQ_SB r0 *1 0,0
Ccc_XD3_XDFFM_SB_XD3_XDFFQ_SB XD3.XDFFM.SB XD3.XDFFQ.SB 1.8151e-17
* device instance cc_XD3_XDFFM_SB_XD3_XNOR_midp r0 *1 0,0
Ccc_XD3_XDFFM_SB_XD3_XNOR_midp XD3.XDFFM.SB XD3.XNOR.midp 1.21e-17
* device instance cc_XD3_XDFFM_SB_XD3_dmodout r0 *1 0,0
Ccc_XD3_XDFFM_SB_XD3_dmodout XD3.XDFFM.SB XD3.dmodout 1.21e-17
* device instance cc_XD3_XDFFM_SB_XD3_dq r0 *1 0,0
Ccc_XD3_XDFFM_SB_XD3_dq XD3.XDFFM.SB XD3.dq 1.21e-17
* device instance cc_XD3_XDFFM_SB_XD3_nm r0 *1 0,0
Ccc_XD3_XDFFM_SB_XD3_nm XD3.XDFFM.SB XD3.nm 1.8151e-17
* device instance cc_XD3_XDFFM_SB_XD3_nt r0 *1 0,0
Ccc_XD3_XDFFM_SB_XD3_nt XD3.XDFFM.SB XD3.nt 2.4201e-17
* device instance cc_XD3_XDFFM_SB_XD3_t1 r0 *1 0,0
Ccc_XD3_XDFFM_SB_XD3_t1 XD3.XDFFM.SB XD3.t1 1.21e-17
* device instance cc_XD3_XDFFM_SB_XD4_XDFFM_CLKB r0 *1 0,0
Ccc_XD3_XDFFM_SB_XD4_XDFFM_CLKB XD3.XDFFM.SB XD4.XDFFM.CLKB 1.8151e-17
* device instance cc_XD3_XDFFM_SB_XD4_XDFFM_M r0 *1 0,0
Ccc_XD3_XDFFM_SB_XD4_XDFFM_M XD3.XDFFM.SB XD4.XDFFM.M 2.4201e-17
* device instance cc_XD3_XDFFM_SB_XD4_XDFFM_MB r0 *1 0,0
Ccc_XD3_XDFFM_SB_XD4_XDFFM_MB XD3.XDFFM.SB XD4.XDFFM.MB 1.21e-17
* device instance cc_XD3_XDFFM_SB_XD4_XDFFM_S r0 *1 0,0
Ccc_XD3_XDFFM_SB_XD4_XDFFM_S XD3.XDFFM.SB XD4.XDFFM.S 1.8151e-17
* device instance cc_XD3_XDFFM_SB_XD4_XDFFM_SB r0 *1 0,0
Ccc_XD3_XDFFM_SB_XD4_XDFFM_SB XD3.XDFFM.SB XD4.XDFFM.SB 1.8151e-17
* device instance cc_XD3_XDFFM_SB_XD4_XDFFQ_CLKB r0 *1 0,0
Ccc_XD3_XDFFM_SB_XD4_XDFFQ_CLKB XD3.XDFFM.SB XD4.XDFFQ.CLKB 1.8151e-17
* device instance cc_XD3_XDFFM_SB_XD4_XDFFQ_M r0 *1 0,0
Ccc_XD3_XDFFM_SB_XD4_XDFFQ_M XD3.XDFFM.SB XD4.XDFFQ.M 2.4201e-17
* device instance cc_XD3_XDFFM_SB_XD4_XDFFQ_MB r0 *1 0,0
Ccc_XD3_XDFFM_SB_XD4_XDFFQ_MB XD3.XDFFM.SB XD4.XDFFQ.MB 1.21e-17
* device instance cc_XD3_XDFFM_SB_XD4_XDFFQ_S r0 *1 0,0
Ccc_XD3_XDFFM_SB_XD4_XDFFQ_S XD3.XDFFM.SB XD4.XDFFQ.S 1.8151e-17
* device instance cc_XD3_XDFFM_SB_XD4_XDFFQ_SB r0 *1 0,0
Ccc_XD3_XDFFM_SB_XD4_XDFFQ_SB XD3.XDFFM.SB XD4.XDFFQ.SB 1.8151e-17
* device instance cc_XD3_XDFFM_SB_XD4_XN2_mid1 r0 *1 0,0
Ccc_XD3_XDFFM_SB_XD4_XN2_mid1 XD3.XDFFM.SB XD4.XN2.mid1 1.21e-17
* device instance cc_XD3_XDFFM_SB_XD4_XN3_mid1 r0 *1 0,0
Ccc_XD3_XDFFM_SB_XD4_XN3_mid1 XD3.XDFFM.SB XD4.XN3.mid1 1.21e-17
* device instance cc_XD3_XDFFM_SB_XD4_XN3_mid2 r0 *1 0,0
Ccc_XD3_XDFFM_SB_XD4_XN3_mid2 XD3.XDFFM.SB XD4.XN3.mid2 1.21e-17
* device instance cc_XD3_XDFFM_SB_XD4_dmodout r0 *1 0,0
Ccc_XD3_XDFFM_SB_XD4_dmodout XD3.XDFFM.SB XD4.dmodout 1.21e-17
* device instance cc_XD3_XDFFM_SB_XD4_dq r0 *1 0,0
Ccc_XD3_XDFFM_SB_XD4_dq XD3.XDFFM.SB XD4.dq 1.8151e-17
* device instance cc_XD3_XDFFM_SB_XD4_nm r0 *1 0,0
Ccc_XD3_XDFFM_SB_XD4_nm XD3.XDFFM.SB XD4.nm 1.21e-17
* device instance cc_XD3_XDFFM_SB_XD4_nt r0 *1 0,0
Ccc_XD3_XDFFM_SB_XD4_nt XD3.XDFFM.SB XD4.nt 1.21e-17
* device instance cc_XD3_XDFFM_SB_XD4_t1 r0 *1 0,0
Ccc_XD3_XDFFM_SB_XD4_t1 XD3.XDFFM.SB XD4.t1 1.21e-17
* device instance cc_XD3_XDFFM_SB_XD5_XDFFM_CLKB r0 *1 0,0
Ccc_XD3_XDFFM_SB_XD5_XDFFM_CLKB XD3.XDFFM.SB XD5.XDFFM.CLKB 1.8151e-17
* device instance cc_XD3_XDFFM_SB_XD5_XDFFM_M r0 *1 0,0
Ccc_XD3_XDFFM_SB_XD5_XDFFM_M XD3.XDFFM.SB XD5.XDFFM.M 2.4201e-17
* device instance cc_XD3_XDFFM_SB_XD5_XDFFM_MB r0 *1 0,0
Ccc_XD3_XDFFM_SB_XD5_XDFFM_MB XD3.XDFFM.SB XD5.XDFFM.MB 1.21e-17
* device instance cc_XD3_XDFFM_SB_XD5_XDFFM_S r0 *1 0,0
Ccc_XD3_XDFFM_SB_XD5_XDFFM_S XD3.XDFFM.SB XD5.XDFFM.S 1.8151e-17
* device instance cc_XD3_XDFFM_SB_XD5_XDFFM_SB r0 *1 0,0
Ccc_XD3_XDFFM_SB_XD5_XDFFM_SB XD3.XDFFM.SB XD5.XDFFM.SB 1.8151e-17
* device instance cc_XD3_XDFFM_SB_XD5_XDFFQ_CLKB r0 *1 0,0
Ccc_XD3_XDFFM_SB_XD5_XDFFQ_CLKB XD3.XDFFM.SB XD5.XDFFQ.CLKB 1.8151e-17
* device instance cc_XD3_XDFFM_SB_XD5_XDFFQ_M r0 *1 0,0
Ccc_XD3_XDFFM_SB_XD5_XDFFQ_M XD3.XDFFM.SB XD5.XDFFQ.M 2.4201e-17
* device instance cc_XD3_XDFFM_SB_XD5_XDFFQ_MB r0 *1 0,0
Ccc_XD3_XDFFM_SB_XD5_XDFFQ_MB XD3.XDFFM.SB XD5.XDFFQ.MB 1.21e-17
* device instance cc_XD3_XDFFM_SB_XD5_XDFFQ_S r0 *1 0,0
Ccc_XD3_XDFFM_SB_XD5_XDFFQ_S XD3.XDFFM.SB XD5.XDFFQ.S 1.8151e-17
* device instance cc_XD3_XDFFM_SB_XD5_XDFFQ_SB r0 *1 0,0
Ccc_XD3_XDFFM_SB_XD5_XDFFQ_SB XD3.XDFFM.SB XD5.XDFFQ.SB 1.8151e-17
* device instance cc_XD3_XDFFM_SB_XD5_XN2_mid1 r0 *1 0,0
Ccc_XD3_XDFFM_SB_XD5_XN2_mid1 XD3.XDFFM.SB XD5.XN2.mid1 1.21e-17
* device instance cc_XD3_XDFFM_SB_XD5_XN3_mid1 r0 *1 0,0
Ccc_XD3_XDFFM_SB_XD5_XN3_mid1 XD3.XDFFM.SB XD5.XN3.mid1 1.21e-17
* device instance cc_XD3_XDFFM_SB_XD5_XN3_mid2 r0 *1 0,0
Ccc_XD3_XDFFM_SB_XD5_XN3_mid2 XD3.XDFFM.SB XD5.XN3.mid2 1.21e-17
* device instance cc_XD3_XDFFM_SB_XD5_dmodout r0 *1 0,0
Ccc_XD3_XDFFM_SB_XD5_dmodout XD3.XDFFM.SB XD5.dmodout 1.21e-17
* device instance cc_XD3_XDFFM_SB_XD5_dq r0 *1 0,0
Ccc_XD3_XDFFM_SB_XD5_dq XD3.XDFFM.SB XD5.dq 1.8151e-17
* device instance cc_XD3_XDFFM_SB_XD5_nm r0 *1 0,0
Ccc_XD3_XDFFM_SB_XD5_nm XD3.XDFFM.SB XD5.nm 1.21e-17
* device instance cc_XD3_XDFFM_SB_XD5_nt r0 *1 0,0
Ccc_XD3_XDFFM_SB_XD5_nt XD3.XDFFM.SB XD5.nt 1.21e-17
* device instance cc_XD3_XDFFM_SB_XD5_t1 r0 *1 0,0
Ccc_XD3_XDFFM_SB_XD5_t1 XD3.XDFFM.SB XD5.t1 1.21e-17
* device instance cc_XD3_XDFFM_SB_XFRT_CLKB r0 *1 0,0
Ccc_XD3_XDFFM_SB_XFRT_CLKB XD3.XDFFM.SB XFRT.CLKB 1.8151e-17
* device instance cc_XD3_XDFFM_SB_XFRT_M r0 *1 0,0
Ccc_XD3_XDFFM_SB_XFRT_M XD3.XDFFM.SB XFRT.M 2.4201e-17
* device instance cc_XD3_XDFFM_SB_XFRT_MB r0 *1 0,0
Ccc_XD3_XDFFM_SB_XFRT_MB XD3.XDFFM.SB XFRT.MB 1.21e-17
* device instance cc_XD3_XDFFM_SB_XFRT_S r0 *1 0,0
Ccc_XD3_XDFFM_SB_XFRT_S XD3.XDFFM.SB XFRT.S 1.8151e-17
* device instance cc_XD3_XDFFM_SB_XFRT_SB r0 *1 0,0
Ccc_XD3_XDFFM_SB_XFRT_SB XD3.XDFFM.SB XFRT.SB 1.8151e-17
* device instance cc_XD3_XDFFM_SB_ck1 r0 *1 0,0
Ccc_XD3_XDFFM_SB_ck1 XD3.XDFFM.SB ck1 5.4452e-17
* device instance cc_XD3_XDFFM_SB_ck2 r0 *1 0,0
Ccc_XD3_XDFFM_SB_ck2 XD3.XDFFM.SB ck2 5.4452e-17
* device instance cc_XD3_XDFFM_SB_ck3 r0 *1 0,0
Ccc_XD3_XDFFM_SB_ck3 XD3.XDFFM.SB ck3 5.4452e-17
* device instance cc_XD3_XDFFM_SB_ck4 r0 *1 0,0
Ccc_XD3_XDFFM_SB_ck4 XD3.XDFFM.SB ck4 5.4452e-17
* device instance cc_XD3_XDFFM_SB_ck5 r0 *1 0,0
Ccc_XD3_XDFFM_SB_ck5 XD3.XDFFM.SB ck5 5.4452e-17
* device instance cc_XD3_XDFFM_SB_mod0 r0 *1 0,0
Ccc_XD3_XDFFM_SB_mod0 XD3.XDFFM.SB mod0 2.4201e-17
* device instance cc_XD3_XDFFM_SB_mod1 r0 *1 0,0
Ccc_XD3_XDFFM_SB_mod1 XD3.XDFFM.SB mod1 2.4201e-17
* device instance cc_XD3_XDFFM_SB_mod2 r0 *1 0,0
Ccc_XD3_XDFFM_SB_mod2 XD3.XDFFM.SB mod2 2.4201e-17
* device instance cc_XD3_XDFFM_SB_mod3 r0 *1 0,0
Ccc_XD3_XDFFM_SB_mod3 XD3.XDFFM.SB mod3 2.4201e-17
* device instance cc_XD3_XDFFM_SB_mod4 r0 *1 0,0
Ccc_XD3_XDFFM_SB_mod4 XD3.XDFFM.SB mod4 2.4201e-17
* device instance cc_XD3_XDFFM_SB_net1 r0 *1 0,0
Ccc_XD3_XDFFM_SB_net1 XD3.XDFFM.SB net1 1.21e-17
* device instance cc_XD3_XDFFQ_CLKB_XD3_XDFFQ_M r0 *1 0,0
Ccc_XD3_XDFFQ_CLKB_XD3_XDFFQ_M XD3.XDFFQ.CLKB XD3.XDFFQ.M 4.2352e-17
* device instance cc_XD3_XDFFQ_CLKB_XD3_XDFFQ_MB r0 *1 0,0
Ccc_XD3_XDFFQ_CLKB_XD3_XDFFQ_MB XD3.XDFFQ.CLKB XD3.XDFFQ.MB 2.4201e-17
* device instance cc_XD3_XDFFQ_CLKB_XD3_XDFFQ_S r0 *1 0,0
Ccc_XD3_XDFFQ_CLKB_XD3_XDFFQ_S XD3.XDFFQ.CLKB XD3.XDFFQ.S 1.8151e-17
* device instance cc_XD3_XDFFQ_CLKB_XD3_XDFFQ_SB r0 *1 0,0
Ccc_XD3_XDFFQ_CLKB_XD3_XDFFQ_SB XD3.XDFFQ.CLKB XD3.XDFFQ.SB 1.8151e-17
* device instance cc_XD3_XDFFQ_CLKB_XD3_XN2_mid1 r0 *1 0,0
Ccc_XD3_XDFFQ_CLKB_XD3_XN2_mid1 XD3.XDFFQ.CLKB XD3.XN2.mid1 1.21e-17
* device instance cc_XD3_XDFFQ_CLKB_XD3_XNOR_midp r0 *1 0,0
Ccc_XD3_XDFFQ_CLKB_XD3_XNOR_midp XD3.XDFFQ.CLKB XD3.XNOR.midp 1.21e-17
* device instance cc_XD3_XDFFQ_CLKB_XD3_dmodout r0 *1 0,0
Ccc_XD3_XDFFQ_CLKB_XD3_dmodout XD3.XDFFQ.CLKB XD3.dmodout 1.21e-17
* device instance cc_XD3_XDFFQ_CLKB_XD3_dq r0 *1 0,0
Ccc_XD3_XDFFQ_CLKB_XD3_dq XD3.XDFFQ.CLKB XD3.dq 1.8151e-17
* device instance cc_XD3_XDFFQ_CLKB_XD3_nm r0 *1 0,0
Ccc_XD3_XDFFQ_CLKB_XD3_nm XD3.XDFFQ.CLKB XD3.nm 1.21e-17
* device instance cc_XD3_XDFFQ_CLKB_XD3_nt r0 *1 0,0
Ccc_XD3_XDFFQ_CLKB_XD3_nt XD3.XDFFQ.CLKB XD3.nt 2.4201e-17
* device instance cc_XD3_XDFFQ_CLKB_XD3_t1 r0 *1 0,0
Ccc_XD3_XDFFQ_CLKB_XD3_t1 XD3.XDFFQ.CLKB XD3.t1 1.21e-17
* device instance cc_XD3_XDFFQ_CLKB_XD4_XDFFM_CLKB r0 *1 0,0
Ccc_XD3_XDFFQ_CLKB_XD4_XDFFM_CLKB XD3.XDFFQ.CLKB XD4.XDFFM.CLKB 1.8151e-17
* device instance cc_XD3_XDFFQ_CLKB_XD4_XDFFM_M r0 *1 0,0
Ccc_XD3_XDFFQ_CLKB_XD4_XDFFM_M XD3.XDFFQ.CLKB XD4.XDFFM.M 2.4201e-17
* device instance cc_XD3_XDFFQ_CLKB_XD4_XDFFM_MB r0 *1 0,0
Ccc_XD3_XDFFQ_CLKB_XD4_XDFFM_MB XD3.XDFFQ.CLKB XD4.XDFFM.MB 1.21e-17
* device instance cc_XD3_XDFFQ_CLKB_XD4_XDFFM_S r0 *1 0,0
Ccc_XD3_XDFFQ_CLKB_XD4_XDFFM_S XD3.XDFFQ.CLKB XD4.XDFFM.S 1.8151e-17
* device instance cc_XD3_XDFFQ_CLKB_XD4_XDFFM_SB r0 *1 0,0
Ccc_XD3_XDFFQ_CLKB_XD4_XDFFM_SB XD3.XDFFQ.CLKB XD4.XDFFM.SB 1.8151e-17
* device instance cc_XD3_XDFFQ_CLKB_XD4_XDFFQ_CLKB r0 *1 0,0
Ccc_XD3_XDFFQ_CLKB_XD4_XDFFQ_CLKB XD3.XDFFQ.CLKB XD4.XDFFQ.CLKB 1.8151e-17
* device instance cc_XD3_XDFFQ_CLKB_XD4_XDFFQ_M r0 *1 0,0
Ccc_XD3_XDFFQ_CLKB_XD4_XDFFQ_M XD3.XDFFQ.CLKB XD4.XDFFQ.M 2.4201e-17
* device instance cc_XD3_XDFFQ_CLKB_XD4_XDFFQ_MB r0 *1 0,0
Ccc_XD3_XDFFQ_CLKB_XD4_XDFFQ_MB XD3.XDFFQ.CLKB XD4.XDFFQ.MB 1.21e-17
* device instance cc_XD3_XDFFQ_CLKB_XD4_XDFFQ_S r0 *1 0,0
Ccc_XD3_XDFFQ_CLKB_XD4_XDFFQ_S XD3.XDFFQ.CLKB XD4.XDFFQ.S 1.8151e-17
* device instance cc_XD3_XDFFQ_CLKB_XD4_XDFFQ_SB r0 *1 0,0
Ccc_XD3_XDFFQ_CLKB_XD4_XDFFQ_SB XD3.XDFFQ.CLKB XD4.XDFFQ.SB 1.8151e-17
* device instance cc_XD3_XDFFQ_CLKB_XD4_XN2_mid1 r0 *1 0,0
Ccc_XD3_XDFFQ_CLKB_XD4_XN2_mid1 XD3.XDFFQ.CLKB XD4.XN2.mid1 1.21e-17
* device instance cc_XD3_XDFFQ_CLKB_XD4_XN3_mid1 r0 *1 0,0
Ccc_XD3_XDFFQ_CLKB_XD4_XN3_mid1 XD3.XDFFQ.CLKB XD4.XN3.mid1 1.21e-17
* device instance cc_XD3_XDFFQ_CLKB_XD4_XN3_mid2 r0 *1 0,0
Ccc_XD3_XDFFQ_CLKB_XD4_XN3_mid2 XD3.XDFFQ.CLKB XD4.XN3.mid2 1.21e-17
* device instance cc_XD3_XDFFQ_CLKB_XD4_dmodout r0 *1 0,0
Ccc_XD3_XDFFQ_CLKB_XD4_dmodout XD3.XDFFQ.CLKB XD4.dmodout 1.21e-17
* device instance cc_XD3_XDFFQ_CLKB_XD4_dq r0 *1 0,0
Ccc_XD3_XDFFQ_CLKB_XD4_dq XD3.XDFFQ.CLKB XD4.dq 1.8151e-17
* device instance cc_XD3_XDFFQ_CLKB_XD4_nm r0 *1 0,0
Ccc_XD3_XDFFQ_CLKB_XD4_nm XD3.XDFFQ.CLKB XD4.nm 1.21e-17
* device instance cc_XD3_XDFFQ_CLKB_XD4_nt r0 *1 0,0
Ccc_XD3_XDFFQ_CLKB_XD4_nt XD3.XDFFQ.CLKB XD4.nt 1.21e-17
* device instance cc_XD3_XDFFQ_CLKB_XD4_t1 r0 *1 0,0
Ccc_XD3_XDFFQ_CLKB_XD4_t1 XD3.XDFFQ.CLKB XD4.t1 1.21e-17
* device instance cc_XD3_XDFFQ_CLKB_XD5_XDFFM_CLKB r0 *1 0,0
Ccc_XD3_XDFFQ_CLKB_XD5_XDFFM_CLKB XD3.XDFFQ.CLKB XD5.XDFFM.CLKB 1.8151e-17
* device instance cc_XD3_XDFFQ_CLKB_XD5_XDFFM_M r0 *1 0,0
Ccc_XD3_XDFFQ_CLKB_XD5_XDFFM_M XD3.XDFFQ.CLKB XD5.XDFFM.M 2.4201e-17
* device instance cc_XD3_XDFFQ_CLKB_XD5_XDFFM_MB r0 *1 0,0
Ccc_XD3_XDFFQ_CLKB_XD5_XDFFM_MB XD3.XDFFQ.CLKB XD5.XDFFM.MB 1.21e-17
* device instance cc_XD3_XDFFQ_CLKB_XD5_XDFFM_S r0 *1 0,0
Ccc_XD3_XDFFQ_CLKB_XD5_XDFFM_S XD3.XDFFQ.CLKB XD5.XDFFM.S 1.8151e-17
* device instance cc_XD3_XDFFQ_CLKB_XD5_XDFFM_SB r0 *1 0,0
Ccc_XD3_XDFFQ_CLKB_XD5_XDFFM_SB XD3.XDFFQ.CLKB XD5.XDFFM.SB 1.8151e-17
* device instance cc_XD3_XDFFQ_CLKB_XD5_XDFFQ_CLKB r0 *1 0,0
Ccc_XD3_XDFFQ_CLKB_XD5_XDFFQ_CLKB XD3.XDFFQ.CLKB XD5.XDFFQ.CLKB 1.8151e-17
* device instance cc_XD3_XDFFQ_CLKB_XD5_XDFFQ_M r0 *1 0,0
Ccc_XD3_XDFFQ_CLKB_XD5_XDFFQ_M XD3.XDFFQ.CLKB XD5.XDFFQ.M 2.4201e-17
* device instance cc_XD3_XDFFQ_CLKB_XD5_XDFFQ_MB r0 *1 0,0
Ccc_XD3_XDFFQ_CLKB_XD5_XDFFQ_MB XD3.XDFFQ.CLKB XD5.XDFFQ.MB 1.21e-17
* device instance cc_XD3_XDFFQ_CLKB_XD5_XDFFQ_S r0 *1 0,0
Ccc_XD3_XDFFQ_CLKB_XD5_XDFFQ_S XD3.XDFFQ.CLKB XD5.XDFFQ.S 1.8151e-17
* device instance cc_XD3_XDFFQ_CLKB_XD5_XDFFQ_SB r0 *1 0,0
Ccc_XD3_XDFFQ_CLKB_XD5_XDFFQ_SB XD3.XDFFQ.CLKB XD5.XDFFQ.SB 1.8151e-17
* device instance cc_XD3_XDFFQ_CLKB_XD5_XN2_mid1 r0 *1 0,0
Ccc_XD3_XDFFQ_CLKB_XD5_XN2_mid1 XD3.XDFFQ.CLKB XD5.XN2.mid1 1.21e-17
* device instance cc_XD3_XDFFQ_CLKB_XD5_XN3_mid1 r0 *1 0,0
Ccc_XD3_XDFFQ_CLKB_XD5_XN3_mid1 XD3.XDFFQ.CLKB XD5.XN3.mid1 1.21e-17
* device instance cc_XD3_XDFFQ_CLKB_XD5_XN3_mid2 r0 *1 0,0
Ccc_XD3_XDFFQ_CLKB_XD5_XN3_mid2 XD3.XDFFQ.CLKB XD5.XN3.mid2 1.21e-17
* device instance cc_XD3_XDFFQ_CLKB_XD5_dmodout r0 *1 0,0
Ccc_XD3_XDFFQ_CLKB_XD5_dmodout XD3.XDFFQ.CLKB XD5.dmodout 1.21e-17
* device instance cc_XD3_XDFFQ_CLKB_XD5_dq r0 *1 0,0
Ccc_XD3_XDFFQ_CLKB_XD5_dq XD3.XDFFQ.CLKB XD5.dq 1.8151e-17
* device instance cc_XD3_XDFFQ_CLKB_XD5_nm r0 *1 0,0
Ccc_XD3_XDFFQ_CLKB_XD5_nm XD3.XDFFQ.CLKB XD5.nm 1.21e-17
* device instance cc_XD3_XDFFQ_CLKB_XD5_nt r0 *1 0,0
Ccc_XD3_XDFFQ_CLKB_XD5_nt XD3.XDFFQ.CLKB XD5.nt 1.21e-17
* device instance cc_XD3_XDFFQ_CLKB_XD5_t1 r0 *1 0,0
Ccc_XD3_XDFFQ_CLKB_XD5_t1 XD3.XDFFQ.CLKB XD5.t1 1.21e-17
* device instance cc_XD3_XDFFQ_CLKB_XFRT_CLKB r0 *1 0,0
Ccc_XD3_XDFFQ_CLKB_XFRT_CLKB XD3.XDFFQ.CLKB XFRT.CLKB 1.8151e-17
* device instance cc_XD3_XDFFQ_CLKB_XFRT_M r0 *1 0,0
Ccc_XD3_XDFFQ_CLKB_XFRT_M XD3.XDFFQ.CLKB XFRT.M 2.4201e-17
* device instance cc_XD3_XDFFQ_CLKB_XFRT_MB r0 *1 0,0
Ccc_XD3_XDFFQ_CLKB_XFRT_MB XD3.XDFFQ.CLKB XFRT.MB 1.21e-17
* device instance cc_XD3_XDFFQ_CLKB_XFRT_S r0 *1 0,0
Ccc_XD3_XDFFQ_CLKB_XFRT_S XD3.XDFFQ.CLKB XFRT.S 1.8151e-17
* device instance cc_XD3_XDFFQ_CLKB_XFRT_SB r0 *1 0,0
Ccc_XD3_XDFFQ_CLKB_XFRT_SB XD3.XDFFQ.CLKB XFRT.SB 1.8151e-17
* device instance cc_XD3_XDFFQ_CLKB_ck1 r0 *1 0,0
Ccc_XD3_XDFFQ_CLKB_ck1 XD3.XDFFQ.CLKB ck1 5.4452e-17
* device instance cc_XD3_XDFFQ_CLKB_ck2 r0 *1 0,0
Ccc_XD3_XDFFQ_CLKB_ck2 XD3.XDFFQ.CLKB ck2 5.4452e-17
* device instance cc_XD3_XDFFQ_CLKB_ck3 r0 *1 0,0
Ccc_XD3_XDFFQ_CLKB_ck3 XD3.XDFFQ.CLKB ck3 6.0502e-17
* device instance cc_XD3_XDFFQ_CLKB_ck4 r0 *1 0,0
Ccc_XD3_XDFFQ_CLKB_ck4 XD3.XDFFQ.CLKB ck4 5.4452e-17
* device instance cc_XD3_XDFFQ_CLKB_ck5 r0 *1 0,0
Ccc_XD3_XDFFQ_CLKB_ck5 XD3.XDFFQ.CLKB ck5 5.4452e-17
* device instance cc_XD3_XDFFQ_CLKB_mod0 r0 *1 0,0
Ccc_XD3_XDFFQ_CLKB_mod0 XD3.XDFFQ.CLKB mod0 2.4201e-17
* device instance cc_XD3_XDFFQ_CLKB_mod1 r0 *1 0,0
Ccc_XD3_XDFFQ_CLKB_mod1 XD3.XDFFQ.CLKB mod1 2.4201e-17
* device instance cc_XD3_XDFFQ_CLKB_mod2 r0 *1 0,0
Ccc_XD3_XDFFQ_CLKB_mod2 XD3.XDFFQ.CLKB mod2 2.4201e-17
* device instance cc_XD3_XDFFQ_CLKB_mod3 r0 *1 0,0
Ccc_XD3_XDFFQ_CLKB_mod3 XD3.XDFFQ.CLKB mod3 2.4201e-17
* device instance cc_XD3_XDFFQ_CLKB_mod4 r0 *1 0,0
Ccc_XD3_XDFFQ_CLKB_mod4 XD3.XDFFQ.CLKB mod4 2.4201e-17
* device instance cc_XD3_XDFFQ_CLKB_net1 r0 *1 0,0
Ccc_XD3_XDFFQ_CLKB_net1 XD3.XDFFQ.CLKB net1 1.21e-17
* device instance cc_XD3_XDFFQ_M_XD3_XDFFQ_MB r0 *1 0,0
Ccc_XD3_XDFFQ_M_XD3_XDFFQ_MB XD3.XDFFQ.M XD3.XDFFQ.MB 3.4688e-17
* device instance cc_XD3_XDFFQ_M_XD3_XDFFQ_S r0 *1 0,0
Ccc_XD3_XDFFQ_M_XD3_XDFFQ_S XD3.XDFFQ.M XD3.XDFFQ.S 2.8638e-17
* device instance cc_XD3_XDFFQ_M_XD3_XDFFQ_SB r0 *1 0,0
Ccc_XD3_XDFFQ_M_XD3_XDFFQ_SB XD3.XDFFQ.M XD3.XDFFQ.SB 1.8151e-17
* device instance cc_XD3_XDFFQ_M_XD3_XN2_mid1 r0 *1 0,0
Ccc_XD3_XDFFQ_M_XD3_XN2_mid1 XD3.XDFFQ.M XD3.XN2.mid1 1.21e-17
* device instance cc_XD3_XDFFQ_M_XD3_XNOR_midp r0 *1 0,0
Ccc_XD3_XDFFQ_M_XD3_XNOR_midp XD3.XDFFQ.M XD3.XNOR.midp 1.21e-17
* device instance cc_XD3_XDFFQ_M_XD3_dmodout r0 *1 0,0
Ccc_XD3_XDFFQ_M_XD3_dmodout XD3.XDFFQ.M XD3.dmodout 1.21e-17
* device instance cc_XD3_XDFFQ_M_XD3_dq r0 *1 0,0
Ccc_XD3_XDFFQ_M_XD3_dq XD3.XDFFQ.M XD3.dq 2.8638e-17
* device instance cc_XD3_XDFFQ_M_XD3_nm r0 *1 0,0
Ccc_XD3_XDFFQ_M_XD3_nm XD3.XDFFQ.M XD3.nm 1.21e-17
* device instance cc_XD3_XDFFQ_M_XD3_nt r0 *1 0,0
Ccc_XD3_XDFFQ_M_XD3_nt XD3.XDFFQ.M XD3.nt 2.4201e-17
* device instance cc_XD3_XDFFQ_M_XD3_t1 r0 *1 0,0
Ccc_XD3_XDFFQ_M_XD3_t1 XD3.XDFFQ.M XD3.t1 1.21e-17
* device instance cc_XD3_XDFFQ_M_XD4_XDFFM_CLKB r0 *1 0,0
Ccc_XD3_XDFFQ_M_XD4_XDFFM_CLKB XD3.XDFFQ.M XD4.XDFFM.CLKB 1.8151e-17
* device instance cc_XD3_XDFFQ_M_XD4_XDFFM_M r0 *1 0,0
Ccc_XD3_XDFFQ_M_XD4_XDFFM_M XD3.XDFFQ.M XD4.XDFFM.M 2.4201e-17
* device instance cc_XD3_XDFFQ_M_XD4_XDFFM_MB r0 *1 0,0
Ccc_XD3_XDFFQ_M_XD4_XDFFM_MB XD3.XDFFQ.M XD4.XDFFM.MB 1.21e-17
* device instance cc_XD3_XDFFQ_M_XD4_XDFFM_S r0 *1 0,0
Ccc_XD3_XDFFQ_M_XD4_XDFFM_S XD3.XDFFQ.M XD4.XDFFM.S 1.8151e-17
* device instance cc_XD3_XDFFQ_M_XD4_XDFFM_SB r0 *1 0,0
Ccc_XD3_XDFFQ_M_XD4_XDFFM_SB XD3.XDFFQ.M XD4.XDFFM.SB 1.8151e-17
* device instance cc_XD3_XDFFQ_M_XD4_XDFFQ_CLKB r0 *1 0,0
Ccc_XD3_XDFFQ_M_XD4_XDFFQ_CLKB XD3.XDFFQ.M XD4.XDFFQ.CLKB 1.8151e-17
* device instance cc_XD3_XDFFQ_M_XD4_XDFFQ_M r0 *1 0,0
Ccc_XD3_XDFFQ_M_XD4_XDFFQ_M XD3.XDFFQ.M XD4.XDFFQ.M 2.4201e-17
* device instance cc_XD3_XDFFQ_M_XD4_XDFFQ_MB r0 *1 0,0
Ccc_XD3_XDFFQ_M_XD4_XDFFQ_MB XD3.XDFFQ.M XD4.XDFFQ.MB 1.21e-17
* device instance cc_XD3_XDFFQ_M_XD4_XDFFQ_S r0 *1 0,0
Ccc_XD3_XDFFQ_M_XD4_XDFFQ_S XD3.XDFFQ.M XD4.XDFFQ.S 1.8151e-17
* device instance cc_XD3_XDFFQ_M_XD4_XDFFQ_SB r0 *1 0,0
Ccc_XD3_XDFFQ_M_XD4_XDFFQ_SB XD3.XDFFQ.M XD4.XDFFQ.SB 1.8151e-17
* device instance cc_XD3_XDFFQ_M_XD4_XN2_mid1 r0 *1 0,0
Ccc_XD3_XDFFQ_M_XD4_XN2_mid1 XD3.XDFFQ.M XD4.XN2.mid1 1.21e-17
* device instance cc_XD3_XDFFQ_M_XD4_XN3_mid1 r0 *1 0,0
Ccc_XD3_XDFFQ_M_XD4_XN3_mid1 XD3.XDFFQ.M XD4.XN3.mid1 1.21e-17
* device instance cc_XD3_XDFFQ_M_XD4_XN3_mid2 r0 *1 0,0
Ccc_XD3_XDFFQ_M_XD4_XN3_mid2 XD3.XDFFQ.M XD4.XN3.mid2 1.21e-17
* device instance cc_XD3_XDFFQ_M_XD4_dmodout r0 *1 0,0
Ccc_XD3_XDFFQ_M_XD4_dmodout XD3.XDFFQ.M XD4.dmodout 1.21e-17
* device instance cc_XD3_XDFFQ_M_XD4_dq r0 *1 0,0
Ccc_XD3_XDFFQ_M_XD4_dq XD3.XDFFQ.M XD4.dq 1.8151e-17
* device instance cc_XD3_XDFFQ_M_XD4_nm r0 *1 0,0
Ccc_XD3_XDFFQ_M_XD4_nm XD3.XDFFQ.M XD4.nm 1.21e-17
* device instance cc_XD3_XDFFQ_M_XD4_nt r0 *1 0,0
Ccc_XD3_XDFFQ_M_XD4_nt XD3.XDFFQ.M XD4.nt 1.21e-17
* device instance cc_XD3_XDFFQ_M_XD4_t1 r0 *1 0,0
Ccc_XD3_XDFFQ_M_XD4_t1 XD3.XDFFQ.M XD4.t1 1.21e-17
* device instance cc_XD3_XDFFQ_M_XD5_XDFFM_CLKB r0 *1 0,0
Ccc_XD3_XDFFQ_M_XD5_XDFFM_CLKB XD3.XDFFQ.M XD5.XDFFM.CLKB 1.8151e-17
* device instance cc_XD3_XDFFQ_M_XD5_XDFFM_M r0 *1 0,0
Ccc_XD3_XDFFQ_M_XD5_XDFFM_M XD3.XDFFQ.M XD5.XDFFM.M 2.4201e-17
* device instance cc_XD3_XDFFQ_M_XD5_XDFFM_MB r0 *1 0,0
Ccc_XD3_XDFFQ_M_XD5_XDFFM_MB XD3.XDFFQ.M XD5.XDFFM.MB 1.21e-17
* device instance cc_XD3_XDFFQ_M_XD5_XDFFM_S r0 *1 0,0
Ccc_XD3_XDFFQ_M_XD5_XDFFM_S XD3.XDFFQ.M XD5.XDFFM.S 1.8151e-17
* device instance cc_XD3_XDFFQ_M_XD5_XDFFM_SB r0 *1 0,0
Ccc_XD3_XDFFQ_M_XD5_XDFFM_SB XD3.XDFFQ.M XD5.XDFFM.SB 1.8151e-17
* device instance cc_XD3_XDFFQ_M_XD5_XDFFQ_CLKB r0 *1 0,0
Ccc_XD3_XDFFQ_M_XD5_XDFFQ_CLKB XD3.XDFFQ.M XD5.XDFFQ.CLKB 1.8151e-17
* device instance cc_XD3_XDFFQ_M_XD5_XDFFQ_M r0 *1 0,0
Ccc_XD3_XDFFQ_M_XD5_XDFFQ_M XD3.XDFFQ.M XD5.XDFFQ.M 2.4201e-17
* device instance cc_XD3_XDFFQ_M_XD5_XDFFQ_MB r0 *1 0,0
Ccc_XD3_XDFFQ_M_XD5_XDFFQ_MB XD3.XDFFQ.M XD5.XDFFQ.MB 1.21e-17
* device instance cc_XD3_XDFFQ_M_XD5_XDFFQ_S r0 *1 0,0
Ccc_XD3_XDFFQ_M_XD5_XDFFQ_S XD3.XDFFQ.M XD5.XDFFQ.S 1.8151e-17
* device instance cc_XD3_XDFFQ_M_XD5_XDFFQ_SB r0 *1 0,0
Ccc_XD3_XDFFQ_M_XD5_XDFFQ_SB XD3.XDFFQ.M XD5.XDFFQ.SB 1.8151e-17
* device instance cc_XD3_XDFFQ_M_XD5_XN2_mid1 r0 *1 0,0
Ccc_XD3_XDFFQ_M_XD5_XN2_mid1 XD3.XDFFQ.M XD5.XN2.mid1 1.21e-17
* device instance cc_XD3_XDFFQ_M_XD5_XN3_mid1 r0 *1 0,0
Ccc_XD3_XDFFQ_M_XD5_XN3_mid1 XD3.XDFFQ.M XD5.XN3.mid1 1.21e-17
* device instance cc_XD3_XDFFQ_M_XD5_XN3_mid2 r0 *1 0,0
Ccc_XD3_XDFFQ_M_XD5_XN3_mid2 XD3.XDFFQ.M XD5.XN3.mid2 1.21e-17
* device instance cc_XD3_XDFFQ_M_XD5_dmodout r0 *1 0,0
Ccc_XD3_XDFFQ_M_XD5_dmodout XD3.XDFFQ.M XD5.dmodout 1.21e-17
* device instance cc_XD3_XDFFQ_M_XD5_dq r0 *1 0,0
Ccc_XD3_XDFFQ_M_XD5_dq XD3.XDFFQ.M XD5.dq 1.8151e-17
* device instance cc_XD3_XDFFQ_M_XD5_nm r0 *1 0,0
Ccc_XD3_XDFFQ_M_XD5_nm XD3.XDFFQ.M XD5.nm 1.21e-17
* device instance cc_XD3_XDFFQ_M_XD5_nt r0 *1 0,0
Ccc_XD3_XDFFQ_M_XD5_nt XD3.XDFFQ.M XD5.nt 1.21e-17
* device instance cc_XD3_XDFFQ_M_XD5_t1 r0 *1 0,0
Ccc_XD3_XDFFQ_M_XD5_t1 XD3.XDFFQ.M XD5.t1 1.21e-17
* device instance cc_XD3_XDFFQ_M_XFRT_CLKB r0 *1 0,0
Ccc_XD3_XDFFQ_M_XFRT_CLKB XD3.XDFFQ.M XFRT.CLKB 1.8151e-17
* device instance cc_XD3_XDFFQ_M_XFRT_M r0 *1 0,0
Ccc_XD3_XDFFQ_M_XFRT_M XD3.XDFFQ.M XFRT.M 2.4201e-17
* device instance cc_XD3_XDFFQ_M_XFRT_MB r0 *1 0,0
Ccc_XD3_XDFFQ_M_XFRT_MB XD3.XDFFQ.M XFRT.MB 1.21e-17
* device instance cc_XD3_XDFFQ_M_XFRT_S r0 *1 0,0
Ccc_XD3_XDFFQ_M_XFRT_S XD3.XDFFQ.M XFRT.S 1.8151e-17
* device instance cc_XD3_XDFFQ_M_XFRT_SB r0 *1 0,0
Ccc_XD3_XDFFQ_M_XFRT_SB XD3.XDFFQ.M XFRT.SB 1.8151e-17
* device instance cc_XD3_XDFFQ_M_ck1 r0 *1 0,0
Ccc_XD3_XDFFQ_M_ck1 XD3.XDFFQ.M ck1 5.4452e-17
* device instance cc_XD3_XDFFQ_M_ck2 r0 *1 0,0
Ccc_XD3_XDFFQ_M_ck2 XD3.XDFFQ.M ck2 5.4452e-17
* device instance cc_XD3_XDFFQ_M_ck3 r0 *1 0,0
Ccc_XD3_XDFFQ_M_ck3 XD3.XDFFQ.M ck3 6.0502e-17
* device instance cc_XD3_XDFFQ_M_ck4 r0 *1 0,0
Ccc_XD3_XDFFQ_M_ck4 XD3.XDFFQ.M ck4 5.4452e-17
* device instance cc_XD3_XDFFQ_M_ck5 r0 *1 0,0
Ccc_XD3_XDFFQ_M_ck5 XD3.XDFFQ.M ck5 5.4452e-17
* device instance cc_XD3_XDFFQ_M_mod0 r0 *1 0,0
Ccc_XD3_XDFFQ_M_mod0 XD3.XDFFQ.M mod0 2.4201e-17
* device instance cc_XD3_XDFFQ_M_mod1 r0 *1 0,0
Ccc_XD3_XDFFQ_M_mod1 XD3.XDFFQ.M mod1 2.4201e-17
* device instance cc_XD3_XDFFQ_M_mod2 r0 *1 0,0
Ccc_XD3_XDFFQ_M_mod2 XD3.XDFFQ.M mod2 2.4201e-17
* device instance cc_XD3_XDFFQ_M_mod3 r0 *1 0,0
Ccc_XD3_XDFFQ_M_mod3 XD3.XDFFQ.M mod3 2.4201e-17
* device instance cc_XD3_XDFFQ_M_mod4 r0 *1 0,0
Ccc_XD3_XDFFQ_M_mod4 XD3.XDFFQ.M mod4 2.4201e-17
* device instance cc_XD3_XDFFQ_M_net1 r0 *1 0,0
Ccc_XD3_XDFFQ_M_net1 XD3.XDFFQ.M net1 1.21e-17
* device instance cc_XD3_XDFFQ_MB_XD3_XDFFQ_S r0 *1 0,0
Ccc_XD3_XDFFQ_MB_XD3_XDFFQ_S XD3.XDFFQ.MB XD3.XDFFQ.S 1.8151e-17
* device instance cc_XD3_XDFFQ_MB_XD3_XDFFQ_SB r0 *1 0,0
Ccc_XD3_XDFFQ_MB_XD3_XDFFQ_SB XD3.XDFFQ.MB XD3.XDFFQ.SB 1.8151e-17
* device instance cc_XD3_XDFFQ_MB_XD3_XN2_mid1 r0 *1 0,0
Ccc_XD3_XDFFQ_MB_XD3_XN2_mid1 XD3.XDFFQ.MB XD3.XN2.mid1 1.21e-17
* device instance cc_XD3_XDFFQ_MB_XD3_XNOR_midp r0 *1 0,0
Ccc_XD3_XDFFQ_MB_XD3_XNOR_midp XD3.XDFFQ.MB XD3.XNOR.midp 1.21e-17
* device instance cc_XD3_XDFFQ_MB_XD3_dmodout r0 *1 0,0
Ccc_XD3_XDFFQ_MB_XD3_dmodout XD3.XDFFQ.MB XD3.dmodout 1.21e-17
* device instance cc_XD3_XDFFQ_MB_XD3_dq r0 *1 0,0
Ccc_XD3_XDFFQ_MB_XD3_dq XD3.XDFFQ.MB XD3.dq 1.21e-17
* device instance cc_XD3_XDFFQ_MB_XD3_nm r0 *1 0,0
Ccc_XD3_XDFFQ_MB_XD3_nm XD3.XDFFQ.MB XD3.nm 1.21e-17
* device instance cc_XD3_XDFFQ_MB_XD3_nt r0 *1 0,0
Ccc_XD3_XDFFQ_MB_XD3_nt XD3.XDFFQ.MB XD3.nt 2.4201e-17
* device instance cc_XD3_XDFFQ_MB_XD3_t1 r0 *1 0,0
Ccc_XD3_XDFFQ_MB_XD3_t1 XD3.XDFFQ.MB XD3.t1 1.21e-17
* device instance cc_XD3_XDFFQ_MB_XD4_XDFFM_CLKB r0 *1 0,0
Ccc_XD3_XDFFQ_MB_XD4_XDFFM_CLKB XD3.XDFFQ.MB XD4.XDFFM.CLKB 1.8151e-17
* device instance cc_XD3_XDFFQ_MB_XD4_XDFFM_M r0 *1 0,0
Ccc_XD3_XDFFQ_MB_XD4_XDFFM_M XD3.XDFFQ.MB XD4.XDFFM.M 2.4201e-17
* device instance cc_XD3_XDFFQ_MB_XD4_XDFFM_MB r0 *1 0,0
Ccc_XD3_XDFFQ_MB_XD4_XDFFM_MB XD3.XDFFQ.MB XD4.XDFFM.MB 1.21e-17
* device instance cc_XD3_XDFFQ_MB_XD4_XDFFM_S r0 *1 0,0
Ccc_XD3_XDFFQ_MB_XD4_XDFFM_S XD3.XDFFQ.MB XD4.XDFFM.S 1.8151e-17
* device instance cc_XD3_XDFFQ_MB_XD4_XDFFM_SB r0 *1 0,0
Ccc_XD3_XDFFQ_MB_XD4_XDFFM_SB XD3.XDFFQ.MB XD4.XDFFM.SB 1.8151e-17
* device instance cc_XD3_XDFFQ_MB_XD4_XDFFQ_CLKB r0 *1 0,0
Ccc_XD3_XDFFQ_MB_XD4_XDFFQ_CLKB XD3.XDFFQ.MB XD4.XDFFQ.CLKB 1.8151e-17
* device instance cc_XD3_XDFFQ_MB_XD4_XDFFQ_M r0 *1 0,0
Ccc_XD3_XDFFQ_MB_XD4_XDFFQ_M XD3.XDFFQ.MB XD4.XDFFQ.M 2.4201e-17
* device instance cc_XD3_XDFFQ_MB_XD4_XDFFQ_MB r0 *1 0,0
Ccc_XD3_XDFFQ_MB_XD4_XDFFQ_MB XD3.XDFFQ.MB XD4.XDFFQ.MB 1.21e-17
* device instance cc_XD3_XDFFQ_MB_XD4_XDFFQ_S r0 *1 0,0
Ccc_XD3_XDFFQ_MB_XD4_XDFFQ_S XD3.XDFFQ.MB XD4.XDFFQ.S 1.8151e-17
* device instance cc_XD3_XDFFQ_MB_XD4_XDFFQ_SB r0 *1 0,0
Ccc_XD3_XDFFQ_MB_XD4_XDFFQ_SB XD3.XDFFQ.MB XD4.XDFFQ.SB 1.8151e-17
* device instance cc_XD3_XDFFQ_MB_XD4_XN2_mid1 r0 *1 0,0
Ccc_XD3_XDFFQ_MB_XD4_XN2_mid1 XD3.XDFFQ.MB XD4.XN2.mid1 1.21e-17
* device instance cc_XD3_XDFFQ_MB_XD4_XN3_mid1 r0 *1 0,0
Ccc_XD3_XDFFQ_MB_XD4_XN3_mid1 XD3.XDFFQ.MB XD4.XN3.mid1 1.21e-17
* device instance cc_XD3_XDFFQ_MB_XD4_XN3_mid2 r0 *1 0,0
Ccc_XD3_XDFFQ_MB_XD4_XN3_mid2 XD3.XDFFQ.MB XD4.XN3.mid2 1.21e-17
* device instance cc_XD3_XDFFQ_MB_XD4_dmodout r0 *1 0,0
Ccc_XD3_XDFFQ_MB_XD4_dmodout XD3.XDFFQ.MB XD4.dmodout 1.21e-17
* device instance cc_XD3_XDFFQ_MB_XD4_dq r0 *1 0,0
Ccc_XD3_XDFFQ_MB_XD4_dq XD3.XDFFQ.MB XD4.dq 1.8151e-17
* device instance cc_XD3_XDFFQ_MB_XD4_nm r0 *1 0,0
Ccc_XD3_XDFFQ_MB_XD4_nm XD3.XDFFQ.MB XD4.nm 1.21e-17
* device instance cc_XD3_XDFFQ_MB_XD4_nt r0 *1 0,0
Ccc_XD3_XDFFQ_MB_XD4_nt XD3.XDFFQ.MB XD4.nt 1.21e-17
* device instance cc_XD3_XDFFQ_MB_XD4_t1 r0 *1 0,0
Ccc_XD3_XDFFQ_MB_XD4_t1 XD3.XDFFQ.MB XD4.t1 1.21e-17
* device instance cc_XD3_XDFFQ_MB_XD5_XDFFM_CLKB r0 *1 0,0
Ccc_XD3_XDFFQ_MB_XD5_XDFFM_CLKB XD3.XDFFQ.MB XD5.XDFFM.CLKB 1.8151e-17
* device instance cc_XD3_XDFFQ_MB_XD5_XDFFM_M r0 *1 0,0
Ccc_XD3_XDFFQ_MB_XD5_XDFFM_M XD3.XDFFQ.MB XD5.XDFFM.M 2.4201e-17
* device instance cc_XD3_XDFFQ_MB_XD5_XDFFM_MB r0 *1 0,0
Ccc_XD3_XDFFQ_MB_XD5_XDFFM_MB XD3.XDFFQ.MB XD5.XDFFM.MB 1.21e-17
* device instance cc_XD3_XDFFQ_MB_XD5_XDFFM_S r0 *1 0,0
Ccc_XD3_XDFFQ_MB_XD5_XDFFM_S XD3.XDFFQ.MB XD5.XDFFM.S 1.8151e-17
* device instance cc_XD3_XDFFQ_MB_XD5_XDFFM_SB r0 *1 0,0
Ccc_XD3_XDFFQ_MB_XD5_XDFFM_SB XD3.XDFFQ.MB XD5.XDFFM.SB 1.8151e-17
* device instance cc_XD3_XDFFQ_MB_XD5_XDFFQ_CLKB r0 *1 0,0
Ccc_XD3_XDFFQ_MB_XD5_XDFFQ_CLKB XD3.XDFFQ.MB XD5.XDFFQ.CLKB 1.8151e-17
* device instance cc_XD3_XDFFQ_MB_XD5_XDFFQ_M r0 *1 0,0
Ccc_XD3_XDFFQ_MB_XD5_XDFFQ_M XD3.XDFFQ.MB XD5.XDFFQ.M 2.4201e-17
* device instance cc_XD3_XDFFQ_MB_XD5_XDFFQ_MB r0 *1 0,0
Ccc_XD3_XDFFQ_MB_XD5_XDFFQ_MB XD3.XDFFQ.MB XD5.XDFFQ.MB 1.21e-17
* device instance cc_XD3_XDFFQ_MB_XD5_XDFFQ_S r0 *1 0,0
Ccc_XD3_XDFFQ_MB_XD5_XDFFQ_S XD3.XDFFQ.MB XD5.XDFFQ.S 1.8151e-17
* device instance cc_XD3_XDFFQ_MB_XD5_XDFFQ_SB r0 *1 0,0
Ccc_XD3_XDFFQ_MB_XD5_XDFFQ_SB XD3.XDFFQ.MB XD5.XDFFQ.SB 1.8151e-17
* device instance cc_XD3_XDFFQ_MB_XD5_XN2_mid1 r0 *1 0,0
Ccc_XD3_XDFFQ_MB_XD5_XN2_mid1 XD3.XDFFQ.MB XD5.XN2.mid1 1.21e-17
* device instance cc_XD3_XDFFQ_MB_XD5_XN3_mid1 r0 *1 0,0
Ccc_XD3_XDFFQ_MB_XD5_XN3_mid1 XD3.XDFFQ.MB XD5.XN3.mid1 1.21e-17
* device instance cc_XD3_XDFFQ_MB_XD5_XN3_mid2 r0 *1 0,0
Ccc_XD3_XDFFQ_MB_XD5_XN3_mid2 XD3.XDFFQ.MB XD5.XN3.mid2 1.21e-17
* device instance cc_XD3_XDFFQ_MB_XD5_dmodout r0 *1 0,0
Ccc_XD3_XDFFQ_MB_XD5_dmodout XD3.XDFFQ.MB XD5.dmodout 1.21e-17
* device instance cc_XD3_XDFFQ_MB_XD5_dq r0 *1 0,0
Ccc_XD3_XDFFQ_MB_XD5_dq XD3.XDFFQ.MB XD5.dq 1.8151e-17
* device instance cc_XD3_XDFFQ_MB_XD5_nm r0 *1 0,0
Ccc_XD3_XDFFQ_MB_XD5_nm XD3.XDFFQ.MB XD5.nm 1.21e-17
* device instance cc_XD3_XDFFQ_MB_XD5_nt r0 *1 0,0
Ccc_XD3_XDFFQ_MB_XD5_nt XD3.XDFFQ.MB XD5.nt 1.21e-17
* device instance cc_XD3_XDFFQ_MB_XD5_t1 r0 *1 0,0
Ccc_XD3_XDFFQ_MB_XD5_t1 XD3.XDFFQ.MB XD5.t1 1.21e-17
* device instance cc_XD3_XDFFQ_MB_XFRT_CLKB r0 *1 0,0
Ccc_XD3_XDFFQ_MB_XFRT_CLKB XD3.XDFFQ.MB XFRT.CLKB 1.8151e-17
* device instance cc_XD3_XDFFQ_MB_XFRT_M r0 *1 0,0
Ccc_XD3_XDFFQ_MB_XFRT_M XD3.XDFFQ.MB XFRT.M 2.4201e-17
* device instance cc_XD3_XDFFQ_MB_XFRT_MB r0 *1 0,0
Ccc_XD3_XDFFQ_MB_XFRT_MB XD3.XDFFQ.MB XFRT.MB 1.21e-17
* device instance cc_XD3_XDFFQ_MB_XFRT_S r0 *1 0,0
Ccc_XD3_XDFFQ_MB_XFRT_S XD3.XDFFQ.MB XFRT.S 1.8151e-17
* device instance cc_XD3_XDFFQ_MB_XFRT_SB r0 *1 0,0
Ccc_XD3_XDFFQ_MB_XFRT_SB XD3.XDFFQ.MB XFRT.SB 1.8151e-17
* device instance cc_XD3_XDFFQ_MB_ck1 r0 *1 0,0
Ccc_XD3_XDFFQ_MB_ck1 XD3.XDFFQ.MB ck1 5.4452e-17
* device instance cc_XD3_XDFFQ_MB_ck2 r0 *1 0,0
Ccc_XD3_XDFFQ_MB_ck2 XD3.XDFFQ.MB ck2 5.4452e-17
* device instance cc_XD3_XDFFQ_MB_ck3 r0 *1 0,0
Ccc_XD3_XDFFQ_MB_ck3 XD3.XDFFQ.MB ck3 6.0502e-17
* device instance cc_XD3_XDFFQ_MB_ck4 r0 *1 0,0
Ccc_XD3_XDFFQ_MB_ck4 XD3.XDFFQ.MB ck4 5.4452e-17
* device instance cc_XD3_XDFFQ_MB_ck5 r0 *1 0,0
Ccc_XD3_XDFFQ_MB_ck5 XD3.XDFFQ.MB ck5 5.4452e-17
* device instance cc_XD3_XDFFQ_MB_mod0 r0 *1 0,0
Ccc_XD3_XDFFQ_MB_mod0 XD3.XDFFQ.MB mod0 2.4201e-17
* device instance cc_XD3_XDFFQ_MB_mod1 r0 *1 0,0
Ccc_XD3_XDFFQ_MB_mod1 XD3.XDFFQ.MB mod1 2.4201e-17
* device instance cc_XD3_XDFFQ_MB_mod2 r0 *1 0,0
Ccc_XD3_XDFFQ_MB_mod2 XD3.XDFFQ.MB mod2 2.4201e-17
* device instance cc_XD3_XDFFQ_MB_mod3 r0 *1 0,0
Ccc_XD3_XDFFQ_MB_mod3 XD3.XDFFQ.MB mod3 2.4201e-17
* device instance cc_XD3_XDFFQ_MB_mod4 r0 *1 0,0
Ccc_XD3_XDFFQ_MB_mod4 XD3.XDFFQ.MB mod4 2.4201e-17
* device instance cc_XD3_XDFFQ_MB_net1 r0 *1 0,0
Ccc_XD3_XDFFQ_MB_net1 XD3.XDFFQ.MB net1 1.21e-17
* device instance cc_XD3_XDFFQ_S_XD3_XDFFQ_SB r0 *1 0,0
Ccc_XD3_XDFFQ_S_XD3_XDFFQ_SB XD3.XDFFQ.S XD3.XDFFQ.SB 4.0738e-17
* device instance cc_XD3_XDFFQ_S_XD3_XN2_mid1 r0 *1 0,0
Ccc_XD3_XDFFQ_S_XD3_XN2_mid1 XD3.XDFFQ.S XD3.XN2.mid1 1.21e-17
* device instance cc_XD3_XDFFQ_S_XD3_XNOR_midp r0 *1 0,0
Ccc_XD3_XDFFQ_S_XD3_XNOR_midp XD3.XDFFQ.S XD3.XNOR.midp 1.21e-17
* device instance cc_XD3_XDFFQ_S_XD3_dmodout r0 *1 0,0
Ccc_XD3_XDFFQ_S_XD3_dmodout XD3.XDFFQ.S XD3.dmodout 1.21e-17
* device instance cc_XD3_XDFFQ_S_XD3_dq r0 *1 0,0
Ccc_XD3_XDFFQ_S_XD3_dq XD3.XDFFQ.S XD3.dq 1.21e-17
* device instance cc_XD3_XDFFQ_S_XD3_nm r0 *1 0,0
Ccc_XD3_XDFFQ_S_XD3_nm XD3.XDFFQ.S XD3.nm 1.21e-17
* device instance cc_XD3_XDFFQ_S_XD3_nt r0 *1 0,0
Ccc_XD3_XDFFQ_S_XD3_nt XD3.XDFFQ.S XD3.nt 2.4201e-17
* device instance cc_XD3_XDFFQ_S_XD3_t1 r0 *1 0,0
Ccc_XD3_XDFFQ_S_XD3_t1 XD3.XDFFQ.S XD3.t1 1.21e-17
* device instance cc_XD3_XDFFQ_S_XD4_XDFFM_CLKB r0 *1 0,0
Ccc_XD3_XDFFQ_S_XD4_XDFFM_CLKB XD3.XDFFQ.S XD4.XDFFM.CLKB 1.8151e-17
* device instance cc_XD3_XDFFQ_S_XD4_XDFFM_M r0 *1 0,0
Ccc_XD3_XDFFQ_S_XD4_XDFFM_M XD3.XDFFQ.S XD4.XDFFM.M 2.4201e-17
* device instance cc_XD3_XDFFQ_S_XD4_XDFFM_MB r0 *1 0,0
Ccc_XD3_XDFFQ_S_XD4_XDFFM_MB XD3.XDFFQ.S XD4.XDFFM.MB 1.21e-17
* device instance cc_XD3_XDFFQ_S_XD4_XDFFM_S r0 *1 0,0
Ccc_XD3_XDFFQ_S_XD4_XDFFM_S XD3.XDFFQ.S XD4.XDFFM.S 1.8151e-17
* device instance cc_XD3_XDFFQ_S_XD4_XDFFM_SB r0 *1 0,0
Ccc_XD3_XDFFQ_S_XD4_XDFFM_SB XD3.XDFFQ.S XD4.XDFFM.SB 1.8151e-17
* device instance cc_XD3_XDFFQ_S_XD4_XDFFQ_CLKB r0 *1 0,0
Ccc_XD3_XDFFQ_S_XD4_XDFFQ_CLKB XD3.XDFFQ.S XD4.XDFFQ.CLKB 1.8151e-17
* device instance cc_XD3_XDFFQ_S_XD4_XDFFQ_M r0 *1 0,0
Ccc_XD3_XDFFQ_S_XD4_XDFFQ_M XD3.XDFFQ.S XD4.XDFFQ.M 2.4201e-17
* device instance cc_XD3_XDFFQ_S_XD4_XDFFQ_MB r0 *1 0,0
Ccc_XD3_XDFFQ_S_XD4_XDFFQ_MB XD3.XDFFQ.S XD4.XDFFQ.MB 1.21e-17
* device instance cc_XD3_XDFFQ_S_XD4_XDFFQ_S r0 *1 0,0
Ccc_XD3_XDFFQ_S_XD4_XDFFQ_S XD3.XDFFQ.S XD4.XDFFQ.S 1.8151e-17
* device instance cc_XD3_XDFFQ_S_XD4_XDFFQ_SB r0 *1 0,0
Ccc_XD3_XDFFQ_S_XD4_XDFFQ_SB XD3.XDFFQ.S XD4.XDFFQ.SB 1.8151e-17
* device instance cc_XD3_XDFFQ_S_XD4_XN2_mid1 r0 *1 0,0
Ccc_XD3_XDFFQ_S_XD4_XN2_mid1 XD3.XDFFQ.S XD4.XN2.mid1 1.21e-17
* device instance cc_XD3_XDFFQ_S_XD4_XN3_mid1 r0 *1 0,0
Ccc_XD3_XDFFQ_S_XD4_XN3_mid1 XD3.XDFFQ.S XD4.XN3.mid1 1.21e-17
* device instance cc_XD3_XDFFQ_S_XD4_XN3_mid2 r0 *1 0,0
Ccc_XD3_XDFFQ_S_XD4_XN3_mid2 XD3.XDFFQ.S XD4.XN3.mid2 1.21e-17
* device instance cc_XD3_XDFFQ_S_XD4_dmodout r0 *1 0,0
Ccc_XD3_XDFFQ_S_XD4_dmodout XD3.XDFFQ.S XD4.dmodout 1.21e-17
* device instance cc_XD3_XDFFQ_S_XD4_dq r0 *1 0,0
Ccc_XD3_XDFFQ_S_XD4_dq XD3.XDFFQ.S XD4.dq 1.8151e-17
* device instance cc_XD3_XDFFQ_S_XD4_nm r0 *1 0,0
Ccc_XD3_XDFFQ_S_XD4_nm XD3.XDFFQ.S XD4.nm 1.21e-17
* device instance cc_XD3_XDFFQ_S_XD4_nt r0 *1 0,0
Ccc_XD3_XDFFQ_S_XD4_nt XD3.XDFFQ.S XD4.nt 1.21e-17
* device instance cc_XD3_XDFFQ_S_XD4_t1 r0 *1 0,0
Ccc_XD3_XDFFQ_S_XD4_t1 XD3.XDFFQ.S XD4.t1 1.21e-17
* device instance cc_XD3_XDFFQ_S_XD5_XDFFM_CLKB r0 *1 0,0
Ccc_XD3_XDFFQ_S_XD5_XDFFM_CLKB XD3.XDFFQ.S XD5.XDFFM.CLKB 1.8151e-17
* device instance cc_XD3_XDFFQ_S_XD5_XDFFM_M r0 *1 0,0
Ccc_XD3_XDFFQ_S_XD5_XDFFM_M XD3.XDFFQ.S XD5.XDFFM.M 2.4201e-17
* device instance cc_XD3_XDFFQ_S_XD5_XDFFM_MB r0 *1 0,0
Ccc_XD3_XDFFQ_S_XD5_XDFFM_MB XD3.XDFFQ.S XD5.XDFFM.MB 1.21e-17
* device instance cc_XD3_XDFFQ_S_XD5_XDFFM_S r0 *1 0,0
Ccc_XD3_XDFFQ_S_XD5_XDFFM_S XD3.XDFFQ.S XD5.XDFFM.S 1.8151e-17
* device instance cc_XD3_XDFFQ_S_XD5_XDFFM_SB r0 *1 0,0
Ccc_XD3_XDFFQ_S_XD5_XDFFM_SB XD3.XDFFQ.S XD5.XDFFM.SB 1.8151e-17
* device instance cc_XD3_XDFFQ_S_XD5_XDFFQ_CLKB r0 *1 0,0
Ccc_XD3_XDFFQ_S_XD5_XDFFQ_CLKB XD3.XDFFQ.S XD5.XDFFQ.CLKB 1.8151e-17
* device instance cc_XD3_XDFFQ_S_XD5_XDFFQ_M r0 *1 0,0
Ccc_XD3_XDFFQ_S_XD5_XDFFQ_M XD3.XDFFQ.S XD5.XDFFQ.M 2.4201e-17
* device instance cc_XD3_XDFFQ_S_XD5_XDFFQ_MB r0 *1 0,0
Ccc_XD3_XDFFQ_S_XD5_XDFFQ_MB XD3.XDFFQ.S XD5.XDFFQ.MB 1.21e-17
* device instance cc_XD3_XDFFQ_S_XD5_XDFFQ_S r0 *1 0,0
Ccc_XD3_XDFFQ_S_XD5_XDFFQ_S XD3.XDFFQ.S XD5.XDFFQ.S 1.8151e-17
* device instance cc_XD3_XDFFQ_S_XD5_XDFFQ_SB r0 *1 0,0
Ccc_XD3_XDFFQ_S_XD5_XDFFQ_SB XD3.XDFFQ.S XD5.XDFFQ.SB 1.8151e-17
* device instance cc_XD3_XDFFQ_S_XD5_XN2_mid1 r0 *1 0,0
Ccc_XD3_XDFFQ_S_XD5_XN2_mid1 XD3.XDFFQ.S XD5.XN2.mid1 1.21e-17
* device instance cc_XD3_XDFFQ_S_XD5_XN3_mid1 r0 *1 0,0
Ccc_XD3_XDFFQ_S_XD5_XN3_mid1 XD3.XDFFQ.S XD5.XN3.mid1 1.21e-17
* device instance cc_XD3_XDFFQ_S_XD5_XN3_mid2 r0 *1 0,0
Ccc_XD3_XDFFQ_S_XD5_XN3_mid2 XD3.XDFFQ.S XD5.XN3.mid2 1.21e-17
* device instance cc_XD3_XDFFQ_S_XD5_dmodout r0 *1 0,0
Ccc_XD3_XDFFQ_S_XD5_dmodout XD3.XDFFQ.S XD5.dmodout 1.21e-17
* device instance cc_XD3_XDFFQ_S_XD5_dq r0 *1 0,0
Ccc_XD3_XDFFQ_S_XD5_dq XD3.XDFFQ.S XD5.dq 1.8151e-17
* device instance cc_XD3_XDFFQ_S_XD5_nm r0 *1 0,0
Ccc_XD3_XDFFQ_S_XD5_nm XD3.XDFFQ.S XD5.nm 1.21e-17
* device instance cc_XD3_XDFFQ_S_XD5_nt r0 *1 0,0
Ccc_XD3_XDFFQ_S_XD5_nt XD3.XDFFQ.S XD5.nt 1.21e-17
* device instance cc_XD3_XDFFQ_S_XD5_t1 r0 *1 0,0
Ccc_XD3_XDFFQ_S_XD5_t1 XD3.XDFFQ.S XD5.t1 1.21e-17
* device instance cc_XD3_XDFFQ_S_XFRT_CLKB r0 *1 0,0
Ccc_XD3_XDFFQ_S_XFRT_CLKB XD3.XDFFQ.S XFRT.CLKB 1.8151e-17
* device instance cc_XD3_XDFFQ_S_XFRT_M r0 *1 0,0
Ccc_XD3_XDFFQ_S_XFRT_M XD3.XDFFQ.S XFRT.M 2.4201e-17
* device instance cc_XD3_XDFFQ_S_XFRT_MB r0 *1 0,0
Ccc_XD3_XDFFQ_S_XFRT_MB XD3.XDFFQ.S XFRT.MB 1.21e-17
* device instance cc_XD3_XDFFQ_S_XFRT_S r0 *1 0,0
Ccc_XD3_XDFFQ_S_XFRT_S XD3.XDFFQ.S XFRT.S 1.8151e-17
* device instance cc_XD3_XDFFQ_S_XFRT_SB r0 *1 0,0
Ccc_XD3_XDFFQ_S_XFRT_SB XD3.XDFFQ.S XFRT.SB 1.8151e-17
* device instance cc_XD3_XDFFQ_S_ck1 r0 *1 0,0
Ccc_XD3_XDFFQ_S_ck1 XD3.XDFFQ.S ck1 5.4452e-17
* device instance cc_XD3_XDFFQ_S_ck2 r0 *1 0,0
Ccc_XD3_XDFFQ_S_ck2 XD3.XDFFQ.S ck2 5.4452e-17
* device instance cc_XD3_XDFFQ_S_ck3 r0 *1 0,0
Ccc_XD3_XDFFQ_S_ck3 XD3.XDFFQ.S ck3 5.4452e-17
* device instance cc_XD3_XDFFQ_S_ck4 r0 *1 0,0
Ccc_XD3_XDFFQ_S_ck4 XD3.XDFFQ.S ck4 5.4452e-17
* device instance cc_XD3_XDFFQ_S_ck5 r0 *1 0,0
Ccc_XD3_XDFFQ_S_ck5 XD3.XDFFQ.S ck5 5.4452e-17
* device instance cc_XD3_XDFFQ_S_mod0 r0 *1 0,0
Ccc_XD3_XDFFQ_S_mod0 XD3.XDFFQ.S mod0 2.4201e-17
* device instance cc_XD3_XDFFQ_S_mod1 r0 *1 0,0
Ccc_XD3_XDFFQ_S_mod1 XD3.XDFFQ.S mod1 2.4201e-17
* device instance cc_XD3_XDFFQ_S_mod2 r0 *1 0,0
Ccc_XD3_XDFFQ_S_mod2 XD3.XDFFQ.S mod2 2.4201e-17
* device instance cc_XD3_XDFFQ_S_mod3 r0 *1 0,0
Ccc_XD3_XDFFQ_S_mod3 XD3.XDFFQ.S mod3 2.4201e-17
* device instance cc_XD3_XDFFQ_S_mod4 r0 *1 0,0
Ccc_XD3_XDFFQ_S_mod4 XD3.XDFFQ.S mod4 2.4201e-17
* device instance cc_XD3_XDFFQ_S_net1 r0 *1 0,0
Ccc_XD3_XDFFQ_S_net1 XD3.XDFFQ.S net1 1.21e-17
* device instance cc_XD3_XDFFQ_SB_XD3_XN2_mid1 r0 *1 0,0
Ccc_XD3_XDFFQ_SB_XD3_XN2_mid1 XD3.XDFFQ.SB XD3.XN2.mid1 1.21e-17
* device instance cc_XD3_XDFFQ_SB_XD3_XNOR_midp r0 *1 0,0
Ccc_XD3_XDFFQ_SB_XD3_XNOR_midp XD3.XDFFQ.SB XD3.XNOR.midp 1.21e-17
* device instance cc_XD3_XDFFQ_SB_XD3_dmodout r0 *1 0,0
Ccc_XD3_XDFFQ_SB_XD3_dmodout XD3.XDFFQ.SB XD3.dmodout 1.21e-17
* device instance cc_XD3_XDFFQ_SB_XD3_dq r0 *1 0,0
Ccc_XD3_XDFFQ_SB_XD3_dq XD3.XDFFQ.SB XD3.dq 1.21e-17
* device instance cc_XD3_XDFFQ_SB_XD3_nm r0 *1 0,0
Ccc_XD3_XDFFQ_SB_XD3_nm XD3.XDFFQ.SB XD3.nm 1.21e-17
* device instance cc_XD3_XDFFQ_SB_XD3_nt r0 *1 0,0
Ccc_XD3_XDFFQ_SB_XD3_nt XD3.XDFFQ.SB XD3.nt 2.4201e-17
* device instance cc_XD3_XDFFQ_SB_XD3_t1 r0 *1 0,0
Ccc_XD3_XDFFQ_SB_XD3_t1 XD3.XDFFQ.SB XD3.t1 1.21e-17
* device instance cc_XD3_XDFFQ_SB_XD4_XDFFM_CLKB r0 *1 0,0
Ccc_XD3_XDFFQ_SB_XD4_XDFFM_CLKB XD3.XDFFQ.SB XD4.XDFFM.CLKB 1.8151e-17
* device instance cc_XD3_XDFFQ_SB_XD4_XDFFM_M r0 *1 0,0
Ccc_XD3_XDFFQ_SB_XD4_XDFFM_M XD3.XDFFQ.SB XD4.XDFFM.M 2.4201e-17
* device instance cc_XD3_XDFFQ_SB_XD4_XDFFM_MB r0 *1 0,0
Ccc_XD3_XDFFQ_SB_XD4_XDFFM_MB XD3.XDFFQ.SB XD4.XDFFM.MB 1.21e-17
* device instance cc_XD3_XDFFQ_SB_XD4_XDFFM_S r0 *1 0,0
Ccc_XD3_XDFFQ_SB_XD4_XDFFM_S XD3.XDFFQ.SB XD4.XDFFM.S 1.8151e-17
* device instance cc_XD3_XDFFQ_SB_XD4_XDFFM_SB r0 *1 0,0
Ccc_XD3_XDFFQ_SB_XD4_XDFFM_SB XD3.XDFFQ.SB XD4.XDFFM.SB 1.8151e-17
* device instance cc_XD3_XDFFQ_SB_XD4_XDFFQ_CLKB r0 *1 0,0
Ccc_XD3_XDFFQ_SB_XD4_XDFFQ_CLKB XD3.XDFFQ.SB XD4.XDFFQ.CLKB 1.8151e-17
* device instance cc_XD3_XDFFQ_SB_XD4_XDFFQ_M r0 *1 0,0
Ccc_XD3_XDFFQ_SB_XD4_XDFFQ_M XD3.XDFFQ.SB XD4.XDFFQ.M 2.4201e-17
* device instance cc_XD3_XDFFQ_SB_XD4_XDFFQ_MB r0 *1 0,0
Ccc_XD3_XDFFQ_SB_XD4_XDFFQ_MB XD3.XDFFQ.SB XD4.XDFFQ.MB 1.21e-17
* device instance cc_XD3_XDFFQ_SB_XD4_XDFFQ_S r0 *1 0,0
Ccc_XD3_XDFFQ_SB_XD4_XDFFQ_S XD3.XDFFQ.SB XD4.XDFFQ.S 1.8151e-17
* device instance cc_XD3_XDFFQ_SB_XD4_XDFFQ_SB r0 *1 0,0
Ccc_XD3_XDFFQ_SB_XD4_XDFFQ_SB XD3.XDFFQ.SB XD4.XDFFQ.SB 1.8151e-17
* device instance cc_XD3_XDFFQ_SB_XD4_XN2_mid1 r0 *1 0,0
Ccc_XD3_XDFFQ_SB_XD4_XN2_mid1 XD3.XDFFQ.SB XD4.XN2.mid1 1.21e-17
* device instance cc_XD3_XDFFQ_SB_XD4_XN3_mid1 r0 *1 0,0
Ccc_XD3_XDFFQ_SB_XD4_XN3_mid1 XD3.XDFFQ.SB XD4.XN3.mid1 1.21e-17
* device instance cc_XD3_XDFFQ_SB_XD4_XN3_mid2 r0 *1 0,0
Ccc_XD3_XDFFQ_SB_XD4_XN3_mid2 XD3.XDFFQ.SB XD4.XN3.mid2 1.21e-17
* device instance cc_XD3_XDFFQ_SB_XD4_dmodout r0 *1 0,0
Ccc_XD3_XDFFQ_SB_XD4_dmodout XD3.XDFFQ.SB XD4.dmodout 1.21e-17
* device instance cc_XD3_XDFFQ_SB_XD4_dq r0 *1 0,0
Ccc_XD3_XDFFQ_SB_XD4_dq XD3.XDFFQ.SB XD4.dq 1.8151e-17
* device instance cc_XD3_XDFFQ_SB_XD4_nm r0 *1 0,0
Ccc_XD3_XDFFQ_SB_XD4_nm XD3.XDFFQ.SB XD4.nm 1.21e-17
* device instance cc_XD3_XDFFQ_SB_XD4_nt r0 *1 0,0
Ccc_XD3_XDFFQ_SB_XD4_nt XD3.XDFFQ.SB XD4.nt 1.21e-17
* device instance cc_XD3_XDFFQ_SB_XD4_t1 r0 *1 0,0
Ccc_XD3_XDFFQ_SB_XD4_t1 XD3.XDFFQ.SB XD4.t1 1.21e-17
* device instance cc_XD3_XDFFQ_SB_XD5_XDFFM_CLKB r0 *1 0,0
Ccc_XD3_XDFFQ_SB_XD5_XDFFM_CLKB XD3.XDFFQ.SB XD5.XDFFM.CLKB 1.8151e-17
* device instance cc_XD3_XDFFQ_SB_XD5_XDFFM_M r0 *1 0,0
Ccc_XD3_XDFFQ_SB_XD5_XDFFM_M XD3.XDFFQ.SB XD5.XDFFM.M 2.4201e-17
* device instance cc_XD3_XDFFQ_SB_XD5_XDFFM_MB r0 *1 0,0
Ccc_XD3_XDFFQ_SB_XD5_XDFFM_MB XD3.XDFFQ.SB XD5.XDFFM.MB 1.21e-17
* device instance cc_XD3_XDFFQ_SB_XD5_XDFFM_S r0 *1 0,0
Ccc_XD3_XDFFQ_SB_XD5_XDFFM_S XD3.XDFFQ.SB XD5.XDFFM.S 1.8151e-17
* device instance cc_XD3_XDFFQ_SB_XD5_XDFFM_SB r0 *1 0,0
Ccc_XD3_XDFFQ_SB_XD5_XDFFM_SB XD3.XDFFQ.SB XD5.XDFFM.SB 1.8151e-17
* device instance cc_XD3_XDFFQ_SB_XD5_XDFFQ_CLKB r0 *1 0,0
Ccc_XD3_XDFFQ_SB_XD5_XDFFQ_CLKB XD3.XDFFQ.SB XD5.XDFFQ.CLKB 1.8151e-17
* device instance cc_XD3_XDFFQ_SB_XD5_XDFFQ_M r0 *1 0,0
Ccc_XD3_XDFFQ_SB_XD5_XDFFQ_M XD3.XDFFQ.SB XD5.XDFFQ.M 2.4201e-17
* device instance cc_XD3_XDFFQ_SB_XD5_XDFFQ_MB r0 *1 0,0
Ccc_XD3_XDFFQ_SB_XD5_XDFFQ_MB XD3.XDFFQ.SB XD5.XDFFQ.MB 1.21e-17
* device instance cc_XD3_XDFFQ_SB_XD5_XDFFQ_S r0 *1 0,0
Ccc_XD3_XDFFQ_SB_XD5_XDFFQ_S XD3.XDFFQ.SB XD5.XDFFQ.S 1.8151e-17
* device instance cc_XD3_XDFFQ_SB_XD5_XDFFQ_SB r0 *1 0,0
Ccc_XD3_XDFFQ_SB_XD5_XDFFQ_SB XD3.XDFFQ.SB XD5.XDFFQ.SB 1.8151e-17
* device instance cc_XD3_XDFFQ_SB_XD5_XN2_mid1 r0 *1 0,0
Ccc_XD3_XDFFQ_SB_XD5_XN2_mid1 XD3.XDFFQ.SB XD5.XN2.mid1 1.21e-17
* device instance cc_XD3_XDFFQ_SB_XD5_XN3_mid1 r0 *1 0,0
Ccc_XD3_XDFFQ_SB_XD5_XN3_mid1 XD3.XDFFQ.SB XD5.XN3.mid1 1.21e-17
* device instance cc_XD3_XDFFQ_SB_XD5_XN3_mid2 r0 *1 0,0
Ccc_XD3_XDFFQ_SB_XD5_XN3_mid2 XD3.XDFFQ.SB XD5.XN3.mid2 1.21e-17
* device instance cc_XD3_XDFFQ_SB_XD5_dmodout r0 *1 0,0
Ccc_XD3_XDFFQ_SB_XD5_dmodout XD3.XDFFQ.SB XD5.dmodout 1.21e-17
* device instance cc_XD3_XDFFQ_SB_XD5_dq r0 *1 0,0
Ccc_XD3_XDFFQ_SB_XD5_dq XD3.XDFFQ.SB XD5.dq 1.8151e-17
* device instance cc_XD3_XDFFQ_SB_XD5_nm r0 *1 0,0
Ccc_XD3_XDFFQ_SB_XD5_nm XD3.XDFFQ.SB XD5.nm 1.21e-17
* device instance cc_XD3_XDFFQ_SB_XD5_nt r0 *1 0,0
Ccc_XD3_XDFFQ_SB_XD5_nt XD3.XDFFQ.SB XD5.nt 1.21e-17
* device instance cc_XD3_XDFFQ_SB_XD5_t1 r0 *1 0,0
Ccc_XD3_XDFFQ_SB_XD5_t1 XD3.XDFFQ.SB XD5.t1 1.21e-17
* device instance cc_XD3_XDFFQ_SB_XFRT_CLKB r0 *1 0,0
Ccc_XD3_XDFFQ_SB_XFRT_CLKB XD3.XDFFQ.SB XFRT.CLKB 1.8151e-17
* device instance cc_XD3_XDFFQ_SB_XFRT_M r0 *1 0,0
Ccc_XD3_XDFFQ_SB_XFRT_M XD3.XDFFQ.SB XFRT.M 2.4201e-17
* device instance cc_XD3_XDFFQ_SB_XFRT_MB r0 *1 0,0
Ccc_XD3_XDFFQ_SB_XFRT_MB XD3.XDFFQ.SB XFRT.MB 1.21e-17
* device instance cc_XD3_XDFFQ_SB_XFRT_S r0 *1 0,0
Ccc_XD3_XDFFQ_SB_XFRT_S XD3.XDFFQ.SB XFRT.S 1.8151e-17
* device instance cc_XD3_XDFFQ_SB_XFRT_SB r0 *1 0,0
Ccc_XD3_XDFFQ_SB_XFRT_SB XD3.XDFFQ.SB XFRT.SB 1.8151e-17
* device instance cc_XD3_XDFFQ_SB_ck1 r0 *1 0,0
Ccc_XD3_XDFFQ_SB_ck1 XD3.XDFFQ.SB ck1 5.4452e-17
* device instance cc_XD3_XDFFQ_SB_ck2 r0 *1 0,0
Ccc_XD3_XDFFQ_SB_ck2 XD3.XDFFQ.SB ck2 5.4452e-17
* device instance cc_XD3_XDFFQ_SB_ck3 r0 *1 0,0
Ccc_XD3_XDFFQ_SB_ck3 XD3.XDFFQ.SB ck3 5.4452e-17
* device instance cc_XD3_XDFFQ_SB_ck4 r0 *1 0,0
Ccc_XD3_XDFFQ_SB_ck4 XD3.XDFFQ.SB ck4 5.4452e-17
* device instance cc_XD3_XDFFQ_SB_ck5 r0 *1 0,0
Ccc_XD3_XDFFQ_SB_ck5 XD3.XDFFQ.SB ck5 5.4452e-17
* device instance cc_XD3_XDFFQ_SB_mod0 r0 *1 0,0
Ccc_XD3_XDFFQ_SB_mod0 XD3.XDFFQ.SB mod0 2.4201e-17
* device instance cc_XD3_XDFFQ_SB_mod1 r0 *1 0,0
Ccc_XD3_XDFFQ_SB_mod1 XD3.XDFFQ.SB mod1 2.4201e-17
* device instance cc_XD3_XDFFQ_SB_mod2 r0 *1 0,0
Ccc_XD3_XDFFQ_SB_mod2 XD3.XDFFQ.SB mod2 2.4201e-17
* device instance cc_XD3_XDFFQ_SB_mod3 r0 *1 0,0
Ccc_XD3_XDFFQ_SB_mod3 XD3.XDFFQ.SB mod3 2.4201e-17
* device instance cc_XD3_XDFFQ_SB_mod4 r0 *1 0,0
Ccc_XD3_XDFFQ_SB_mod4 XD3.XDFFQ.SB mod4 2.4201e-17
* device instance cc_XD3_XDFFQ_SB_net1 r0 *1 0,0
Ccc_XD3_XDFFQ_SB_net1 XD3.XDFFQ.SB net1 1.21e-17
* device instance cc_XD3_XN2_mid1_XD3_nm r0 *1 0,0
Ccc_XD3_XN2_mid1_XD3_nm XD3.XN2.mid1 XD3.nm 1.1294e-17
* device instance cc_XD3_XN2_mid1_ck4 r0 *1 0,0
Ccc_XD3_XN2_mid1_ck4 XD3.XN2.mid1 ck4 6.05e-18
* device instance cc_XD3_XN3_mid1_XD3_XN3_mid2 r0 *1 0,0
Ccc_XD3_XN3_mid1_XD3_XN3_mid2 XD3.XN3.mid1 XD3.XN3.mid2 1.1294e-17
* device instance cc_XD3_XN3_mid1_XD3_nt r0 *1 0,0
Ccc_XD3_XN3_mid1_XD3_nt XD3.XN3.mid1 XD3.nt 1.1294e-17
* device instance cc_XD3_XN3_mid2_mod2 r0 *1 0,0
Ccc_XD3_XN3_mid2_mod2 XD3.XN3.mid2 mod2 6.05e-18
* device instance cc_XD3_XNOR_midp_XD3_dq r0 *1 0,0
Ccc_XD3_XNOR_midp_XD3_dq XD3.XNOR.midp XD3.dq 5.244e-18
* device instance cc_XD3_XNOR_midp_XD3_t1 r0 *1 0,0
Ccc_XD3_XNOR_midp_XD3_t1 XD3.XNOR.midp XD3.t1 6.05e-18
* device instance cc_XD3_dmodout_XD3_dq r0 *1 0,0
Ccc_XD3_dmodout_XD3_dq XD3.dmodout XD3.dq 1.21e-17
* device instance cc_XD3_dmodout_XD3_nm r0 *1 0,0
Ccc_XD3_dmodout_XD3_nm XD3.dmodout XD3.nm 1.8151e-17
* device instance cc_XD3_dmodout_XD3_nt r0 *1 0,0
Ccc_XD3_dmodout_XD3_nt XD3.dmodout XD3.nt 2.4201e-17
* device instance cc_XD3_dmodout_XD3_t1 r0 *1 0,0
Ccc_XD3_dmodout_XD3_t1 XD3.dmodout XD3.t1 1.21e-17
* device instance cc_XD3_dmodout_XD4_XDFFM_CLKB r0 *1 0,0
Ccc_XD3_dmodout_XD4_XDFFM_CLKB XD3.dmodout XD4.XDFFM.CLKB 1.8151e-17
* device instance cc_XD3_dmodout_XD4_XDFFM_M r0 *1 0,0
Ccc_XD3_dmodout_XD4_XDFFM_M XD3.dmodout XD4.XDFFM.M 2.4201e-17
* device instance cc_XD3_dmodout_XD4_XDFFM_MB r0 *1 0,0
Ccc_XD3_dmodout_XD4_XDFFM_MB XD3.dmodout XD4.XDFFM.MB 1.21e-17
* device instance cc_XD3_dmodout_XD4_XDFFM_S r0 *1 0,0
Ccc_XD3_dmodout_XD4_XDFFM_S XD3.dmodout XD4.XDFFM.S 1.8151e-17
* device instance cc_XD3_dmodout_XD4_XDFFM_SB r0 *1 0,0
Ccc_XD3_dmodout_XD4_XDFFM_SB XD3.dmodout XD4.XDFFM.SB 1.8151e-17
* device instance cc_XD3_dmodout_XD4_XDFFQ_CLKB r0 *1 0,0
Ccc_XD3_dmodout_XD4_XDFFQ_CLKB XD3.dmodout XD4.XDFFQ.CLKB 1.8151e-17
* device instance cc_XD3_dmodout_XD4_XDFFQ_M r0 *1 0,0
Ccc_XD3_dmodout_XD4_XDFFQ_M XD3.dmodout XD4.XDFFQ.M 2.4201e-17
* device instance cc_XD3_dmodout_XD4_XDFFQ_MB r0 *1 0,0
Ccc_XD3_dmodout_XD4_XDFFQ_MB XD3.dmodout XD4.XDFFQ.MB 1.21e-17
* device instance cc_XD3_dmodout_XD4_XDFFQ_S r0 *1 0,0
Ccc_XD3_dmodout_XD4_XDFFQ_S XD3.dmodout XD4.XDFFQ.S 1.8151e-17
* device instance cc_XD3_dmodout_XD4_XDFFQ_SB r0 *1 0,0
Ccc_XD3_dmodout_XD4_XDFFQ_SB XD3.dmodout XD4.XDFFQ.SB 1.8151e-17
* device instance cc_XD3_dmodout_XD4_XN2_mid1 r0 *1 0,0
Ccc_XD3_dmodout_XD4_XN2_mid1 XD3.dmodout XD4.XN2.mid1 1.21e-17
* device instance cc_XD3_dmodout_XD4_XN3_mid1 r0 *1 0,0
Ccc_XD3_dmodout_XD4_XN3_mid1 XD3.dmodout XD4.XN3.mid1 1.21e-17
* device instance cc_XD3_dmodout_XD4_XN3_mid2 r0 *1 0,0
Ccc_XD3_dmodout_XD4_XN3_mid2 XD3.dmodout XD4.XN3.mid2 1.21e-17
* device instance cc_XD3_dmodout_XD4_dmodout r0 *1 0,0
Ccc_XD3_dmodout_XD4_dmodout XD3.dmodout XD4.dmodout 1.21e-17
* device instance cc_XD3_dmodout_XD4_dq r0 *1 0,0
Ccc_XD3_dmodout_XD4_dq XD3.dmodout XD4.dq 1.8151e-17
* device instance cc_XD3_dmodout_XD4_nm r0 *1 0,0
Ccc_XD3_dmodout_XD4_nm XD3.dmodout XD4.nm 1.21e-17
* device instance cc_XD3_dmodout_XD4_nt r0 *1 0,0
Ccc_XD3_dmodout_XD4_nt XD3.dmodout XD4.nt 1.21e-17
* device instance cc_XD3_dmodout_XD4_t1 r0 *1 0,0
Ccc_XD3_dmodout_XD4_t1 XD3.dmodout XD4.t1 1.21e-17
* device instance cc_XD3_dmodout_XD5_XDFFM_CLKB r0 *1 0,0
Ccc_XD3_dmodout_XD5_XDFFM_CLKB XD3.dmodout XD5.XDFFM.CLKB 1.8151e-17
* device instance cc_XD3_dmodout_XD5_XDFFM_M r0 *1 0,0
Ccc_XD3_dmodout_XD5_XDFFM_M XD3.dmodout XD5.XDFFM.M 2.4201e-17
* device instance cc_XD3_dmodout_XD5_XDFFM_MB r0 *1 0,0
Ccc_XD3_dmodout_XD5_XDFFM_MB XD3.dmodout XD5.XDFFM.MB 1.21e-17
* device instance cc_XD3_dmodout_XD5_XDFFM_S r0 *1 0,0
Ccc_XD3_dmodout_XD5_XDFFM_S XD3.dmodout XD5.XDFFM.S 1.8151e-17
* device instance cc_XD3_dmodout_XD5_XDFFM_SB r0 *1 0,0
Ccc_XD3_dmodout_XD5_XDFFM_SB XD3.dmodout XD5.XDFFM.SB 1.8151e-17
* device instance cc_XD3_dmodout_XD5_XDFFQ_CLKB r0 *1 0,0
Ccc_XD3_dmodout_XD5_XDFFQ_CLKB XD3.dmodout XD5.XDFFQ.CLKB 1.8151e-17
* device instance cc_XD3_dmodout_XD5_XDFFQ_M r0 *1 0,0
Ccc_XD3_dmodout_XD5_XDFFQ_M XD3.dmodout XD5.XDFFQ.M 2.4201e-17
* device instance cc_XD3_dmodout_XD5_XDFFQ_MB r0 *1 0,0
Ccc_XD3_dmodout_XD5_XDFFQ_MB XD3.dmodout XD5.XDFFQ.MB 1.21e-17
* device instance cc_XD3_dmodout_XD5_XDFFQ_S r0 *1 0,0
Ccc_XD3_dmodout_XD5_XDFFQ_S XD3.dmodout XD5.XDFFQ.S 1.8151e-17
* device instance cc_XD3_dmodout_XD5_XDFFQ_SB r0 *1 0,0
Ccc_XD3_dmodout_XD5_XDFFQ_SB XD3.dmodout XD5.XDFFQ.SB 1.8151e-17
* device instance cc_XD3_dmodout_XD5_XN2_mid1 r0 *1 0,0
Ccc_XD3_dmodout_XD5_XN2_mid1 XD3.dmodout XD5.XN2.mid1 1.21e-17
* device instance cc_XD3_dmodout_XD5_XN3_mid1 r0 *1 0,0
Ccc_XD3_dmodout_XD5_XN3_mid1 XD3.dmodout XD5.XN3.mid1 1.21e-17
* device instance cc_XD3_dmodout_XD5_XN3_mid2 r0 *1 0,0
Ccc_XD3_dmodout_XD5_XN3_mid2 XD3.dmodout XD5.XN3.mid2 1.21e-17
* device instance cc_XD3_dmodout_XD5_dmodout r0 *1 0,0
Ccc_XD3_dmodout_XD5_dmodout XD3.dmodout XD5.dmodout 1.21e-17
* device instance cc_XD3_dmodout_XD5_dq r0 *1 0,0
Ccc_XD3_dmodout_XD5_dq XD3.dmodout XD5.dq 1.8151e-17
* device instance cc_XD3_dmodout_XD5_nm r0 *1 0,0
Ccc_XD3_dmodout_XD5_nm XD3.dmodout XD5.nm 1.21e-17
* device instance cc_XD3_dmodout_XD5_nt r0 *1 0,0
Ccc_XD3_dmodout_XD5_nt XD3.dmodout XD5.nt 1.21e-17
* device instance cc_XD3_dmodout_XD5_t1 r0 *1 0,0
Ccc_XD3_dmodout_XD5_t1 XD3.dmodout XD5.t1 1.21e-17
* device instance cc_XD3_dmodout_XFRT_CLKB r0 *1 0,0
Ccc_XD3_dmodout_XFRT_CLKB XD3.dmodout XFRT.CLKB 1.8151e-17
* device instance cc_XD3_dmodout_XFRT_M r0 *1 0,0
Ccc_XD3_dmodout_XFRT_M XD3.dmodout XFRT.M 2.4201e-17
* device instance cc_XD3_dmodout_XFRT_MB r0 *1 0,0
Ccc_XD3_dmodout_XFRT_MB XD3.dmodout XFRT.MB 1.21e-17
* device instance cc_XD3_dmodout_XFRT_S r0 *1 0,0
Ccc_XD3_dmodout_XFRT_S XD3.dmodout XFRT.S 1.8151e-17
* device instance cc_XD3_dmodout_XFRT_SB r0 *1 0,0
Ccc_XD3_dmodout_XFRT_SB XD3.dmodout XFRT.SB 1.8151e-17
* device instance cc_XD3_dmodout_ck1 r0 *1 0,0
Ccc_XD3_dmodout_ck1 XD3.dmodout ck1 5.4452e-17
* device instance cc_XD3_dmodout_ck2 r0 *1 0,0
Ccc_XD3_dmodout_ck2 XD3.dmodout ck2 5.4452e-17
* device instance cc_XD3_dmodout_ck3 r0 *1 0,0
Ccc_XD3_dmodout_ck3 XD3.dmodout ck3 6.6553e-17
* device instance cc_XD3_dmodout_ck4 r0 *1 0,0
Ccc_XD3_dmodout_ck4 XD3.dmodout ck4 5.4452e-17
* device instance cc_XD3_dmodout_ck5 r0 *1 0,0
Ccc_XD3_dmodout_ck5 XD3.dmodout ck5 5.4452e-17
* device instance cc_XD3_dmodout_mod0 r0 *1 0,0
Ccc_XD3_dmodout_mod0 XD3.dmodout mod0 2.4201e-17
* device instance cc_XD3_dmodout_mod1 r0 *1 0,0
Ccc_XD3_dmodout_mod1 XD3.dmodout mod1 2.4201e-17
* device instance cc_XD3_dmodout_mod2 r0 *1 0,0
Ccc_XD3_dmodout_mod2 XD3.dmodout mod2 2.4201e-17
* device instance cc_XD3_dmodout_mod3 r0 *1 0,0
Ccc_XD3_dmodout_mod3 XD3.dmodout mod3 2.4201e-17
* device instance cc_XD3_dmodout_mod4 r0 *1 0,0
Ccc_XD3_dmodout_mod4 XD3.dmodout mod4 2.4201e-17
* device instance cc_XD3_dmodout_net1 r0 *1 0,0
Ccc_XD3_dmodout_net1 XD3.dmodout net1 1.21e-17
* device instance cc_XD3_dq_XD3_nm r0 *1 0,0
Ccc_XD3_dq_XD3_nm XD3.dq XD3.nm 1.21e-17
* device instance cc_XD3_dq_XD3_nt r0 *1 0,0
Ccc_XD3_dq_XD3_nt XD3.dq XD3.nt 2.4201e-17
* device instance cc_XD3_dq_XD3_t1 r0 *1 0,0
Ccc_XD3_dq_XD3_t1 XD3.dq XD3.t1 1.8151e-17
* device instance cc_XD3_dq_XD4_XDFFM_CLKB r0 *1 0,0
Ccc_XD3_dq_XD4_XDFFM_CLKB XD3.dq XD4.XDFFM.CLKB 1.8151e-17
* device instance cc_XD3_dq_XD4_XDFFM_M r0 *1 0,0
Ccc_XD3_dq_XD4_XDFFM_M XD3.dq XD4.XDFFM.M 2.4201e-17
* device instance cc_XD3_dq_XD4_XDFFM_MB r0 *1 0,0
Ccc_XD3_dq_XD4_XDFFM_MB XD3.dq XD4.XDFFM.MB 1.21e-17
* device instance cc_XD3_dq_XD4_XDFFM_S r0 *1 0,0
Ccc_XD3_dq_XD4_XDFFM_S XD3.dq XD4.XDFFM.S 1.8151e-17
* device instance cc_XD3_dq_XD4_XDFFM_SB r0 *1 0,0
Ccc_XD3_dq_XD4_XDFFM_SB XD3.dq XD4.XDFFM.SB 1.8151e-17
* device instance cc_XD3_dq_XD4_XDFFQ_CLKB r0 *1 0,0
Ccc_XD3_dq_XD4_XDFFQ_CLKB XD3.dq XD4.XDFFQ.CLKB 1.8151e-17
* device instance cc_XD3_dq_XD4_XDFFQ_M r0 *1 0,0
Ccc_XD3_dq_XD4_XDFFQ_M XD3.dq XD4.XDFFQ.M 2.4201e-17
* device instance cc_XD3_dq_XD4_XDFFQ_MB r0 *1 0,0
Ccc_XD3_dq_XD4_XDFFQ_MB XD3.dq XD4.XDFFQ.MB 1.21e-17
* device instance cc_XD3_dq_XD4_XDFFQ_S r0 *1 0,0
Ccc_XD3_dq_XD4_XDFFQ_S XD3.dq XD4.XDFFQ.S 1.8151e-17
* device instance cc_XD3_dq_XD4_XDFFQ_SB r0 *1 0,0
Ccc_XD3_dq_XD4_XDFFQ_SB XD3.dq XD4.XDFFQ.SB 1.8151e-17
* device instance cc_XD3_dq_XD4_XN2_mid1 r0 *1 0,0
Ccc_XD3_dq_XD4_XN2_mid1 XD3.dq XD4.XN2.mid1 1.21e-17
* device instance cc_XD3_dq_XD4_XN3_mid1 r0 *1 0,0
Ccc_XD3_dq_XD4_XN3_mid1 XD3.dq XD4.XN3.mid1 1.21e-17
* device instance cc_XD3_dq_XD4_XN3_mid2 r0 *1 0,0
Ccc_XD3_dq_XD4_XN3_mid2 XD3.dq XD4.XN3.mid2 1.21e-17
* device instance cc_XD3_dq_XD4_dmodout r0 *1 0,0
Ccc_XD3_dq_XD4_dmodout XD3.dq XD4.dmodout 1.21e-17
* device instance cc_XD3_dq_XD4_dq r0 *1 0,0
Ccc_XD3_dq_XD4_dq XD3.dq XD4.dq 1.8151e-17
* device instance cc_XD3_dq_XD4_nm r0 *1 0,0
Ccc_XD3_dq_XD4_nm XD3.dq XD4.nm 1.21e-17
* device instance cc_XD3_dq_XD4_nt r0 *1 0,0
Ccc_XD3_dq_XD4_nt XD3.dq XD4.nt 1.21e-17
* device instance cc_XD3_dq_XD4_t1 r0 *1 0,0
Ccc_XD3_dq_XD4_t1 XD3.dq XD4.t1 1.21e-17
* device instance cc_XD3_dq_XD5_XDFFM_CLKB r0 *1 0,0
Ccc_XD3_dq_XD5_XDFFM_CLKB XD3.dq XD5.XDFFM.CLKB 1.8151e-17
* device instance cc_XD3_dq_XD5_XDFFM_M r0 *1 0,0
Ccc_XD3_dq_XD5_XDFFM_M XD3.dq XD5.XDFFM.M 2.4201e-17
* device instance cc_XD3_dq_XD5_XDFFM_MB r0 *1 0,0
Ccc_XD3_dq_XD5_XDFFM_MB XD3.dq XD5.XDFFM.MB 1.21e-17
* device instance cc_XD3_dq_XD5_XDFFM_S r0 *1 0,0
Ccc_XD3_dq_XD5_XDFFM_S XD3.dq XD5.XDFFM.S 1.8151e-17
* device instance cc_XD3_dq_XD5_XDFFM_SB r0 *1 0,0
Ccc_XD3_dq_XD5_XDFFM_SB XD3.dq XD5.XDFFM.SB 1.8151e-17
* device instance cc_XD3_dq_XD5_XDFFQ_CLKB r0 *1 0,0
Ccc_XD3_dq_XD5_XDFFQ_CLKB XD3.dq XD5.XDFFQ.CLKB 1.8151e-17
* device instance cc_XD3_dq_XD5_XDFFQ_M r0 *1 0,0
Ccc_XD3_dq_XD5_XDFFQ_M XD3.dq XD5.XDFFQ.M 2.4201e-17
* device instance cc_XD3_dq_XD5_XDFFQ_MB r0 *1 0,0
Ccc_XD3_dq_XD5_XDFFQ_MB XD3.dq XD5.XDFFQ.MB 1.21e-17
* device instance cc_XD3_dq_XD5_XDFFQ_S r0 *1 0,0
Ccc_XD3_dq_XD5_XDFFQ_S XD3.dq XD5.XDFFQ.S 1.8151e-17
* device instance cc_XD3_dq_XD5_XDFFQ_SB r0 *1 0,0
Ccc_XD3_dq_XD5_XDFFQ_SB XD3.dq XD5.XDFFQ.SB 1.8151e-17
* device instance cc_XD3_dq_XD5_XN2_mid1 r0 *1 0,0
Ccc_XD3_dq_XD5_XN2_mid1 XD3.dq XD5.XN2.mid1 1.21e-17
* device instance cc_XD3_dq_XD5_XN3_mid1 r0 *1 0,0
Ccc_XD3_dq_XD5_XN3_mid1 XD3.dq XD5.XN3.mid1 1.21e-17
* device instance cc_XD3_dq_XD5_XN3_mid2 r0 *1 0,0
Ccc_XD3_dq_XD5_XN3_mid2 XD3.dq XD5.XN3.mid2 1.21e-17
* device instance cc_XD3_dq_XD5_dmodout r0 *1 0,0
Ccc_XD3_dq_XD5_dmodout XD3.dq XD5.dmodout 1.21e-17
* device instance cc_XD3_dq_XD5_dq r0 *1 0,0
Ccc_XD3_dq_XD5_dq XD3.dq XD5.dq 1.8151e-17
* device instance cc_XD3_dq_XD5_nm r0 *1 0,0
Ccc_XD3_dq_XD5_nm XD3.dq XD5.nm 1.21e-17
* device instance cc_XD3_dq_XD5_nt r0 *1 0,0
Ccc_XD3_dq_XD5_nt XD3.dq XD5.nt 1.21e-17
* device instance cc_XD3_dq_XD5_t1 r0 *1 0,0
Ccc_XD3_dq_XD5_t1 XD3.dq XD5.t1 1.21e-17
* device instance cc_XD3_dq_XFRT_CLKB r0 *1 0,0
Ccc_XD3_dq_XFRT_CLKB XD3.dq XFRT.CLKB 1.8151e-17
* device instance cc_XD3_dq_XFRT_M r0 *1 0,0
Ccc_XD3_dq_XFRT_M XD3.dq XFRT.M 2.4201e-17
* device instance cc_XD3_dq_XFRT_MB r0 *1 0,0
Ccc_XD3_dq_XFRT_MB XD3.dq XFRT.MB 1.21e-17
* device instance cc_XD3_dq_XFRT_S r0 *1 0,0
Ccc_XD3_dq_XFRT_S XD3.dq XFRT.S 1.8151e-17
* device instance cc_XD3_dq_XFRT_SB r0 *1 0,0
Ccc_XD3_dq_XFRT_SB XD3.dq XFRT.SB 1.8151e-17
* device instance cc_XD3_dq_ck1 r0 *1 0,0
Ccc_XD3_dq_ck1 XD3.dq ck1 5.4452e-17
* device instance cc_XD3_dq_ck2 r0 *1 0,0
Ccc_XD3_dq_ck2 XD3.dq ck2 5.4452e-17
* device instance cc_XD3_dq_ck3 r0 *1 0,0
Ccc_XD3_dq_ck3 XD3.dq ck3 6.6553e-17
* device instance cc_XD3_dq_ck4 r0 *1 0,0
Ccc_XD3_dq_ck4 XD3.dq ck4 5.4452e-17
* device instance cc_XD3_dq_ck5 r0 *1 0,0
Ccc_XD3_dq_ck5 XD3.dq ck5 5.4452e-17
* device instance cc_XD3_dq_mod0 r0 *1 0,0
Ccc_XD3_dq_mod0 XD3.dq mod0 2.4201e-17
* device instance cc_XD3_dq_mod1 r0 *1 0,0
Ccc_XD3_dq_mod1 XD3.dq mod1 2.4201e-17
* device instance cc_XD3_dq_mod2 r0 *1 0,0
Ccc_XD3_dq_mod2 XD3.dq mod2 2.4201e-17
* device instance cc_XD3_dq_mod3 r0 *1 0,0
Ccc_XD3_dq_mod3 XD3.dq mod3 2.4201e-17
* device instance cc_XD3_dq_mod4 r0 *1 0,0
Ccc_XD3_dq_mod4 XD3.dq mod4 2.4201e-17
* device instance cc_XD3_dq_net1 r0 *1 0,0
Ccc_XD3_dq_net1 XD3.dq net1 1.21e-17
* device instance cc_XD3_nm_XD3_nt r0 *1 0,0
Ccc_XD3_nm_XD3_nt XD3.nm XD3.nt 2.4201e-17
* device instance cc_XD3_nm_XD3_t1 r0 *1 0,0
Ccc_XD3_nm_XD3_t1 XD3.nm XD3.t1 1.21e-17
* device instance cc_XD3_nm_XD4_XDFFM_CLKB r0 *1 0,0
Ccc_XD3_nm_XD4_XDFFM_CLKB XD3.nm XD4.XDFFM.CLKB 1.8151e-17
* device instance cc_XD3_nm_XD4_XDFFM_M r0 *1 0,0
Ccc_XD3_nm_XD4_XDFFM_M XD3.nm XD4.XDFFM.M 2.4201e-17
* device instance cc_XD3_nm_XD4_XDFFM_MB r0 *1 0,0
Ccc_XD3_nm_XD4_XDFFM_MB XD3.nm XD4.XDFFM.MB 1.21e-17
* device instance cc_XD3_nm_XD4_XDFFM_S r0 *1 0,0
Ccc_XD3_nm_XD4_XDFFM_S XD3.nm XD4.XDFFM.S 1.8151e-17
* device instance cc_XD3_nm_XD4_XDFFM_SB r0 *1 0,0
Ccc_XD3_nm_XD4_XDFFM_SB XD3.nm XD4.XDFFM.SB 1.8151e-17
* device instance cc_XD3_nm_XD4_XDFFQ_CLKB r0 *1 0,0
Ccc_XD3_nm_XD4_XDFFQ_CLKB XD3.nm XD4.XDFFQ.CLKB 1.8151e-17
* device instance cc_XD3_nm_XD4_XDFFQ_M r0 *1 0,0
Ccc_XD3_nm_XD4_XDFFQ_M XD3.nm XD4.XDFFQ.M 2.4201e-17
* device instance cc_XD3_nm_XD4_XDFFQ_MB r0 *1 0,0
Ccc_XD3_nm_XD4_XDFFQ_MB XD3.nm XD4.XDFFQ.MB 1.21e-17
* device instance cc_XD3_nm_XD4_XDFFQ_S r0 *1 0,0
Ccc_XD3_nm_XD4_XDFFQ_S XD3.nm XD4.XDFFQ.S 1.8151e-17
* device instance cc_XD3_nm_XD4_XDFFQ_SB r0 *1 0,0
Ccc_XD3_nm_XD4_XDFFQ_SB XD3.nm XD4.XDFFQ.SB 1.8151e-17
* device instance cc_XD3_nm_XD4_XN2_mid1 r0 *1 0,0
Ccc_XD3_nm_XD4_XN2_mid1 XD3.nm XD4.XN2.mid1 1.21e-17
* device instance cc_XD3_nm_XD4_XN3_mid1 r0 *1 0,0
Ccc_XD3_nm_XD4_XN3_mid1 XD3.nm XD4.XN3.mid1 1.21e-17
* device instance cc_XD3_nm_XD4_XN3_mid2 r0 *1 0,0
Ccc_XD3_nm_XD4_XN3_mid2 XD3.nm XD4.XN3.mid2 1.21e-17
* device instance cc_XD3_nm_XD4_dmodout r0 *1 0,0
Ccc_XD3_nm_XD4_dmodout XD3.nm XD4.dmodout 1.21e-17
* device instance cc_XD3_nm_XD4_dq r0 *1 0,0
Ccc_XD3_nm_XD4_dq XD3.nm XD4.dq 1.8151e-17
* device instance cc_XD3_nm_XD4_nm r0 *1 0,0
Ccc_XD3_nm_XD4_nm XD3.nm XD4.nm 1.21e-17
* device instance cc_XD3_nm_XD4_nt r0 *1 0,0
Ccc_XD3_nm_XD4_nt XD3.nm XD4.nt 1.21e-17
* device instance cc_XD3_nm_XD4_t1 r0 *1 0,0
Ccc_XD3_nm_XD4_t1 XD3.nm XD4.t1 1.21e-17
* device instance cc_XD3_nm_XD5_XDFFM_CLKB r0 *1 0,0
Ccc_XD3_nm_XD5_XDFFM_CLKB XD3.nm XD5.XDFFM.CLKB 1.8151e-17
* device instance cc_XD3_nm_XD5_XDFFM_M r0 *1 0,0
Ccc_XD3_nm_XD5_XDFFM_M XD3.nm XD5.XDFFM.M 2.4201e-17
* device instance cc_XD3_nm_XD5_XDFFM_MB r0 *1 0,0
Ccc_XD3_nm_XD5_XDFFM_MB XD3.nm XD5.XDFFM.MB 1.21e-17
* device instance cc_XD3_nm_XD5_XDFFM_S r0 *1 0,0
Ccc_XD3_nm_XD5_XDFFM_S XD3.nm XD5.XDFFM.S 1.8151e-17
* device instance cc_XD3_nm_XD5_XDFFM_SB r0 *1 0,0
Ccc_XD3_nm_XD5_XDFFM_SB XD3.nm XD5.XDFFM.SB 1.8151e-17
* device instance cc_XD3_nm_XD5_XDFFQ_CLKB r0 *1 0,0
Ccc_XD3_nm_XD5_XDFFQ_CLKB XD3.nm XD5.XDFFQ.CLKB 1.8151e-17
* device instance cc_XD3_nm_XD5_XDFFQ_M r0 *1 0,0
Ccc_XD3_nm_XD5_XDFFQ_M XD3.nm XD5.XDFFQ.M 2.4201e-17
* device instance cc_XD3_nm_XD5_XDFFQ_MB r0 *1 0,0
Ccc_XD3_nm_XD5_XDFFQ_MB XD3.nm XD5.XDFFQ.MB 1.21e-17
* device instance cc_XD3_nm_XD5_XDFFQ_S r0 *1 0,0
Ccc_XD3_nm_XD5_XDFFQ_S XD3.nm XD5.XDFFQ.S 1.8151e-17
* device instance cc_XD3_nm_XD5_XDFFQ_SB r0 *1 0,0
Ccc_XD3_nm_XD5_XDFFQ_SB XD3.nm XD5.XDFFQ.SB 1.8151e-17
* device instance cc_XD3_nm_XD5_XN2_mid1 r0 *1 0,0
Ccc_XD3_nm_XD5_XN2_mid1 XD3.nm XD5.XN2.mid1 1.21e-17
* device instance cc_XD3_nm_XD5_XN3_mid1 r0 *1 0,0
Ccc_XD3_nm_XD5_XN3_mid1 XD3.nm XD5.XN3.mid1 1.21e-17
* device instance cc_XD3_nm_XD5_XN3_mid2 r0 *1 0,0
Ccc_XD3_nm_XD5_XN3_mid2 XD3.nm XD5.XN3.mid2 1.21e-17
* device instance cc_XD3_nm_XD5_dmodout r0 *1 0,0
Ccc_XD3_nm_XD5_dmodout XD3.nm XD5.dmodout 1.21e-17
* device instance cc_XD3_nm_XD5_dq r0 *1 0,0
Ccc_XD3_nm_XD5_dq XD3.nm XD5.dq 1.8151e-17
* device instance cc_XD3_nm_XD5_nm r0 *1 0,0
Ccc_XD3_nm_XD5_nm XD3.nm XD5.nm 1.21e-17
* device instance cc_XD3_nm_XD5_nt r0 *1 0,0
Ccc_XD3_nm_XD5_nt XD3.nm XD5.nt 1.21e-17
* device instance cc_XD3_nm_XD5_t1 r0 *1 0,0
Ccc_XD3_nm_XD5_t1 XD3.nm XD5.t1 1.21e-17
* device instance cc_XD3_nm_XFRT_CLKB r0 *1 0,0
Ccc_XD3_nm_XFRT_CLKB XD3.nm XFRT.CLKB 1.8151e-17
* device instance cc_XD3_nm_XFRT_M r0 *1 0,0
Ccc_XD3_nm_XFRT_M XD3.nm XFRT.M 2.4201e-17
* device instance cc_XD3_nm_XFRT_MB r0 *1 0,0
Ccc_XD3_nm_XFRT_MB XD3.nm XFRT.MB 1.21e-17
* device instance cc_XD3_nm_XFRT_S r0 *1 0,0
Ccc_XD3_nm_XFRT_S XD3.nm XFRT.S 1.8151e-17
* device instance cc_XD3_nm_XFRT_SB r0 *1 0,0
Ccc_XD3_nm_XFRT_SB XD3.nm XFRT.SB 1.8151e-17
* device instance cc_XD3_nm_ck1 r0 *1 0,0
Ccc_XD3_nm_ck1 XD3.nm ck1 5.4452e-17
* device instance cc_XD3_nm_ck2 r0 *1 0,0
Ccc_XD3_nm_ck2 XD3.nm ck2 5.4452e-17
* device instance cc_XD3_nm_ck3 r0 *1 0,0
Ccc_XD3_nm_ck3 XD3.nm ck3 5.4452e-17
* device instance cc_XD3_nm_ck4 r0 *1 0,0
Ccc_XD3_nm_ck4 XD3.nm ck4 6.0502e-17
* device instance cc_XD3_nm_ck5 r0 *1 0,0
Ccc_XD3_nm_ck5 XD3.nm ck5 5.4452e-17
* device instance cc_XD3_nm_mod0 r0 *1 0,0
Ccc_XD3_nm_mod0 XD3.nm mod0 2.4201e-17
* device instance cc_XD3_nm_mod1 r0 *1 0,0
Ccc_XD3_nm_mod1 XD3.nm mod1 2.4201e-17
* device instance cc_XD3_nm_mod2 r0 *1 0,0
Ccc_XD3_nm_mod2 XD3.nm mod2 2.4201e-17
* device instance cc_XD3_nm_mod3 r0 *1 0,0
Ccc_XD3_nm_mod3 XD3.nm mod3 2.4201e-17
* device instance cc_XD3_nm_mod4 r0 *1 0,0
Ccc_XD3_nm_mod4 XD3.nm mod4 2.4201e-17
* device instance cc_XD3_nm_net1 r0 *1 0,0
Ccc_XD3_nm_net1 XD3.nm net1 1.21e-17
* device instance cc_XD3_nt_XD3_t1 r0 *1 0,0
Ccc_XD3_nt_XD3_t1 XD3.nt XD3.t1 1.21e-17
* device instance cc_XD3_nt_XD4_XDFFM_CLKB r0 *1 0,0
Ccc_XD3_nt_XD4_XDFFM_CLKB XD3.nt XD4.XDFFM.CLKB 1.8151e-17
* device instance cc_XD3_nt_XD4_XDFFM_M r0 *1 0,0
Ccc_XD3_nt_XD4_XDFFM_M XD3.nt XD4.XDFFM.M 2.4201e-17
* device instance cc_XD3_nt_XD4_XDFFM_MB r0 *1 0,0
Ccc_XD3_nt_XD4_XDFFM_MB XD3.nt XD4.XDFFM.MB 1.21e-17
* device instance cc_XD3_nt_XD4_XDFFM_S r0 *1 0,0
Ccc_XD3_nt_XD4_XDFFM_S XD3.nt XD4.XDFFM.S 1.8151e-17
* device instance cc_XD3_nt_XD4_XDFFM_SB r0 *1 0,0
Ccc_XD3_nt_XD4_XDFFM_SB XD3.nt XD4.XDFFM.SB 1.8151e-17
* device instance cc_XD3_nt_XD4_XDFFQ_CLKB r0 *1 0,0
Ccc_XD3_nt_XD4_XDFFQ_CLKB XD3.nt XD4.XDFFQ.CLKB 1.8151e-17
* device instance cc_XD3_nt_XD4_XDFFQ_M r0 *1 0,0
Ccc_XD3_nt_XD4_XDFFQ_M XD3.nt XD4.XDFFQ.M 2.4201e-17
* device instance cc_XD3_nt_XD4_XDFFQ_MB r0 *1 0,0
Ccc_XD3_nt_XD4_XDFFQ_MB XD3.nt XD4.XDFFQ.MB 1.21e-17
* device instance cc_XD3_nt_XD4_XDFFQ_S r0 *1 0,0
Ccc_XD3_nt_XD4_XDFFQ_S XD3.nt XD4.XDFFQ.S 1.8151e-17
* device instance cc_XD3_nt_XD4_XDFFQ_SB r0 *1 0,0
Ccc_XD3_nt_XD4_XDFFQ_SB XD3.nt XD4.XDFFQ.SB 1.8151e-17
* device instance cc_XD3_nt_XD4_XN2_mid1 r0 *1 0,0
Ccc_XD3_nt_XD4_XN2_mid1 XD3.nt XD4.XN2.mid1 1.21e-17
* device instance cc_XD3_nt_XD4_XN3_mid1 r0 *1 0,0
Ccc_XD3_nt_XD4_XN3_mid1 XD3.nt XD4.XN3.mid1 1.21e-17
* device instance cc_XD3_nt_XD4_XN3_mid2 r0 *1 0,0
Ccc_XD3_nt_XD4_XN3_mid2 XD3.nt XD4.XN3.mid2 1.21e-17
* device instance cc_XD3_nt_XD4_dmodout r0 *1 0,0
Ccc_XD3_nt_XD4_dmodout XD3.nt XD4.dmodout 1.21e-17
* device instance cc_XD3_nt_XD4_dq r0 *1 0,0
Ccc_XD3_nt_XD4_dq XD3.nt XD4.dq 1.8151e-17
* device instance cc_XD3_nt_XD4_nm r0 *1 0,0
Ccc_XD3_nt_XD4_nm XD3.nt XD4.nm 1.21e-17
* device instance cc_XD3_nt_XD4_nt r0 *1 0,0
Ccc_XD3_nt_XD4_nt XD3.nt XD4.nt 1.21e-17
* device instance cc_XD3_nt_XD4_t1 r0 *1 0,0
Ccc_XD3_nt_XD4_t1 XD3.nt XD4.t1 1.21e-17
* device instance cc_XD3_nt_XD5_XDFFM_CLKB r0 *1 0,0
Ccc_XD3_nt_XD5_XDFFM_CLKB XD3.nt XD5.XDFFM.CLKB 1.8151e-17
* device instance cc_XD3_nt_XD5_XDFFM_M r0 *1 0,0
Ccc_XD3_nt_XD5_XDFFM_M XD3.nt XD5.XDFFM.M 2.4201e-17
* device instance cc_XD3_nt_XD5_XDFFM_MB r0 *1 0,0
Ccc_XD3_nt_XD5_XDFFM_MB XD3.nt XD5.XDFFM.MB 1.21e-17
* device instance cc_XD3_nt_XD5_XDFFM_S r0 *1 0,0
Ccc_XD3_nt_XD5_XDFFM_S XD3.nt XD5.XDFFM.S 1.8151e-17
* device instance cc_XD3_nt_XD5_XDFFM_SB r0 *1 0,0
Ccc_XD3_nt_XD5_XDFFM_SB XD3.nt XD5.XDFFM.SB 1.8151e-17
* device instance cc_XD3_nt_XD5_XDFFQ_CLKB r0 *1 0,0
Ccc_XD3_nt_XD5_XDFFQ_CLKB XD3.nt XD5.XDFFQ.CLKB 1.8151e-17
* device instance cc_XD3_nt_XD5_XDFFQ_M r0 *1 0,0
Ccc_XD3_nt_XD5_XDFFQ_M XD3.nt XD5.XDFFQ.M 2.4201e-17
* device instance cc_XD3_nt_XD5_XDFFQ_MB r0 *1 0,0
Ccc_XD3_nt_XD5_XDFFQ_MB XD3.nt XD5.XDFFQ.MB 1.21e-17
* device instance cc_XD3_nt_XD5_XDFFQ_S r0 *1 0,0
Ccc_XD3_nt_XD5_XDFFQ_S XD3.nt XD5.XDFFQ.S 1.8151e-17
* device instance cc_XD3_nt_XD5_XDFFQ_SB r0 *1 0,0
Ccc_XD3_nt_XD5_XDFFQ_SB XD3.nt XD5.XDFFQ.SB 1.8151e-17
* device instance cc_XD3_nt_XD5_XN2_mid1 r0 *1 0,0
Ccc_XD3_nt_XD5_XN2_mid1 XD3.nt XD5.XN2.mid1 1.21e-17
* device instance cc_XD3_nt_XD5_XN3_mid1 r0 *1 0,0
Ccc_XD3_nt_XD5_XN3_mid1 XD3.nt XD5.XN3.mid1 1.21e-17
* device instance cc_XD3_nt_XD5_XN3_mid2 r0 *1 0,0
Ccc_XD3_nt_XD5_XN3_mid2 XD3.nt XD5.XN3.mid2 1.21e-17
* device instance cc_XD3_nt_XD5_dmodout r0 *1 0,0
Ccc_XD3_nt_XD5_dmodout XD3.nt XD5.dmodout 1.21e-17
* device instance cc_XD3_nt_XD5_dq r0 *1 0,0
Ccc_XD3_nt_XD5_dq XD3.nt XD5.dq 1.8151e-17
* device instance cc_XD3_nt_XD5_nm r0 *1 0,0
Ccc_XD3_nt_XD5_nm XD3.nt XD5.nm 1.21e-17
* device instance cc_XD3_nt_XD5_nt r0 *1 0,0
Ccc_XD3_nt_XD5_nt XD3.nt XD5.nt 1.21e-17
* device instance cc_XD3_nt_XD5_t1 r0 *1 0,0
Ccc_XD3_nt_XD5_t1 XD3.nt XD5.t1 1.21e-17
* device instance cc_XD3_nt_XFRT_CLKB r0 *1 0,0
Ccc_XD3_nt_XFRT_CLKB XD3.nt XFRT.CLKB 1.8151e-17
* device instance cc_XD3_nt_XFRT_M r0 *1 0,0
Ccc_XD3_nt_XFRT_M XD3.nt XFRT.M 2.4201e-17
* device instance cc_XD3_nt_XFRT_MB r0 *1 0,0
Ccc_XD3_nt_XFRT_MB XD3.nt XFRT.MB 1.21e-17
* device instance cc_XD3_nt_XFRT_S r0 *1 0,0
Ccc_XD3_nt_XFRT_S XD3.nt XFRT.S 1.8151e-17
* device instance cc_XD3_nt_XFRT_SB r0 *1 0,0
Ccc_XD3_nt_XFRT_SB XD3.nt XFRT.SB 1.8151e-17
* device instance cc_XD3_nt_ck1 r0 *1 0,0
Ccc_XD3_nt_ck1 XD3.nt ck1 5.4452e-17
* device instance cc_XD3_nt_ck2 r0 *1 0,0
Ccc_XD3_nt_ck2 XD3.nt ck2 5.4452e-17
* device instance cc_XD3_nt_ck3 r0 *1 0,0
Ccc_XD3_nt_ck3 XD3.nt ck3 5.4452e-17
* device instance cc_XD3_nt_ck4 r0 *1 0,0
Ccc_XD3_nt_ck4 XD3.nt ck4 5.4452e-17
* device instance cc_XD3_nt_ck5 r0 *1 0,0
Ccc_XD3_nt_ck5 XD3.nt ck5 5.4452e-17
* device instance cc_XD3_nt_mod0 r0 *1 0,0
Ccc_XD3_nt_mod0 XD3.nt mod0 2.4201e-17
* device instance cc_XD3_nt_mod1 r0 *1 0,0
Ccc_XD3_nt_mod1 XD3.nt mod1 2.4201e-17
* device instance cc_XD3_nt_mod2 r0 *1 0,0
Ccc_XD3_nt_mod2 XD3.nt mod2 3.0251e-17
* device instance cc_XD3_nt_mod3 r0 *1 0,0
Ccc_XD3_nt_mod3 XD3.nt mod3 2.4201e-17
* device instance cc_XD3_nt_mod4 r0 *1 0,0
Ccc_XD3_nt_mod4 XD3.nt mod4 2.4201e-17
* device instance cc_XD3_nt_net1 r0 *1 0,0
Ccc_XD3_nt_net1 XD3.nt net1 1.21e-17
* device instance cc_XD3_t1_XD4_XDFFM_CLKB r0 *1 0,0
Ccc_XD3_t1_XD4_XDFFM_CLKB XD3.t1 XD4.XDFFM.CLKB 1.8151e-17
* device instance cc_XD3_t1_XD4_XDFFM_M r0 *1 0,0
Ccc_XD3_t1_XD4_XDFFM_M XD3.t1 XD4.XDFFM.M 2.4201e-17
* device instance cc_XD3_t1_XD4_XDFFM_MB r0 *1 0,0
Ccc_XD3_t1_XD4_XDFFM_MB XD3.t1 XD4.XDFFM.MB 1.21e-17
* device instance cc_XD3_t1_XD4_XDFFM_S r0 *1 0,0
Ccc_XD3_t1_XD4_XDFFM_S XD3.t1 XD4.XDFFM.S 1.8151e-17
* device instance cc_XD3_t1_XD4_XDFFM_SB r0 *1 0,0
Ccc_XD3_t1_XD4_XDFFM_SB XD3.t1 XD4.XDFFM.SB 1.8151e-17
* device instance cc_XD3_t1_XD4_XDFFQ_CLKB r0 *1 0,0
Ccc_XD3_t1_XD4_XDFFQ_CLKB XD3.t1 XD4.XDFFQ.CLKB 1.8151e-17
* device instance cc_XD3_t1_XD4_XDFFQ_M r0 *1 0,0
Ccc_XD3_t1_XD4_XDFFQ_M XD3.t1 XD4.XDFFQ.M 2.4201e-17
* device instance cc_XD3_t1_XD4_XDFFQ_MB r0 *1 0,0
Ccc_XD3_t1_XD4_XDFFQ_MB XD3.t1 XD4.XDFFQ.MB 1.21e-17
* device instance cc_XD3_t1_XD4_XDFFQ_S r0 *1 0,0
Ccc_XD3_t1_XD4_XDFFQ_S XD3.t1 XD4.XDFFQ.S 1.8151e-17
* device instance cc_XD3_t1_XD4_XDFFQ_SB r0 *1 0,0
Ccc_XD3_t1_XD4_XDFFQ_SB XD3.t1 XD4.XDFFQ.SB 1.8151e-17
* device instance cc_XD3_t1_XD4_XN2_mid1 r0 *1 0,0
Ccc_XD3_t1_XD4_XN2_mid1 XD3.t1 XD4.XN2.mid1 1.21e-17
* device instance cc_XD3_t1_XD4_XN3_mid1 r0 *1 0,0
Ccc_XD3_t1_XD4_XN3_mid1 XD3.t1 XD4.XN3.mid1 1.21e-17
* device instance cc_XD3_t1_XD4_XN3_mid2 r0 *1 0,0
Ccc_XD3_t1_XD4_XN3_mid2 XD3.t1 XD4.XN3.mid2 1.21e-17
* device instance cc_XD3_t1_XD4_dmodout r0 *1 0,0
Ccc_XD3_t1_XD4_dmodout XD3.t1 XD4.dmodout 1.21e-17
* device instance cc_XD3_t1_XD4_dq r0 *1 0,0
Ccc_XD3_t1_XD4_dq XD3.t1 XD4.dq 1.8151e-17
* device instance cc_XD3_t1_XD4_nm r0 *1 0,0
Ccc_XD3_t1_XD4_nm XD3.t1 XD4.nm 1.21e-17
* device instance cc_XD3_t1_XD4_nt r0 *1 0,0
Ccc_XD3_t1_XD4_nt XD3.t1 XD4.nt 1.21e-17
* device instance cc_XD3_t1_XD4_t1 r0 *1 0,0
Ccc_XD3_t1_XD4_t1 XD3.t1 XD4.t1 1.21e-17
* device instance cc_XD3_t1_XD5_XDFFM_CLKB r0 *1 0,0
Ccc_XD3_t1_XD5_XDFFM_CLKB XD3.t1 XD5.XDFFM.CLKB 1.8151e-17
* device instance cc_XD3_t1_XD5_XDFFM_M r0 *1 0,0
Ccc_XD3_t1_XD5_XDFFM_M XD3.t1 XD5.XDFFM.M 2.4201e-17
* device instance cc_XD3_t1_XD5_XDFFM_MB r0 *1 0,0
Ccc_XD3_t1_XD5_XDFFM_MB XD3.t1 XD5.XDFFM.MB 1.21e-17
* device instance cc_XD3_t1_XD5_XDFFM_S r0 *1 0,0
Ccc_XD3_t1_XD5_XDFFM_S XD3.t1 XD5.XDFFM.S 1.8151e-17
* device instance cc_XD3_t1_XD5_XDFFM_SB r0 *1 0,0
Ccc_XD3_t1_XD5_XDFFM_SB XD3.t1 XD5.XDFFM.SB 1.8151e-17
* device instance cc_XD3_t1_XD5_XDFFQ_CLKB r0 *1 0,0
Ccc_XD3_t1_XD5_XDFFQ_CLKB XD3.t1 XD5.XDFFQ.CLKB 1.8151e-17
* device instance cc_XD3_t1_XD5_XDFFQ_M r0 *1 0,0
Ccc_XD3_t1_XD5_XDFFQ_M XD3.t1 XD5.XDFFQ.M 2.4201e-17
* device instance cc_XD3_t1_XD5_XDFFQ_MB r0 *1 0,0
Ccc_XD3_t1_XD5_XDFFQ_MB XD3.t1 XD5.XDFFQ.MB 1.21e-17
* device instance cc_XD3_t1_XD5_XDFFQ_S r0 *1 0,0
Ccc_XD3_t1_XD5_XDFFQ_S XD3.t1 XD5.XDFFQ.S 1.8151e-17
* device instance cc_XD3_t1_XD5_XDFFQ_SB r0 *1 0,0
Ccc_XD3_t1_XD5_XDFFQ_SB XD3.t1 XD5.XDFFQ.SB 1.8151e-17
* device instance cc_XD3_t1_XD5_XN2_mid1 r0 *1 0,0
Ccc_XD3_t1_XD5_XN2_mid1 XD3.t1 XD5.XN2.mid1 1.21e-17
* device instance cc_XD3_t1_XD5_XN3_mid1 r0 *1 0,0
Ccc_XD3_t1_XD5_XN3_mid1 XD3.t1 XD5.XN3.mid1 1.21e-17
* device instance cc_XD3_t1_XD5_XN3_mid2 r0 *1 0,0
Ccc_XD3_t1_XD5_XN3_mid2 XD3.t1 XD5.XN3.mid2 1.21e-17
* device instance cc_XD3_t1_XD5_dmodout r0 *1 0,0
Ccc_XD3_t1_XD5_dmodout XD3.t1 XD5.dmodout 1.21e-17
* device instance cc_XD3_t1_XD5_dq r0 *1 0,0
Ccc_XD3_t1_XD5_dq XD3.t1 XD5.dq 1.8151e-17
* device instance cc_XD3_t1_XD5_nm r0 *1 0,0
Ccc_XD3_t1_XD5_nm XD3.t1 XD5.nm 1.21e-17
* device instance cc_XD3_t1_XD5_nt r0 *1 0,0
Ccc_XD3_t1_XD5_nt XD3.t1 XD5.nt 1.21e-17
* device instance cc_XD3_t1_XD5_t1 r0 *1 0,0
Ccc_XD3_t1_XD5_t1 XD3.t1 XD5.t1 1.21e-17
* device instance cc_XD3_t1_XFRT_CLKB r0 *1 0,0
Ccc_XD3_t1_XFRT_CLKB XD3.t1 XFRT.CLKB 1.8151e-17
* device instance cc_XD3_t1_XFRT_M r0 *1 0,0
Ccc_XD3_t1_XFRT_M XD3.t1 XFRT.M 2.4201e-17
* device instance cc_XD3_t1_XFRT_MB r0 *1 0,0
Ccc_XD3_t1_XFRT_MB XD3.t1 XFRT.MB 1.21e-17
* device instance cc_XD3_t1_XFRT_S r0 *1 0,0
Ccc_XD3_t1_XFRT_S XD3.t1 XFRT.S 1.8151e-17
* device instance cc_XD3_t1_XFRT_SB r0 *1 0,0
Ccc_XD3_t1_XFRT_SB XD3.t1 XFRT.SB 1.8151e-17
* device instance cc_XD3_t1_ck1 r0 *1 0,0
Ccc_XD3_t1_ck1 XD3.t1 ck1 5.4452e-17
* device instance cc_XD3_t1_ck2 r0 *1 0,0
Ccc_XD3_t1_ck2 XD3.t1 ck2 5.4452e-17
* device instance cc_XD3_t1_ck3 r0 *1 0,0
Ccc_XD3_t1_ck3 XD3.t1 ck3 5.4452e-17
* device instance cc_XD3_t1_ck4 r0 *1 0,0
Ccc_XD3_t1_ck4 XD3.t1 ck4 6.0502e-17
* device instance cc_XD3_t1_ck5 r0 *1 0,0
Ccc_XD3_t1_ck5 XD3.t1 ck5 5.4452e-17
* device instance cc_XD3_t1_mod0 r0 *1 0,0
Ccc_XD3_t1_mod0 XD3.t1 mod0 2.4201e-17
* device instance cc_XD3_t1_mod1 r0 *1 0,0
Ccc_XD3_t1_mod1 XD3.t1 mod1 2.4201e-17
* device instance cc_XD3_t1_mod2 r0 *1 0,0
Ccc_XD3_t1_mod2 XD3.t1 mod2 2.4201e-17
* device instance cc_XD3_t1_mod3 r0 *1 0,0
Ccc_XD3_t1_mod3 XD3.t1 mod3 2.4201e-17
* device instance cc_XD3_t1_mod4 r0 *1 0,0
Ccc_XD3_t1_mod4 XD3.t1 mod4 2.4201e-17
* device instance cc_XD3_t1_net1 r0 *1 0,0
Ccc_XD3_t1_net1 XD3.t1 net1 1.21e-17
* device instance cc_XD4_XDFFM_CLKB_XD4_XDFFM_M r0 *1 0,0
Ccc_XD4_XDFFM_CLKB_XD4_XDFFM_M XD4.XDFFM.CLKB XD4.XDFFM.M 4.2352e-17
* device instance cc_XD4_XDFFM_CLKB_XD4_XDFFM_MB r0 *1 0,0
Ccc_XD4_XDFFM_CLKB_XD4_XDFFM_MB XD4.XDFFM.CLKB XD4.XDFFM.MB 2.4201e-17
* device instance cc_XD4_XDFFM_CLKB_XD4_XDFFM_S r0 *1 0,0
Ccc_XD4_XDFFM_CLKB_XD4_XDFFM_S XD4.XDFFM.CLKB XD4.XDFFM.S 1.8151e-17
* device instance cc_XD4_XDFFM_CLKB_XD4_XDFFM_SB r0 *1 0,0
Ccc_XD4_XDFFM_CLKB_XD4_XDFFM_SB XD4.XDFFM.CLKB XD4.XDFFM.SB 1.8151e-17
* device instance cc_XD4_XDFFM_CLKB_XD4_XDFFQ_CLKB r0 *1 0,0
Ccc_XD4_XDFFM_CLKB_XD4_XDFFQ_CLKB XD4.XDFFM.CLKB XD4.XDFFQ.CLKB 1.8151e-17
* device instance cc_XD4_XDFFM_CLKB_XD4_XDFFQ_M r0 *1 0,0
Ccc_XD4_XDFFM_CLKB_XD4_XDFFQ_M XD4.XDFFM.CLKB XD4.XDFFQ.M 2.4201e-17
* device instance cc_XD4_XDFFM_CLKB_XD4_XDFFQ_MB r0 *1 0,0
Ccc_XD4_XDFFM_CLKB_XD4_XDFFQ_MB XD4.XDFFM.CLKB XD4.XDFFQ.MB 1.21e-17
* device instance cc_XD4_XDFFM_CLKB_XD4_XDFFQ_S r0 *1 0,0
Ccc_XD4_XDFFM_CLKB_XD4_XDFFQ_S XD4.XDFFM.CLKB XD4.XDFFQ.S 1.8151e-17
* device instance cc_XD4_XDFFM_CLKB_XD4_XDFFQ_SB r0 *1 0,0
Ccc_XD4_XDFFM_CLKB_XD4_XDFFQ_SB XD4.XDFFM.CLKB XD4.XDFFQ.SB 1.8151e-17
* device instance cc_XD4_XDFFM_CLKB_XD4_XNOR_midp r0 *1 0,0
Ccc_XD4_XDFFM_CLKB_XD4_XNOR_midp XD4.XDFFM.CLKB XD4.XNOR.midp 1.21e-17
* device instance cc_XD4_XDFFM_CLKB_XD4_dmodout r0 *1 0,0
Ccc_XD4_XDFFM_CLKB_XD4_dmodout XD4.XDFFM.CLKB XD4.dmodout 1.8151e-17
* device instance cc_XD4_XDFFM_CLKB_XD4_dq r0 *1 0,0
Ccc_XD4_XDFFM_CLKB_XD4_dq XD4.XDFFM.CLKB XD4.dq 1.21e-17
* device instance cc_XD4_XDFFM_CLKB_XD4_nm r0 *1 0,0
Ccc_XD4_XDFFM_CLKB_XD4_nm XD4.XDFFM.CLKB XD4.nm 1.8151e-17
* device instance cc_XD4_XDFFM_CLKB_XD4_nt r0 *1 0,0
Ccc_XD4_XDFFM_CLKB_XD4_nt XD4.XDFFM.CLKB XD4.nt 2.4201e-17
* device instance cc_XD4_XDFFM_CLKB_XD4_t1 r0 *1 0,0
Ccc_XD4_XDFFM_CLKB_XD4_t1 XD4.XDFFM.CLKB XD4.t1 1.21e-17
* device instance cc_XD4_XDFFM_CLKB_XD5_XDFFM_CLKB r0 *1 0,0
Ccc_XD4_XDFFM_CLKB_XD5_XDFFM_CLKB XD4.XDFFM.CLKB XD5.XDFFM.CLKB 1.8151e-17
* device instance cc_XD4_XDFFM_CLKB_XD5_XDFFM_M r0 *1 0,0
Ccc_XD4_XDFFM_CLKB_XD5_XDFFM_M XD4.XDFFM.CLKB XD5.XDFFM.M 2.4201e-17
* device instance cc_XD4_XDFFM_CLKB_XD5_XDFFM_MB r0 *1 0,0
Ccc_XD4_XDFFM_CLKB_XD5_XDFFM_MB XD4.XDFFM.CLKB XD5.XDFFM.MB 1.21e-17
* device instance cc_XD4_XDFFM_CLKB_XD5_XDFFM_S r0 *1 0,0
Ccc_XD4_XDFFM_CLKB_XD5_XDFFM_S XD4.XDFFM.CLKB XD5.XDFFM.S 1.8151e-17
* device instance cc_XD4_XDFFM_CLKB_XD5_XDFFM_SB r0 *1 0,0
Ccc_XD4_XDFFM_CLKB_XD5_XDFFM_SB XD4.XDFFM.CLKB XD5.XDFFM.SB 1.8151e-17
* device instance cc_XD4_XDFFM_CLKB_XD5_XDFFQ_CLKB r0 *1 0,0
Ccc_XD4_XDFFM_CLKB_XD5_XDFFQ_CLKB XD4.XDFFM.CLKB XD5.XDFFQ.CLKB 1.8151e-17
* device instance cc_XD4_XDFFM_CLKB_XD5_XDFFQ_M r0 *1 0,0
Ccc_XD4_XDFFM_CLKB_XD5_XDFFQ_M XD4.XDFFM.CLKB XD5.XDFFQ.M 2.4201e-17
* device instance cc_XD4_XDFFM_CLKB_XD5_XDFFQ_MB r0 *1 0,0
Ccc_XD4_XDFFM_CLKB_XD5_XDFFQ_MB XD4.XDFFM.CLKB XD5.XDFFQ.MB 1.21e-17
* device instance cc_XD4_XDFFM_CLKB_XD5_XDFFQ_S r0 *1 0,0
Ccc_XD4_XDFFM_CLKB_XD5_XDFFQ_S XD4.XDFFM.CLKB XD5.XDFFQ.S 1.8151e-17
* device instance cc_XD4_XDFFM_CLKB_XD5_XDFFQ_SB r0 *1 0,0
Ccc_XD4_XDFFM_CLKB_XD5_XDFFQ_SB XD4.XDFFM.CLKB XD5.XDFFQ.SB 1.8151e-17
* device instance cc_XD4_XDFFM_CLKB_XD5_XN2_mid1 r0 *1 0,0
Ccc_XD4_XDFFM_CLKB_XD5_XN2_mid1 XD4.XDFFM.CLKB XD5.XN2.mid1 1.21e-17
* device instance cc_XD4_XDFFM_CLKB_XD5_XN3_mid1 r0 *1 0,0
Ccc_XD4_XDFFM_CLKB_XD5_XN3_mid1 XD4.XDFFM.CLKB XD5.XN3.mid1 1.21e-17
* device instance cc_XD4_XDFFM_CLKB_XD5_XN3_mid2 r0 *1 0,0
Ccc_XD4_XDFFM_CLKB_XD5_XN3_mid2 XD4.XDFFM.CLKB XD5.XN3.mid2 1.21e-17
* device instance cc_XD4_XDFFM_CLKB_XD5_dmodout r0 *1 0,0
Ccc_XD4_XDFFM_CLKB_XD5_dmodout XD4.XDFFM.CLKB XD5.dmodout 1.21e-17
* device instance cc_XD4_XDFFM_CLKB_XD5_dq r0 *1 0,0
Ccc_XD4_XDFFM_CLKB_XD5_dq XD4.XDFFM.CLKB XD5.dq 1.8151e-17
* device instance cc_XD4_XDFFM_CLKB_XD5_nm r0 *1 0,0
Ccc_XD4_XDFFM_CLKB_XD5_nm XD4.XDFFM.CLKB XD5.nm 1.21e-17
* device instance cc_XD4_XDFFM_CLKB_XD5_nt r0 *1 0,0
Ccc_XD4_XDFFM_CLKB_XD5_nt XD4.XDFFM.CLKB XD5.nt 1.21e-17
* device instance cc_XD4_XDFFM_CLKB_XD5_t1 r0 *1 0,0
Ccc_XD4_XDFFM_CLKB_XD5_t1 XD4.XDFFM.CLKB XD5.t1 1.21e-17
* device instance cc_XD4_XDFFM_CLKB_XFRT_CLKB r0 *1 0,0
Ccc_XD4_XDFFM_CLKB_XFRT_CLKB XD4.XDFFM.CLKB XFRT.CLKB 1.8151e-17
* device instance cc_XD4_XDFFM_CLKB_XFRT_M r0 *1 0,0
Ccc_XD4_XDFFM_CLKB_XFRT_M XD4.XDFFM.CLKB XFRT.M 2.4201e-17
* device instance cc_XD4_XDFFM_CLKB_XFRT_MB r0 *1 0,0
Ccc_XD4_XDFFM_CLKB_XFRT_MB XD4.XDFFM.CLKB XFRT.MB 1.21e-17
* device instance cc_XD4_XDFFM_CLKB_XFRT_S r0 *1 0,0
Ccc_XD4_XDFFM_CLKB_XFRT_S XD4.XDFFM.CLKB XFRT.S 1.8151e-17
* device instance cc_XD4_XDFFM_CLKB_XFRT_SB r0 *1 0,0
Ccc_XD4_XDFFM_CLKB_XFRT_SB XD4.XDFFM.CLKB XFRT.SB 1.8151e-17
* device instance cc_XD4_XDFFM_CLKB_ck1 r0 *1 0,0
Ccc_XD4_XDFFM_CLKB_ck1 XD4.XDFFM.CLKB ck1 5.4452e-17
* device instance cc_XD4_XDFFM_CLKB_ck2 r0 *1 0,0
Ccc_XD4_XDFFM_CLKB_ck2 XD4.XDFFM.CLKB ck2 5.4452e-17
* device instance cc_XD4_XDFFM_CLKB_ck3 r0 *1 0,0
Ccc_XD4_XDFFM_CLKB_ck3 XD4.XDFFM.CLKB ck3 5.4452e-17
* device instance cc_XD4_XDFFM_CLKB_ck4 r0 *1 0,0
Ccc_XD4_XDFFM_CLKB_ck4 XD4.XDFFM.CLKB ck4 6.0502e-17
* device instance cc_XD4_XDFFM_CLKB_ck5 r0 *1 0,0
Ccc_XD4_XDFFM_CLKB_ck5 XD4.XDFFM.CLKB ck5 5.4452e-17
* device instance cc_XD4_XDFFM_CLKB_mod0 r0 *1 0,0
Ccc_XD4_XDFFM_CLKB_mod0 XD4.XDFFM.CLKB mod0 2.4201e-17
* device instance cc_XD4_XDFFM_CLKB_mod1 r0 *1 0,0
Ccc_XD4_XDFFM_CLKB_mod1 XD4.XDFFM.CLKB mod1 2.4201e-17
* device instance cc_XD4_XDFFM_CLKB_mod2 r0 *1 0,0
Ccc_XD4_XDFFM_CLKB_mod2 XD4.XDFFM.CLKB mod2 2.4201e-17
* device instance cc_XD4_XDFFM_CLKB_mod3 r0 *1 0,0
Ccc_XD4_XDFFM_CLKB_mod3 XD4.XDFFM.CLKB mod3 2.4201e-17
* device instance cc_XD4_XDFFM_CLKB_mod4 r0 *1 0,0
Ccc_XD4_XDFFM_CLKB_mod4 XD4.XDFFM.CLKB mod4 2.4201e-17
* device instance cc_XD4_XDFFM_CLKB_net1 r0 *1 0,0
Ccc_XD4_XDFFM_CLKB_net1 XD4.XDFFM.CLKB net1 1.21e-17
* device instance cc_XD4_XDFFM_M_XD4_XDFFM_MB r0 *1 0,0
Ccc_XD4_XDFFM_M_XD4_XDFFM_MB XD4.XDFFM.M XD4.XDFFM.MB 3.4688e-17
* device instance cc_XD4_XDFFM_M_XD4_XDFFM_S r0 *1 0,0
Ccc_XD4_XDFFM_M_XD4_XDFFM_S XD4.XDFFM.M XD4.XDFFM.S 2.8638e-17
* device instance cc_XD4_XDFFM_M_XD4_XDFFM_SB r0 *1 0,0
Ccc_XD4_XDFFM_M_XD4_XDFFM_SB XD4.XDFFM.M XD4.XDFFM.SB 1.8151e-17
* device instance cc_XD4_XDFFM_M_XD4_XDFFQ_CLKB r0 *1 0,0
Ccc_XD4_XDFFM_M_XD4_XDFFQ_CLKB XD4.XDFFM.M XD4.XDFFQ.CLKB 1.8151e-17
* device instance cc_XD4_XDFFM_M_XD4_XDFFQ_M r0 *1 0,0
Ccc_XD4_XDFFM_M_XD4_XDFFQ_M XD4.XDFFM.M XD4.XDFFQ.M 2.4201e-17
* device instance cc_XD4_XDFFM_M_XD4_XDFFQ_MB r0 *1 0,0
Ccc_XD4_XDFFM_M_XD4_XDFFQ_MB XD4.XDFFM.M XD4.XDFFQ.MB 1.21e-17
* device instance cc_XD4_XDFFM_M_XD4_XDFFQ_S r0 *1 0,0
Ccc_XD4_XDFFM_M_XD4_XDFFQ_S XD4.XDFFM.M XD4.XDFFQ.S 1.8151e-17
* device instance cc_XD4_XDFFM_M_XD4_XDFFQ_SB r0 *1 0,0
Ccc_XD4_XDFFM_M_XD4_XDFFQ_SB XD4.XDFFM.M XD4.XDFFQ.SB 1.8151e-17
* device instance cc_XD4_XDFFM_M_XD4_XNOR_midp r0 *1 0,0
Ccc_XD4_XDFFM_M_XD4_XNOR_midp XD4.XDFFM.M XD4.XNOR.midp 1.21e-17
* device instance cc_XD4_XDFFM_M_XD4_dmodout r0 *1 0,0
Ccc_XD4_XDFFM_M_XD4_dmodout XD4.XDFFM.M XD4.dmodout 2.8638e-17
* device instance cc_XD4_XDFFM_M_XD4_dq r0 *1 0,0
Ccc_XD4_XDFFM_M_XD4_dq XD4.XDFFM.M XD4.dq 1.21e-17
* device instance cc_XD4_XDFFM_M_XD4_nm r0 *1 0,0
Ccc_XD4_XDFFM_M_XD4_nm XD4.XDFFM.M XD4.nm 1.8151e-17
* device instance cc_XD4_XDFFM_M_XD4_nt r0 *1 0,0
Ccc_XD4_XDFFM_M_XD4_nt XD4.XDFFM.M XD4.nt 2.4201e-17
* device instance cc_XD4_XDFFM_M_XD4_t1 r0 *1 0,0
Ccc_XD4_XDFFM_M_XD4_t1 XD4.XDFFM.M XD4.t1 1.21e-17
* device instance cc_XD4_XDFFM_M_XD5_XDFFM_CLKB r0 *1 0,0
Ccc_XD4_XDFFM_M_XD5_XDFFM_CLKB XD4.XDFFM.M XD5.XDFFM.CLKB 1.8151e-17
* device instance cc_XD4_XDFFM_M_XD5_XDFFM_M r0 *1 0,0
Ccc_XD4_XDFFM_M_XD5_XDFFM_M XD4.XDFFM.M XD5.XDFFM.M 2.4201e-17
* device instance cc_XD4_XDFFM_M_XD5_XDFFM_MB r0 *1 0,0
Ccc_XD4_XDFFM_M_XD5_XDFFM_MB XD4.XDFFM.M XD5.XDFFM.MB 1.21e-17
* device instance cc_XD4_XDFFM_M_XD5_XDFFM_S r0 *1 0,0
Ccc_XD4_XDFFM_M_XD5_XDFFM_S XD4.XDFFM.M XD5.XDFFM.S 1.8151e-17
* device instance cc_XD4_XDFFM_M_XD5_XDFFM_SB r0 *1 0,0
Ccc_XD4_XDFFM_M_XD5_XDFFM_SB XD4.XDFFM.M XD5.XDFFM.SB 1.8151e-17
* device instance cc_XD4_XDFFM_M_XD5_XDFFQ_CLKB r0 *1 0,0
Ccc_XD4_XDFFM_M_XD5_XDFFQ_CLKB XD4.XDFFM.M XD5.XDFFQ.CLKB 1.8151e-17
* device instance cc_XD4_XDFFM_M_XD5_XDFFQ_M r0 *1 0,0
Ccc_XD4_XDFFM_M_XD5_XDFFQ_M XD4.XDFFM.M XD5.XDFFQ.M 2.4201e-17
* device instance cc_XD4_XDFFM_M_XD5_XDFFQ_MB r0 *1 0,0
Ccc_XD4_XDFFM_M_XD5_XDFFQ_MB XD4.XDFFM.M XD5.XDFFQ.MB 1.21e-17
* device instance cc_XD4_XDFFM_M_XD5_XDFFQ_S r0 *1 0,0
Ccc_XD4_XDFFM_M_XD5_XDFFQ_S XD4.XDFFM.M XD5.XDFFQ.S 1.8151e-17
* device instance cc_XD4_XDFFM_M_XD5_XDFFQ_SB r0 *1 0,0
Ccc_XD4_XDFFM_M_XD5_XDFFQ_SB XD4.XDFFM.M XD5.XDFFQ.SB 1.8151e-17
* device instance cc_XD4_XDFFM_M_XD5_XN2_mid1 r0 *1 0,0
Ccc_XD4_XDFFM_M_XD5_XN2_mid1 XD4.XDFFM.M XD5.XN2.mid1 1.21e-17
* device instance cc_XD4_XDFFM_M_XD5_XN3_mid1 r0 *1 0,0
Ccc_XD4_XDFFM_M_XD5_XN3_mid1 XD4.XDFFM.M XD5.XN3.mid1 1.21e-17
* device instance cc_XD4_XDFFM_M_XD5_XN3_mid2 r0 *1 0,0
Ccc_XD4_XDFFM_M_XD5_XN3_mid2 XD4.XDFFM.M XD5.XN3.mid2 1.21e-17
* device instance cc_XD4_XDFFM_M_XD5_dmodout r0 *1 0,0
Ccc_XD4_XDFFM_M_XD5_dmodout XD4.XDFFM.M XD5.dmodout 1.21e-17
* device instance cc_XD4_XDFFM_M_XD5_dq r0 *1 0,0
Ccc_XD4_XDFFM_M_XD5_dq XD4.XDFFM.M XD5.dq 1.8151e-17
* device instance cc_XD4_XDFFM_M_XD5_nm r0 *1 0,0
Ccc_XD4_XDFFM_M_XD5_nm XD4.XDFFM.M XD5.nm 1.21e-17
* device instance cc_XD4_XDFFM_M_XD5_nt r0 *1 0,0
Ccc_XD4_XDFFM_M_XD5_nt XD4.XDFFM.M XD5.nt 1.21e-17
* device instance cc_XD4_XDFFM_M_XD5_t1 r0 *1 0,0
Ccc_XD4_XDFFM_M_XD5_t1 XD4.XDFFM.M XD5.t1 1.21e-17
* device instance cc_XD4_XDFFM_M_XFRT_CLKB r0 *1 0,0
Ccc_XD4_XDFFM_M_XFRT_CLKB XD4.XDFFM.M XFRT.CLKB 1.8151e-17
* device instance cc_XD4_XDFFM_M_XFRT_M r0 *1 0,0
Ccc_XD4_XDFFM_M_XFRT_M XD4.XDFFM.M XFRT.M 2.4201e-17
* device instance cc_XD4_XDFFM_M_XFRT_MB r0 *1 0,0
Ccc_XD4_XDFFM_M_XFRT_MB XD4.XDFFM.M XFRT.MB 1.21e-17
* device instance cc_XD4_XDFFM_M_XFRT_S r0 *1 0,0
Ccc_XD4_XDFFM_M_XFRT_S XD4.XDFFM.M XFRT.S 1.8151e-17
* device instance cc_XD4_XDFFM_M_XFRT_SB r0 *1 0,0
Ccc_XD4_XDFFM_M_XFRT_SB XD4.XDFFM.M XFRT.SB 1.8151e-17
* device instance cc_XD4_XDFFM_M_ck1 r0 *1 0,0
Ccc_XD4_XDFFM_M_ck1 XD4.XDFFM.M ck1 5.4452e-17
* device instance cc_XD4_XDFFM_M_ck2 r0 *1 0,0
Ccc_XD4_XDFFM_M_ck2 XD4.XDFFM.M ck2 5.4452e-17
* device instance cc_XD4_XDFFM_M_ck3 r0 *1 0,0
Ccc_XD4_XDFFM_M_ck3 XD4.XDFFM.M ck3 5.4452e-17
* device instance cc_XD4_XDFFM_M_ck4 r0 *1 0,0
Ccc_XD4_XDFFM_M_ck4 XD4.XDFFM.M ck4 6.0502e-17
* device instance cc_XD4_XDFFM_M_ck5 r0 *1 0,0
Ccc_XD4_XDFFM_M_ck5 XD4.XDFFM.M ck5 5.4452e-17
* device instance cc_XD4_XDFFM_M_mod0 r0 *1 0,0
Ccc_XD4_XDFFM_M_mod0 XD4.XDFFM.M mod0 2.4201e-17
* device instance cc_XD4_XDFFM_M_mod1 r0 *1 0,0
Ccc_XD4_XDFFM_M_mod1 XD4.XDFFM.M mod1 2.4201e-17
* device instance cc_XD4_XDFFM_M_mod2 r0 *1 0,0
Ccc_XD4_XDFFM_M_mod2 XD4.XDFFM.M mod2 2.4201e-17
* device instance cc_XD4_XDFFM_M_mod3 r0 *1 0,0
Ccc_XD4_XDFFM_M_mod3 XD4.XDFFM.M mod3 2.4201e-17
* device instance cc_XD4_XDFFM_M_mod4 r0 *1 0,0
Ccc_XD4_XDFFM_M_mod4 XD4.XDFFM.M mod4 2.4201e-17
* device instance cc_XD4_XDFFM_M_net1 r0 *1 0,0
Ccc_XD4_XDFFM_M_net1 XD4.XDFFM.M net1 1.21e-17
* device instance cc_XD4_XDFFM_MB_XD4_XDFFM_S r0 *1 0,0
Ccc_XD4_XDFFM_MB_XD4_XDFFM_S XD4.XDFFM.MB XD4.XDFFM.S 1.8151e-17
* device instance cc_XD4_XDFFM_MB_XD4_XDFFM_SB r0 *1 0,0
Ccc_XD4_XDFFM_MB_XD4_XDFFM_SB XD4.XDFFM.MB XD4.XDFFM.SB 1.8151e-17
* device instance cc_XD4_XDFFM_MB_XD4_XDFFQ_CLKB r0 *1 0,0
Ccc_XD4_XDFFM_MB_XD4_XDFFQ_CLKB XD4.XDFFM.MB XD4.XDFFQ.CLKB 1.8151e-17
* device instance cc_XD4_XDFFM_MB_XD4_XDFFQ_M r0 *1 0,0
Ccc_XD4_XDFFM_MB_XD4_XDFFQ_M XD4.XDFFM.MB XD4.XDFFQ.M 2.4201e-17
* device instance cc_XD4_XDFFM_MB_XD4_XDFFQ_MB r0 *1 0,0
Ccc_XD4_XDFFM_MB_XD4_XDFFQ_MB XD4.XDFFM.MB XD4.XDFFQ.MB 1.21e-17
* device instance cc_XD4_XDFFM_MB_XD4_XDFFQ_S r0 *1 0,0
Ccc_XD4_XDFFM_MB_XD4_XDFFQ_S XD4.XDFFM.MB XD4.XDFFQ.S 1.8151e-17
* device instance cc_XD4_XDFFM_MB_XD4_XDFFQ_SB r0 *1 0,0
Ccc_XD4_XDFFM_MB_XD4_XDFFQ_SB XD4.XDFFM.MB XD4.XDFFQ.SB 1.8151e-17
* device instance cc_XD4_XDFFM_MB_XD4_XNOR_midp r0 *1 0,0
Ccc_XD4_XDFFM_MB_XD4_XNOR_midp XD4.XDFFM.MB XD4.XNOR.midp 1.21e-17
* device instance cc_XD4_XDFFM_MB_XD4_dmodout r0 *1 0,0
Ccc_XD4_XDFFM_MB_XD4_dmodout XD4.XDFFM.MB XD4.dmodout 1.21e-17
* device instance cc_XD4_XDFFM_MB_XD4_dq r0 *1 0,0
Ccc_XD4_XDFFM_MB_XD4_dq XD4.XDFFM.MB XD4.dq 1.21e-17
* device instance cc_XD4_XDFFM_MB_XD4_nm r0 *1 0,0
Ccc_XD4_XDFFM_MB_XD4_nm XD4.XDFFM.MB XD4.nm 1.8151e-17
* device instance cc_XD4_XDFFM_MB_XD4_nt r0 *1 0,0
Ccc_XD4_XDFFM_MB_XD4_nt XD4.XDFFM.MB XD4.nt 2.4201e-17
* device instance cc_XD4_XDFFM_MB_XD4_t1 r0 *1 0,0
Ccc_XD4_XDFFM_MB_XD4_t1 XD4.XDFFM.MB XD4.t1 1.21e-17
* device instance cc_XD4_XDFFM_MB_XD5_XDFFM_CLKB r0 *1 0,0
Ccc_XD4_XDFFM_MB_XD5_XDFFM_CLKB XD4.XDFFM.MB XD5.XDFFM.CLKB 1.8151e-17
* device instance cc_XD4_XDFFM_MB_XD5_XDFFM_M r0 *1 0,0
Ccc_XD4_XDFFM_MB_XD5_XDFFM_M XD4.XDFFM.MB XD5.XDFFM.M 2.4201e-17
* device instance cc_XD4_XDFFM_MB_XD5_XDFFM_MB r0 *1 0,0
Ccc_XD4_XDFFM_MB_XD5_XDFFM_MB XD4.XDFFM.MB XD5.XDFFM.MB 1.21e-17
* device instance cc_XD4_XDFFM_MB_XD5_XDFFM_S r0 *1 0,0
Ccc_XD4_XDFFM_MB_XD5_XDFFM_S XD4.XDFFM.MB XD5.XDFFM.S 1.8151e-17
* device instance cc_XD4_XDFFM_MB_XD5_XDFFM_SB r0 *1 0,0
Ccc_XD4_XDFFM_MB_XD5_XDFFM_SB XD4.XDFFM.MB XD5.XDFFM.SB 1.8151e-17
* device instance cc_XD4_XDFFM_MB_XD5_XDFFQ_CLKB r0 *1 0,0
Ccc_XD4_XDFFM_MB_XD5_XDFFQ_CLKB XD4.XDFFM.MB XD5.XDFFQ.CLKB 1.8151e-17
* device instance cc_XD4_XDFFM_MB_XD5_XDFFQ_M r0 *1 0,0
Ccc_XD4_XDFFM_MB_XD5_XDFFQ_M XD4.XDFFM.MB XD5.XDFFQ.M 2.4201e-17
* device instance cc_XD4_XDFFM_MB_XD5_XDFFQ_MB r0 *1 0,0
Ccc_XD4_XDFFM_MB_XD5_XDFFQ_MB XD4.XDFFM.MB XD5.XDFFQ.MB 1.21e-17
* device instance cc_XD4_XDFFM_MB_XD5_XDFFQ_S r0 *1 0,0
Ccc_XD4_XDFFM_MB_XD5_XDFFQ_S XD4.XDFFM.MB XD5.XDFFQ.S 1.8151e-17
* device instance cc_XD4_XDFFM_MB_XD5_XDFFQ_SB r0 *1 0,0
Ccc_XD4_XDFFM_MB_XD5_XDFFQ_SB XD4.XDFFM.MB XD5.XDFFQ.SB 1.8151e-17
* device instance cc_XD4_XDFFM_MB_XD5_XN2_mid1 r0 *1 0,0
Ccc_XD4_XDFFM_MB_XD5_XN2_mid1 XD4.XDFFM.MB XD5.XN2.mid1 1.21e-17
* device instance cc_XD4_XDFFM_MB_XD5_XN3_mid1 r0 *1 0,0
Ccc_XD4_XDFFM_MB_XD5_XN3_mid1 XD4.XDFFM.MB XD5.XN3.mid1 1.21e-17
* device instance cc_XD4_XDFFM_MB_XD5_XN3_mid2 r0 *1 0,0
Ccc_XD4_XDFFM_MB_XD5_XN3_mid2 XD4.XDFFM.MB XD5.XN3.mid2 1.21e-17
* device instance cc_XD4_XDFFM_MB_XD5_dmodout r0 *1 0,0
Ccc_XD4_XDFFM_MB_XD5_dmodout XD4.XDFFM.MB XD5.dmodout 1.21e-17
* device instance cc_XD4_XDFFM_MB_XD5_dq r0 *1 0,0
Ccc_XD4_XDFFM_MB_XD5_dq XD4.XDFFM.MB XD5.dq 1.8151e-17
* device instance cc_XD4_XDFFM_MB_XD5_nm r0 *1 0,0
Ccc_XD4_XDFFM_MB_XD5_nm XD4.XDFFM.MB XD5.nm 1.21e-17
* device instance cc_XD4_XDFFM_MB_XD5_nt r0 *1 0,0
Ccc_XD4_XDFFM_MB_XD5_nt XD4.XDFFM.MB XD5.nt 1.21e-17
* device instance cc_XD4_XDFFM_MB_XD5_t1 r0 *1 0,0
Ccc_XD4_XDFFM_MB_XD5_t1 XD4.XDFFM.MB XD5.t1 1.21e-17
* device instance cc_XD4_XDFFM_MB_XFRT_CLKB r0 *1 0,0
Ccc_XD4_XDFFM_MB_XFRT_CLKB XD4.XDFFM.MB XFRT.CLKB 1.8151e-17
* device instance cc_XD4_XDFFM_MB_XFRT_M r0 *1 0,0
Ccc_XD4_XDFFM_MB_XFRT_M XD4.XDFFM.MB XFRT.M 2.4201e-17
* device instance cc_XD4_XDFFM_MB_XFRT_MB r0 *1 0,0
Ccc_XD4_XDFFM_MB_XFRT_MB XD4.XDFFM.MB XFRT.MB 1.21e-17
* device instance cc_XD4_XDFFM_MB_XFRT_S r0 *1 0,0
Ccc_XD4_XDFFM_MB_XFRT_S XD4.XDFFM.MB XFRT.S 1.8151e-17
* device instance cc_XD4_XDFFM_MB_XFRT_SB r0 *1 0,0
Ccc_XD4_XDFFM_MB_XFRT_SB XD4.XDFFM.MB XFRT.SB 1.8151e-17
* device instance cc_XD4_XDFFM_MB_ck1 r0 *1 0,0
Ccc_XD4_XDFFM_MB_ck1 XD4.XDFFM.MB ck1 5.4452e-17
* device instance cc_XD4_XDFFM_MB_ck2 r0 *1 0,0
Ccc_XD4_XDFFM_MB_ck2 XD4.XDFFM.MB ck2 5.4452e-17
* device instance cc_XD4_XDFFM_MB_ck3 r0 *1 0,0
Ccc_XD4_XDFFM_MB_ck3 XD4.XDFFM.MB ck3 5.4452e-17
* device instance cc_XD4_XDFFM_MB_ck4 r0 *1 0,0
Ccc_XD4_XDFFM_MB_ck4 XD4.XDFFM.MB ck4 6.0502e-17
* device instance cc_XD4_XDFFM_MB_ck5 r0 *1 0,0
Ccc_XD4_XDFFM_MB_ck5 XD4.XDFFM.MB ck5 5.4452e-17
* device instance cc_XD4_XDFFM_MB_mod0 r0 *1 0,0
Ccc_XD4_XDFFM_MB_mod0 XD4.XDFFM.MB mod0 2.4201e-17
* device instance cc_XD4_XDFFM_MB_mod1 r0 *1 0,0
Ccc_XD4_XDFFM_MB_mod1 XD4.XDFFM.MB mod1 2.4201e-17
* device instance cc_XD4_XDFFM_MB_mod2 r0 *1 0,0
Ccc_XD4_XDFFM_MB_mod2 XD4.XDFFM.MB mod2 2.4201e-17
* device instance cc_XD4_XDFFM_MB_mod3 r0 *1 0,0
Ccc_XD4_XDFFM_MB_mod3 XD4.XDFFM.MB mod3 2.4201e-17
* device instance cc_XD4_XDFFM_MB_mod4 r0 *1 0,0
Ccc_XD4_XDFFM_MB_mod4 XD4.XDFFM.MB mod4 2.4201e-17
* device instance cc_XD4_XDFFM_MB_net1 r0 *1 0,0
Ccc_XD4_XDFFM_MB_net1 XD4.XDFFM.MB net1 1.21e-17
* device instance cc_XD4_XDFFM_S_XD4_XDFFM_SB r0 *1 0,0
Ccc_XD4_XDFFM_S_XD4_XDFFM_SB XD4.XDFFM.S XD4.XDFFM.SB 4.0738e-17
* device instance cc_XD4_XDFFM_S_XD4_XDFFQ_CLKB r0 *1 0,0
Ccc_XD4_XDFFM_S_XD4_XDFFQ_CLKB XD4.XDFFM.S XD4.XDFFQ.CLKB 1.8151e-17
* device instance cc_XD4_XDFFM_S_XD4_XDFFQ_M r0 *1 0,0
Ccc_XD4_XDFFM_S_XD4_XDFFQ_M XD4.XDFFM.S XD4.XDFFQ.M 2.4201e-17
* device instance cc_XD4_XDFFM_S_XD4_XDFFQ_MB r0 *1 0,0
Ccc_XD4_XDFFM_S_XD4_XDFFQ_MB XD4.XDFFM.S XD4.XDFFQ.MB 1.21e-17
* device instance cc_XD4_XDFFM_S_XD4_XDFFQ_S r0 *1 0,0
Ccc_XD4_XDFFM_S_XD4_XDFFQ_S XD4.XDFFM.S XD4.XDFFQ.S 1.8151e-17
* device instance cc_XD4_XDFFM_S_XD4_XDFFQ_SB r0 *1 0,0
Ccc_XD4_XDFFM_S_XD4_XDFFQ_SB XD4.XDFFM.S XD4.XDFFQ.SB 1.8151e-17
* device instance cc_XD4_XDFFM_S_XD4_XNOR_midp r0 *1 0,0
Ccc_XD4_XDFFM_S_XD4_XNOR_midp XD4.XDFFM.S XD4.XNOR.midp 1.21e-17
* device instance cc_XD4_XDFFM_S_XD4_dmodout r0 *1 0,0
Ccc_XD4_XDFFM_S_XD4_dmodout XD4.XDFFM.S XD4.dmodout 1.21e-17
* device instance cc_XD4_XDFFM_S_XD4_dq r0 *1 0,0
Ccc_XD4_XDFFM_S_XD4_dq XD4.XDFFM.S XD4.dq 1.21e-17
* device instance cc_XD4_XDFFM_S_XD4_nm r0 *1 0,0
Ccc_XD4_XDFFM_S_XD4_nm XD4.XDFFM.S XD4.nm 1.8151e-17
* device instance cc_XD4_XDFFM_S_XD4_nt r0 *1 0,0
Ccc_XD4_XDFFM_S_XD4_nt XD4.XDFFM.S XD4.nt 2.4201e-17
* device instance cc_XD4_XDFFM_S_XD4_t1 r0 *1 0,0
Ccc_XD4_XDFFM_S_XD4_t1 XD4.XDFFM.S XD4.t1 1.21e-17
* device instance cc_XD4_XDFFM_S_XD5_XDFFM_CLKB r0 *1 0,0
Ccc_XD4_XDFFM_S_XD5_XDFFM_CLKB XD4.XDFFM.S XD5.XDFFM.CLKB 1.8151e-17
* device instance cc_XD4_XDFFM_S_XD5_XDFFM_M r0 *1 0,0
Ccc_XD4_XDFFM_S_XD5_XDFFM_M XD4.XDFFM.S XD5.XDFFM.M 2.4201e-17
* device instance cc_XD4_XDFFM_S_XD5_XDFFM_MB r0 *1 0,0
Ccc_XD4_XDFFM_S_XD5_XDFFM_MB XD4.XDFFM.S XD5.XDFFM.MB 1.21e-17
* device instance cc_XD4_XDFFM_S_XD5_XDFFM_S r0 *1 0,0
Ccc_XD4_XDFFM_S_XD5_XDFFM_S XD4.XDFFM.S XD5.XDFFM.S 1.8151e-17
* device instance cc_XD4_XDFFM_S_XD5_XDFFM_SB r0 *1 0,0
Ccc_XD4_XDFFM_S_XD5_XDFFM_SB XD4.XDFFM.S XD5.XDFFM.SB 1.8151e-17
* device instance cc_XD4_XDFFM_S_XD5_XDFFQ_CLKB r0 *1 0,0
Ccc_XD4_XDFFM_S_XD5_XDFFQ_CLKB XD4.XDFFM.S XD5.XDFFQ.CLKB 1.8151e-17
* device instance cc_XD4_XDFFM_S_XD5_XDFFQ_M r0 *1 0,0
Ccc_XD4_XDFFM_S_XD5_XDFFQ_M XD4.XDFFM.S XD5.XDFFQ.M 2.4201e-17
* device instance cc_XD4_XDFFM_S_XD5_XDFFQ_MB r0 *1 0,0
Ccc_XD4_XDFFM_S_XD5_XDFFQ_MB XD4.XDFFM.S XD5.XDFFQ.MB 1.21e-17
* device instance cc_XD4_XDFFM_S_XD5_XDFFQ_S r0 *1 0,0
Ccc_XD4_XDFFM_S_XD5_XDFFQ_S XD4.XDFFM.S XD5.XDFFQ.S 1.8151e-17
* device instance cc_XD4_XDFFM_S_XD5_XDFFQ_SB r0 *1 0,0
Ccc_XD4_XDFFM_S_XD5_XDFFQ_SB XD4.XDFFM.S XD5.XDFFQ.SB 1.8151e-17
* device instance cc_XD4_XDFFM_S_XD5_XN2_mid1 r0 *1 0,0
Ccc_XD4_XDFFM_S_XD5_XN2_mid1 XD4.XDFFM.S XD5.XN2.mid1 1.21e-17
* device instance cc_XD4_XDFFM_S_XD5_XN3_mid1 r0 *1 0,0
Ccc_XD4_XDFFM_S_XD5_XN3_mid1 XD4.XDFFM.S XD5.XN3.mid1 1.21e-17
* device instance cc_XD4_XDFFM_S_XD5_XN3_mid2 r0 *1 0,0
Ccc_XD4_XDFFM_S_XD5_XN3_mid2 XD4.XDFFM.S XD5.XN3.mid2 1.21e-17
* device instance cc_XD4_XDFFM_S_XD5_dmodout r0 *1 0,0
Ccc_XD4_XDFFM_S_XD5_dmodout XD4.XDFFM.S XD5.dmodout 1.21e-17
* device instance cc_XD4_XDFFM_S_XD5_dq r0 *1 0,0
Ccc_XD4_XDFFM_S_XD5_dq XD4.XDFFM.S XD5.dq 1.8151e-17
* device instance cc_XD4_XDFFM_S_XD5_nm r0 *1 0,0
Ccc_XD4_XDFFM_S_XD5_nm XD4.XDFFM.S XD5.nm 1.21e-17
* device instance cc_XD4_XDFFM_S_XD5_nt r0 *1 0,0
Ccc_XD4_XDFFM_S_XD5_nt XD4.XDFFM.S XD5.nt 1.21e-17
* device instance cc_XD4_XDFFM_S_XD5_t1 r0 *1 0,0
Ccc_XD4_XDFFM_S_XD5_t1 XD4.XDFFM.S XD5.t1 1.21e-17
* device instance cc_XD4_XDFFM_S_XFRT_CLKB r0 *1 0,0
Ccc_XD4_XDFFM_S_XFRT_CLKB XD4.XDFFM.S XFRT.CLKB 1.8151e-17
* device instance cc_XD4_XDFFM_S_XFRT_M r0 *1 0,0
Ccc_XD4_XDFFM_S_XFRT_M XD4.XDFFM.S XFRT.M 2.4201e-17
* device instance cc_XD4_XDFFM_S_XFRT_MB r0 *1 0,0
Ccc_XD4_XDFFM_S_XFRT_MB XD4.XDFFM.S XFRT.MB 1.21e-17
* device instance cc_XD4_XDFFM_S_XFRT_S r0 *1 0,0
Ccc_XD4_XDFFM_S_XFRT_S XD4.XDFFM.S XFRT.S 1.8151e-17
* device instance cc_XD4_XDFFM_S_XFRT_SB r0 *1 0,0
Ccc_XD4_XDFFM_S_XFRT_SB XD4.XDFFM.S XFRT.SB 1.8151e-17
* device instance cc_XD4_XDFFM_S_ck1 r0 *1 0,0
Ccc_XD4_XDFFM_S_ck1 XD4.XDFFM.S ck1 5.4452e-17
* device instance cc_XD4_XDFFM_S_ck2 r0 *1 0,0
Ccc_XD4_XDFFM_S_ck2 XD4.XDFFM.S ck2 5.4452e-17
* device instance cc_XD4_XDFFM_S_ck3 r0 *1 0,0
Ccc_XD4_XDFFM_S_ck3 XD4.XDFFM.S ck3 5.4452e-17
* device instance cc_XD4_XDFFM_S_ck4 r0 *1 0,0
Ccc_XD4_XDFFM_S_ck4 XD4.XDFFM.S ck4 5.4452e-17
* device instance cc_XD4_XDFFM_S_ck5 r0 *1 0,0
Ccc_XD4_XDFFM_S_ck5 XD4.XDFFM.S ck5 5.4452e-17
* device instance cc_XD4_XDFFM_S_mod0 r0 *1 0,0
Ccc_XD4_XDFFM_S_mod0 XD4.XDFFM.S mod0 2.4201e-17
* device instance cc_XD4_XDFFM_S_mod1 r0 *1 0,0
Ccc_XD4_XDFFM_S_mod1 XD4.XDFFM.S mod1 2.4201e-17
* device instance cc_XD4_XDFFM_S_mod2 r0 *1 0,0
Ccc_XD4_XDFFM_S_mod2 XD4.XDFFM.S mod2 2.4201e-17
* device instance cc_XD4_XDFFM_S_mod3 r0 *1 0,0
Ccc_XD4_XDFFM_S_mod3 XD4.XDFFM.S mod3 2.4201e-17
* device instance cc_XD4_XDFFM_S_mod4 r0 *1 0,0
Ccc_XD4_XDFFM_S_mod4 XD4.XDFFM.S mod4 2.4201e-17
* device instance cc_XD4_XDFFM_S_net1 r0 *1 0,0
Ccc_XD4_XDFFM_S_net1 XD4.XDFFM.S net1 1.21e-17
* device instance cc_XD4_XDFFM_SB_XD4_XDFFQ_CLKB r0 *1 0,0
Ccc_XD4_XDFFM_SB_XD4_XDFFQ_CLKB XD4.XDFFM.SB XD4.XDFFQ.CLKB 1.8151e-17
* device instance cc_XD4_XDFFM_SB_XD4_XDFFQ_M r0 *1 0,0
Ccc_XD4_XDFFM_SB_XD4_XDFFQ_M XD4.XDFFM.SB XD4.XDFFQ.M 2.4201e-17
* device instance cc_XD4_XDFFM_SB_XD4_XDFFQ_MB r0 *1 0,0
Ccc_XD4_XDFFM_SB_XD4_XDFFQ_MB XD4.XDFFM.SB XD4.XDFFQ.MB 1.21e-17
* device instance cc_XD4_XDFFM_SB_XD4_XDFFQ_S r0 *1 0,0
Ccc_XD4_XDFFM_SB_XD4_XDFFQ_S XD4.XDFFM.SB XD4.XDFFQ.S 1.8151e-17
* device instance cc_XD4_XDFFM_SB_XD4_XDFFQ_SB r0 *1 0,0
Ccc_XD4_XDFFM_SB_XD4_XDFFQ_SB XD4.XDFFM.SB XD4.XDFFQ.SB 1.8151e-17
* device instance cc_XD4_XDFFM_SB_XD4_XNOR_midp r0 *1 0,0
Ccc_XD4_XDFFM_SB_XD4_XNOR_midp XD4.XDFFM.SB XD4.XNOR.midp 1.21e-17
* device instance cc_XD4_XDFFM_SB_XD4_dmodout r0 *1 0,0
Ccc_XD4_XDFFM_SB_XD4_dmodout XD4.XDFFM.SB XD4.dmodout 1.21e-17
* device instance cc_XD4_XDFFM_SB_XD4_dq r0 *1 0,0
Ccc_XD4_XDFFM_SB_XD4_dq XD4.XDFFM.SB XD4.dq 1.21e-17
* device instance cc_XD4_XDFFM_SB_XD4_nm r0 *1 0,0
Ccc_XD4_XDFFM_SB_XD4_nm XD4.XDFFM.SB XD4.nm 1.8151e-17
* device instance cc_XD4_XDFFM_SB_XD4_nt r0 *1 0,0
Ccc_XD4_XDFFM_SB_XD4_nt XD4.XDFFM.SB XD4.nt 2.4201e-17
* device instance cc_XD4_XDFFM_SB_XD4_t1 r0 *1 0,0
Ccc_XD4_XDFFM_SB_XD4_t1 XD4.XDFFM.SB XD4.t1 1.21e-17
* device instance cc_XD4_XDFFM_SB_XD5_XDFFM_CLKB r0 *1 0,0
Ccc_XD4_XDFFM_SB_XD5_XDFFM_CLKB XD4.XDFFM.SB XD5.XDFFM.CLKB 1.8151e-17
* device instance cc_XD4_XDFFM_SB_XD5_XDFFM_M r0 *1 0,0
Ccc_XD4_XDFFM_SB_XD5_XDFFM_M XD4.XDFFM.SB XD5.XDFFM.M 2.4201e-17
* device instance cc_XD4_XDFFM_SB_XD5_XDFFM_MB r0 *1 0,0
Ccc_XD4_XDFFM_SB_XD5_XDFFM_MB XD4.XDFFM.SB XD5.XDFFM.MB 1.21e-17
* device instance cc_XD4_XDFFM_SB_XD5_XDFFM_S r0 *1 0,0
Ccc_XD4_XDFFM_SB_XD5_XDFFM_S XD4.XDFFM.SB XD5.XDFFM.S 1.8151e-17
* device instance cc_XD4_XDFFM_SB_XD5_XDFFM_SB r0 *1 0,0
Ccc_XD4_XDFFM_SB_XD5_XDFFM_SB XD4.XDFFM.SB XD5.XDFFM.SB 1.8151e-17
* device instance cc_XD4_XDFFM_SB_XD5_XDFFQ_CLKB r0 *1 0,0
Ccc_XD4_XDFFM_SB_XD5_XDFFQ_CLKB XD4.XDFFM.SB XD5.XDFFQ.CLKB 1.8151e-17
* device instance cc_XD4_XDFFM_SB_XD5_XDFFQ_M r0 *1 0,0
Ccc_XD4_XDFFM_SB_XD5_XDFFQ_M XD4.XDFFM.SB XD5.XDFFQ.M 2.4201e-17
* device instance cc_XD4_XDFFM_SB_XD5_XDFFQ_MB r0 *1 0,0
Ccc_XD4_XDFFM_SB_XD5_XDFFQ_MB XD4.XDFFM.SB XD5.XDFFQ.MB 1.21e-17
* device instance cc_XD4_XDFFM_SB_XD5_XDFFQ_S r0 *1 0,0
Ccc_XD4_XDFFM_SB_XD5_XDFFQ_S XD4.XDFFM.SB XD5.XDFFQ.S 1.8151e-17
* device instance cc_XD4_XDFFM_SB_XD5_XDFFQ_SB r0 *1 0,0
Ccc_XD4_XDFFM_SB_XD5_XDFFQ_SB XD4.XDFFM.SB XD5.XDFFQ.SB 1.8151e-17
* device instance cc_XD4_XDFFM_SB_XD5_XN2_mid1 r0 *1 0,0
Ccc_XD4_XDFFM_SB_XD5_XN2_mid1 XD4.XDFFM.SB XD5.XN2.mid1 1.21e-17
* device instance cc_XD4_XDFFM_SB_XD5_XN3_mid1 r0 *1 0,0
Ccc_XD4_XDFFM_SB_XD5_XN3_mid1 XD4.XDFFM.SB XD5.XN3.mid1 1.21e-17
* device instance cc_XD4_XDFFM_SB_XD5_XN3_mid2 r0 *1 0,0
Ccc_XD4_XDFFM_SB_XD5_XN3_mid2 XD4.XDFFM.SB XD5.XN3.mid2 1.21e-17
* device instance cc_XD4_XDFFM_SB_XD5_dmodout r0 *1 0,0
Ccc_XD4_XDFFM_SB_XD5_dmodout XD4.XDFFM.SB XD5.dmodout 1.21e-17
* device instance cc_XD4_XDFFM_SB_XD5_dq r0 *1 0,0
Ccc_XD4_XDFFM_SB_XD5_dq XD4.XDFFM.SB XD5.dq 1.8151e-17
* device instance cc_XD4_XDFFM_SB_XD5_nm r0 *1 0,0
Ccc_XD4_XDFFM_SB_XD5_nm XD4.XDFFM.SB XD5.nm 1.21e-17
* device instance cc_XD4_XDFFM_SB_XD5_nt r0 *1 0,0
Ccc_XD4_XDFFM_SB_XD5_nt XD4.XDFFM.SB XD5.nt 1.21e-17
* device instance cc_XD4_XDFFM_SB_XD5_t1 r0 *1 0,0
Ccc_XD4_XDFFM_SB_XD5_t1 XD4.XDFFM.SB XD5.t1 1.21e-17
* device instance cc_XD4_XDFFM_SB_XFRT_CLKB r0 *1 0,0
Ccc_XD4_XDFFM_SB_XFRT_CLKB XD4.XDFFM.SB XFRT.CLKB 1.8151e-17
* device instance cc_XD4_XDFFM_SB_XFRT_M r0 *1 0,0
Ccc_XD4_XDFFM_SB_XFRT_M XD4.XDFFM.SB XFRT.M 2.4201e-17
* device instance cc_XD4_XDFFM_SB_XFRT_MB r0 *1 0,0
Ccc_XD4_XDFFM_SB_XFRT_MB XD4.XDFFM.SB XFRT.MB 1.21e-17
* device instance cc_XD4_XDFFM_SB_XFRT_S r0 *1 0,0
Ccc_XD4_XDFFM_SB_XFRT_S XD4.XDFFM.SB XFRT.S 1.8151e-17
* device instance cc_XD4_XDFFM_SB_XFRT_SB r0 *1 0,0
Ccc_XD4_XDFFM_SB_XFRT_SB XD4.XDFFM.SB XFRT.SB 1.8151e-17
* device instance cc_XD4_XDFFM_SB_ck1 r0 *1 0,0
Ccc_XD4_XDFFM_SB_ck1 XD4.XDFFM.SB ck1 5.4452e-17
* device instance cc_XD4_XDFFM_SB_ck2 r0 *1 0,0
Ccc_XD4_XDFFM_SB_ck2 XD4.XDFFM.SB ck2 5.4452e-17
* device instance cc_XD4_XDFFM_SB_ck3 r0 *1 0,0
Ccc_XD4_XDFFM_SB_ck3 XD4.XDFFM.SB ck3 5.4452e-17
* device instance cc_XD4_XDFFM_SB_ck4 r0 *1 0,0
Ccc_XD4_XDFFM_SB_ck4 XD4.XDFFM.SB ck4 5.4452e-17
* device instance cc_XD4_XDFFM_SB_ck5 r0 *1 0,0
Ccc_XD4_XDFFM_SB_ck5 XD4.XDFFM.SB ck5 5.4452e-17
* device instance cc_XD4_XDFFM_SB_mod0 r0 *1 0,0
Ccc_XD4_XDFFM_SB_mod0 XD4.XDFFM.SB mod0 2.4201e-17
* device instance cc_XD4_XDFFM_SB_mod1 r0 *1 0,0
Ccc_XD4_XDFFM_SB_mod1 XD4.XDFFM.SB mod1 2.4201e-17
* device instance cc_XD4_XDFFM_SB_mod2 r0 *1 0,0
Ccc_XD4_XDFFM_SB_mod2 XD4.XDFFM.SB mod2 2.4201e-17
* device instance cc_XD4_XDFFM_SB_mod3 r0 *1 0,0
Ccc_XD4_XDFFM_SB_mod3 XD4.XDFFM.SB mod3 2.4201e-17
* device instance cc_XD4_XDFFM_SB_mod4 r0 *1 0,0
Ccc_XD4_XDFFM_SB_mod4 XD4.XDFFM.SB mod4 2.4201e-17
* device instance cc_XD4_XDFFM_SB_net1 r0 *1 0,0
Ccc_XD4_XDFFM_SB_net1 XD4.XDFFM.SB net1 1.21e-17
* device instance cc_XD4_XDFFQ_CLKB_XD4_XDFFQ_M r0 *1 0,0
Ccc_XD4_XDFFQ_CLKB_XD4_XDFFQ_M XD4.XDFFQ.CLKB XD4.XDFFQ.M 4.2352e-17
* device instance cc_XD4_XDFFQ_CLKB_XD4_XDFFQ_MB r0 *1 0,0
Ccc_XD4_XDFFQ_CLKB_XD4_XDFFQ_MB XD4.XDFFQ.CLKB XD4.XDFFQ.MB 2.4201e-17
* device instance cc_XD4_XDFFQ_CLKB_XD4_XDFFQ_S r0 *1 0,0
Ccc_XD4_XDFFQ_CLKB_XD4_XDFFQ_S XD4.XDFFQ.CLKB XD4.XDFFQ.S 1.8151e-17
* device instance cc_XD4_XDFFQ_CLKB_XD4_XDFFQ_SB r0 *1 0,0
Ccc_XD4_XDFFQ_CLKB_XD4_XDFFQ_SB XD4.XDFFQ.CLKB XD4.XDFFQ.SB 1.8151e-17
* device instance cc_XD4_XDFFQ_CLKB_XD4_XN2_mid1 r0 *1 0,0
Ccc_XD4_XDFFQ_CLKB_XD4_XN2_mid1 XD4.XDFFQ.CLKB XD4.XN2.mid1 1.21e-17
* device instance cc_XD4_XDFFQ_CLKB_XD4_XNOR_midp r0 *1 0,0
Ccc_XD4_XDFFQ_CLKB_XD4_XNOR_midp XD4.XDFFQ.CLKB XD4.XNOR.midp 1.21e-17
* device instance cc_XD4_XDFFQ_CLKB_XD4_dmodout r0 *1 0,0
Ccc_XD4_XDFFQ_CLKB_XD4_dmodout XD4.XDFFQ.CLKB XD4.dmodout 1.21e-17
* device instance cc_XD4_XDFFQ_CLKB_XD4_dq r0 *1 0,0
Ccc_XD4_XDFFQ_CLKB_XD4_dq XD4.XDFFQ.CLKB XD4.dq 1.8151e-17
* device instance cc_XD4_XDFFQ_CLKB_XD4_nm r0 *1 0,0
Ccc_XD4_XDFFQ_CLKB_XD4_nm XD4.XDFFQ.CLKB XD4.nm 1.21e-17
* device instance cc_XD4_XDFFQ_CLKB_XD4_nt r0 *1 0,0
Ccc_XD4_XDFFQ_CLKB_XD4_nt XD4.XDFFQ.CLKB XD4.nt 2.4201e-17
* device instance cc_XD4_XDFFQ_CLKB_XD4_t1 r0 *1 0,0
Ccc_XD4_XDFFQ_CLKB_XD4_t1 XD4.XDFFQ.CLKB XD4.t1 1.21e-17
* device instance cc_XD4_XDFFQ_CLKB_XD5_XDFFM_CLKB r0 *1 0,0
Ccc_XD4_XDFFQ_CLKB_XD5_XDFFM_CLKB XD4.XDFFQ.CLKB XD5.XDFFM.CLKB 1.8151e-17
* device instance cc_XD4_XDFFQ_CLKB_XD5_XDFFM_M r0 *1 0,0
Ccc_XD4_XDFFQ_CLKB_XD5_XDFFM_M XD4.XDFFQ.CLKB XD5.XDFFM.M 2.4201e-17
* device instance cc_XD4_XDFFQ_CLKB_XD5_XDFFM_MB r0 *1 0,0
Ccc_XD4_XDFFQ_CLKB_XD5_XDFFM_MB XD4.XDFFQ.CLKB XD5.XDFFM.MB 1.21e-17
* device instance cc_XD4_XDFFQ_CLKB_XD5_XDFFM_S r0 *1 0,0
Ccc_XD4_XDFFQ_CLKB_XD5_XDFFM_S XD4.XDFFQ.CLKB XD5.XDFFM.S 1.8151e-17
* device instance cc_XD4_XDFFQ_CLKB_XD5_XDFFM_SB r0 *1 0,0
Ccc_XD4_XDFFQ_CLKB_XD5_XDFFM_SB XD4.XDFFQ.CLKB XD5.XDFFM.SB 1.8151e-17
* device instance cc_XD4_XDFFQ_CLKB_XD5_XDFFQ_CLKB r0 *1 0,0
Ccc_XD4_XDFFQ_CLKB_XD5_XDFFQ_CLKB XD4.XDFFQ.CLKB XD5.XDFFQ.CLKB 1.8151e-17
* device instance cc_XD4_XDFFQ_CLKB_XD5_XDFFQ_M r0 *1 0,0
Ccc_XD4_XDFFQ_CLKB_XD5_XDFFQ_M XD4.XDFFQ.CLKB XD5.XDFFQ.M 2.4201e-17
* device instance cc_XD4_XDFFQ_CLKB_XD5_XDFFQ_MB r0 *1 0,0
Ccc_XD4_XDFFQ_CLKB_XD5_XDFFQ_MB XD4.XDFFQ.CLKB XD5.XDFFQ.MB 1.21e-17
* device instance cc_XD4_XDFFQ_CLKB_XD5_XDFFQ_S r0 *1 0,0
Ccc_XD4_XDFFQ_CLKB_XD5_XDFFQ_S XD4.XDFFQ.CLKB XD5.XDFFQ.S 1.8151e-17
* device instance cc_XD4_XDFFQ_CLKB_XD5_XDFFQ_SB r0 *1 0,0
Ccc_XD4_XDFFQ_CLKB_XD5_XDFFQ_SB XD4.XDFFQ.CLKB XD5.XDFFQ.SB 1.8151e-17
* device instance cc_XD4_XDFFQ_CLKB_XD5_XN2_mid1 r0 *1 0,0
Ccc_XD4_XDFFQ_CLKB_XD5_XN2_mid1 XD4.XDFFQ.CLKB XD5.XN2.mid1 1.21e-17
* device instance cc_XD4_XDFFQ_CLKB_XD5_XN3_mid1 r0 *1 0,0
Ccc_XD4_XDFFQ_CLKB_XD5_XN3_mid1 XD4.XDFFQ.CLKB XD5.XN3.mid1 1.21e-17
* device instance cc_XD4_XDFFQ_CLKB_XD5_XN3_mid2 r0 *1 0,0
Ccc_XD4_XDFFQ_CLKB_XD5_XN3_mid2 XD4.XDFFQ.CLKB XD5.XN3.mid2 1.21e-17
* device instance cc_XD4_XDFFQ_CLKB_XD5_dmodout r0 *1 0,0
Ccc_XD4_XDFFQ_CLKB_XD5_dmodout XD4.XDFFQ.CLKB XD5.dmodout 1.21e-17
* device instance cc_XD4_XDFFQ_CLKB_XD5_dq r0 *1 0,0
Ccc_XD4_XDFFQ_CLKB_XD5_dq XD4.XDFFQ.CLKB XD5.dq 1.8151e-17
* device instance cc_XD4_XDFFQ_CLKB_XD5_nm r0 *1 0,0
Ccc_XD4_XDFFQ_CLKB_XD5_nm XD4.XDFFQ.CLKB XD5.nm 1.21e-17
* device instance cc_XD4_XDFFQ_CLKB_XD5_nt r0 *1 0,0
Ccc_XD4_XDFFQ_CLKB_XD5_nt XD4.XDFFQ.CLKB XD5.nt 1.21e-17
* device instance cc_XD4_XDFFQ_CLKB_XD5_t1 r0 *1 0,0
Ccc_XD4_XDFFQ_CLKB_XD5_t1 XD4.XDFFQ.CLKB XD5.t1 1.21e-17
* device instance cc_XD4_XDFFQ_CLKB_XFRT_CLKB r0 *1 0,0
Ccc_XD4_XDFFQ_CLKB_XFRT_CLKB XD4.XDFFQ.CLKB XFRT.CLKB 1.8151e-17
* device instance cc_XD4_XDFFQ_CLKB_XFRT_M r0 *1 0,0
Ccc_XD4_XDFFQ_CLKB_XFRT_M XD4.XDFFQ.CLKB XFRT.M 2.4201e-17
* device instance cc_XD4_XDFFQ_CLKB_XFRT_MB r0 *1 0,0
Ccc_XD4_XDFFQ_CLKB_XFRT_MB XD4.XDFFQ.CLKB XFRT.MB 1.21e-17
* device instance cc_XD4_XDFFQ_CLKB_XFRT_S r0 *1 0,0
Ccc_XD4_XDFFQ_CLKB_XFRT_S XD4.XDFFQ.CLKB XFRT.S 1.8151e-17
* device instance cc_XD4_XDFFQ_CLKB_XFRT_SB r0 *1 0,0
Ccc_XD4_XDFFQ_CLKB_XFRT_SB XD4.XDFFQ.CLKB XFRT.SB 1.8151e-17
* device instance cc_XD4_XDFFQ_CLKB_ck1 r0 *1 0,0
Ccc_XD4_XDFFQ_CLKB_ck1 XD4.XDFFQ.CLKB ck1 5.4452e-17
* device instance cc_XD4_XDFFQ_CLKB_ck2 r0 *1 0,0
Ccc_XD4_XDFFQ_CLKB_ck2 XD4.XDFFQ.CLKB ck2 5.4452e-17
* device instance cc_XD4_XDFFQ_CLKB_ck3 r0 *1 0,0
Ccc_XD4_XDFFQ_CLKB_ck3 XD4.XDFFQ.CLKB ck3 5.4452e-17
* device instance cc_XD4_XDFFQ_CLKB_ck4 r0 *1 0,0
Ccc_XD4_XDFFQ_CLKB_ck4 XD4.XDFFQ.CLKB ck4 6.0502e-17
* device instance cc_XD4_XDFFQ_CLKB_ck5 r0 *1 0,0
Ccc_XD4_XDFFQ_CLKB_ck5 XD4.XDFFQ.CLKB ck5 5.4452e-17
* device instance cc_XD4_XDFFQ_CLKB_mod0 r0 *1 0,0
Ccc_XD4_XDFFQ_CLKB_mod0 XD4.XDFFQ.CLKB mod0 2.4201e-17
* device instance cc_XD4_XDFFQ_CLKB_mod1 r0 *1 0,0
Ccc_XD4_XDFFQ_CLKB_mod1 XD4.XDFFQ.CLKB mod1 2.4201e-17
* device instance cc_XD4_XDFFQ_CLKB_mod2 r0 *1 0,0
Ccc_XD4_XDFFQ_CLKB_mod2 XD4.XDFFQ.CLKB mod2 2.4201e-17
* device instance cc_XD4_XDFFQ_CLKB_mod3 r0 *1 0,0
Ccc_XD4_XDFFQ_CLKB_mod3 XD4.XDFFQ.CLKB mod3 2.4201e-17
* device instance cc_XD4_XDFFQ_CLKB_mod4 r0 *1 0,0
Ccc_XD4_XDFFQ_CLKB_mod4 XD4.XDFFQ.CLKB mod4 2.4201e-17
* device instance cc_XD4_XDFFQ_CLKB_net1 r0 *1 0,0
Ccc_XD4_XDFFQ_CLKB_net1 XD4.XDFFQ.CLKB net1 1.21e-17
* device instance cc_XD4_XDFFQ_M_XD4_XDFFQ_MB r0 *1 0,0
Ccc_XD4_XDFFQ_M_XD4_XDFFQ_MB XD4.XDFFQ.M XD4.XDFFQ.MB 3.4688e-17
* device instance cc_XD4_XDFFQ_M_XD4_XDFFQ_S r0 *1 0,0
Ccc_XD4_XDFFQ_M_XD4_XDFFQ_S XD4.XDFFQ.M XD4.XDFFQ.S 2.8638e-17
* device instance cc_XD4_XDFFQ_M_XD4_XDFFQ_SB r0 *1 0,0
Ccc_XD4_XDFFQ_M_XD4_XDFFQ_SB XD4.XDFFQ.M XD4.XDFFQ.SB 1.8151e-17
* device instance cc_XD4_XDFFQ_M_XD4_XN2_mid1 r0 *1 0,0
Ccc_XD4_XDFFQ_M_XD4_XN2_mid1 XD4.XDFFQ.M XD4.XN2.mid1 1.21e-17
* device instance cc_XD4_XDFFQ_M_XD4_XNOR_midp r0 *1 0,0
Ccc_XD4_XDFFQ_M_XD4_XNOR_midp XD4.XDFFQ.M XD4.XNOR.midp 1.21e-17
* device instance cc_XD4_XDFFQ_M_XD4_dmodout r0 *1 0,0
Ccc_XD4_XDFFQ_M_XD4_dmodout XD4.XDFFQ.M XD4.dmodout 1.21e-17
* device instance cc_XD4_XDFFQ_M_XD4_dq r0 *1 0,0
Ccc_XD4_XDFFQ_M_XD4_dq XD4.XDFFQ.M XD4.dq 2.8638e-17
* device instance cc_XD4_XDFFQ_M_XD4_nm r0 *1 0,0
Ccc_XD4_XDFFQ_M_XD4_nm XD4.XDFFQ.M XD4.nm 1.21e-17
* device instance cc_XD4_XDFFQ_M_XD4_nt r0 *1 0,0
Ccc_XD4_XDFFQ_M_XD4_nt XD4.XDFFQ.M XD4.nt 2.4201e-17
* device instance cc_XD4_XDFFQ_M_XD4_t1 r0 *1 0,0
Ccc_XD4_XDFFQ_M_XD4_t1 XD4.XDFFQ.M XD4.t1 1.21e-17
* device instance cc_XD4_XDFFQ_M_XD5_XDFFM_CLKB r0 *1 0,0
Ccc_XD4_XDFFQ_M_XD5_XDFFM_CLKB XD4.XDFFQ.M XD5.XDFFM.CLKB 1.8151e-17
* device instance cc_XD4_XDFFQ_M_XD5_XDFFM_M r0 *1 0,0
Ccc_XD4_XDFFQ_M_XD5_XDFFM_M XD4.XDFFQ.M XD5.XDFFM.M 2.4201e-17
* device instance cc_XD4_XDFFQ_M_XD5_XDFFM_MB r0 *1 0,0
Ccc_XD4_XDFFQ_M_XD5_XDFFM_MB XD4.XDFFQ.M XD5.XDFFM.MB 1.21e-17
* device instance cc_XD4_XDFFQ_M_XD5_XDFFM_S r0 *1 0,0
Ccc_XD4_XDFFQ_M_XD5_XDFFM_S XD4.XDFFQ.M XD5.XDFFM.S 1.8151e-17
* device instance cc_XD4_XDFFQ_M_XD5_XDFFM_SB r0 *1 0,0
Ccc_XD4_XDFFQ_M_XD5_XDFFM_SB XD4.XDFFQ.M XD5.XDFFM.SB 1.8151e-17
* device instance cc_XD4_XDFFQ_M_XD5_XDFFQ_CLKB r0 *1 0,0
Ccc_XD4_XDFFQ_M_XD5_XDFFQ_CLKB XD4.XDFFQ.M XD5.XDFFQ.CLKB 1.8151e-17
* device instance cc_XD4_XDFFQ_M_XD5_XDFFQ_M r0 *1 0,0
Ccc_XD4_XDFFQ_M_XD5_XDFFQ_M XD4.XDFFQ.M XD5.XDFFQ.M 2.4201e-17
* device instance cc_XD4_XDFFQ_M_XD5_XDFFQ_MB r0 *1 0,0
Ccc_XD4_XDFFQ_M_XD5_XDFFQ_MB XD4.XDFFQ.M XD5.XDFFQ.MB 1.21e-17
* device instance cc_XD4_XDFFQ_M_XD5_XDFFQ_S r0 *1 0,0
Ccc_XD4_XDFFQ_M_XD5_XDFFQ_S XD4.XDFFQ.M XD5.XDFFQ.S 1.8151e-17
* device instance cc_XD4_XDFFQ_M_XD5_XDFFQ_SB r0 *1 0,0
Ccc_XD4_XDFFQ_M_XD5_XDFFQ_SB XD4.XDFFQ.M XD5.XDFFQ.SB 1.8151e-17
* device instance cc_XD4_XDFFQ_M_XD5_XN2_mid1 r0 *1 0,0
Ccc_XD4_XDFFQ_M_XD5_XN2_mid1 XD4.XDFFQ.M XD5.XN2.mid1 1.21e-17
* device instance cc_XD4_XDFFQ_M_XD5_XN3_mid1 r0 *1 0,0
Ccc_XD4_XDFFQ_M_XD5_XN3_mid1 XD4.XDFFQ.M XD5.XN3.mid1 1.21e-17
* device instance cc_XD4_XDFFQ_M_XD5_XN3_mid2 r0 *1 0,0
Ccc_XD4_XDFFQ_M_XD5_XN3_mid2 XD4.XDFFQ.M XD5.XN3.mid2 1.21e-17
* device instance cc_XD4_XDFFQ_M_XD5_dmodout r0 *1 0,0
Ccc_XD4_XDFFQ_M_XD5_dmodout XD4.XDFFQ.M XD5.dmodout 1.21e-17
* device instance cc_XD4_XDFFQ_M_XD5_dq r0 *1 0,0
Ccc_XD4_XDFFQ_M_XD5_dq XD4.XDFFQ.M XD5.dq 1.8151e-17
* device instance cc_XD4_XDFFQ_M_XD5_nm r0 *1 0,0
Ccc_XD4_XDFFQ_M_XD5_nm XD4.XDFFQ.M XD5.nm 1.21e-17
* device instance cc_XD4_XDFFQ_M_XD5_nt r0 *1 0,0
Ccc_XD4_XDFFQ_M_XD5_nt XD4.XDFFQ.M XD5.nt 1.21e-17
* device instance cc_XD4_XDFFQ_M_XD5_t1 r0 *1 0,0
Ccc_XD4_XDFFQ_M_XD5_t1 XD4.XDFFQ.M XD5.t1 1.21e-17
* device instance cc_XD4_XDFFQ_M_XFRT_CLKB r0 *1 0,0
Ccc_XD4_XDFFQ_M_XFRT_CLKB XD4.XDFFQ.M XFRT.CLKB 1.8151e-17
* device instance cc_XD4_XDFFQ_M_XFRT_M r0 *1 0,0
Ccc_XD4_XDFFQ_M_XFRT_M XD4.XDFFQ.M XFRT.M 2.4201e-17
* device instance cc_XD4_XDFFQ_M_XFRT_MB r0 *1 0,0
Ccc_XD4_XDFFQ_M_XFRT_MB XD4.XDFFQ.M XFRT.MB 1.21e-17
* device instance cc_XD4_XDFFQ_M_XFRT_S r0 *1 0,0
Ccc_XD4_XDFFQ_M_XFRT_S XD4.XDFFQ.M XFRT.S 1.8151e-17
* device instance cc_XD4_XDFFQ_M_XFRT_SB r0 *1 0,0
Ccc_XD4_XDFFQ_M_XFRT_SB XD4.XDFFQ.M XFRT.SB 1.8151e-17
* device instance cc_XD4_XDFFQ_M_ck1 r0 *1 0,0
Ccc_XD4_XDFFQ_M_ck1 XD4.XDFFQ.M ck1 5.4452e-17
* device instance cc_XD4_XDFFQ_M_ck2 r0 *1 0,0
Ccc_XD4_XDFFQ_M_ck2 XD4.XDFFQ.M ck2 5.4452e-17
* device instance cc_XD4_XDFFQ_M_ck3 r0 *1 0,0
Ccc_XD4_XDFFQ_M_ck3 XD4.XDFFQ.M ck3 5.4452e-17
* device instance cc_XD4_XDFFQ_M_ck4 r0 *1 0,0
Ccc_XD4_XDFFQ_M_ck4 XD4.XDFFQ.M ck4 6.0502e-17
* device instance cc_XD4_XDFFQ_M_ck5 r0 *1 0,0
Ccc_XD4_XDFFQ_M_ck5 XD4.XDFFQ.M ck5 5.4452e-17
* device instance cc_XD4_XDFFQ_M_mod0 r0 *1 0,0
Ccc_XD4_XDFFQ_M_mod0 XD4.XDFFQ.M mod0 2.4201e-17
* device instance cc_XD4_XDFFQ_M_mod1 r0 *1 0,0
Ccc_XD4_XDFFQ_M_mod1 XD4.XDFFQ.M mod1 2.4201e-17
* device instance cc_XD4_XDFFQ_M_mod2 r0 *1 0,0
Ccc_XD4_XDFFQ_M_mod2 XD4.XDFFQ.M mod2 2.4201e-17
* device instance cc_XD4_XDFFQ_M_mod3 r0 *1 0,0
Ccc_XD4_XDFFQ_M_mod3 XD4.XDFFQ.M mod3 2.4201e-17
* device instance cc_XD4_XDFFQ_M_mod4 r0 *1 0,0
Ccc_XD4_XDFFQ_M_mod4 XD4.XDFFQ.M mod4 2.4201e-17
* device instance cc_XD4_XDFFQ_M_net1 r0 *1 0,0
Ccc_XD4_XDFFQ_M_net1 XD4.XDFFQ.M net1 1.21e-17
* device instance cc_XD4_XDFFQ_MB_XD4_XDFFQ_S r0 *1 0,0
Ccc_XD4_XDFFQ_MB_XD4_XDFFQ_S XD4.XDFFQ.MB XD4.XDFFQ.S 1.8151e-17
* device instance cc_XD4_XDFFQ_MB_XD4_XDFFQ_SB r0 *1 0,0
Ccc_XD4_XDFFQ_MB_XD4_XDFFQ_SB XD4.XDFFQ.MB XD4.XDFFQ.SB 1.8151e-17
* device instance cc_XD4_XDFFQ_MB_XD4_XN2_mid1 r0 *1 0,0
Ccc_XD4_XDFFQ_MB_XD4_XN2_mid1 XD4.XDFFQ.MB XD4.XN2.mid1 1.21e-17
* device instance cc_XD4_XDFFQ_MB_XD4_XNOR_midp r0 *1 0,0
Ccc_XD4_XDFFQ_MB_XD4_XNOR_midp XD4.XDFFQ.MB XD4.XNOR.midp 1.21e-17
* device instance cc_XD4_XDFFQ_MB_XD4_dmodout r0 *1 0,0
Ccc_XD4_XDFFQ_MB_XD4_dmodout XD4.XDFFQ.MB XD4.dmodout 1.21e-17
* device instance cc_XD4_XDFFQ_MB_XD4_dq r0 *1 0,0
Ccc_XD4_XDFFQ_MB_XD4_dq XD4.XDFFQ.MB XD4.dq 1.21e-17
* device instance cc_XD4_XDFFQ_MB_XD4_nm r0 *1 0,0
Ccc_XD4_XDFFQ_MB_XD4_nm XD4.XDFFQ.MB XD4.nm 1.21e-17
* device instance cc_XD4_XDFFQ_MB_XD4_nt r0 *1 0,0
Ccc_XD4_XDFFQ_MB_XD4_nt XD4.XDFFQ.MB XD4.nt 2.4201e-17
* device instance cc_XD4_XDFFQ_MB_XD4_t1 r0 *1 0,0
Ccc_XD4_XDFFQ_MB_XD4_t1 XD4.XDFFQ.MB XD4.t1 1.21e-17
* device instance cc_XD4_XDFFQ_MB_XD5_XDFFM_CLKB r0 *1 0,0
Ccc_XD4_XDFFQ_MB_XD5_XDFFM_CLKB XD4.XDFFQ.MB XD5.XDFFM.CLKB 1.8151e-17
* device instance cc_XD4_XDFFQ_MB_XD5_XDFFM_M r0 *1 0,0
Ccc_XD4_XDFFQ_MB_XD5_XDFFM_M XD4.XDFFQ.MB XD5.XDFFM.M 2.4201e-17
* device instance cc_XD4_XDFFQ_MB_XD5_XDFFM_MB r0 *1 0,0
Ccc_XD4_XDFFQ_MB_XD5_XDFFM_MB XD4.XDFFQ.MB XD5.XDFFM.MB 1.21e-17
* device instance cc_XD4_XDFFQ_MB_XD5_XDFFM_S r0 *1 0,0
Ccc_XD4_XDFFQ_MB_XD5_XDFFM_S XD4.XDFFQ.MB XD5.XDFFM.S 1.8151e-17
* device instance cc_XD4_XDFFQ_MB_XD5_XDFFM_SB r0 *1 0,0
Ccc_XD4_XDFFQ_MB_XD5_XDFFM_SB XD4.XDFFQ.MB XD5.XDFFM.SB 1.8151e-17
* device instance cc_XD4_XDFFQ_MB_XD5_XDFFQ_CLKB r0 *1 0,0
Ccc_XD4_XDFFQ_MB_XD5_XDFFQ_CLKB XD4.XDFFQ.MB XD5.XDFFQ.CLKB 1.8151e-17
* device instance cc_XD4_XDFFQ_MB_XD5_XDFFQ_M r0 *1 0,0
Ccc_XD4_XDFFQ_MB_XD5_XDFFQ_M XD4.XDFFQ.MB XD5.XDFFQ.M 2.4201e-17
* device instance cc_XD4_XDFFQ_MB_XD5_XDFFQ_MB r0 *1 0,0
Ccc_XD4_XDFFQ_MB_XD5_XDFFQ_MB XD4.XDFFQ.MB XD5.XDFFQ.MB 1.21e-17
* device instance cc_XD4_XDFFQ_MB_XD5_XDFFQ_S r0 *1 0,0
Ccc_XD4_XDFFQ_MB_XD5_XDFFQ_S XD4.XDFFQ.MB XD5.XDFFQ.S 1.8151e-17
* device instance cc_XD4_XDFFQ_MB_XD5_XDFFQ_SB r0 *1 0,0
Ccc_XD4_XDFFQ_MB_XD5_XDFFQ_SB XD4.XDFFQ.MB XD5.XDFFQ.SB 1.8151e-17
* device instance cc_XD4_XDFFQ_MB_XD5_XN2_mid1 r0 *1 0,0
Ccc_XD4_XDFFQ_MB_XD5_XN2_mid1 XD4.XDFFQ.MB XD5.XN2.mid1 1.21e-17
* device instance cc_XD4_XDFFQ_MB_XD5_XN3_mid1 r0 *1 0,0
Ccc_XD4_XDFFQ_MB_XD5_XN3_mid1 XD4.XDFFQ.MB XD5.XN3.mid1 1.21e-17
* device instance cc_XD4_XDFFQ_MB_XD5_XN3_mid2 r0 *1 0,0
Ccc_XD4_XDFFQ_MB_XD5_XN3_mid2 XD4.XDFFQ.MB XD5.XN3.mid2 1.21e-17
* device instance cc_XD4_XDFFQ_MB_XD5_dmodout r0 *1 0,0
Ccc_XD4_XDFFQ_MB_XD5_dmodout XD4.XDFFQ.MB XD5.dmodout 1.21e-17
* device instance cc_XD4_XDFFQ_MB_XD5_dq r0 *1 0,0
Ccc_XD4_XDFFQ_MB_XD5_dq XD4.XDFFQ.MB XD5.dq 1.8151e-17
* device instance cc_XD4_XDFFQ_MB_XD5_nm r0 *1 0,0
Ccc_XD4_XDFFQ_MB_XD5_nm XD4.XDFFQ.MB XD5.nm 1.21e-17
* device instance cc_XD4_XDFFQ_MB_XD5_nt r0 *1 0,0
Ccc_XD4_XDFFQ_MB_XD5_nt XD4.XDFFQ.MB XD5.nt 1.21e-17
* device instance cc_XD4_XDFFQ_MB_XD5_t1 r0 *1 0,0
Ccc_XD4_XDFFQ_MB_XD5_t1 XD4.XDFFQ.MB XD5.t1 1.21e-17
* device instance cc_XD4_XDFFQ_MB_XFRT_CLKB r0 *1 0,0
Ccc_XD4_XDFFQ_MB_XFRT_CLKB XD4.XDFFQ.MB XFRT.CLKB 1.8151e-17
* device instance cc_XD4_XDFFQ_MB_XFRT_M r0 *1 0,0
Ccc_XD4_XDFFQ_MB_XFRT_M XD4.XDFFQ.MB XFRT.M 2.4201e-17
* device instance cc_XD4_XDFFQ_MB_XFRT_MB r0 *1 0,0
Ccc_XD4_XDFFQ_MB_XFRT_MB XD4.XDFFQ.MB XFRT.MB 1.21e-17
* device instance cc_XD4_XDFFQ_MB_XFRT_S r0 *1 0,0
Ccc_XD4_XDFFQ_MB_XFRT_S XD4.XDFFQ.MB XFRT.S 1.8151e-17
* device instance cc_XD4_XDFFQ_MB_XFRT_SB r0 *1 0,0
Ccc_XD4_XDFFQ_MB_XFRT_SB XD4.XDFFQ.MB XFRT.SB 1.8151e-17
* device instance cc_XD4_XDFFQ_MB_ck1 r0 *1 0,0
Ccc_XD4_XDFFQ_MB_ck1 XD4.XDFFQ.MB ck1 5.4452e-17
* device instance cc_XD4_XDFFQ_MB_ck2 r0 *1 0,0
Ccc_XD4_XDFFQ_MB_ck2 XD4.XDFFQ.MB ck2 5.4452e-17
* device instance cc_XD4_XDFFQ_MB_ck3 r0 *1 0,0
Ccc_XD4_XDFFQ_MB_ck3 XD4.XDFFQ.MB ck3 5.4452e-17
* device instance cc_XD4_XDFFQ_MB_ck4 r0 *1 0,0
Ccc_XD4_XDFFQ_MB_ck4 XD4.XDFFQ.MB ck4 6.0502e-17
* device instance cc_XD4_XDFFQ_MB_ck5 r0 *1 0,0
Ccc_XD4_XDFFQ_MB_ck5 XD4.XDFFQ.MB ck5 5.4452e-17
* device instance cc_XD4_XDFFQ_MB_mod0 r0 *1 0,0
Ccc_XD4_XDFFQ_MB_mod0 XD4.XDFFQ.MB mod0 2.4201e-17
* device instance cc_XD4_XDFFQ_MB_mod1 r0 *1 0,0
Ccc_XD4_XDFFQ_MB_mod1 XD4.XDFFQ.MB mod1 2.4201e-17
* device instance cc_XD4_XDFFQ_MB_mod2 r0 *1 0,0
Ccc_XD4_XDFFQ_MB_mod2 XD4.XDFFQ.MB mod2 2.4201e-17
* device instance cc_XD4_XDFFQ_MB_mod3 r0 *1 0,0
Ccc_XD4_XDFFQ_MB_mod3 XD4.XDFFQ.MB mod3 2.4201e-17
* device instance cc_XD4_XDFFQ_MB_mod4 r0 *1 0,0
Ccc_XD4_XDFFQ_MB_mod4 XD4.XDFFQ.MB mod4 2.4201e-17
* device instance cc_XD4_XDFFQ_MB_net1 r0 *1 0,0
Ccc_XD4_XDFFQ_MB_net1 XD4.XDFFQ.MB net1 1.21e-17
* device instance cc_XD4_XDFFQ_S_XD4_XDFFQ_SB r0 *1 0,0
Ccc_XD4_XDFFQ_S_XD4_XDFFQ_SB XD4.XDFFQ.S XD4.XDFFQ.SB 4.0738e-17
* device instance cc_XD4_XDFFQ_S_XD4_XN2_mid1 r0 *1 0,0
Ccc_XD4_XDFFQ_S_XD4_XN2_mid1 XD4.XDFFQ.S XD4.XN2.mid1 1.21e-17
* device instance cc_XD4_XDFFQ_S_XD4_XNOR_midp r0 *1 0,0
Ccc_XD4_XDFFQ_S_XD4_XNOR_midp XD4.XDFFQ.S XD4.XNOR.midp 1.21e-17
* device instance cc_XD4_XDFFQ_S_XD4_dmodout r0 *1 0,0
Ccc_XD4_XDFFQ_S_XD4_dmodout XD4.XDFFQ.S XD4.dmodout 1.21e-17
* device instance cc_XD4_XDFFQ_S_XD4_dq r0 *1 0,0
Ccc_XD4_XDFFQ_S_XD4_dq XD4.XDFFQ.S XD4.dq 1.21e-17
* device instance cc_XD4_XDFFQ_S_XD4_nm r0 *1 0,0
Ccc_XD4_XDFFQ_S_XD4_nm XD4.XDFFQ.S XD4.nm 1.21e-17
* device instance cc_XD4_XDFFQ_S_XD4_nt r0 *1 0,0
Ccc_XD4_XDFFQ_S_XD4_nt XD4.XDFFQ.S XD4.nt 2.4201e-17
* device instance cc_XD4_XDFFQ_S_XD4_t1 r0 *1 0,0
Ccc_XD4_XDFFQ_S_XD4_t1 XD4.XDFFQ.S XD4.t1 1.21e-17
* device instance cc_XD4_XDFFQ_S_XD5_XDFFM_CLKB r0 *1 0,0
Ccc_XD4_XDFFQ_S_XD5_XDFFM_CLKB XD4.XDFFQ.S XD5.XDFFM.CLKB 1.8151e-17
* device instance cc_XD4_XDFFQ_S_XD5_XDFFM_M r0 *1 0,0
Ccc_XD4_XDFFQ_S_XD5_XDFFM_M XD4.XDFFQ.S XD5.XDFFM.M 2.4201e-17
* device instance cc_XD4_XDFFQ_S_XD5_XDFFM_MB r0 *1 0,0
Ccc_XD4_XDFFQ_S_XD5_XDFFM_MB XD4.XDFFQ.S XD5.XDFFM.MB 1.21e-17
* device instance cc_XD4_XDFFQ_S_XD5_XDFFM_S r0 *1 0,0
Ccc_XD4_XDFFQ_S_XD5_XDFFM_S XD4.XDFFQ.S XD5.XDFFM.S 1.8151e-17
* device instance cc_XD4_XDFFQ_S_XD5_XDFFM_SB r0 *1 0,0
Ccc_XD4_XDFFQ_S_XD5_XDFFM_SB XD4.XDFFQ.S XD5.XDFFM.SB 1.8151e-17
* device instance cc_XD4_XDFFQ_S_XD5_XDFFQ_CLKB r0 *1 0,0
Ccc_XD4_XDFFQ_S_XD5_XDFFQ_CLKB XD4.XDFFQ.S XD5.XDFFQ.CLKB 1.8151e-17
* device instance cc_XD4_XDFFQ_S_XD5_XDFFQ_M r0 *1 0,0
Ccc_XD4_XDFFQ_S_XD5_XDFFQ_M XD4.XDFFQ.S XD5.XDFFQ.M 2.4201e-17
* device instance cc_XD4_XDFFQ_S_XD5_XDFFQ_MB r0 *1 0,0
Ccc_XD4_XDFFQ_S_XD5_XDFFQ_MB XD4.XDFFQ.S XD5.XDFFQ.MB 1.21e-17
* device instance cc_XD4_XDFFQ_S_XD5_XDFFQ_S r0 *1 0,0
Ccc_XD4_XDFFQ_S_XD5_XDFFQ_S XD4.XDFFQ.S XD5.XDFFQ.S 1.8151e-17
* device instance cc_XD4_XDFFQ_S_XD5_XDFFQ_SB r0 *1 0,0
Ccc_XD4_XDFFQ_S_XD5_XDFFQ_SB XD4.XDFFQ.S XD5.XDFFQ.SB 1.8151e-17
* device instance cc_XD4_XDFFQ_S_XD5_XN2_mid1 r0 *1 0,0
Ccc_XD4_XDFFQ_S_XD5_XN2_mid1 XD4.XDFFQ.S XD5.XN2.mid1 1.21e-17
* device instance cc_XD4_XDFFQ_S_XD5_XN3_mid1 r0 *1 0,0
Ccc_XD4_XDFFQ_S_XD5_XN3_mid1 XD4.XDFFQ.S XD5.XN3.mid1 1.21e-17
* device instance cc_XD4_XDFFQ_S_XD5_XN3_mid2 r0 *1 0,0
Ccc_XD4_XDFFQ_S_XD5_XN3_mid2 XD4.XDFFQ.S XD5.XN3.mid2 1.21e-17
* device instance cc_XD4_XDFFQ_S_XD5_dmodout r0 *1 0,0
Ccc_XD4_XDFFQ_S_XD5_dmodout XD4.XDFFQ.S XD5.dmodout 1.21e-17
* device instance cc_XD4_XDFFQ_S_XD5_dq r0 *1 0,0
Ccc_XD4_XDFFQ_S_XD5_dq XD4.XDFFQ.S XD5.dq 1.8151e-17
* device instance cc_XD4_XDFFQ_S_XD5_nm r0 *1 0,0
Ccc_XD4_XDFFQ_S_XD5_nm XD4.XDFFQ.S XD5.nm 1.21e-17
* device instance cc_XD4_XDFFQ_S_XD5_nt r0 *1 0,0
Ccc_XD4_XDFFQ_S_XD5_nt XD4.XDFFQ.S XD5.nt 1.21e-17
* device instance cc_XD4_XDFFQ_S_XD5_t1 r0 *1 0,0
Ccc_XD4_XDFFQ_S_XD5_t1 XD4.XDFFQ.S XD5.t1 1.21e-17
* device instance cc_XD4_XDFFQ_S_XFRT_CLKB r0 *1 0,0
Ccc_XD4_XDFFQ_S_XFRT_CLKB XD4.XDFFQ.S XFRT.CLKB 1.8151e-17
* device instance cc_XD4_XDFFQ_S_XFRT_M r0 *1 0,0
Ccc_XD4_XDFFQ_S_XFRT_M XD4.XDFFQ.S XFRT.M 2.4201e-17
* device instance cc_XD4_XDFFQ_S_XFRT_MB r0 *1 0,0
Ccc_XD4_XDFFQ_S_XFRT_MB XD4.XDFFQ.S XFRT.MB 1.21e-17
* device instance cc_XD4_XDFFQ_S_XFRT_S r0 *1 0,0
Ccc_XD4_XDFFQ_S_XFRT_S XD4.XDFFQ.S XFRT.S 1.8151e-17
* device instance cc_XD4_XDFFQ_S_XFRT_SB r0 *1 0,0
Ccc_XD4_XDFFQ_S_XFRT_SB XD4.XDFFQ.S XFRT.SB 1.8151e-17
* device instance cc_XD4_XDFFQ_S_ck1 r0 *1 0,0
Ccc_XD4_XDFFQ_S_ck1 XD4.XDFFQ.S ck1 5.4452e-17
* device instance cc_XD4_XDFFQ_S_ck2 r0 *1 0,0
Ccc_XD4_XDFFQ_S_ck2 XD4.XDFFQ.S ck2 5.4452e-17
* device instance cc_XD4_XDFFQ_S_ck3 r0 *1 0,0
Ccc_XD4_XDFFQ_S_ck3 XD4.XDFFQ.S ck3 5.4452e-17
* device instance cc_XD4_XDFFQ_S_ck4 r0 *1 0,0
Ccc_XD4_XDFFQ_S_ck4 XD4.XDFFQ.S ck4 5.4452e-17
* device instance cc_XD4_XDFFQ_S_ck5 r0 *1 0,0
Ccc_XD4_XDFFQ_S_ck5 XD4.XDFFQ.S ck5 5.4452e-17
* device instance cc_XD4_XDFFQ_S_mod0 r0 *1 0,0
Ccc_XD4_XDFFQ_S_mod0 XD4.XDFFQ.S mod0 2.4201e-17
* device instance cc_XD4_XDFFQ_S_mod1 r0 *1 0,0
Ccc_XD4_XDFFQ_S_mod1 XD4.XDFFQ.S mod1 2.4201e-17
* device instance cc_XD4_XDFFQ_S_mod2 r0 *1 0,0
Ccc_XD4_XDFFQ_S_mod2 XD4.XDFFQ.S mod2 2.4201e-17
* device instance cc_XD4_XDFFQ_S_mod3 r0 *1 0,0
Ccc_XD4_XDFFQ_S_mod3 XD4.XDFFQ.S mod3 2.4201e-17
* device instance cc_XD4_XDFFQ_S_mod4 r0 *1 0,0
Ccc_XD4_XDFFQ_S_mod4 XD4.XDFFQ.S mod4 2.4201e-17
* device instance cc_XD4_XDFFQ_S_net1 r0 *1 0,0
Ccc_XD4_XDFFQ_S_net1 XD4.XDFFQ.S net1 1.21e-17
* device instance cc_XD4_XDFFQ_SB_XD4_XN2_mid1 r0 *1 0,0
Ccc_XD4_XDFFQ_SB_XD4_XN2_mid1 XD4.XDFFQ.SB XD4.XN2.mid1 1.21e-17
* device instance cc_XD4_XDFFQ_SB_XD4_XNOR_midp r0 *1 0,0
Ccc_XD4_XDFFQ_SB_XD4_XNOR_midp XD4.XDFFQ.SB XD4.XNOR.midp 1.21e-17
* device instance cc_XD4_XDFFQ_SB_XD4_dmodout r0 *1 0,0
Ccc_XD4_XDFFQ_SB_XD4_dmodout XD4.XDFFQ.SB XD4.dmodout 1.21e-17
* device instance cc_XD4_XDFFQ_SB_XD4_dq r0 *1 0,0
Ccc_XD4_XDFFQ_SB_XD4_dq XD4.XDFFQ.SB XD4.dq 1.21e-17
* device instance cc_XD4_XDFFQ_SB_XD4_nm r0 *1 0,0
Ccc_XD4_XDFFQ_SB_XD4_nm XD4.XDFFQ.SB XD4.nm 1.21e-17
* device instance cc_XD4_XDFFQ_SB_XD4_nt r0 *1 0,0
Ccc_XD4_XDFFQ_SB_XD4_nt XD4.XDFFQ.SB XD4.nt 2.4201e-17
* device instance cc_XD4_XDFFQ_SB_XD4_t1 r0 *1 0,0
Ccc_XD4_XDFFQ_SB_XD4_t1 XD4.XDFFQ.SB XD4.t1 1.21e-17
* device instance cc_XD4_XDFFQ_SB_XD5_XDFFM_CLKB r0 *1 0,0
Ccc_XD4_XDFFQ_SB_XD5_XDFFM_CLKB XD4.XDFFQ.SB XD5.XDFFM.CLKB 1.8151e-17
* device instance cc_XD4_XDFFQ_SB_XD5_XDFFM_M r0 *1 0,0
Ccc_XD4_XDFFQ_SB_XD5_XDFFM_M XD4.XDFFQ.SB XD5.XDFFM.M 2.4201e-17
* device instance cc_XD4_XDFFQ_SB_XD5_XDFFM_MB r0 *1 0,0
Ccc_XD4_XDFFQ_SB_XD5_XDFFM_MB XD4.XDFFQ.SB XD5.XDFFM.MB 1.21e-17
* device instance cc_XD4_XDFFQ_SB_XD5_XDFFM_S r0 *1 0,0
Ccc_XD4_XDFFQ_SB_XD5_XDFFM_S XD4.XDFFQ.SB XD5.XDFFM.S 1.8151e-17
* device instance cc_XD4_XDFFQ_SB_XD5_XDFFM_SB r0 *1 0,0
Ccc_XD4_XDFFQ_SB_XD5_XDFFM_SB XD4.XDFFQ.SB XD5.XDFFM.SB 1.8151e-17
* device instance cc_XD4_XDFFQ_SB_XD5_XDFFQ_CLKB r0 *1 0,0
Ccc_XD4_XDFFQ_SB_XD5_XDFFQ_CLKB XD4.XDFFQ.SB XD5.XDFFQ.CLKB 1.8151e-17
* device instance cc_XD4_XDFFQ_SB_XD5_XDFFQ_M r0 *1 0,0
Ccc_XD4_XDFFQ_SB_XD5_XDFFQ_M XD4.XDFFQ.SB XD5.XDFFQ.M 2.4201e-17
* device instance cc_XD4_XDFFQ_SB_XD5_XDFFQ_MB r0 *1 0,0
Ccc_XD4_XDFFQ_SB_XD5_XDFFQ_MB XD4.XDFFQ.SB XD5.XDFFQ.MB 1.21e-17
* device instance cc_XD4_XDFFQ_SB_XD5_XDFFQ_S r0 *1 0,0
Ccc_XD4_XDFFQ_SB_XD5_XDFFQ_S XD4.XDFFQ.SB XD5.XDFFQ.S 1.8151e-17
* device instance cc_XD4_XDFFQ_SB_XD5_XDFFQ_SB r0 *1 0,0
Ccc_XD4_XDFFQ_SB_XD5_XDFFQ_SB XD4.XDFFQ.SB XD5.XDFFQ.SB 1.8151e-17
* device instance cc_XD4_XDFFQ_SB_XD5_XN2_mid1 r0 *1 0,0
Ccc_XD4_XDFFQ_SB_XD5_XN2_mid1 XD4.XDFFQ.SB XD5.XN2.mid1 1.21e-17
* device instance cc_XD4_XDFFQ_SB_XD5_XN3_mid1 r0 *1 0,0
Ccc_XD4_XDFFQ_SB_XD5_XN3_mid1 XD4.XDFFQ.SB XD5.XN3.mid1 1.21e-17
* device instance cc_XD4_XDFFQ_SB_XD5_XN3_mid2 r0 *1 0,0
Ccc_XD4_XDFFQ_SB_XD5_XN3_mid2 XD4.XDFFQ.SB XD5.XN3.mid2 1.21e-17
* device instance cc_XD4_XDFFQ_SB_XD5_dmodout r0 *1 0,0
Ccc_XD4_XDFFQ_SB_XD5_dmodout XD4.XDFFQ.SB XD5.dmodout 1.21e-17
* device instance cc_XD4_XDFFQ_SB_XD5_dq r0 *1 0,0
Ccc_XD4_XDFFQ_SB_XD5_dq XD4.XDFFQ.SB XD5.dq 1.8151e-17
* device instance cc_XD4_XDFFQ_SB_XD5_nm r0 *1 0,0
Ccc_XD4_XDFFQ_SB_XD5_nm XD4.XDFFQ.SB XD5.nm 1.21e-17
* device instance cc_XD4_XDFFQ_SB_XD5_nt r0 *1 0,0
Ccc_XD4_XDFFQ_SB_XD5_nt XD4.XDFFQ.SB XD5.nt 1.21e-17
* device instance cc_XD4_XDFFQ_SB_XD5_t1 r0 *1 0,0
Ccc_XD4_XDFFQ_SB_XD5_t1 XD4.XDFFQ.SB XD5.t1 1.21e-17
* device instance cc_XD4_XDFFQ_SB_XFRT_CLKB r0 *1 0,0
Ccc_XD4_XDFFQ_SB_XFRT_CLKB XD4.XDFFQ.SB XFRT.CLKB 1.8151e-17
* device instance cc_XD4_XDFFQ_SB_XFRT_M r0 *1 0,0
Ccc_XD4_XDFFQ_SB_XFRT_M XD4.XDFFQ.SB XFRT.M 2.4201e-17
* device instance cc_XD4_XDFFQ_SB_XFRT_MB r0 *1 0,0
Ccc_XD4_XDFFQ_SB_XFRT_MB XD4.XDFFQ.SB XFRT.MB 1.21e-17
* device instance cc_XD4_XDFFQ_SB_XFRT_S r0 *1 0,0
Ccc_XD4_XDFFQ_SB_XFRT_S XD4.XDFFQ.SB XFRT.S 1.8151e-17
* device instance cc_XD4_XDFFQ_SB_XFRT_SB r0 *1 0,0
Ccc_XD4_XDFFQ_SB_XFRT_SB XD4.XDFFQ.SB XFRT.SB 1.8151e-17
* device instance cc_XD4_XDFFQ_SB_ck1 r0 *1 0,0
Ccc_XD4_XDFFQ_SB_ck1 XD4.XDFFQ.SB ck1 5.4452e-17
* device instance cc_XD4_XDFFQ_SB_ck2 r0 *1 0,0
Ccc_XD4_XDFFQ_SB_ck2 XD4.XDFFQ.SB ck2 5.4452e-17
* device instance cc_XD4_XDFFQ_SB_ck3 r0 *1 0,0
Ccc_XD4_XDFFQ_SB_ck3 XD4.XDFFQ.SB ck3 5.4452e-17
* device instance cc_XD4_XDFFQ_SB_ck4 r0 *1 0,0
Ccc_XD4_XDFFQ_SB_ck4 XD4.XDFFQ.SB ck4 5.4452e-17
* device instance cc_XD4_XDFFQ_SB_ck5 r0 *1 0,0
Ccc_XD4_XDFFQ_SB_ck5 XD4.XDFFQ.SB ck5 5.4452e-17
* device instance cc_XD4_XDFFQ_SB_mod0 r0 *1 0,0
Ccc_XD4_XDFFQ_SB_mod0 XD4.XDFFQ.SB mod0 2.4201e-17
* device instance cc_XD4_XDFFQ_SB_mod1 r0 *1 0,0
Ccc_XD4_XDFFQ_SB_mod1 XD4.XDFFQ.SB mod1 2.4201e-17
* device instance cc_XD4_XDFFQ_SB_mod2 r0 *1 0,0
Ccc_XD4_XDFFQ_SB_mod2 XD4.XDFFQ.SB mod2 2.4201e-17
* device instance cc_XD4_XDFFQ_SB_mod3 r0 *1 0,0
Ccc_XD4_XDFFQ_SB_mod3 XD4.XDFFQ.SB mod3 2.4201e-17
* device instance cc_XD4_XDFFQ_SB_mod4 r0 *1 0,0
Ccc_XD4_XDFFQ_SB_mod4 XD4.XDFFQ.SB mod4 2.4201e-17
* device instance cc_XD4_XDFFQ_SB_net1 r0 *1 0,0
Ccc_XD4_XDFFQ_SB_net1 XD4.XDFFQ.SB net1 1.21e-17
* device instance cc_XD4_XN2_mid1_XD4_nm r0 *1 0,0
Ccc_XD4_XN2_mid1_XD4_nm XD4.XN2.mid1 XD4.nm 1.1294e-17
* device instance cc_XD4_XN2_mid1_ck5 r0 *1 0,0
Ccc_XD4_XN2_mid1_ck5 XD4.XN2.mid1 ck5 6.05e-18
* device instance cc_XD4_XN3_mid1_XD4_XN3_mid2 r0 *1 0,0
Ccc_XD4_XN3_mid1_XD4_XN3_mid2 XD4.XN3.mid1 XD4.XN3.mid2 1.1294e-17
* device instance cc_XD4_XN3_mid1_XD4_nt r0 *1 0,0
Ccc_XD4_XN3_mid1_XD4_nt XD4.XN3.mid1 XD4.nt 1.1294e-17
* device instance cc_XD4_XN3_mid2_mod3 r0 *1 0,0
Ccc_XD4_XN3_mid2_mod3 XD4.XN3.mid2 mod3 6.05e-18
* device instance cc_XD4_XNOR_midp_XD4_dq r0 *1 0,0
Ccc_XD4_XNOR_midp_XD4_dq XD4.XNOR.midp XD4.dq 5.244e-18
* device instance cc_XD4_XNOR_midp_XD4_t1 r0 *1 0,0
Ccc_XD4_XNOR_midp_XD4_t1 XD4.XNOR.midp XD4.t1 6.05e-18
* device instance cc_XD4_dmodout_XD4_dq r0 *1 0,0
Ccc_XD4_dmodout_XD4_dq XD4.dmodout XD4.dq 1.21e-17
* device instance cc_XD4_dmodout_XD4_nm r0 *1 0,0
Ccc_XD4_dmodout_XD4_nm XD4.dmodout XD4.nm 1.8151e-17
* device instance cc_XD4_dmodout_XD4_nt r0 *1 0,0
Ccc_XD4_dmodout_XD4_nt XD4.dmodout XD4.nt 2.4201e-17
* device instance cc_XD4_dmodout_XD4_t1 r0 *1 0,0
Ccc_XD4_dmodout_XD4_t1 XD4.dmodout XD4.t1 1.21e-17
* device instance cc_XD4_dmodout_XD5_XDFFM_CLKB r0 *1 0,0
Ccc_XD4_dmodout_XD5_XDFFM_CLKB XD4.dmodout XD5.XDFFM.CLKB 1.8151e-17
* device instance cc_XD4_dmodout_XD5_XDFFM_M r0 *1 0,0
Ccc_XD4_dmodout_XD5_XDFFM_M XD4.dmodout XD5.XDFFM.M 2.4201e-17
* device instance cc_XD4_dmodout_XD5_XDFFM_MB r0 *1 0,0
Ccc_XD4_dmodout_XD5_XDFFM_MB XD4.dmodout XD5.XDFFM.MB 1.21e-17
* device instance cc_XD4_dmodout_XD5_XDFFM_S r0 *1 0,0
Ccc_XD4_dmodout_XD5_XDFFM_S XD4.dmodout XD5.XDFFM.S 1.8151e-17
* device instance cc_XD4_dmodout_XD5_XDFFM_SB r0 *1 0,0
Ccc_XD4_dmodout_XD5_XDFFM_SB XD4.dmodout XD5.XDFFM.SB 1.8151e-17
* device instance cc_XD4_dmodout_XD5_XDFFQ_CLKB r0 *1 0,0
Ccc_XD4_dmodout_XD5_XDFFQ_CLKB XD4.dmodout XD5.XDFFQ.CLKB 1.8151e-17
* device instance cc_XD4_dmodout_XD5_XDFFQ_M r0 *1 0,0
Ccc_XD4_dmodout_XD5_XDFFQ_M XD4.dmodout XD5.XDFFQ.M 2.4201e-17
* device instance cc_XD4_dmodout_XD5_XDFFQ_MB r0 *1 0,0
Ccc_XD4_dmodout_XD5_XDFFQ_MB XD4.dmodout XD5.XDFFQ.MB 1.21e-17
* device instance cc_XD4_dmodout_XD5_XDFFQ_S r0 *1 0,0
Ccc_XD4_dmodout_XD5_XDFFQ_S XD4.dmodout XD5.XDFFQ.S 1.8151e-17
* device instance cc_XD4_dmodout_XD5_XDFFQ_SB r0 *1 0,0
Ccc_XD4_dmodout_XD5_XDFFQ_SB XD4.dmodout XD5.XDFFQ.SB 1.8151e-17
* device instance cc_XD4_dmodout_XD5_XN2_mid1 r0 *1 0,0
Ccc_XD4_dmodout_XD5_XN2_mid1 XD4.dmodout XD5.XN2.mid1 1.21e-17
* device instance cc_XD4_dmodout_XD5_XN3_mid1 r0 *1 0,0
Ccc_XD4_dmodout_XD5_XN3_mid1 XD4.dmodout XD5.XN3.mid1 1.21e-17
* device instance cc_XD4_dmodout_XD5_XN3_mid2 r0 *1 0,0
Ccc_XD4_dmodout_XD5_XN3_mid2 XD4.dmodout XD5.XN3.mid2 1.21e-17
* device instance cc_XD4_dmodout_XD5_dmodout r0 *1 0,0
Ccc_XD4_dmodout_XD5_dmodout XD4.dmodout XD5.dmodout 1.21e-17
* device instance cc_XD4_dmodout_XD5_dq r0 *1 0,0
Ccc_XD4_dmodout_XD5_dq XD4.dmodout XD5.dq 1.8151e-17
* device instance cc_XD4_dmodout_XD5_nm r0 *1 0,0
Ccc_XD4_dmodout_XD5_nm XD4.dmodout XD5.nm 1.21e-17
* device instance cc_XD4_dmodout_XD5_nt r0 *1 0,0
Ccc_XD4_dmodout_XD5_nt XD4.dmodout XD5.nt 1.21e-17
* device instance cc_XD4_dmodout_XD5_t1 r0 *1 0,0
Ccc_XD4_dmodout_XD5_t1 XD4.dmodout XD5.t1 1.21e-17
* device instance cc_XD4_dmodout_XFRT_CLKB r0 *1 0,0
Ccc_XD4_dmodout_XFRT_CLKB XD4.dmodout XFRT.CLKB 1.8151e-17
* device instance cc_XD4_dmodout_XFRT_M r0 *1 0,0
Ccc_XD4_dmodout_XFRT_M XD4.dmodout XFRT.M 2.4201e-17
* device instance cc_XD4_dmodout_XFRT_MB r0 *1 0,0
Ccc_XD4_dmodout_XFRT_MB XD4.dmodout XFRT.MB 1.21e-17
* device instance cc_XD4_dmodout_XFRT_S r0 *1 0,0
Ccc_XD4_dmodout_XFRT_S XD4.dmodout XFRT.S 1.8151e-17
* device instance cc_XD4_dmodout_XFRT_SB r0 *1 0,0
Ccc_XD4_dmodout_XFRT_SB XD4.dmodout XFRT.SB 1.8151e-17
* device instance cc_XD4_dmodout_ck1 r0 *1 0,0
Ccc_XD4_dmodout_ck1 XD4.dmodout ck1 5.4452e-17
* device instance cc_XD4_dmodout_ck2 r0 *1 0,0
Ccc_XD4_dmodout_ck2 XD4.dmodout ck2 5.4452e-17
* device instance cc_XD4_dmodout_ck3 r0 *1 0,0
Ccc_XD4_dmodout_ck3 XD4.dmodout ck3 5.4452e-17
* device instance cc_XD4_dmodout_ck4 r0 *1 0,0
Ccc_XD4_dmodout_ck4 XD4.dmodout ck4 6.6553e-17
* device instance cc_XD4_dmodout_ck5 r0 *1 0,0
Ccc_XD4_dmodout_ck5 XD4.dmodout ck5 5.4452e-17
* device instance cc_XD4_dmodout_mod0 r0 *1 0,0
Ccc_XD4_dmodout_mod0 XD4.dmodout mod0 2.4201e-17
* device instance cc_XD4_dmodout_mod1 r0 *1 0,0
Ccc_XD4_dmodout_mod1 XD4.dmodout mod1 2.4201e-17
* device instance cc_XD4_dmodout_mod2 r0 *1 0,0
Ccc_XD4_dmodout_mod2 XD4.dmodout mod2 2.4201e-17
* device instance cc_XD4_dmodout_mod3 r0 *1 0,0
Ccc_XD4_dmodout_mod3 XD4.dmodout mod3 2.4201e-17
* device instance cc_XD4_dmodout_mod4 r0 *1 0,0
Ccc_XD4_dmodout_mod4 XD4.dmodout mod4 2.4201e-17
* device instance cc_XD4_dmodout_net1 r0 *1 0,0
Ccc_XD4_dmodout_net1 XD4.dmodout net1 1.21e-17
* device instance cc_XD4_dq_XD4_nm r0 *1 0,0
Ccc_XD4_dq_XD4_nm XD4.dq XD4.nm 1.21e-17
* device instance cc_XD4_dq_XD4_nt r0 *1 0,0
Ccc_XD4_dq_XD4_nt XD4.dq XD4.nt 2.4201e-17
* device instance cc_XD4_dq_XD4_t1 r0 *1 0,0
Ccc_XD4_dq_XD4_t1 XD4.dq XD4.t1 1.8151e-17
* device instance cc_XD4_dq_XD5_XDFFM_CLKB r0 *1 0,0
Ccc_XD4_dq_XD5_XDFFM_CLKB XD4.dq XD5.XDFFM.CLKB 1.8151e-17
* device instance cc_XD4_dq_XD5_XDFFM_M r0 *1 0,0
Ccc_XD4_dq_XD5_XDFFM_M XD4.dq XD5.XDFFM.M 2.4201e-17
* device instance cc_XD4_dq_XD5_XDFFM_MB r0 *1 0,0
Ccc_XD4_dq_XD5_XDFFM_MB XD4.dq XD5.XDFFM.MB 1.21e-17
* device instance cc_XD4_dq_XD5_XDFFM_S r0 *1 0,0
Ccc_XD4_dq_XD5_XDFFM_S XD4.dq XD5.XDFFM.S 1.8151e-17
* device instance cc_XD4_dq_XD5_XDFFM_SB r0 *1 0,0
Ccc_XD4_dq_XD5_XDFFM_SB XD4.dq XD5.XDFFM.SB 1.8151e-17
* device instance cc_XD4_dq_XD5_XDFFQ_CLKB r0 *1 0,0
Ccc_XD4_dq_XD5_XDFFQ_CLKB XD4.dq XD5.XDFFQ.CLKB 1.8151e-17
* device instance cc_XD4_dq_XD5_XDFFQ_M r0 *1 0,0
Ccc_XD4_dq_XD5_XDFFQ_M XD4.dq XD5.XDFFQ.M 2.4201e-17
* device instance cc_XD4_dq_XD5_XDFFQ_MB r0 *1 0,0
Ccc_XD4_dq_XD5_XDFFQ_MB XD4.dq XD5.XDFFQ.MB 1.21e-17
* device instance cc_XD4_dq_XD5_XDFFQ_S r0 *1 0,0
Ccc_XD4_dq_XD5_XDFFQ_S XD4.dq XD5.XDFFQ.S 1.8151e-17
* device instance cc_XD4_dq_XD5_XDFFQ_SB r0 *1 0,0
Ccc_XD4_dq_XD5_XDFFQ_SB XD4.dq XD5.XDFFQ.SB 1.8151e-17
* device instance cc_XD4_dq_XD5_XN2_mid1 r0 *1 0,0
Ccc_XD4_dq_XD5_XN2_mid1 XD4.dq XD5.XN2.mid1 1.21e-17
* device instance cc_XD4_dq_XD5_XN3_mid1 r0 *1 0,0
Ccc_XD4_dq_XD5_XN3_mid1 XD4.dq XD5.XN3.mid1 1.21e-17
* device instance cc_XD4_dq_XD5_XN3_mid2 r0 *1 0,0
Ccc_XD4_dq_XD5_XN3_mid2 XD4.dq XD5.XN3.mid2 1.21e-17
* device instance cc_XD4_dq_XD5_dmodout r0 *1 0,0
Ccc_XD4_dq_XD5_dmodout XD4.dq XD5.dmodout 1.21e-17
* device instance cc_XD4_dq_XD5_dq r0 *1 0,0
Ccc_XD4_dq_XD5_dq XD4.dq XD5.dq 1.8151e-17
* device instance cc_XD4_dq_XD5_nm r0 *1 0,0
Ccc_XD4_dq_XD5_nm XD4.dq XD5.nm 1.21e-17
* device instance cc_XD4_dq_XD5_nt r0 *1 0,0
Ccc_XD4_dq_XD5_nt XD4.dq XD5.nt 1.21e-17
* device instance cc_XD4_dq_XD5_t1 r0 *1 0,0
Ccc_XD4_dq_XD5_t1 XD4.dq XD5.t1 1.21e-17
* device instance cc_XD4_dq_XFRT_CLKB r0 *1 0,0
Ccc_XD4_dq_XFRT_CLKB XD4.dq XFRT.CLKB 1.8151e-17
* device instance cc_XD4_dq_XFRT_M r0 *1 0,0
Ccc_XD4_dq_XFRT_M XD4.dq XFRT.M 2.4201e-17
* device instance cc_XD4_dq_XFRT_MB r0 *1 0,0
Ccc_XD4_dq_XFRT_MB XD4.dq XFRT.MB 1.21e-17
* device instance cc_XD4_dq_XFRT_S r0 *1 0,0
Ccc_XD4_dq_XFRT_S XD4.dq XFRT.S 1.8151e-17
* device instance cc_XD4_dq_XFRT_SB r0 *1 0,0
Ccc_XD4_dq_XFRT_SB XD4.dq XFRT.SB 1.8151e-17
* device instance cc_XD4_dq_ck1 r0 *1 0,0
Ccc_XD4_dq_ck1 XD4.dq ck1 5.4452e-17
* device instance cc_XD4_dq_ck2 r0 *1 0,0
Ccc_XD4_dq_ck2 XD4.dq ck2 5.4452e-17
* device instance cc_XD4_dq_ck3 r0 *1 0,0
Ccc_XD4_dq_ck3 XD4.dq ck3 5.4452e-17
* device instance cc_XD4_dq_ck4 r0 *1 0,0
Ccc_XD4_dq_ck4 XD4.dq ck4 6.6553e-17
* device instance cc_XD4_dq_ck5 r0 *1 0,0
Ccc_XD4_dq_ck5 XD4.dq ck5 5.4452e-17
* device instance cc_XD4_dq_mod0 r0 *1 0,0
Ccc_XD4_dq_mod0 XD4.dq mod0 2.4201e-17
* device instance cc_XD4_dq_mod1 r0 *1 0,0
Ccc_XD4_dq_mod1 XD4.dq mod1 2.4201e-17
* device instance cc_XD4_dq_mod2 r0 *1 0,0
Ccc_XD4_dq_mod2 XD4.dq mod2 2.4201e-17
* device instance cc_XD4_dq_mod3 r0 *1 0,0
Ccc_XD4_dq_mod3 XD4.dq mod3 2.4201e-17
* device instance cc_XD4_dq_mod4 r0 *1 0,0
Ccc_XD4_dq_mod4 XD4.dq mod4 2.4201e-17
* device instance cc_XD4_dq_net1 r0 *1 0,0
Ccc_XD4_dq_net1 XD4.dq net1 1.21e-17
* device instance cc_XD4_nm_XD4_nt r0 *1 0,0
Ccc_XD4_nm_XD4_nt XD4.nm XD4.nt 2.4201e-17
* device instance cc_XD4_nm_XD4_t1 r0 *1 0,0
Ccc_XD4_nm_XD4_t1 XD4.nm XD4.t1 1.21e-17
* device instance cc_XD4_nm_XD5_XDFFM_CLKB r0 *1 0,0
Ccc_XD4_nm_XD5_XDFFM_CLKB XD4.nm XD5.XDFFM.CLKB 1.8151e-17
* device instance cc_XD4_nm_XD5_XDFFM_M r0 *1 0,0
Ccc_XD4_nm_XD5_XDFFM_M XD4.nm XD5.XDFFM.M 2.4201e-17
* device instance cc_XD4_nm_XD5_XDFFM_MB r0 *1 0,0
Ccc_XD4_nm_XD5_XDFFM_MB XD4.nm XD5.XDFFM.MB 1.21e-17
* device instance cc_XD4_nm_XD5_XDFFM_S r0 *1 0,0
Ccc_XD4_nm_XD5_XDFFM_S XD4.nm XD5.XDFFM.S 1.8151e-17
* device instance cc_XD4_nm_XD5_XDFFM_SB r0 *1 0,0
Ccc_XD4_nm_XD5_XDFFM_SB XD4.nm XD5.XDFFM.SB 1.8151e-17
* device instance cc_XD4_nm_XD5_XDFFQ_CLKB r0 *1 0,0
Ccc_XD4_nm_XD5_XDFFQ_CLKB XD4.nm XD5.XDFFQ.CLKB 1.8151e-17
* device instance cc_XD4_nm_XD5_XDFFQ_M r0 *1 0,0
Ccc_XD4_nm_XD5_XDFFQ_M XD4.nm XD5.XDFFQ.M 2.4201e-17
* device instance cc_XD4_nm_XD5_XDFFQ_MB r0 *1 0,0
Ccc_XD4_nm_XD5_XDFFQ_MB XD4.nm XD5.XDFFQ.MB 1.21e-17
* device instance cc_XD4_nm_XD5_XDFFQ_S r0 *1 0,0
Ccc_XD4_nm_XD5_XDFFQ_S XD4.nm XD5.XDFFQ.S 1.8151e-17
* device instance cc_XD4_nm_XD5_XDFFQ_SB r0 *1 0,0
Ccc_XD4_nm_XD5_XDFFQ_SB XD4.nm XD5.XDFFQ.SB 1.8151e-17
* device instance cc_XD4_nm_XD5_XN2_mid1 r0 *1 0,0
Ccc_XD4_nm_XD5_XN2_mid1 XD4.nm XD5.XN2.mid1 1.21e-17
* device instance cc_XD4_nm_XD5_XN3_mid1 r0 *1 0,0
Ccc_XD4_nm_XD5_XN3_mid1 XD4.nm XD5.XN3.mid1 1.21e-17
* device instance cc_XD4_nm_XD5_XN3_mid2 r0 *1 0,0
Ccc_XD4_nm_XD5_XN3_mid2 XD4.nm XD5.XN3.mid2 1.21e-17
* device instance cc_XD4_nm_XD5_dmodout r0 *1 0,0
Ccc_XD4_nm_XD5_dmodout XD4.nm XD5.dmodout 1.21e-17
* device instance cc_XD4_nm_XD5_dq r0 *1 0,0
Ccc_XD4_nm_XD5_dq XD4.nm XD5.dq 1.8151e-17
* device instance cc_XD4_nm_XD5_nm r0 *1 0,0
Ccc_XD4_nm_XD5_nm XD4.nm XD5.nm 1.21e-17
* device instance cc_XD4_nm_XD5_nt r0 *1 0,0
Ccc_XD4_nm_XD5_nt XD4.nm XD5.nt 1.21e-17
* device instance cc_XD4_nm_XD5_t1 r0 *1 0,0
Ccc_XD4_nm_XD5_t1 XD4.nm XD5.t1 1.21e-17
* device instance cc_XD4_nm_XFRT_CLKB r0 *1 0,0
Ccc_XD4_nm_XFRT_CLKB XD4.nm XFRT.CLKB 1.8151e-17
* device instance cc_XD4_nm_XFRT_M r0 *1 0,0
Ccc_XD4_nm_XFRT_M XD4.nm XFRT.M 2.4201e-17
* device instance cc_XD4_nm_XFRT_MB r0 *1 0,0
Ccc_XD4_nm_XFRT_MB XD4.nm XFRT.MB 1.21e-17
* device instance cc_XD4_nm_XFRT_S r0 *1 0,0
Ccc_XD4_nm_XFRT_S XD4.nm XFRT.S 1.8151e-17
* device instance cc_XD4_nm_XFRT_SB r0 *1 0,0
Ccc_XD4_nm_XFRT_SB XD4.nm XFRT.SB 1.8151e-17
* device instance cc_XD4_nm_ck1 r0 *1 0,0
Ccc_XD4_nm_ck1 XD4.nm ck1 5.4452e-17
* device instance cc_XD4_nm_ck2 r0 *1 0,0
Ccc_XD4_nm_ck2 XD4.nm ck2 5.4452e-17
* device instance cc_XD4_nm_ck3 r0 *1 0,0
Ccc_XD4_nm_ck3 XD4.nm ck3 5.4452e-17
* device instance cc_XD4_nm_ck4 r0 *1 0,0
Ccc_XD4_nm_ck4 XD4.nm ck4 5.4452e-17
* device instance cc_XD4_nm_ck5 r0 *1 0,0
Ccc_XD4_nm_ck5 XD4.nm ck5 6.0502e-17
* device instance cc_XD4_nm_mod0 r0 *1 0,0
Ccc_XD4_nm_mod0 XD4.nm mod0 2.4201e-17
* device instance cc_XD4_nm_mod1 r0 *1 0,0
Ccc_XD4_nm_mod1 XD4.nm mod1 2.4201e-17
* device instance cc_XD4_nm_mod2 r0 *1 0,0
Ccc_XD4_nm_mod2 XD4.nm mod2 2.4201e-17
* device instance cc_XD4_nm_mod3 r0 *1 0,0
Ccc_XD4_nm_mod3 XD4.nm mod3 2.4201e-17
* device instance cc_XD4_nm_mod4 r0 *1 0,0
Ccc_XD4_nm_mod4 XD4.nm mod4 2.4201e-17
* device instance cc_XD4_nm_net1 r0 *1 0,0
Ccc_XD4_nm_net1 XD4.nm net1 1.21e-17
* device instance cc_XD4_nt_XD4_t1 r0 *1 0,0
Ccc_XD4_nt_XD4_t1 XD4.nt XD4.t1 1.21e-17
* device instance cc_XD4_nt_XD5_XDFFM_CLKB r0 *1 0,0
Ccc_XD4_nt_XD5_XDFFM_CLKB XD4.nt XD5.XDFFM.CLKB 1.8151e-17
* device instance cc_XD4_nt_XD5_XDFFM_M r0 *1 0,0
Ccc_XD4_nt_XD5_XDFFM_M XD4.nt XD5.XDFFM.M 2.4201e-17
* device instance cc_XD4_nt_XD5_XDFFM_MB r0 *1 0,0
Ccc_XD4_nt_XD5_XDFFM_MB XD4.nt XD5.XDFFM.MB 1.21e-17
* device instance cc_XD4_nt_XD5_XDFFM_S r0 *1 0,0
Ccc_XD4_nt_XD5_XDFFM_S XD4.nt XD5.XDFFM.S 1.8151e-17
* device instance cc_XD4_nt_XD5_XDFFM_SB r0 *1 0,0
Ccc_XD4_nt_XD5_XDFFM_SB XD4.nt XD5.XDFFM.SB 1.8151e-17
* device instance cc_XD4_nt_XD5_XDFFQ_CLKB r0 *1 0,0
Ccc_XD4_nt_XD5_XDFFQ_CLKB XD4.nt XD5.XDFFQ.CLKB 1.8151e-17
* device instance cc_XD4_nt_XD5_XDFFQ_M r0 *1 0,0
Ccc_XD4_nt_XD5_XDFFQ_M XD4.nt XD5.XDFFQ.M 2.4201e-17
* device instance cc_XD4_nt_XD5_XDFFQ_MB r0 *1 0,0
Ccc_XD4_nt_XD5_XDFFQ_MB XD4.nt XD5.XDFFQ.MB 1.21e-17
* device instance cc_XD4_nt_XD5_XDFFQ_S r0 *1 0,0
Ccc_XD4_nt_XD5_XDFFQ_S XD4.nt XD5.XDFFQ.S 1.8151e-17
* device instance cc_XD4_nt_XD5_XDFFQ_SB r0 *1 0,0
Ccc_XD4_nt_XD5_XDFFQ_SB XD4.nt XD5.XDFFQ.SB 1.8151e-17
* device instance cc_XD4_nt_XD5_XN2_mid1 r0 *1 0,0
Ccc_XD4_nt_XD5_XN2_mid1 XD4.nt XD5.XN2.mid1 1.21e-17
* device instance cc_XD4_nt_XD5_XN3_mid1 r0 *1 0,0
Ccc_XD4_nt_XD5_XN3_mid1 XD4.nt XD5.XN3.mid1 1.21e-17
* device instance cc_XD4_nt_XD5_XN3_mid2 r0 *1 0,0
Ccc_XD4_nt_XD5_XN3_mid2 XD4.nt XD5.XN3.mid2 1.21e-17
* device instance cc_XD4_nt_XD5_dmodout r0 *1 0,0
Ccc_XD4_nt_XD5_dmodout XD4.nt XD5.dmodout 1.21e-17
* device instance cc_XD4_nt_XD5_dq r0 *1 0,0
Ccc_XD4_nt_XD5_dq XD4.nt XD5.dq 1.8151e-17
* device instance cc_XD4_nt_XD5_nm r0 *1 0,0
Ccc_XD4_nt_XD5_nm XD4.nt XD5.nm 1.21e-17
* device instance cc_XD4_nt_XD5_nt r0 *1 0,0
Ccc_XD4_nt_XD5_nt XD4.nt XD5.nt 1.21e-17
* device instance cc_XD4_nt_XD5_t1 r0 *1 0,0
Ccc_XD4_nt_XD5_t1 XD4.nt XD5.t1 1.21e-17
* device instance cc_XD4_nt_XFRT_CLKB r0 *1 0,0
Ccc_XD4_nt_XFRT_CLKB XD4.nt XFRT.CLKB 1.8151e-17
* device instance cc_XD4_nt_XFRT_M r0 *1 0,0
Ccc_XD4_nt_XFRT_M XD4.nt XFRT.M 2.4201e-17
* device instance cc_XD4_nt_XFRT_MB r0 *1 0,0
Ccc_XD4_nt_XFRT_MB XD4.nt XFRT.MB 1.21e-17
* device instance cc_XD4_nt_XFRT_S r0 *1 0,0
Ccc_XD4_nt_XFRT_S XD4.nt XFRT.S 1.8151e-17
* device instance cc_XD4_nt_XFRT_SB r0 *1 0,0
Ccc_XD4_nt_XFRT_SB XD4.nt XFRT.SB 1.8151e-17
* device instance cc_XD4_nt_ck1 r0 *1 0,0
Ccc_XD4_nt_ck1 XD4.nt ck1 5.4452e-17
* device instance cc_XD4_nt_ck2 r0 *1 0,0
Ccc_XD4_nt_ck2 XD4.nt ck2 5.4452e-17
* device instance cc_XD4_nt_ck3 r0 *1 0,0
Ccc_XD4_nt_ck3 XD4.nt ck3 5.4452e-17
* device instance cc_XD4_nt_ck4 r0 *1 0,0
Ccc_XD4_nt_ck4 XD4.nt ck4 5.4452e-17
* device instance cc_XD4_nt_ck5 r0 *1 0,0
Ccc_XD4_nt_ck5 XD4.nt ck5 5.4452e-17
* device instance cc_XD4_nt_mod0 r0 *1 0,0
Ccc_XD4_nt_mod0 XD4.nt mod0 2.4201e-17
* device instance cc_XD4_nt_mod1 r0 *1 0,0
Ccc_XD4_nt_mod1 XD4.nt mod1 2.4201e-17
* device instance cc_XD4_nt_mod2 r0 *1 0,0
Ccc_XD4_nt_mod2 XD4.nt mod2 2.4201e-17
* device instance cc_XD4_nt_mod3 r0 *1 0,0
Ccc_XD4_nt_mod3 XD4.nt mod3 3.0251e-17
* device instance cc_XD4_nt_mod4 r0 *1 0,0
Ccc_XD4_nt_mod4 XD4.nt mod4 2.4201e-17
* device instance cc_XD4_nt_net1 r0 *1 0,0
Ccc_XD4_nt_net1 XD4.nt net1 1.21e-17
* device instance cc_XD4_t1_XD5_XDFFM_CLKB r0 *1 0,0
Ccc_XD4_t1_XD5_XDFFM_CLKB XD4.t1 XD5.XDFFM.CLKB 1.8151e-17
* device instance cc_XD4_t1_XD5_XDFFM_M r0 *1 0,0
Ccc_XD4_t1_XD5_XDFFM_M XD4.t1 XD5.XDFFM.M 2.4201e-17
* device instance cc_XD4_t1_XD5_XDFFM_MB r0 *1 0,0
Ccc_XD4_t1_XD5_XDFFM_MB XD4.t1 XD5.XDFFM.MB 1.21e-17
* device instance cc_XD4_t1_XD5_XDFFM_S r0 *1 0,0
Ccc_XD4_t1_XD5_XDFFM_S XD4.t1 XD5.XDFFM.S 1.8151e-17
* device instance cc_XD4_t1_XD5_XDFFM_SB r0 *1 0,0
Ccc_XD4_t1_XD5_XDFFM_SB XD4.t1 XD5.XDFFM.SB 1.8151e-17
* device instance cc_XD4_t1_XD5_XDFFQ_CLKB r0 *1 0,0
Ccc_XD4_t1_XD5_XDFFQ_CLKB XD4.t1 XD5.XDFFQ.CLKB 1.8151e-17
* device instance cc_XD4_t1_XD5_XDFFQ_M r0 *1 0,0
Ccc_XD4_t1_XD5_XDFFQ_M XD4.t1 XD5.XDFFQ.M 2.4201e-17
* device instance cc_XD4_t1_XD5_XDFFQ_MB r0 *1 0,0
Ccc_XD4_t1_XD5_XDFFQ_MB XD4.t1 XD5.XDFFQ.MB 1.21e-17
* device instance cc_XD4_t1_XD5_XDFFQ_S r0 *1 0,0
Ccc_XD4_t1_XD5_XDFFQ_S XD4.t1 XD5.XDFFQ.S 1.8151e-17
* device instance cc_XD4_t1_XD5_XDFFQ_SB r0 *1 0,0
Ccc_XD4_t1_XD5_XDFFQ_SB XD4.t1 XD5.XDFFQ.SB 1.8151e-17
* device instance cc_XD4_t1_XD5_XN2_mid1 r0 *1 0,0
Ccc_XD4_t1_XD5_XN2_mid1 XD4.t1 XD5.XN2.mid1 1.21e-17
* device instance cc_XD4_t1_XD5_XN3_mid1 r0 *1 0,0
Ccc_XD4_t1_XD5_XN3_mid1 XD4.t1 XD5.XN3.mid1 1.21e-17
* device instance cc_XD4_t1_XD5_XN3_mid2 r0 *1 0,0
Ccc_XD4_t1_XD5_XN3_mid2 XD4.t1 XD5.XN3.mid2 1.21e-17
* device instance cc_XD4_t1_XD5_dmodout r0 *1 0,0
Ccc_XD4_t1_XD5_dmodout XD4.t1 XD5.dmodout 1.21e-17
* device instance cc_XD4_t1_XD5_dq r0 *1 0,0
Ccc_XD4_t1_XD5_dq XD4.t1 XD5.dq 1.8151e-17
* device instance cc_XD4_t1_XD5_nm r0 *1 0,0
Ccc_XD4_t1_XD5_nm XD4.t1 XD5.nm 1.21e-17
* device instance cc_XD4_t1_XD5_nt r0 *1 0,0
Ccc_XD4_t1_XD5_nt XD4.t1 XD5.nt 1.21e-17
* device instance cc_XD4_t1_XD5_t1 r0 *1 0,0
Ccc_XD4_t1_XD5_t1 XD4.t1 XD5.t1 1.21e-17
* device instance cc_XD4_t1_XFRT_CLKB r0 *1 0,0
Ccc_XD4_t1_XFRT_CLKB XD4.t1 XFRT.CLKB 1.8151e-17
* device instance cc_XD4_t1_XFRT_M r0 *1 0,0
Ccc_XD4_t1_XFRT_M XD4.t1 XFRT.M 2.4201e-17
* device instance cc_XD4_t1_XFRT_MB r0 *1 0,0
Ccc_XD4_t1_XFRT_MB XD4.t1 XFRT.MB 1.21e-17
* device instance cc_XD4_t1_XFRT_S r0 *1 0,0
Ccc_XD4_t1_XFRT_S XD4.t1 XFRT.S 1.8151e-17
* device instance cc_XD4_t1_XFRT_SB r0 *1 0,0
Ccc_XD4_t1_XFRT_SB XD4.t1 XFRT.SB 1.8151e-17
* device instance cc_XD4_t1_ck1 r0 *1 0,0
Ccc_XD4_t1_ck1 XD4.t1 ck1 5.4452e-17
* device instance cc_XD4_t1_ck2 r0 *1 0,0
Ccc_XD4_t1_ck2 XD4.t1 ck2 5.4452e-17
* device instance cc_XD4_t1_ck3 r0 *1 0,0
Ccc_XD4_t1_ck3 XD4.t1 ck3 5.4452e-17
* device instance cc_XD4_t1_ck4 r0 *1 0,0
Ccc_XD4_t1_ck4 XD4.t1 ck4 5.4452e-17
* device instance cc_XD4_t1_ck5 r0 *1 0,0
Ccc_XD4_t1_ck5 XD4.t1 ck5 6.0502e-17
* device instance cc_XD4_t1_mod0 r0 *1 0,0
Ccc_XD4_t1_mod0 XD4.t1 mod0 2.4201e-17
* device instance cc_XD4_t1_mod1 r0 *1 0,0
Ccc_XD4_t1_mod1 XD4.t1 mod1 2.4201e-17
* device instance cc_XD4_t1_mod2 r0 *1 0,0
Ccc_XD4_t1_mod2 XD4.t1 mod2 2.4201e-17
* device instance cc_XD4_t1_mod3 r0 *1 0,0
Ccc_XD4_t1_mod3 XD4.t1 mod3 2.4201e-17
* device instance cc_XD4_t1_mod4 r0 *1 0,0
Ccc_XD4_t1_mod4 XD4.t1 mod4 2.4201e-17
* device instance cc_XD4_t1_net1 r0 *1 0,0
Ccc_XD4_t1_net1 XD4.t1 net1 1.21e-17
* device instance cc_XD5_XDFFM_CLKB_XD5_XDFFM_M r0 *1 0,0
Ccc_XD5_XDFFM_CLKB_XD5_XDFFM_M XD5.XDFFM.CLKB XD5.XDFFM.M 4.2352e-17
* device instance cc_XD5_XDFFM_CLKB_XD5_XDFFM_MB r0 *1 0,0
Ccc_XD5_XDFFM_CLKB_XD5_XDFFM_MB XD5.XDFFM.CLKB XD5.XDFFM.MB 2.4201e-17
* device instance cc_XD5_XDFFM_CLKB_XD5_XDFFM_S r0 *1 0,0
Ccc_XD5_XDFFM_CLKB_XD5_XDFFM_S XD5.XDFFM.CLKB XD5.XDFFM.S 1.8151e-17
* device instance cc_XD5_XDFFM_CLKB_XD5_XDFFM_SB r0 *1 0,0
Ccc_XD5_XDFFM_CLKB_XD5_XDFFM_SB XD5.XDFFM.CLKB XD5.XDFFM.SB 1.8151e-17
* device instance cc_XD5_XDFFM_CLKB_XD5_XDFFQ_CLKB r0 *1 0,0
Ccc_XD5_XDFFM_CLKB_XD5_XDFFQ_CLKB XD5.XDFFM.CLKB XD5.XDFFQ.CLKB 1.8151e-17
* device instance cc_XD5_XDFFM_CLKB_XD5_XDFFQ_M r0 *1 0,0
Ccc_XD5_XDFFM_CLKB_XD5_XDFFQ_M XD5.XDFFM.CLKB XD5.XDFFQ.M 2.4201e-17
* device instance cc_XD5_XDFFM_CLKB_XD5_XDFFQ_MB r0 *1 0,0
Ccc_XD5_XDFFM_CLKB_XD5_XDFFQ_MB XD5.XDFFM.CLKB XD5.XDFFQ.MB 1.21e-17
* device instance cc_XD5_XDFFM_CLKB_XD5_XDFFQ_S r0 *1 0,0
Ccc_XD5_XDFFM_CLKB_XD5_XDFFQ_S XD5.XDFFM.CLKB XD5.XDFFQ.S 1.8151e-17
* device instance cc_XD5_XDFFM_CLKB_XD5_XDFFQ_SB r0 *1 0,0
Ccc_XD5_XDFFM_CLKB_XD5_XDFFQ_SB XD5.XDFFM.CLKB XD5.XDFFQ.SB 1.8151e-17
* device instance cc_XD5_XDFFM_CLKB_XD5_XNOR_midp r0 *1 0,0
Ccc_XD5_XDFFM_CLKB_XD5_XNOR_midp XD5.XDFFM.CLKB XD5.XNOR.midp 1.21e-17
* device instance cc_XD5_XDFFM_CLKB_XD5_dmodout r0 *1 0,0
Ccc_XD5_XDFFM_CLKB_XD5_dmodout XD5.XDFFM.CLKB XD5.dmodout 1.8151e-17
* device instance cc_XD5_XDFFM_CLKB_XD5_dq r0 *1 0,0
Ccc_XD5_XDFFM_CLKB_XD5_dq XD5.XDFFM.CLKB XD5.dq 1.21e-17
* device instance cc_XD5_XDFFM_CLKB_XD5_nm r0 *1 0,0
Ccc_XD5_XDFFM_CLKB_XD5_nm XD5.XDFFM.CLKB XD5.nm 1.8151e-17
* device instance cc_XD5_XDFFM_CLKB_XD5_nt r0 *1 0,0
Ccc_XD5_XDFFM_CLKB_XD5_nt XD5.XDFFM.CLKB XD5.nt 2.4201e-17
* device instance cc_XD5_XDFFM_CLKB_XD5_t1 r0 *1 0,0
Ccc_XD5_XDFFM_CLKB_XD5_t1 XD5.XDFFM.CLKB XD5.t1 1.21e-17
* device instance cc_XD5_XDFFM_CLKB_XFRT_CLKB r0 *1 0,0
Ccc_XD5_XDFFM_CLKB_XFRT_CLKB XD5.XDFFM.CLKB XFRT.CLKB 1.8151e-17
* device instance cc_XD5_XDFFM_CLKB_XFRT_M r0 *1 0,0
Ccc_XD5_XDFFM_CLKB_XFRT_M XD5.XDFFM.CLKB XFRT.M 2.4201e-17
* device instance cc_XD5_XDFFM_CLKB_XFRT_MB r0 *1 0,0
Ccc_XD5_XDFFM_CLKB_XFRT_MB XD5.XDFFM.CLKB XFRT.MB 1.21e-17
* device instance cc_XD5_XDFFM_CLKB_XFRT_S r0 *1 0,0
Ccc_XD5_XDFFM_CLKB_XFRT_S XD5.XDFFM.CLKB XFRT.S 1.8151e-17
* device instance cc_XD5_XDFFM_CLKB_XFRT_SB r0 *1 0,0
Ccc_XD5_XDFFM_CLKB_XFRT_SB XD5.XDFFM.CLKB XFRT.SB 1.8151e-17
* device instance cc_XD5_XDFFM_CLKB_ck1 r0 *1 0,0
Ccc_XD5_XDFFM_CLKB_ck1 XD5.XDFFM.CLKB ck1 5.4452e-17
* device instance cc_XD5_XDFFM_CLKB_ck2 r0 *1 0,0
Ccc_XD5_XDFFM_CLKB_ck2 XD5.XDFFM.CLKB ck2 5.4452e-17
* device instance cc_XD5_XDFFM_CLKB_ck3 r0 *1 0,0
Ccc_XD5_XDFFM_CLKB_ck3 XD5.XDFFM.CLKB ck3 5.4452e-17
* device instance cc_XD5_XDFFM_CLKB_ck4 r0 *1 0,0
Ccc_XD5_XDFFM_CLKB_ck4 XD5.XDFFM.CLKB ck4 5.4452e-17
* device instance cc_XD5_XDFFM_CLKB_ck5 r0 *1 0,0
Ccc_XD5_XDFFM_CLKB_ck5 XD5.XDFFM.CLKB ck5 6.0502e-17
* device instance cc_XD5_XDFFM_CLKB_mod0 r0 *1 0,0
Ccc_XD5_XDFFM_CLKB_mod0 XD5.XDFFM.CLKB mod0 2.4201e-17
* device instance cc_XD5_XDFFM_CLKB_mod1 r0 *1 0,0
Ccc_XD5_XDFFM_CLKB_mod1 XD5.XDFFM.CLKB mod1 2.4201e-17
* device instance cc_XD5_XDFFM_CLKB_mod2 r0 *1 0,0
Ccc_XD5_XDFFM_CLKB_mod2 XD5.XDFFM.CLKB mod2 2.4201e-17
* device instance cc_XD5_XDFFM_CLKB_mod3 r0 *1 0,0
Ccc_XD5_XDFFM_CLKB_mod3 XD5.XDFFM.CLKB mod3 2.4201e-17
* device instance cc_XD5_XDFFM_CLKB_mod4 r0 *1 0,0
Ccc_XD5_XDFFM_CLKB_mod4 XD5.XDFFM.CLKB mod4 2.4201e-17
* device instance cc_XD5_XDFFM_CLKB_net1 r0 *1 0,0
Ccc_XD5_XDFFM_CLKB_net1 XD5.XDFFM.CLKB net1 1.21e-17
* device instance cc_XD5_XDFFM_M_XD5_XDFFM_MB r0 *1 0,0
Ccc_XD5_XDFFM_M_XD5_XDFFM_MB XD5.XDFFM.M XD5.XDFFM.MB 3.4688e-17
* device instance cc_XD5_XDFFM_M_XD5_XDFFM_S r0 *1 0,0
Ccc_XD5_XDFFM_M_XD5_XDFFM_S XD5.XDFFM.M XD5.XDFFM.S 2.8638e-17
* device instance cc_XD5_XDFFM_M_XD5_XDFFM_SB r0 *1 0,0
Ccc_XD5_XDFFM_M_XD5_XDFFM_SB XD5.XDFFM.M XD5.XDFFM.SB 1.8151e-17
* device instance cc_XD5_XDFFM_M_XD5_XDFFQ_CLKB r0 *1 0,0
Ccc_XD5_XDFFM_M_XD5_XDFFQ_CLKB XD5.XDFFM.M XD5.XDFFQ.CLKB 1.8151e-17
* device instance cc_XD5_XDFFM_M_XD5_XDFFQ_M r0 *1 0,0
Ccc_XD5_XDFFM_M_XD5_XDFFQ_M XD5.XDFFM.M XD5.XDFFQ.M 2.4201e-17
* device instance cc_XD5_XDFFM_M_XD5_XDFFQ_MB r0 *1 0,0
Ccc_XD5_XDFFM_M_XD5_XDFFQ_MB XD5.XDFFM.M XD5.XDFFQ.MB 1.21e-17
* device instance cc_XD5_XDFFM_M_XD5_XDFFQ_S r0 *1 0,0
Ccc_XD5_XDFFM_M_XD5_XDFFQ_S XD5.XDFFM.M XD5.XDFFQ.S 1.8151e-17
* device instance cc_XD5_XDFFM_M_XD5_XDFFQ_SB r0 *1 0,0
Ccc_XD5_XDFFM_M_XD5_XDFFQ_SB XD5.XDFFM.M XD5.XDFFQ.SB 1.8151e-17
* device instance cc_XD5_XDFFM_M_XD5_XNOR_midp r0 *1 0,0
Ccc_XD5_XDFFM_M_XD5_XNOR_midp XD5.XDFFM.M XD5.XNOR.midp 1.21e-17
* device instance cc_XD5_XDFFM_M_XD5_dmodout r0 *1 0,0
Ccc_XD5_XDFFM_M_XD5_dmodout XD5.XDFFM.M XD5.dmodout 2.8638e-17
* device instance cc_XD5_XDFFM_M_XD5_dq r0 *1 0,0
Ccc_XD5_XDFFM_M_XD5_dq XD5.XDFFM.M XD5.dq 1.21e-17
* device instance cc_XD5_XDFFM_M_XD5_nm r0 *1 0,0
Ccc_XD5_XDFFM_M_XD5_nm XD5.XDFFM.M XD5.nm 1.8151e-17
* device instance cc_XD5_XDFFM_M_XD5_nt r0 *1 0,0
Ccc_XD5_XDFFM_M_XD5_nt XD5.XDFFM.M XD5.nt 2.4201e-17
* device instance cc_XD5_XDFFM_M_XD5_t1 r0 *1 0,0
Ccc_XD5_XDFFM_M_XD5_t1 XD5.XDFFM.M XD5.t1 1.21e-17
* device instance cc_XD5_XDFFM_M_XFRT_CLKB r0 *1 0,0
Ccc_XD5_XDFFM_M_XFRT_CLKB XD5.XDFFM.M XFRT.CLKB 1.8151e-17
* device instance cc_XD5_XDFFM_M_XFRT_M r0 *1 0,0
Ccc_XD5_XDFFM_M_XFRT_M XD5.XDFFM.M XFRT.M 2.4201e-17
* device instance cc_XD5_XDFFM_M_XFRT_MB r0 *1 0,0
Ccc_XD5_XDFFM_M_XFRT_MB XD5.XDFFM.M XFRT.MB 1.21e-17
* device instance cc_XD5_XDFFM_M_XFRT_S r0 *1 0,0
Ccc_XD5_XDFFM_M_XFRT_S XD5.XDFFM.M XFRT.S 1.8151e-17
* device instance cc_XD5_XDFFM_M_XFRT_SB r0 *1 0,0
Ccc_XD5_XDFFM_M_XFRT_SB XD5.XDFFM.M XFRT.SB 1.8151e-17
* device instance cc_XD5_XDFFM_M_ck1 r0 *1 0,0
Ccc_XD5_XDFFM_M_ck1 XD5.XDFFM.M ck1 5.4452e-17
* device instance cc_XD5_XDFFM_M_ck2 r0 *1 0,0
Ccc_XD5_XDFFM_M_ck2 XD5.XDFFM.M ck2 5.4452e-17
* device instance cc_XD5_XDFFM_M_ck3 r0 *1 0,0
Ccc_XD5_XDFFM_M_ck3 XD5.XDFFM.M ck3 5.4452e-17
* device instance cc_XD5_XDFFM_M_ck4 r0 *1 0,0
Ccc_XD5_XDFFM_M_ck4 XD5.XDFFM.M ck4 5.4452e-17
* device instance cc_XD5_XDFFM_M_ck5 r0 *1 0,0
Ccc_XD5_XDFFM_M_ck5 XD5.XDFFM.M ck5 6.0502e-17
* device instance cc_XD5_XDFFM_M_mod0 r0 *1 0,0
Ccc_XD5_XDFFM_M_mod0 XD5.XDFFM.M mod0 2.4201e-17
* device instance cc_XD5_XDFFM_M_mod1 r0 *1 0,0
Ccc_XD5_XDFFM_M_mod1 XD5.XDFFM.M mod1 2.4201e-17
* device instance cc_XD5_XDFFM_M_mod2 r0 *1 0,0
Ccc_XD5_XDFFM_M_mod2 XD5.XDFFM.M mod2 2.4201e-17
* device instance cc_XD5_XDFFM_M_mod3 r0 *1 0,0
Ccc_XD5_XDFFM_M_mod3 XD5.XDFFM.M mod3 2.4201e-17
* device instance cc_XD5_XDFFM_M_mod4 r0 *1 0,0
Ccc_XD5_XDFFM_M_mod4 XD5.XDFFM.M mod4 2.4201e-17
* device instance cc_XD5_XDFFM_M_net1 r0 *1 0,0
Ccc_XD5_XDFFM_M_net1 XD5.XDFFM.M net1 1.21e-17
* device instance cc_XD5_XDFFM_MB_XD5_XDFFM_S r0 *1 0,0
Ccc_XD5_XDFFM_MB_XD5_XDFFM_S XD5.XDFFM.MB XD5.XDFFM.S 1.8151e-17
* device instance cc_XD5_XDFFM_MB_XD5_XDFFM_SB r0 *1 0,0
Ccc_XD5_XDFFM_MB_XD5_XDFFM_SB XD5.XDFFM.MB XD5.XDFFM.SB 1.8151e-17
* device instance cc_XD5_XDFFM_MB_XD5_XDFFQ_CLKB r0 *1 0,0
Ccc_XD5_XDFFM_MB_XD5_XDFFQ_CLKB XD5.XDFFM.MB XD5.XDFFQ.CLKB 1.8151e-17
* device instance cc_XD5_XDFFM_MB_XD5_XDFFQ_M r0 *1 0,0
Ccc_XD5_XDFFM_MB_XD5_XDFFQ_M XD5.XDFFM.MB XD5.XDFFQ.M 2.4201e-17
* device instance cc_XD5_XDFFM_MB_XD5_XDFFQ_MB r0 *1 0,0
Ccc_XD5_XDFFM_MB_XD5_XDFFQ_MB XD5.XDFFM.MB XD5.XDFFQ.MB 1.21e-17
* device instance cc_XD5_XDFFM_MB_XD5_XDFFQ_S r0 *1 0,0
Ccc_XD5_XDFFM_MB_XD5_XDFFQ_S XD5.XDFFM.MB XD5.XDFFQ.S 1.8151e-17
* device instance cc_XD5_XDFFM_MB_XD5_XDFFQ_SB r0 *1 0,0
Ccc_XD5_XDFFM_MB_XD5_XDFFQ_SB XD5.XDFFM.MB XD5.XDFFQ.SB 1.8151e-17
* device instance cc_XD5_XDFFM_MB_XD5_XNOR_midp r0 *1 0,0
Ccc_XD5_XDFFM_MB_XD5_XNOR_midp XD5.XDFFM.MB XD5.XNOR.midp 1.21e-17
* device instance cc_XD5_XDFFM_MB_XD5_dmodout r0 *1 0,0
Ccc_XD5_XDFFM_MB_XD5_dmodout XD5.XDFFM.MB XD5.dmodout 1.21e-17
* device instance cc_XD5_XDFFM_MB_XD5_dq r0 *1 0,0
Ccc_XD5_XDFFM_MB_XD5_dq XD5.XDFFM.MB XD5.dq 1.21e-17
* device instance cc_XD5_XDFFM_MB_XD5_nm r0 *1 0,0
Ccc_XD5_XDFFM_MB_XD5_nm XD5.XDFFM.MB XD5.nm 1.8151e-17
* device instance cc_XD5_XDFFM_MB_XD5_nt r0 *1 0,0
Ccc_XD5_XDFFM_MB_XD5_nt XD5.XDFFM.MB XD5.nt 2.4201e-17
* device instance cc_XD5_XDFFM_MB_XD5_t1 r0 *1 0,0
Ccc_XD5_XDFFM_MB_XD5_t1 XD5.XDFFM.MB XD5.t1 1.21e-17
* device instance cc_XD5_XDFFM_MB_XFRT_CLKB r0 *1 0,0
Ccc_XD5_XDFFM_MB_XFRT_CLKB XD5.XDFFM.MB XFRT.CLKB 1.8151e-17
* device instance cc_XD5_XDFFM_MB_XFRT_M r0 *1 0,0
Ccc_XD5_XDFFM_MB_XFRT_M XD5.XDFFM.MB XFRT.M 2.4201e-17
* device instance cc_XD5_XDFFM_MB_XFRT_MB r0 *1 0,0
Ccc_XD5_XDFFM_MB_XFRT_MB XD5.XDFFM.MB XFRT.MB 1.21e-17
* device instance cc_XD5_XDFFM_MB_XFRT_S r0 *1 0,0
Ccc_XD5_XDFFM_MB_XFRT_S XD5.XDFFM.MB XFRT.S 1.8151e-17
* device instance cc_XD5_XDFFM_MB_XFRT_SB r0 *1 0,0
Ccc_XD5_XDFFM_MB_XFRT_SB XD5.XDFFM.MB XFRT.SB 1.8151e-17
* device instance cc_XD5_XDFFM_MB_ck1 r0 *1 0,0
Ccc_XD5_XDFFM_MB_ck1 XD5.XDFFM.MB ck1 5.4452e-17
* device instance cc_XD5_XDFFM_MB_ck2 r0 *1 0,0
Ccc_XD5_XDFFM_MB_ck2 XD5.XDFFM.MB ck2 5.4452e-17
* device instance cc_XD5_XDFFM_MB_ck3 r0 *1 0,0
Ccc_XD5_XDFFM_MB_ck3 XD5.XDFFM.MB ck3 5.4452e-17
* device instance cc_XD5_XDFFM_MB_ck4 r0 *1 0,0
Ccc_XD5_XDFFM_MB_ck4 XD5.XDFFM.MB ck4 5.4452e-17
* device instance cc_XD5_XDFFM_MB_ck5 r0 *1 0,0
Ccc_XD5_XDFFM_MB_ck5 XD5.XDFFM.MB ck5 6.0502e-17
* device instance cc_XD5_XDFFM_MB_mod0 r0 *1 0,0
Ccc_XD5_XDFFM_MB_mod0 XD5.XDFFM.MB mod0 2.4201e-17
* device instance cc_XD5_XDFFM_MB_mod1 r0 *1 0,0
Ccc_XD5_XDFFM_MB_mod1 XD5.XDFFM.MB mod1 2.4201e-17
* device instance cc_XD5_XDFFM_MB_mod2 r0 *1 0,0
Ccc_XD5_XDFFM_MB_mod2 XD5.XDFFM.MB mod2 2.4201e-17
* device instance cc_XD5_XDFFM_MB_mod3 r0 *1 0,0
Ccc_XD5_XDFFM_MB_mod3 XD5.XDFFM.MB mod3 2.4201e-17
* device instance cc_XD5_XDFFM_MB_mod4 r0 *1 0,0
Ccc_XD5_XDFFM_MB_mod4 XD5.XDFFM.MB mod4 2.4201e-17
* device instance cc_XD5_XDFFM_MB_net1 r0 *1 0,0
Ccc_XD5_XDFFM_MB_net1 XD5.XDFFM.MB net1 1.21e-17
* device instance cc_XD5_XDFFM_S_XD5_XDFFM_SB r0 *1 0,0
Ccc_XD5_XDFFM_S_XD5_XDFFM_SB XD5.XDFFM.S XD5.XDFFM.SB 4.0738e-17
* device instance cc_XD5_XDFFM_S_XD5_XDFFQ_CLKB r0 *1 0,0
Ccc_XD5_XDFFM_S_XD5_XDFFQ_CLKB XD5.XDFFM.S XD5.XDFFQ.CLKB 1.8151e-17
* device instance cc_XD5_XDFFM_S_XD5_XDFFQ_M r0 *1 0,0
Ccc_XD5_XDFFM_S_XD5_XDFFQ_M XD5.XDFFM.S XD5.XDFFQ.M 2.4201e-17
* device instance cc_XD5_XDFFM_S_XD5_XDFFQ_MB r0 *1 0,0
Ccc_XD5_XDFFM_S_XD5_XDFFQ_MB XD5.XDFFM.S XD5.XDFFQ.MB 1.21e-17
* device instance cc_XD5_XDFFM_S_XD5_XDFFQ_S r0 *1 0,0
Ccc_XD5_XDFFM_S_XD5_XDFFQ_S XD5.XDFFM.S XD5.XDFFQ.S 1.8151e-17
* device instance cc_XD5_XDFFM_S_XD5_XDFFQ_SB r0 *1 0,0
Ccc_XD5_XDFFM_S_XD5_XDFFQ_SB XD5.XDFFM.S XD5.XDFFQ.SB 1.8151e-17
* device instance cc_XD5_XDFFM_S_XD5_XNOR_midp r0 *1 0,0
Ccc_XD5_XDFFM_S_XD5_XNOR_midp XD5.XDFFM.S XD5.XNOR.midp 1.21e-17
* device instance cc_XD5_XDFFM_S_XD5_dmodout r0 *1 0,0
Ccc_XD5_XDFFM_S_XD5_dmodout XD5.XDFFM.S XD5.dmodout 1.21e-17
* device instance cc_XD5_XDFFM_S_XD5_dq r0 *1 0,0
Ccc_XD5_XDFFM_S_XD5_dq XD5.XDFFM.S XD5.dq 1.21e-17
* device instance cc_XD5_XDFFM_S_XD5_nm r0 *1 0,0
Ccc_XD5_XDFFM_S_XD5_nm XD5.XDFFM.S XD5.nm 1.8151e-17
* device instance cc_XD5_XDFFM_S_XD5_nt r0 *1 0,0
Ccc_XD5_XDFFM_S_XD5_nt XD5.XDFFM.S XD5.nt 2.4201e-17
* device instance cc_XD5_XDFFM_S_XD5_t1 r0 *1 0,0
Ccc_XD5_XDFFM_S_XD5_t1 XD5.XDFFM.S XD5.t1 1.21e-17
* device instance cc_XD5_XDFFM_S_XFRT_CLKB r0 *1 0,0
Ccc_XD5_XDFFM_S_XFRT_CLKB XD5.XDFFM.S XFRT.CLKB 1.8151e-17
* device instance cc_XD5_XDFFM_S_XFRT_M r0 *1 0,0
Ccc_XD5_XDFFM_S_XFRT_M XD5.XDFFM.S XFRT.M 2.4201e-17
* device instance cc_XD5_XDFFM_S_XFRT_MB r0 *1 0,0
Ccc_XD5_XDFFM_S_XFRT_MB XD5.XDFFM.S XFRT.MB 1.21e-17
* device instance cc_XD5_XDFFM_S_XFRT_S r0 *1 0,0
Ccc_XD5_XDFFM_S_XFRT_S XD5.XDFFM.S XFRT.S 1.8151e-17
* device instance cc_XD5_XDFFM_S_XFRT_SB r0 *1 0,0
Ccc_XD5_XDFFM_S_XFRT_SB XD5.XDFFM.S XFRT.SB 1.8151e-17
* device instance cc_XD5_XDFFM_S_ck1 r0 *1 0,0
Ccc_XD5_XDFFM_S_ck1 XD5.XDFFM.S ck1 5.4452e-17
* device instance cc_XD5_XDFFM_S_ck2 r0 *1 0,0
Ccc_XD5_XDFFM_S_ck2 XD5.XDFFM.S ck2 5.4452e-17
* device instance cc_XD5_XDFFM_S_ck3 r0 *1 0,0
Ccc_XD5_XDFFM_S_ck3 XD5.XDFFM.S ck3 5.4452e-17
* device instance cc_XD5_XDFFM_S_ck4 r0 *1 0,0
Ccc_XD5_XDFFM_S_ck4 XD5.XDFFM.S ck4 5.4452e-17
* device instance cc_XD5_XDFFM_S_ck5 r0 *1 0,0
Ccc_XD5_XDFFM_S_ck5 XD5.XDFFM.S ck5 5.4452e-17
* device instance cc_XD5_XDFFM_S_mod0 r0 *1 0,0
Ccc_XD5_XDFFM_S_mod0 XD5.XDFFM.S mod0 2.4201e-17
* device instance cc_XD5_XDFFM_S_mod1 r0 *1 0,0
Ccc_XD5_XDFFM_S_mod1 XD5.XDFFM.S mod1 2.4201e-17
* device instance cc_XD5_XDFFM_S_mod2 r0 *1 0,0
Ccc_XD5_XDFFM_S_mod2 XD5.XDFFM.S mod2 2.4201e-17
* device instance cc_XD5_XDFFM_S_mod3 r0 *1 0,0
Ccc_XD5_XDFFM_S_mod3 XD5.XDFFM.S mod3 2.4201e-17
* device instance cc_XD5_XDFFM_S_mod4 r0 *1 0,0
Ccc_XD5_XDFFM_S_mod4 XD5.XDFFM.S mod4 2.4201e-17
* device instance cc_XD5_XDFFM_S_net1 r0 *1 0,0
Ccc_XD5_XDFFM_S_net1 XD5.XDFFM.S net1 1.21e-17
* device instance cc_XD5_XDFFM_SB_XD5_XDFFQ_CLKB r0 *1 0,0
Ccc_XD5_XDFFM_SB_XD5_XDFFQ_CLKB XD5.XDFFM.SB XD5.XDFFQ.CLKB 1.8151e-17
* device instance cc_XD5_XDFFM_SB_XD5_XDFFQ_M r0 *1 0,0
Ccc_XD5_XDFFM_SB_XD5_XDFFQ_M XD5.XDFFM.SB XD5.XDFFQ.M 2.4201e-17
* device instance cc_XD5_XDFFM_SB_XD5_XDFFQ_MB r0 *1 0,0
Ccc_XD5_XDFFM_SB_XD5_XDFFQ_MB XD5.XDFFM.SB XD5.XDFFQ.MB 1.21e-17
* device instance cc_XD5_XDFFM_SB_XD5_XDFFQ_S r0 *1 0,0
Ccc_XD5_XDFFM_SB_XD5_XDFFQ_S XD5.XDFFM.SB XD5.XDFFQ.S 1.8151e-17
* device instance cc_XD5_XDFFM_SB_XD5_XDFFQ_SB r0 *1 0,0
Ccc_XD5_XDFFM_SB_XD5_XDFFQ_SB XD5.XDFFM.SB XD5.XDFFQ.SB 1.8151e-17
* device instance cc_XD5_XDFFM_SB_XD5_XNOR_midp r0 *1 0,0
Ccc_XD5_XDFFM_SB_XD5_XNOR_midp XD5.XDFFM.SB XD5.XNOR.midp 1.21e-17
* device instance cc_XD5_XDFFM_SB_XD5_dmodout r0 *1 0,0
Ccc_XD5_XDFFM_SB_XD5_dmodout XD5.XDFFM.SB XD5.dmodout 1.21e-17
* device instance cc_XD5_XDFFM_SB_XD5_dq r0 *1 0,0
Ccc_XD5_XDFFM_SB_XD5_dq XD5.XDFFM.SB XD5.dq 1.21e-17
* device instance cc_XD5_XDFFM_SB_XD5_nm r0 *1 0,0
Ccc_XD5_XDFFM_SB_XD5_nm XD5.XDFFM.SB XD5.nm 1.8151e-17
* device instance cc_XD5_XDFFM_SB_XD5_nt r0 *1 0,0
Ccc_XD5_XDFFM_SB_XD5_nt XD5.XDFFM.SB XD5.nt 2.4201e-17
* device instance cc_XD5_XDFFM_SB_XD5_t1 r0 *1 0,0
Ccc_XD5_XDFFM_SB_XD5_t1 XD5.XDFFM.SB XD5.t1 1.21e-17
* device instance cc_XD5_XDFFM_SB_XFRT_CLKB r0 *1 0,0
Ccc_XD5_XDFFM_SB_XFRT_CLKB XD5.XDFFM.SB XFRT.CLKB 1.8151e-17
* device instance cc_XD5_XDFFM_SB_XFRT_M r0 *1 0,0
Ccc_XD5_XDFFM_SB_XFRT_M XD5.XDFFM.SB XFRT.M 2.4201e-17
* device instance cc_XD5_XDFFM_SB_XFRT_MB r0 *1 0,0
Ccc_XD5_XDFFM_SB_XFRT_MB XD5.XDFFM.SB XFRT.MB 1.21e-17
* device instance cc_XD5_XDFFM_SB_XFRT_S r0 *1 0,0
Ccc_XD5_XDFFM_SB_XFRT_S XD5.XDFFM.SB XFRT.S 1.8151e-17
* device instance cc_XD5_XDFFM_SB_XFRT_SB r0 *1 0,0
Ccc_XD5_XDFFM_SB_XFRT_SB XD5.XDFFM.SB XFRT.SB 1.8151e-17
* device instance cc_XD5_XDFFM_SB_ck1 r0 *1 0,0
Ccc_XD5_XDFFM_SB_ck1 XD5.XDFFM.SB ck1 5.4452e-17
* device instance cc_XD5_XDFFM_SB_ck2 r0 *1 0,0
Ccc_XD5_XDFFM_SB_ck2 XD5.XDFFM.SB ck2 5.4452e-17
* device instance cc_XD5_XDFFM_SB_ck3 r0 *1 0,0
Ccc_XD5_XDFFM_SB_ck3 XD5.XDFFM.SB ck3 5.4452e-17
* device instance cc_XD5_XDFFM_SB_ck4 r0 *1 0,0
Ccc_XD5_XDFFM_SB_ck4 XD5.XDFFM.SB ck4 5.4452e-17
* device instance cc_XD5_XDFFM_SB_ck5 r0 *1 0,0
Ccc_XD5_XDFFM_SB_ck5 XD5.XDFFM.SB ck5 5.4452e-17
* device instance cc_XD5_XDFFM_SB_mod0 r0 *1 0,0
Ccc_XD5_XDFFM_SB_mod0 XD5.XDFFM.SB mod0 2.4201e-17
* device instance cc_XD5_XDFFM_SB_mod1 r0 *1 0,0
Ccc_XD5_XDFFM_SB_mod1 XD5.XDFFM.SB mod1 2.4201e-17
* device instance cc_XD5_XDFFM_SB_mod2 r0 *1 0,0
Ccc_XD5_XDFFM_SB_mod2 XD5.XDFFM.SB mod2 2.4201e-17
* device instance cc_XD5_XDFFM_SB_mod3 r0 *1 0,0
Ccc_XD5_XDFFM_SB_mod3 XD5.XDFFM.SB mod3 2.4201e-17
* device instance cc_XD5_XDFFM_SB_mod4 r0 *1 0,0
Ccc_XD5_XDFFM_SB_mod4 XD5.XDFFM.SB mod4 2.4201e-17
* device instance cc_XD5_XDFFM_SB_net1 r0 *1 0,0
Ccc_XD5_XDFFM_SB_net1 XD5.XDFFM.SB net1 1.21e-17
* device instance cc_XD5_XDFFQ_CLKB_XD5_XDFFQ_M r0 *1 0,0
Ccc_XD5_XDFFQ_CLKB_XD5_XDFFQ_M XD5.XDFFQ.CLKB XD5.XDFFQ.M 4.2352e-17
* device instance cc_XD5_XDFFQ_CLKB_XD5_XDFFQ_MB r0 *1 0,0
Ccc_XD5_XDFFQ_CLKB_XD5_XDFFQ_MB XD5.XDFFQ.CLKB XD5.XDFFQ.MB 2.4201e-17
* device instance cc_XD5_XDFFQ_CLKB_XD5_XDFFQ_S r0 *1 0,0
Ccc_XD5_XDFFQ_CLKB_XD5_XDFFQ_S XD5.XDFFQ.CLKB XD5.XDFFQ.S 1.8151e-17
* device instance cc_XD5_XDFFQ_CLKB_XD5_XDFFQ_SB r0 *1 0,0
Ccc_XD5_XDFFQ_CLKB_XD5_XDFFQ_SB XD5.XDFFQ.CLKB XD5.XDFFQ.SB 1.8151e-17
* device instance cc_XD5_XDFFQ_CLKB_XD5_XN2_mid1 r0 *1 0,0
Ccc_XD5_XDFFQ_CLKB_XD5_XN2_mid1 XD5.XDFFQ.CLKB XD5.XN2.mid1 1.21e-17
* device instance cc_XD5_XDFFQ_CLKB_XD5_XNOR_midp r0 *1 0,0
Ccc_XD5_XDFFQ_CLKB_XD5_XNOR_midp XD5.XDFFQ.CLKB XD5.XNOR.midp 1.21e-17
* device instance cc_XD5_XDFFQ_CLKB_XD5_dmodout r0 *1 0,0
Ccc_XD5_XDFFQ_CLKB_XD5_dmodout XD5.XDFFQ.CLKB XD5.dmodout 1.21e-17
* device instance cc_XD5_XDFFQ_CLKB_XD5_dq r0 *1 0,0
Ccc_XD5_XDFFQ_CLKB_XD5_dq XD5.XDFFQ.CLKB XD5.dq 1.8151e-17
* device instance cc_XD5_XDFFQ_CLKB_XD5_nm r0 *1 0,0
Ccc_XD5_XDFFQ_CLKB_XD5_nm XD5.XDFFQ.CLKB XD5.nm 1.21e-17
* device instance cc_XD5_XDFFQ_CLKB_XD5_nt r0 *1 0,0
Ccc_XD5_XDFFQ_CLKB_XD5_nt XD5.XDFFQ.CLKB XD5.nt 2.4201e-17
* device instance cc_XD5_XDFFQ_CLKB_XD5_t1 r0 *1 0,0
Ccc_XD5_XDFFQ_CLKB_XD5_t1 XD5.XDFFQ.CLKB XD5.t1 1.21e-17
* device instance cc_XD5_XDFFQ_CLKB_XFRT_CLKB r0 *1 0,0
Ccc_XD5_XDFFQ_CLKB_XFRT_CLKB XD5.XDFFQ.CLKB XFRT.CLKB 1.8151e-17
* device instance cc_XD5_XDFFQ_CLKB_XFRT_M r0 *1 0,0
Ccc_XD5_XDFFQ_CLKB_XFRT_M XD5.XDFFQ.CLKB XFRT.M 2.4201e-17
* device instance cc_XD5_XDFFQ_CLKB_XFRT_MB r0 *1 0,0
Ccc_XD5_XDFFQ_CLKB_XFRT_MB XD5.XDFFQ.CLKB XFRT.MB 1.21e-17
* device instance cc_XD5_XDFFQ_CLKB_XFRT_S r0 *1 0,0
Ccc_XD5_XDFFQ_CLKB_XFRT_S XD5.XDFFQ.CLKB XFRT.S 1.8151e-17
* device instance cc_XD5_XDFFQ_CLKB_XFRT_SB r0 *1 0,0
Ccc_XD5_XDFFQ_CLKB_XFRT_SB XD5.XDFFQ.CLKB XFRT.SB 1.8151e-17
* device instance cc_XD5_XDFFQ_CLKB_ck1 r0 *1 0,0
Ccc_XD5_XDFFQ_CLKB_ck1 XD5.XDFFQ.CLKB ck1 5.4452e-17
* device instance cc_XD5_XDFFQ_CLKB_ck2 r0 *1 0,0
Ccc_XD5_XDFFQ_CLKB_ck2 XD5.XDFFQ.CLKB ck2 5.4452e-17
* device instance cc_XD5_XDFFQ_CLKB_ck3 r0 *1 0,0
Ccc_XD5_XDFFQ_CLKB_ck3 XD5.XDFFQ.CLKB ck3 5.4452e-17
* device instance cc_XD5_XDFFQ_CLKB_ck4 r0 *1 0,0
Ccc_XD5_XDFFQ_CLKB_ck4 XD5.XDFFQ.CLKB ck4 5.4452e-17
* device instance cc_XD5_XDFFQ_CLKB_ck5 r0 *1 0,0
Ccc_XD5_XDFFQ_CLKB_ck5 XD5.XDFFQ.CLKB ck5 6.0502e-17
* device instance cc_XD5_XDFFQ_CLKB_mod0 r0 *1 0,0
Ccc_XD5_XDFFQ_CLKB_mod0 XD5.XDFFQ.CLKB mod0 2.4201e-17
* device instance cc_XD5_XDFFQ_CLKB_mod1 r0 *1 0,0
Ccc_XD5_XDFFQ_CLKB_mod1 XD5.XDFFQ.CLKB mod1 2.4201e-17
* device instance cc_XD5_XDFFQ_CLKB_mod2 r0 *1 0,0
Ccc_XD5_XDFFQ_CLKB_mod2 XD5.XDFFQ.CLKB mod2 2.4201e-17
* device instance cc_XD5_XDFFQ_CLKB_mod3 r0 *1 0,0
Ccc_XD5_XDFFQ_CLKB_mod3 XD5.XDFFQ.CLKB mod3 2.4201e-17
* device instance cc_XD5_XDFFQ_CLKB_mod4 r0 *1 0,0
Ccc_XD5_XDFFQ_CLKB_mod4 XD5.XDFFQ.CLKB mod4 2.4201e-17
* device instance cc_XD5_XDFFQ_CLKB_net1 r0 *1 0,0
Ccc_XD5_XDFFQ_CLKB_net1 XD5.XDFFQ.CLKB net1 1.21e-17
* device instance cc_XD5_XDFFQ_M_XD5_XDFFQ_MB r0 *1 0,0
Ccc_XD5_XDFFQ_M_XD5_XDFFQ_MB XD5.XDFFQ.M XD5.XDFFQ.MB 3.4688e-17
* device instance cc_XD5_XDFFQ_M_XD5_XDFFQ_S r0 *1 0,0
Ccc_XD5_XDFFQ_M_XD5_XDFFQ_S XD5.XDFFQ.M XD5.XDFFQ.S 2.8638e-17
* device instance cc_XD5_XDFFQ_M_XD5_XDFFQ_SB r0 *1 0,0
Ccc_XD5_XDFFQ_M_XD5_XDFFQ_SB XD5.XDFFQ.M XD5.XDFFQ.SB 1.8151e-17
* device instance cc_XD5_XDFFQ_M_XD5_XN2_mid1 r0 *1 0,0
Ccc_XD5_XDFFQ_M_XD5_XN2_mid1 XD5.XDFFQ.M XD5.XN2.mid1 1.21e-17
* device instance cc_XD5_XDFFQ_M_XD5_XNOR_midp r0 *1 0,0
Ccc_XD5_XDFFQ_M_XD5_XNOR_midp XD5.XDFFQ.M XD5.XNOR.midp 1.21e-17
* device instance cc_XD5_XDFFQ_M_XD5_dmodout r0 *1 0,0
Ccc_XD5_XDFFQ_M_XD5_dmodout XD5.XDFFQ.M XD5.dmodout 1.21e-17
* device instance cc_XD5_XDFFQ_M_XD5_dq r0 *1 0,0
Ccc_XD5_XDFFQ_M_XD5_dq XD5.XDFFQ.M XD5.dq 2.8638e-17
* device instance cc_XD5_XDFFQ_M_XD5_nm r0 *1 0,0
Ccc_XD5_XDFFQ_M_XD5_nm XD5.XDFFQ.M XD5.nm 1.21e-17
* device instance cc_XD5_XDFFQ_M_XD5_nt r0 *1 0,0
Ccc_XD5_XDFFQ_M_XD5_nt XD5.XDFFQ.M XD5.nt 2.4201e-17
* device instance cc_XD5_XDFFQ_M_XD5_t1 r0 *1 0,0
Ccc_XD5_XDFFQ_M_XD5_t1 XD5.XDFFQ.M XD5.t1 1.21e-17
* device instance cc_XD5_XDFFQ_M_XFRT_CLKB r0 *1 0,0
Ccc_XD5_XDFFQ_M_XFRT_CLKB XD5.XDFFQ.M XFRT.CLKB 1.8151e-17
* device instance cc_XD5_XDFFQ_M_XFRT_M r0 *1 0,0
Ccc_XD5_XDFFQ_M_XFRT_M XD5.XDFFQ.M XFRT.M 2.4201e-17
* device instance cc_XD5_XDFFQ_M_XFRT_MB r0 *1 0,0
Ccc_XD5_XDFFQ_M_XFRT_MB XD5.XDFFQ.M XFRT.MB 1.21e-17
* device instance cc_XD5_XDFFQ_M_XFRT_S r0 *1 0,0
Ccc_XD5_XDFFQ_M_XFRT_S XD5.XDFFQ.M XFRT.S 1.8151e-17
* device instance cc_XD5_XDFFQ_M_XFRT_SB r0 *1 0,0
Ccc_XD5_XDFFQ_M_XFRT_SB XD5.XDFFQ.M XFRT.SB 1.8151e-17
* device instance cc_XD5_XDFFQ_M_ck1 r0 *1 0,0
Ccc_XD5_XDFFQ_M_ck1 XD5.XDFFQ.M ck1 5.4452e-17
* device instance cc_XD5_XDFFQ_M_ck2 r0 *1 0,0
Ccc_XD5_XDFFQ_M_ck2 XD5.XDFFQ.M ck2 5.4452e-17
* device instance cc_XD5_XDFFQ_M_ck3 r0 *1 0,0
Ccc_XD5_XDFFQ_M_ck3 XD5.XDFFQ.M ck3 5.4452e-17
* device instance cc_XD5_XDFFQ_M_ck4 r0 *1 0,0
Ccc_XD5_XDFFQ_M_ck4 XD5.XDFFQ.M ck4 5.4452e-17
* device instance cc_XD5_XDFFQ_M_ck5 r0 *1 0,0
Ccc_XD5_XDFFQ_M_ck5 XD5.XDFFQ.M ck5 6.0502e-17
* device instance cc_XD5_XDFFQ_M_mod0 r0 *1 0,0
Ccc_XD5_XDFFQ_M_mod0 XD5.XDFFQ.M mod0 2.4201e-17
* device instance cc_XD5_XDFFQ_M_mod1 r0 *1 0,0
Ccc_XD5_XDFFQ_M_mod1 XD5.XDFFQ.M mod1 2.4201e-17
* device instance cc_XD5_XDFFQ_M_mod2 r0 *1 0,0
Ccc_XD5_XDFFQ_M_mod2 XD5.XDFFQ.M mod2 2.4201e-17
* device instance cc_XD5_XDFFQ_M_mod3 r0 *1 0,0
Ccc_XD5_XDFFQ_M_mod3 XD5.XDFFQ.M mod3 2.4201e-17
* device instance cc_XD5_XDFFQ_M_mod4 r0 *1 0,0
Ccc_XD5_XDFFQ_M_mod4 XD5.XDFFQ.M mod4 2.4201e-17
* device instance cc_XD5_XDFFQ_M_net1 r0 *1 0,0
Ccc_XD5_XDFFQ_M_net1 XD5.XDFFQ.M net1 1.21e-17
* device instance cc_XD5_XDFFQ_MB_XD5_XDFFQ_S r0 *1 0,0
Ccc_XD5_XDFFQ_MB_XD5_XDFFQ_S XD5.XDFFQ.MB XD5.XDFFQ.S 1.8151e-17
* device instance cc_XD5_XDFFQ_MB_XD5_XDFFQ_SB r0 *1 0,0
Ccc_XD5_XDFFQ_MB_XD5_XDFFQ_SB XD5.XDFFQ.MB XD5.XDFFQ.SB 1.8151e-17
* device instance cc_XD5_XDFFQ_MB_XD5_XN2_mid1 r0 *1 0,0
Ccc_XD5_XDFFQ_MB_XD5_XN2_mid1 XD5.XDFFQ.MB XD5.XN2.mid1 1.21e-17
* device instance cc_XD5_XDFFQ_MB_XD5_XNOR_midp r0 *1 0,0
Ccc_XD5_XDFFQ_MB_XD5_XNOR_midp XD5.XDFFQ.MB XD5.XNOR.midp 1.21e-17
* device instance cc_XD5_XDFFQ_MB_XD5_dmodout r0 *1 0,0
Ccc_XD5_XDFFQ_MB_XD5_dmodout XD5.XDFFQ.MB XD5.dmodout 1.21e-17
* device instance cc_XD5_XDFFQ_MB_XD5_dq r0 *1 0,0
Ccc_XD5_XDFFQ_MB_XD5_dq XD5.XDFFQ.MB XD5.dq 1.21e-17
* device instance cc_XD5_XDFFQ_MB_XD5_nm r0 *1 0,0
Ccc_XD5_XDFFQ_MB_XD5_nm XD5.XDFFQ.MB XD5.nm 1.21e-17
* device instance cc_XD5_XDFFQ_MB_XD5_nt r0 *1 0,0
Ccc_XD5_XDFFQ_MB_XD5_nt XD5.XDFFQ.MB XD5.nt 2.4201e-17
* device instance cc_XD5_XDFFQ_MB_XD5_t1 r0 *1 0,0
Ccc_XD5_XDFFQ_MB_XD5_t1 XD5.XDFFQ.MB XD5.t1 1.21e-17
* device instance cc_XD5_XDFFQ_MB_XFRT_CLKB r0 *1 0,0
Ccc_XD5_XDFFQ_MB_XFRT_CLKB XD5.XDFFQ.MB XFRT.CLKB 1.8151e-17
* device instance cc_XD5_XDFFQ_MB_XFRT_M r0 *1 0,0
Ccc_XD5_XDFFQ_MB_XFRT_M XD5.XDFFQ.MB XFRT.M 2.4201e-17
* device instance cc_XD5_XDFFQ_MB_XFRT_MB r0 *1 0,0
Ccc_XD5_XDFFQ_MB_XFRT_MB XD5.XDFFQ.MB XFRT.MB 1.21e-17
* device instance cc_XD5_XDFFQ_MB_XFRT_S r0 *1 0,0
Ccc_XD5_XDFFQ_MB_XFRT_S XD5.XDFFQ.MB XFRT.S 1.8151e-17
* device instance cc_XD5_XDFFQ_MB_XFRT_SB r0 *1 0,0
Ccc_XD5_XDFFQ_MB_XFRT_SB XD5.XDFFQ.MB XFRT.SB 1.8151e-17
* device instance cc_XD5_XDFFQ_MB_ck1 r0 *1 0,0
Ccc_XD5_XDFFQ_MB_ck1 XD5.XDFFQ.MB ck1 5.4452e-17
* device instance cc_XD5_XDFFQ_MB_ck2 r0 *1 0,0
Ccc_XD5_XDFFQ_MB_ck2 XD5.XDFFQ.MB ck2 5.4452e-17
* device instance cc_XD5_XDFFQ_MB_ck3 r0 *1 0,0
Ccc_XD5_XDFFQ_MB_ck3 XD5.XDFFQ.MB ck3 5.4452e-17
* device instance cc_XD5_XDFFQ_MB_ck4 r0 *1 0,0
Ccc_XD5_XDFFQ_MB_ck4 XD5.XDFFQ.MB ck4 5.4452e-17
* device instance cc_XD5_XDFFQ_MB_ck5 r0 *1 0,0
Ccc_XD5_XDFFQ_MB_ck5 XD5.XDFFQ.MB ck5 6.0502e-17
* device instance cc_XD5_XDFFQ_MB_mod0 r0 *1 0,0
Ccc_XD5_XDFFQ_MB_mod0 XD5.XDFFQ.MB mod0 2.4201e-17
* device instance cc_XD5_XDFFQ_MB_mod1 r0 *1 0,0
Ccc_XD5_XDFFQ_MB_mod1 XD5.XDFFQ.MB mod1 2.4201e-17
* device instance cc_XD5_XDFFQ_MB_mod2 r0 *1 0,0
Ccc_XD5_XDFFQ_MB_mod2 XD5.XDFFQ.MB mod2 2.4201e-17
* device instance cc_XD5_XDFFQ_MB_mod3 r0 *1 0,0
Ccc_XD5_XDFFQ_MB_mod3 XD5.XDFFQ.MB mod3 2.4201e-17
* device instance cc_XD5_XDFFQ_MB_mod4 r0 *1 0,0
Ccc_XD5_XDFFQ_MB_mod4 XD5.XDFFQ.MB mod4 2.4201e-17
* device instance cc_XD5_XDFFQ_MB_net1 r0 *1 0,0
Ccc_XD5_XDFFQ_MB_net1 XD5.XDFFQ.MB net1 1.21e-17
* device instance cc_XD5_XDFFQ_S_XD5_XDFFQ_SB r0 *1 0,0
Ccc_XD5_XDFFQ_S_XD5_XDFFQ_SB XD5.XDFFQ.S XD5.XDFFQ.SB 4.0738e-17
* device instance cc_XD5_XDFFQ_S_XD5_XN2_mid1 r0 *1 0,0
Ccc_XD5_XDFFQ_S_XD5_XN2_mid1 XD5.XDFFQ.S XD5.XN2.mid1 1.21e-17
* device instance cc_XD5_XDFFQ_S_XD5_XNOR_midp r0 *1 0,0
Ccc_XD5_XDFFQ_S_XD5_XNOR_midp XD5.XDFFQ.S XD5.XNOR.midp 1.21e-17
* device instance cc_XD5_XDFFQ_S_XD5_dmodout r0 *1 0,0
Ccc_XD5_XDFFQ_S_XD5_dmodout XD5.XDFFQ.S XD5.dmodout 1.21e-17
* device instance cc_XD5_XDFFQ_S_XD5_dq r0 *1 0,0
Ccc_XD5_XDFFQ_S_XD5_dq XD5.XDFFQ.S XD5.dq 1.21e-17
* device instance cc_XD5_XDFFQ_S_XD5_nm r0 *1 0,0
Ccc_XD5_XDFFQ_S_XD5_nm XD5.XDFFQ.S XD5.nm 1.21e-17
* device instance cc_XD5_XDFFQ_S_XD5_nt r0 *1 0,0
Ccc_XD5_XDFFQ_S_XD5_nt XD5.XDFFQ.S XD5.nt 2.4201e-17
* device instance cc_XD5_XDFFQ_S_XD5_t1 r0 *1 0,0
Ccc_XD5_XDFFQ_S_XD5_t1 XD5.XDFFQ.S XD5.t1 1.21e-17
* device instance cc_XD5_XDFFQ_S_XFRT_CLKB r0 *1 0,0
Ccc_XD5_XDFFQ_S_XFRT_CLKB XD5.XDFFQ.S XFRT.CLKB 1.8151e-17
* device instance cc_XD5_XDFFQ_S_XFRT_M r0 *1 0,0
Ccc_XD5_XDFFQ_S_XFRT_M XD5.XDFFQ.S XFRT.M 2.4201e-17
* device instance cc_XD5_XDFFQ_S_XFRT_MB r0 *1 0,0
Ccc_XD5_XDFFQ_S_XFRT_MB XD5.XDFFQ.S XFRT.MB 1.21e-17
* device instance cc_XD5_XDFFQ_S_XFRT_S r0 *1 0,0
Ccc_XD5_XDFFQ_S_XFRT_S XD5.XDFFQ.S XFRT.S 1.8151e-17
* device instance cc_XD5_XDFFQ_S_XFRT_SB r0 *1 0,0
Ccc_XD5_XDFFQ_S_XFRT_SB XD5.XDFFQ.S XFRT.SB 1.8151e-17
* device instance cc_XD5_XDFFQ_S_ck1 r0 *1 0,0
Ccc_XD5_XDFFQ_S_ck1 XD5.XDFFQ.S ck1 5.4452e-17
* device instance cc_XD5_XDFFQ_S_ck2 r0 *1 0,0
Ccc_XD5_XDFFQ_S_ck2 XD5.XDFFQ.S ck2 5.4452e-17
* device instance cc_XD5_XDFFQ_S_ck3 r0 *1 0,0
Ccc_XD5_XDFFQ_S_ck3 XD5.XDFFQ.S ck3 5.4452e-17
* device instance cc_XD5_XDFFQ_S_ck4 r0 *1 0,0
Ccc_XD5_XDFFQ_S_ck4 XD5.XDFFQ.S ck4 5.4452e-17
* device instance cc_XD5_XDFFQ_S_ck5 r0 *1 0,0
Ccc_XD5_XDFFQ_S_ck5 XD5.XDFFQ.S ck5 5.4452e-17
* device instance cc_XD5_XDFFQ_S_mod0 r0 *1 0,0
Ccc_XD5_XDFFQ_S_mod0 XD5.XDFFQ.S mod0 2.4201e-17
* device instance cc_XD5_XDFFQ_S_mod1 r0 *1 0,0
Ccc_XD5_XDFFQ_S_mod1 XD5.XDFFQ.S mod1 2.4201e-17
* device instance cc_XD5_XDFFQ_S_mod2 r0 *1 0,0
Ccc_XD5_XDFFQ_S_mod2 XD5.XDFFQ.S mod2 2.4201e-17
* device instance cc_XD5_XDFFQ_S_mod3 r0 *1 0,0
Ccc_XD5_XDFFQ_S_mod3 XD5.XDFFQ.S mod3 2.4201e-17
* device instance cc_XD5_XDFFQ_S_mod4 r0 *1 0,0
Ccc_XD5_XDFFQ_S_mod4 XD5.XDFFQ.S mod4 2.4201e-17
* device instance cc_XD5_XDFFQ_S_net1 r0 *1 0,0
Ccc_XD5_XDFFQ_S_net1 XD5.XDFFQ.S net1 1.21e-17
* device instance cc_XD5_XDFFQ_SB_XD5_XN2_mid1 r0 *1 0,0
Ccc_XD5_XDFFQ_SB_XD5_XN2_mid1 XD5.XDFFQ.SB XD5.XN2.mid1 1.21e-17
* device instance cc_XD5_XDFFQ_SB_XD5_XNOR_midp r0 *1 0,0
Ccc_XD5_XDFFQ_SB_XD5_XNOR_midp XD5.XDFFQ.SB XD5.XNOR.midp 1.21e-17
* device instance cc_XD5_XDFFQ_SB_XD5_dmodout r0 *1 0,0
Ccc_XD5_XDFFQ_SB_XD5_dmodout XD5.XDFFQ.SB XD5.dmodout 1.21e-17
* device instance cc_XD5_XDFFQ_SB_XD5_dq r0 *1 0,0
Ccc_XD5_XDFFQ_SB_XD5_dq XD5.XDFFQ.SB XD5.dq 1.21e-17
* device instance cc_XD5_XDFFQ_SB_XD5_nm r0 *1 0,0
Ccc_XD5_XDFFQ_SB_XD5_nm XD5.XDFFQ.SB XD5.nm 1.21e-17
* device instance cc_XD5_XDFFQ_SB_XD5_nt r0 *1 0,0
Ccc_XD5_XDFFQ_SB_XD5_nt XD5.XDFFQ.SB XD5.nt 2.4201e-17
* device instance cc_XD5_XDFFQ_SB_XD5_t1 r0 *1 0,0
Ccc_XD5_XDFFQ_SB_XD5_t1 XD5.XDFFQ.SB XD5.t1 1.21e-17
* device instance cc_XD5_XDFFQ_SB_XFRT_CLKB r0 *1 0,0
Ccc_XD5_XDFFQ_SB_XFRT_CLKB XD5.XDFFQ.SB XFRT.CLKB 1.8151e-17
* device instance cc_XD5_XDFFQ_SB_XFRT_M r0 *1 0,0
Ccc_XD5_XDFFQ_SB_XFRT_M XD5.XDFFQ.SB XFRT.M 2.4201e-17
* device instance cc_XD5_XDFFQ_SB_XFRT_MB r0 *1 0,0
Ccc_XD5_XDFFQ_SB_XFRT_MB XD5.XDFFQ.SB XFRT.MB 1.21e-17
* device instance cc_XD5_XDFFQ_SB_XFRT_S r0 *1 0,0
Ccc_XD5_XDFFQ_SB_XFRT_S XD5.XDFFQ.SB XFRT.S 1.8151e-17
* device instance cc_XD5_XDFFQ_SB_XFRT_SB r0 *1 0,0
Ccc_XD5_XDFFQ_SB_XFRT_SB XD5.XDFFQ.SB XFRT.SB 1.8151e-17
* device instance cc_XD5_XDFFQ_SB_ck1 r0 *1 0,0
Ccc_XD5_XDFFQ_SB_ck1 XD5.XDFFQ.SB ck1 5.4452e-17
* device instance cc_XD5_XDFFQ_SB_ck2 r0 *1 0,0
Ccc_XD5_XDFFQ_SB_ck2 XD5.XDFFQ.SB ck2 5.4452e-17
* device instance cc_XD5_XDFFQ_SB_ck3 r0 *1 0,0
Ccc_XD5_XDFFQ_SB_ck3 XD5.XDFFQ.SB ck3 5.4452e-17
* device instance cc_XD5_XDFFQ_SB_ck4 r0 *1 0,0
Ccc_XD5_XDFFQ_SB_ck4 XD5.XDFFQ.SB ck4 5.4452e-17
* device instance cc_XD5_XDFFQ_SB_ck5 r0 *1 0,0
Ccc_XD5_XDFFQ_SB_ck5 XD5.XDFFQ.SB ck5 5.4452e-17
* device instance cc_XD5_XDFFQ_SB_mod0 r0 *1 0,0
Ccc_XD5_XDFFQ_SB_mod0 XD5.XDFFQ.SB mod0 2.4201e-17
* device instance cc_XD5_XDFFQ_SB_mod1 r0 *1 0,0
Ccc_XD5_XDFFQ_SB_mod1 XD5.XDFFQ.SB mod1 2.4201e-17
* device instance cc_XD5_XDFFQ_SB_mod2 r0 *1 0,0
Ccc_XD5_XDFFQ_SB_mod2 XD5.XDFFQ.SB mod2 2.4201e-17
* device instance cc_XD5_XDFFQ_SB_mod3 r0 *1 0,0
Ccc_XD5_XDFFQ_SB_mod3 XD5.XDFFQ.SB mod3 2.4201e-17
* device instance cc_XD5_XDFFQ_SB_mod4 r0 *1 0,0
Ccc_XD5_XDFFQ_SB_mod4 XD5.XDFFQ.SB mod4 2.4201e-17
* device instance cc_XD5_XDFFQ_SB_net1 r0 *1 0,0
Ccc_XD5_XDFFQ_SB_net1 XD5.XDFFQ.SB net1 1.21e-17
* device instance cc_XD5_XN2_mid1_XD5_nm r0 *1 0,0
Ccc_XD5_XN2_mid1_XD5_nm XD5.XN2.mid1 XD5.nm 1.1294e-17
* device instance cc_XD5_XN3_mid1_XD5_XN3_mid2 r0 *1 0,0
Ccc_XD5_XN3_mid1_XD5_XN3_mid2 XD5.XN3.mid1 XD5.XN3.mid2 1.1294e-17
* device instance cc_XD5_XN3_mid1_XD5_nt r0 *1 0,0
Ccc_XD5_XN3_mid1_XD5_nt XD5.XN3.mid1 XD5.nt 1.1294e-17
* device instance cc_XD5_XN3_mid2_mod4 r0 *1 0,0
Ccc_XD5_XN3_mid2_mod4 XD5.XN3.mid2 mod4 6.05e-18
* device instance cc_XD5_XNOR_midp_XD5_dq r0 *1 0,0
Ccc_XD5_XNOR_midp_XD5_dq XD5.XNOR.midp XD5.dq 5.244e-18
* device instance cc_XD5_XNOR_midp_XD5_t1 r0 *1 0,0
Ccc_XD5_XNOR_midp_XD5_t1 XD5.XNOR.midp XD5.t1 6.05e-18
* device instance cc_XD5_dmodout_XD5_dq r0 *1 0,0
Ccc_XD5_dmodout_XD5_dq XD5.dmodout XD5.dq 1.21e-17
* device instance cc_XD5_dmodout_XD5_nm r0 *1 0,0
Ccc_XD5_dmodout_XD5_nm XD5.dmodout XD5.nm 1.8151e-17
* device instance cc_XD5_dmodout_XD5_nt r0 *1 0,0
Ccc_XD5_dmodout_XD5_nt XD5.dmodout XD5.nt 2.4201e-17
* device instance cc_XD5_dmodout_XD5_t1 r0 *1 0,0
Ccc_XD5_dmodout_XD5_t1 XD5.dmodout XD5.t1 1.21e-17
* device instance cc_XD5_dmodout_XFRT_CLKB r0 *1 0,0
Ccc_XD5_dmodout_XFRT_CLKB XD5.dmodout XFRT.CLKB 1.8151e-17
* device instance cc_XD5_dmodout_XFRT_M r0 *1 0,0
Ccc_XD5_dmodout_XFRT_M XD5.dmodout XFRT.M 2.4201e-17
* device instance cc_XD5_dmodout_XFRT_MB r0 *1 0,0
Ccc_XD5_dmodout_XFRT_MB XD5.dmodout XFRT.MB 1.21e-17
* device instance cc_XD5_dmodout_XFRT_S r0 *1 0,0
Ccc_XD5_dmodout_XFRT_S XD5.dmodout XFRT.S 1.8151e-17
* device instance cc_XD5_dmodout_XFRT_SB r0 *1 0,0
Ccc_XD5_dmodout_XFRT_SB XD5.dmodout XFRT.SB 1.8151e-17
* device instance cc_XD5_dmodout_ck1 r0 *1 0,0
Ccc_XD5_dmodout_ck1 XD5.dmodout ck1 5.4452e-17
* device instance cc_XD5_dmodout_ck2 r0 *1 0,0
Ccc_XD5_dmodout_ck2 XD5.dmodout ck2 5.4452e-17
* device instance cc_XD5_dmodout_ck3 r0 *1 0,0
Ccc_XD5_dmodout_ck3 XD5.dmodout ck3 5.4452e-17
* device instance cc_XD5_dmodout_ck4 r0 *1 0,0
Ccc_XD5_dmodout_ck4 XD5.dmodout ck4 5.4452e-17
* device instance cc_XD5_dmodout_ck5 r0 *1 0,0
Ccc_XD5_dmodout_ck5 XD5.dmodout ck5 6.6553e-17
* device instance cc_XD5_dmodout_mod0 r0 *1 0,0
Ccc_XD5_dmodout_mod0 XD5.dmodout mod0 2.4201e-17
* device instance cc_XD5_dmodout_mod1 r0 *1 0,0
Ccc_XD5_dmodout_mod1 XD5.dmodout mod1 2.4201e-17
* device instance cc_XD5_dmodout_mod2 r0 *1 0,0
Ccc_XD5_dmodout_mod2 XD5.dmodout mod2 2.4201e-17
* device instance cc_XD5_dmodout_mod3 r0 *1 0,0
Ccc_XD5_dmodout_mod3 XD5.dmodout mod3 2.4201e-17
* device instance cc_XD5_dmodout_mod4 r0 *1 0,0
Ccc_XD5_dmodout_mod4 XD5.dmodout mod4 2.4201e-17
* device instance cc_XD5_dmodout_net1 r0 *1 0,0
Ccc_XD5_dmodout_net1 XD5.dmodout net1 1.21e-17
* device instance cc_XD5_dq_XD5_nm r0 *1 0,0
Ccc_XD5_dq_XD5_nm XD5.dq XD5.nm 1.21e-17
* device instance cc_XD5_dq_XD5_nt r0 *1 0,0
Ccc_XD5_dq_XD5_nt XD5.dq XD5.nt 2.4201e-17
* device instance cc_XD5_dq_XD5_t1 r0 *1 0,0
Ccc_XD5_dq_XD5_t1 XD5.dq XD5.t1 1.8151e-17
* device instance cc_XD5_dq_XFRT_CLKB r0 *1 0,0
Ccc_XD5_dq_XFRT_CLKB XD5.dq XFRT.CLKB 1.8151e-17
* device instance cc_XD5_dq_XFRT_M r0 *1 0,0
Ccc_XD5_dq_XFRT_M XD5.dq XFRT.M 2.4201e-17
* device instance cc_XD5_dq_XFRT_MB r0 *1 0,0
Ccc_XD5_dq_XFRT_MB XD5.dq XFRT.MB 1.21e-17
* device instance cc_XD5_dq_XFRT_S r0 *1 0,0
Ccc_XD5_dq_XFRT_S XD5.dq XFRT.S 1.8151e-17
* device instance cc_XD5_dq_XFRT_SB r0 *1 0,0
Ccc_XD5_dq_XFRT_SB XD5.dq XFRT.SB 1.8151e-17
* device instance cc_XD5_dq_ck1 r0 *1 0,0
Ccc_XD5_dq_ck1 XD5.dq ck1 5.4452e-17
* device instance cc_XD5_dq_ck2 r0 *1 0,0
Ccc_XD5_dq_ck2 XD5.dq ck2 5.4452e-17
* device instance cc_XD5_dq_ck3 r0 *1 0,0
Ccc_XD5_dq_ck3 XD5.dq ck3 5.4452e-17
* device instance cc_XD5_dq_ck4 r0 *1 0,0
Ccc_XD5_dq_ck4 XD5.dq ck4 5.4452e-17
* device instance cc_XD5_dq_ck5 r0 *1 0,0
Ccc_XD5_dq_ck5 XD5.dq ck5 6.6553e-17
* device instance cc_XD5_dq_mod0 r0 *1 0,0
Ccc_XD5_dq_mod0 XD5.dq mod0 2.4201e-17
* device instance cc_XD5_dq_mod1 r0 *1 0,0
Ccc_XD5_dq_mod1 XD5.dq mod1 2.4201e-17
* device instance cc_XD5_dq_mod2 r0 *1 0,0
Ccc_XD5_dq_mod2 XD5.dq mod2 2.4201e-17
* device instance cc_XD5_dq_mod3 r0 *1 0,0
Ccc_XD5_dq_mod3 XD5.dq mod3 2.4201e-17
* device instance cc_XD5_dq_mod4 r0 *1 0,0
Ccc_XD5_dq_mod4 XD5.dq mod4 2.4201e-17
* device instance cc_XD5_dq_net1 r0 *1 0,0
Ccc_XD5_dq_net1 XD5.dq net1 1.21e-17
* device instance cc_XD5_nm_XD5_nt r0 *1 0,0
Ccc_XD5_nm_XD5_nt XD5.nm XD5.nt 2.4201e-17
* device instance cc_XD5_nm_XD5_t1 r0 *1 0,0
Ccc_XD5_nm_XD5_t1 XD5.nm XD5.t1 1.21e-17
* device instance cc_XD5_nm_XFRT_CLKB r0 *1 0,0
Ccc_XD5_nm_XFRT_CLKB XD5.nm XFRT.CLKB 1.8151e-17
* device instance cc_XD5_nm_XFRT_M r0 *1 0,0
Ccc_XD5_nm_XFRT_M XD5.nm XFRT.M 2.4201e-17
* device instance cc_XD5_nm_XFRT_MB r0 *1 0,0
Ccc_XD5_nm_XFRT_MB XD5.nm XFRT.MB 1.21e-17
* device instance cc_XD5_nm_XFRT_S r0 *1 0,0
Ccc_XD5_nm_XFRT_S XD5.nm XFRT.S 1.8151e-17
* device instance cc_XD5_nm_XFRT_SB r0 *1 0,0
Ccc_XD5_nm_XFRT_SB XD5.nm XFRT.SB 1.8151e-17
* device instance cc_XD5_nm_ck1 r0 *1 0,0
Ccc_XD5_nm_ck1 XD5.nm ck1 5.4452e-17
* device instance cc_XD5_nm_ck2 r0 *1 0,0
Ccc_XD5_nm_ck2 XD5.nm ck2 5.4452e-17
* device instance cc_XD5_nm_ck3 r0 *1 0,0
Ccc_XD5_nm_ck3 XD5.nm ck3 5.4452e-17
* device instance cc_XD5_nm_ck4 r0 *1 0,0
Ccc_XD5_nm_ck4 XD5.nm ck4 5.4452e-17
* device instance cc_XD5_nm_ck5 r0 *1 0,0
Ccc_XD5_nm_ck5 XD5.nm ck5 5.4452e-17
* device instance cc_XD5_nm_mod0 r0 *1 0,0
Ccc_XD5_nm_mod0 XD5.nm mod0 2.4201e-17
* device instance cc_XD5_nm_mod1 r0 *1 0,0
Ccc_XD5_nm_mod1 XD5.nm mod1 2.4201e-17
* device instance cc_XD5_nm_mod2 r0 *1 0,0
Ccc_XD5_nm_mod2 XD5.nm mod2 2.4201e-17
* device instance cc_XD5_nm_mod3 r0 *1 0,0
Ccc_XD5_nm_mod3 XD5.nm mod3 2.4201e-17
* device instance cc_XD5_nm_mod4 r0 *1 0,0
Ccc_XD5_nm_mod4 XD5.nm mod4 2.4201e-17
* device instance cc_XD5_nm_net1 r0 *1 0,0
Ccc_XD5_nm_net1 XD5.nm net1 1.21e-17
* device instance cc_XD5_nt_XD5_t1 r0 *1 0,0
Ccc_XD5_nt_XD5_t1 XD5.nt XD5.t1 1.21e-17
* device instance cc_XD5_nt_XFRT_CLKB r0 *1 0,0
Ccc_XD5_nt_XFRT_CLKB XD5.nt XFRT.CLKB 1.8151e-17
* device instance cc_XD5_nt_XFRT_M r0 *1 0,0
Ccc_XD5_nt_XFRT_M XD5.nt XFRT.M 2.4201e-17
* device instance cc_XD5_nt_XFRT_MB r0 *1 0,0
Ccc_XD5_nt_XFRT_MB XD5.nt XFRT.MB 1.21e-17
* device instance cc_XD5_nt_XFRT_S r0 *1 0,0
Ccc_XD5_nt_XFRT_S XD5.nt XFRT.S 1.8151e-17
* device instance cc_XD5_nt_XFRT_SB r0 *1 0,0
Ccc_XD5_nt_XFRT_SB XD5.nt XFRT.SB 1.8151e-17
* device instance cc_XD5_nt_ck1 r0 *1 0,0
Ccc_XD5_nt_ck1 XD5.nt ck1 5.4452e-17
* device instance cc_XD5_nt_ck2 r0 *1 0,0
Ccc_XD5_nt_ck2 XD5.nt ck2 5.4452e-17
* device instance cc_XD5_nt_ck3 r0 *1 0,0
Ccc_XD5_nt_ck3 XD5.nt ck3 5.4452e-17
* device instance cc_XD5_nt_ck4 r0 *1 0,0
Ccc_XD5_nt_ck4 XD5.nt ck4 5.4452e-17
* device instance cc_XD5_nt_ck5 r0 *1 0,0
Ccc_XD5_nt_ck5 XD5.nt ck5 5.4452e-17
* device instance cc_XD5_nt_mod0 r0 *1 0,0
Ccc_XD5_nt_mod0 XD5.nt mod0 2.4201e-17
* device instance cc_XD5_nt_mod1 r0 *1 0,0
Ccc_XD5_nt_mod1 XD5.nt mod1 2.4201e-17
* device instance cc_XD5_nt_mod2 r0 *1 0,0
Ccc_XD5_nt_mod2 XD5.nt mod2 2.4201e-17
* device instance cc_XD5_nt_mod3 r0 *1 0,0
Ccc_XD5_nt_mod3 XD5.nt mod3 2.4201e-17
* device instance cc_XD5_nt_mod4 r0 *1 0,0
Ccc_XD5_nt_mod4 XD5.nt mod4 3.0251e-17
* device instance cc_XD5_nt_net1 r0 *1 0,0
Ccc_XD5_nt_net1 XD5.nt net1 1.21e-17
* device instance cc_XD5_t1_XFRT_CLKB r0 *1 0,0
Ccc_XD5_t1_XFRT_CLKB XD5.t1 XFRT.CLKB 1.8151e-17
* device instance cc_XD5_t1_XFRT_M r0 *1 0,0
Ccc_XD5_t1_XFRT_M XD5.t1 XFRT.M 2.4201e-17
* device instance cc_XD5_t1_XFRT_MB r0 *1 0,0
Ccc_XD5_t1_XFRT_MB XD5.t1 XFRT.MB 1.21e-17
* device instance cc_XD5_t1_XFRT_S r0 *1 0,0
Ccc_XD5_t1_XFRT_S XD5.t1 XFRT.S 1.8151e-17
* device instance cc_XD5_t1_XFRT_SB r0 *1 0,0
Ccc_XD5_t1_XFRT_SB XD5.t1 XFRT.SB 1.8151e-17
* device instance cc_XD5_t1_ck1 r0 *1 0,0
Ccc_XD5_t1_ck1 XD5.t1 ck1 5.4452e-17
* device instance cc_XD5_t1_ck2 r0 *1 0,0
Ccc_XD5_t1_ck2 XD5.t1 ck2 5.4452e-17
* device instance cc_XD5_t1_ck3 r0 *1 0,0
Ccc_XD5_t1_ck3 XD5.t1 ck3 5.4452e-17
* device instance cc_XD5_t1_ck4 r0 *1 0,0
Ccc_XD5_t1_ck4 XD5.t1 ck4 5.4452e-17
* device instance cc_XD5_t1_ck5 r0 *1 0,0
Ccc_XD5_t1_ck5 XD5.t1 ck5 5.4452e-17
* device instance cc_XD5_t1_mod0 r0 *1 0,0
Ccc_XD5_t1_mod0 XD5.t1 mod0 2.4201e-17
* device instance cc_XD5_t1_mod1 r0 *1 0,0
Ccc_XD5_t1_mod1 XD5.t1 mod1 2.4201e-17
* device instance cc_XD5_t1_mod2 r0 *1 0,0
Ccc_XD5_t1_mod2 XD5.t1 mod2 2.4201e-17
* device instance cc_XD5_t1_mod3 r0 *1 0,0
Ccc_XD5_t1_mod3 XD5.t1 mod3 2.4201e-17
* device instance cc_XD5_t1_mod4 r0 *1 0,0
Ccc_XD5_t1_mod4 XD5.t1 mod4 2.4201e-17
* device instance cc_XD5_t1_net1 r0 *1 0,0
Ccc_XD5_t1_net1 XD5.t1 net1 1.21e-17
* device instance cc_XFRT_CLKB_XFRT_M r0 *1 0,0
Ccc_XFRT_CLKB_XFRT_M XFRT.CLKB XFRT.M 4.2352e-17
* device instance cc_XFRT_CLKB_XFRT_MB r0 *1 0,0
Ccc_XFRT_CLKB_XFRT_MB XFRT.CLKB XFRT.MB 2.4201e-17
* device instance cc_XFRT_CLKB_XFRT_S r0 *1 0,0
Ccc_XFRT_CLKB_XFRT_S XFRT.CLKB XFRT.S 1.8151e-17
* device instance cc_XFRT_CLKB_XFRT_SB r0 *1 0,0
Ccc_XFRT_CLKB_XFRT_SB XFRT.CLKB XFRT.SB 1.8151e-17
* device instance cc_XFRT_CLKB_ck1 r0 *1 0,0
Ccc_XFRT_CLKB_ck1 XFRT.CLKB ck1 5.4452e-17
* device instance cc_XFRT_CLKB_ck2 r0 *1 0,0
Ccc_XFRT_CLKB_ck2 XFRT.CLKB ck2 5.4452e-17
* device instance cc_XFRT_CLKB_ck3 r0 *1 0,0
Ccc_XFRT_CLKB_ck3 XFRT.CLKB ck3 5.4452e-17
* device instance cc_XFRT_CLKB_ck4 r0 *1 0,0
Ccc_XFRT_CLKB_ck4 XFRT.CLKB ck4 5.4452e-17
* device instance cc_XFRT_CLKB_ck5 r0 *1 0,0
Ccc_XFRT_CLKB_ck5 XFRT.CLKB ck5 5.4452e-17
* device instance cc_XFRT_CLKB_mod0 r0 *1 0,0
Ccc_XFRT_CLKB_mod0 XFRT.CLKB mod0 2.4201e-17
* device instance cc_XFRT_CLKB_mod1 r0 *1 0,0
Ccc_XFRT_CLKB_mod1 XFRT.CLKB mod1 2.4201e-17
* device instance cc_XFRT_CLKB_mod2 r0 *1 0,0
Ccc_XFRT_CLKB_mod2 XFRT.CLKB mod2 2.4201e-17
* device instance cc_XFRT_CLKB_mod3 r0 *1 0,0
Ccc_XFRT_CLKB_mod3 XFRT.CLKB mod3 2.4201e-17
* device instance cc_XFRT_CLKB_mod4 r0 *1 0,0
Ccc_XFRT_CLKB_mod4 XFRT.CLKB mod4 2.4201e-17
* device instance cc_XFRT_CLKB_net1 r0 *1 0,0
Ccc_XFRT_CLKB_net1 XFRT.CLKB net1 1.21e-17
* device instance cc_XFRT_M_XFRT_MB r0 *1 0,0
Ccc_XFRT_M_XFRT_MB XFRT.M XFRT.MB 3.4688e-17
* device instance cc_XFRT_M_XFRT_S r0 *1 0,0
Ccc_XFRT_M_XFRT_S XFRT.M XFRT.S 2.8638e-17
* device instance cc_XFRT_M_XFRT_SB r0 *1 0,0
Ccc_XFRT_M_XFRT_SB XFRT.M XFRT.SB 1.8151e-17
* device instance cc_XFRT_M_ck1 r0 *1 0,0
Ccc_XFRT_M_ck1 XFRT.M ck1 5.4452e-17
* device instance cc_XFRT_M_ck2 r0 *1 0,0
Ccc_XFRT_M_ck2 XFRT.M ck2 5.4452e-17
* device instance cc_XFRT_M_ck3 r0 *1 0,0
Ccc_XFRT_M_ck3 XFRT.M ck3 5.4452e-17
* device instance cc_XFRT_M_ck4 r0 *1 0,0
Ccc_XFRT_M_ck4 XFRT.M ck4 5.4452e-17
* device instance cc_XFRT_M_ck5 r0 *1 0,0
Ccc_XFRT_M_ck5 XFRT.M ck5 5.4452e-17
* device instance cc_XFRT_M_mod0 r0 *1 0,0
Ccc_XFRT_M_mod0 XFRT.M mod0 2.4201e-17
* device instance cc_XFRT_M_mod1 r0 *1 0,0
Ccc_XFRT_M_mod1 XFRT.M mod1 2.4201e-17
* device instance cc_XFRT_M_mod2 r0 *1 0,0
Ccc_XFRT_M_mod2 XFRT.M mod2 2.4201e-17
* device instance cc_XFRT_M_mod3 r0 *1 0,0
Ccc_XFRT_M_mod3 XFRT.M mod3 2.4201e-17
* device instance cc_XFRT_M_mod4 r0 *1 0,0
Ccc_XFRT_M_mod4 XFRT.M mod4 2.4201e-17
* device instance cc_XFRT_M_net1 r0 *1 0,0
Ccc_XFRT_M_net1 XFRT.M net1 1.21e-17
* device instance cc_XFRT_MB_XFRT_S r0 *1 0,0
Ccc_XFRT_MB_XFRT_S XFRT.MB XFRT.S 1.8151e-17
* device instance cc_XFRT_MB_XFRT_SB r0 *1 0,0
Ccc_XFRT_MB_XFRT_SB XFRT.MB XFRT.SB 1.8151e-17
* device instance cc_XFRT_MB_ck1 r0 *1 0,0
Ccc_XFRT_MB_ck1 XFRT.MB ck1 5.4452e-17
* device instance cc_XFRT_MB_ck2 r0 *1 0,0
Ccc_XFRT_MB_ck2 XFRT.MB ck2 5.4452e-17
* device instance cc_XFRT_MB_ck3 r0 *1 0,0
Ccc_XFRT_MB_ck3 XFRT.MB ck3 5.4452e-17
* device instance cc_XFRT_MB_ck4 r0 *1 0,0
Ccc_XFRT_MB_ck4 XFRT.MB ck4 5.4452e-17
* device instance cc_XFRT_MB_ck5 r0 *1 0,0
Ccc_XFRT_MB_ck5 XFRT.MB ck5 5.4452e-17
* device instance cc_XFRT_MB_mod0 r0 *1 0,0
Ccc_XFRT_MB_mod0 XFRT.MB mod0 2.4201e-17
* device instance cc_XFRT_MB_mod1 r0 *1 0,0
Ccc_XFRT_MB_mod1 XFRT.MB mod1 2.4201e-17
* device instance cc_XFRT_MB_mod2 r0 *1 0,0
Ccc_XFRT_MB_mod2 XFRT.MB mod2 2.4201e-17
* device instance cc_XFRT_MB_mod3 r0 *1 0,0
Ccc_XFRT_MB_mod3 XFRT.MB mod3 2.4201e-17
* device instance cc_XFRT_MB_mod4 r0 *1 0,0
Ccc_XFRT_MB_mod4 XFRT.MB mod4 2.4201e-17
* device instance cc_XFRT_MB_net1 r0 *1 0,0
Ccc_XFRT_MB_net1 XFRT.MB net1 1.21e-17
* device instance cc_XFRT_S_XFRT_SB r0 *1 0,0
Ccc_XFRT_S_XFRT_SB XFRT.S XFRT.SB 4.0738e-17
* device instance cc_XFRT_S_ck1 r0 *1 0,0
Ccc_XFRT_S_ck1 XFRT.S ck1 5.4452e-17
* device instance cc_XFRT_S_ck2 r0 *1 0,0
Ccc_XFRT_S_ck2 XFRT.S ck2 5.4452e-17
* device instance cc_XFRT_S_ck3 r0 *1 0,0
Ccc_XFRT_S_ck3 XFRT.S ck3 5.4452e-17
* device instance cc_XFRT_S_ck4 r0 *1 0,0
Ccc_XFRT_S_ck4 XFRT.S ck4 5.4452e-17
* device instance cc_XFRT_S_ck5 r0 *1 0,0
Ccc_XFRT_S_ck5 XFRT.S ck5 5.4452e-17
* device instance cc_XFRT_S_mod0 r0 *1 0,0
Ccc_XFRT_S_mod0 XFRT.S mod0 2.4201e-17
* device instance cc_XFRT_S_mod1 r0 *1 0,0
Ccc_XFRT_S_mod1 XFRT.S mod1 2.4201e-17
* device instance cc_XFRT_S_mod2 r0 *1 0,0
Ccc_XFRT_S_mod2 XFRT.S mod2 2.4201e-17
* device instance cc_XFRT_S_mod3 r0 *1 0,0
Ccc_XFRT_S_mod3 XFRT.S mod3 2.4201e-17
* device instance cc_XFRT_S_mod4 r0 *1 0,0
Ccc_XFRT_S_mod4 XFRT.S mod4 2.4201e-17
* device instance cc_XFRT_S_net1 r0 *1 0,0
Ccc_XFRT_S_net1 XFRT.S net1 1.21e-17
* device instance cc_XFRT_SB_ck1 r0 *1 0,0
Ccc_XFRT_SB_ck1 XFRT.SB ck1 5.4452e-17
* device instance cc_XFRT_SB_ck2 r0 *1 0,0
Ccc_XFRT_SB_ck2 XFRT.SB ck2 5.4452e-17
* device instance cc_XFRT_SB_ck3 r0 *1 0,0
Ccc_XFRT_SB_ck3 XFRT.SB ck3 5.4452e-17
* device instance cc_XFRT_SB_ck4 r0 *1 0,0
Ccc_XFRT_SB_ck4 XFRT.SB ck4 5.4452e-17
* device instance cc_XFRT_SB_ck5 r0 *1 0,0
Ccc_XFRT_SB_ck5 XFRT.SB ck5 5.4452e-17
* device instance cc_XFRT_SB_mod0 r0 *1 0,0
Ccc_XFRT_SB_mod0 XFRT.SB mod0 2.4201e-17
* device instance cc_XFRT_SB_mod1 r0 *1 0,0
Ccc_XFRT_SB_mod1 XFRT.SB mod1 2.4201e-17
* device instance cc_XFRT_SB_mod2 r0 *1 0,0
Ccc_XFRT_SB_mod2 XFRT.SB mod2 2.4201e-17
* device instance cc_XFRT_SB_mod3 r0 *1 0,0
Ccc_XFRT_SB_mod3 XFRT.SB mod3 2.4201e-17
* device instance cc_XFRT_SB_mod4 r0 *1 0,0
Ccc_XFRT_SB_mod4 XFRT.SB mod4 2.4201e-17
* device instance cc_XFRT_SB_net1 r0 *1 0,0
Ccc_XFRT_SB_net1 XFRT.SB net1 1.21e-17
* device instance cc_ck1_ck2 r0 *1 0,0
Ccc_ck1_ck2 ck1 ck2 7.2603e-17
* device instance cc_ck1_ck3 r0 *1 0,0
Ccc_ck1_ck3 ck1 ck3 5.4452e-17
* device instance cc_ck1_ck4 r0 *1 0,0
Ccc_ck1_ck4 ck1 ck4 5.4452e-17
* device instance cc_ck1_ck5 r0 *1 0,0
Ccc_ck1_ck5 ck1 ck5 5.4452e-17
* device instance cc_ck1_mod0 r0 *1 0,0
Ccc_ck1_mod0 ck1 mod0 3.6302e-17
* device instance cc_ck1_mod1 r0 *1 0,0
Ccc_ck1_mod1 ck1 mod1 3.6302e-17
* device instance cc_ck1_mod2 r0 *1 0,0
Ccc_ck1_mod2 ck1 mod2 2.4201e-17
* device instance cc_ck1_mod3 r0 *1 0,0
Ccc_ck1_mod3 ck1 mod3 2.4201e-17
* device instance cc_ck1_mod4 r0 *1 0,0
Ccc_ck1_mod4 ck1 mod4 2.4201e-17
* device instance cc_ck1_net1 r0 *1 0,0
Ccc_ck1_net1 ck1 net1 1.8151e-17
* device instance cc_ck2_ck3 r0 *1 0,0
Ccc_ck2_ck3 ck2 ck3 7.2603e-17
* device instance cc_ck2_ck4 r0 *1 0,0
Ccc_ck2_ck4 ck2 ck4 5.4452e-17
* device instance cc_ck2_ck5 r0 *1 0,0
Ccc_ck2_ck5 ck2 ck5 5.4452e-17
* device instance cc_ck2_mod0 r0 *1 0,0
Ccc_ck2_mod0 ck2 mod0 3.0251e-17
* device instance cc_ck2_mod1 r0 *1 0,0
Ccc_ck2_mod1 ck2 mod1 3.6302e-17
* device instance cc_ck2_mod2 r0 *1 0,0
Ccc_ck2_mod2 ck2 mod2 3.6302e-17
* device instance cc_ck2_mod3 r0 *1 0,0
Ccc_ck2_mod3 ck2 mod3 2.4201e-17
* device instance cc_ck2_mod4 r0 *1 0,0
Ccc_ck2_mod4 ck2 mod4 2.4201e-17
* device instance cc_ck2_net1 r0 *1 0,0
Ccc_ck2_net1 ck2 net1 1.21e-17
* device instance cc_ck3_ck4 r0 *1 0,0
Ccc_ck3_ck4 ck3 ck4 7.2603e-17
* device instance cc_ck3_ck5 r0 *1 0,0
Ccc_ck3_ck5 ck3 ck5 5.4452e-17
* device instance cc_ck3_mod0 r0 *1 0,0
Ccc_ck3_mod0 ck3 mod0 2.4201e-17
* device instance cc_ck3_mod1 r0 *1 0,0
Ccc_ck3_mod1 ck3 mod1 3.0251e-17
* device instance cc_ck3_mod2 r0 *1 0,0
Ccc_ck3_mod2 ck3 mod2 3.6302e-17
* device instance cc_ck3_mod3 r0 *1 0,0
Ccc_ck3_mod3 ck3 mod3 3.6302e-17
* device instance cc_ck3_mod4 r0 *1 0,0
Ccc_ck3_mod4 ck3 mod4 2.4201e-17
* device instance cc_ck3_net1 r0 *1 0,0
Ccc_ck3_net1 ck3 net1 1.21e-17
* device instance cc_ck4_ck5 r0 *1 0,0
Ccc_ck4_ck5 ck4 ck5 7.2603e-17
* device instance cc_ck4_mod0 r0 *1 0,0
Ccc_ck4_mod0 ck4 mod0 2.4201e-17
* device instance cc_ck4_mod1 r0 *1 0,0
Ccc_ck4_mod1 ck4 mod1 2.4201e-17
* device instance cc_ck4_mod2 r0 *1 0,0
Ccc_ck4_mod2 ck4 mod2 3.0251e-17
* device instance cc_ck4_mod3 r0 *1 0,0
Ccc_ck4_mod3 ck4 mod3 3.6302e-17
* device instance cc_ck4_mod4 r0 *1 0,0
Ccc_ck4_mod4 ck4 mod4 3.6302e-17
* device instance cc_ck4_net1 r0 *1 0,0
Ccc_ck4_net1 ck4 net1 1.21e-17
* device instance cc_ck5_mod0 r0 *1 0,0
Ccc_ck5_mod0 ck5 mod0 2.4201e-17
* device instance cc_ck5_mod1 r0 *1 0,0
Ccc_ck5_mod1 ck5 mod1 2.4201e-17
* device instance cc_ck5_mod2 r0 *1 0,0
Ccc_ck5_mod2 ck5 mod2 2.4201e-17
* device instance cc_ck5_mod3 r0 *1 0,0
Ccc_ck5_mod3 ck5 mod3 3.0251e-17
* device instance cc_ck5_mod4 r0 *1 0,0
Ccc_ck5_mod4 ck5 mod4 3.6302e-17
* device instance cc_ck5_net1 r0 *1 0,0
Ccc_ck5_net1 ck5 net1 1.21e-17
* device instance cc_mod0_mod1 r0 *1 0,0
Ccc_mod0_mod1 mod0 mod1 3.6302e-17
* device instance cc_mod0_mod2 r0 *1 0,0
Ccc_mod0_mod2 mod0 mod2 2.4201e-17
* device instance cc_mod0_mod3 r0 *1 0,0
Ccc_mod0_mod3 mod0 mod3 2.4201e-17
* device instance cc_mod0_mod4 r0 *1 0,0
Ccc_mod0_mod4 mod0 mod4 2.4201e-17
* device instance cc_mod0_net1 r0 *1 0,0
Ccc_mod0_net1 mod0 net1 2.4201e-17
* device instance cc_mod1_mod2 r0 *1 0,0
Ccc_mod1_mod2 mod1 mod2 3.6302e-17
* device instance cc_mod1_mod3 r0 *1 0,0
Ccc_mod1_mod3 mod1 mod3 2.4201e-17
* device instance cc_mod1_mod4 r0 *1 0,0
Ccc_mod1_mod4 mod1 mod4 2.4201e-17
* device instance cc_mod1_net1 r0 *1 0,0
Ccc_mod1_net1 mod1 net1 1.21e-17
* device instance cc_mod2_mod3 r0 *1 0,0
Ccc_mod2_mod3 mod2 mod3 3.6302e-17
* device instance cc_mod2_mod4 r0 *1 0,0
Ccc_mod2_mod4 mod2 mod4 2.4201e-17
* device instance cc_mod2_net1 r0 *1 0,0
Ccc_mod2_net1 mod2 net1 1.21e-17
* device instance cc_mod3_mod4 r0 *1 0,0
Ccc_mod3_mod4 mod3 mod4 3.6302e-17
* device instance cc_mod3_net1 r0 *1 0,0
Ccc_mod3_net1 mod3 net1 1.21e-17
* device instance cc_mod4_net1 r0 *1 0,0
Ccc_mod4_net1 mod4 net1 1.21e-17
* device instance vsubs_dctie r0 *1 0,0
Rvsubs_dctie vsubs 0 1e+12
.ENDS pll_divider_chain
