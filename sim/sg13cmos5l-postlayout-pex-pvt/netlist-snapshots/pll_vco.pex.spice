* extracted by klt extract --deck sg13cmos5l
* parasitic model (--parasitics):
* - capacitance: net-to-ground for every net's own (non-coupled) area/perimeter, plus net-to-net for the vertical-overlap coupling `coupling` describes below -- a coupled net pair gets a direct capacitor between their two hub nodes, not just capacitors to the deck's ground/substrate net
* - coupling: vertical overlap (crossover) unconditionally -- where one net's conductor on an adjacent metal level sits directly over another *distinct* net's conductor, that overlap area is charged between the two nets instead of to ground (issue #760) -- plus lateral (same-layer, sidewall) coupling, but only for a net pair naming one of the caller's declared `--critical-net` nets (issue #976): facing-edge length within that layer's own minimum-spacing lookback is charged between the two nets, *additively* (not deducted from either net's substrate fringe term, unlike the vertical case -- a known simplification). Any same-layer pair with neither side named `--critical-net`, and fringe shielding in general, are still not modelled
* - resistance: single lumped series resistance per net, distributed as a star across that net's device terminals (issue #592) -- not a per-segment, distributed RC ladder, *unless* `--distributed-rc` names this net via `--critical-net` (issue #977, Epic #709 Phase 2b): then the net's terminals are ordered along their approximate physical spread and its total R/C is broken into a chain of per-segment resistors (segment length proportional to inter-terminal distance) with a ground capacitor at each terminal node (proportional to its adjacent segment length/2), instead of one star hub -- still an approximation (terminal position is a device-placement proxy, not true per-segment routing geometry), but a strictly finer-grained one than the single-hub star
* - frequency: quasi-static -- one frequency-independent R and C per net; no skin effect, no distributed transmission-line behavior
.GLOBAL vsubs

* cell pll_vco
* pin B0
* pin B1
* pin CLK
* pin GND_VCO
* pin VBN
* pin VBP
* pin VCTRL
* pin VDD_VCO
* pin XBIAS.VFIX
* pin XBIAS.dega
* pin XBIAS.degb
* pin XBIAS.n2s
* pin XBIAS.nb0
* pin XBIAS.nb1
* pin XBIAS.vb1
* pin XBIAS.vb2
* pin XBIAS.vfixmid
* pin XS1.nh
* pin XS1.nt
* pin XS2.nh
* pin XS2.nt
* pin XS3.nh
* pin XS3.nt
* pin XS4.nh
* pin XS4.nt
* pin XS5.nh
* pin XS5.nt
* pin bufmid
* pin ring1
* pin ring2
* pin ring3
* pin ring4
* pin ring5
.SUBCKT pll_vco B0 B1 CLK GND_VCO VBN VBP VCTRL VDD_VCO XBIAS.VFIX XBIAS.dega
+ XBIAS.degb XBIAS.n2s XBIAS.nb0 XBIAS.nb1 XBIAS.vb1 XBIAS.vb2 XBIAS.vfixmid
+ XS1.nh XS1.nt XS2.nh XS2.nt XS3.nh XS3.nt XS4.nh XS4.nt XS5.nh XS5.nt bufmid
+ ring1 ring2 ring3 ring4 ring5
* device instance $1 r0 *1 2.3,3 nfet
M$1 ring1__t0 ring5__t0 XS1.nt__t0 GND_VCO__t21 nfet L=0.28U W=2U AS=0.8P
+ AD=0.8P PS=4.8U PD=4.8U
* device instance $2 r0 *1 6.26,3 nfet
M$2 ring2__t2 ring1__t5 XS2.nt__t1 GND_VCO__t22 nfet L=0.28U W=2U AS=0.8P
+ AD=0.8P PS=4.8U PD=4.8U
* device instance $3 r0 *1 10.22,3 nfet
M$3 ring3__t2 ring2__t3 XS3.nt__t1 GND_VCO__t23 nfet L=0.28U W=2U AS=0.8P
+ AD=0.8P PS=4.8U PD=4.8U
* device instance $4 r0 *1 14.18,3 nfet
M$4 ring4__t2 ring3__t3 XS4.nt__t1 GND_VCO__t24 nfet L=0.28U W=2U AS=0.8P
+ AD=0.8P PS=4.8U PD=4.8U
* device instance $5 r0 *1 18.14,3 nfet
M$5 ring5__t3 ring4__t3 XS5.nt__t1 GND_VCO__t25 nfet L=0.28U W=2U AS=0.8P
+ AD=0.8P PS=4.8U PD=4.8U
* device instance $6 r0 *1 28.74,3.36 nfet
M$6 XBIAS.vb1__t4 XBIAS.vb2__t4 GND_VCO__t2 GND_VCO__t26 nfet L=1U W=2U AS=0.8P
+ AD=0.8P PS=4.8U PD=4.8U
* device instance $7 r0 *1 32.7,3.36 nfet
M$7 XBIAS.VFIX__t3 XBIAS.VFIX__t2 XBIAS.vfixmid__t2 GND_VCO__t27 nfet L=1U W=2U
+ AS=0.8P AD=0.8P PS=4.8U PD=4.8U
* device instance $8 r0 *1 36.66,3.36 nfet
M$8 XBIAS.vfixmid__t0 XBIAS.vfixmid__t1 GND_VCO__t11 GND_VCO__t28 nfet L=1U
+ W=2U AS=0.8P AD=0.8P PS=4.8U PD=4.8U
* device instance $9 r0 *1 48.26,3.01 nfet
M$9 XBIAS.degb__t0 B0__t0 XBIAS.nb0__t0 GND_VCO__t29 nfet L=0.3U W=4U AS=1.6P
+ AD=1.6P PS=8.8U PD=8.8U
* device instance $10 r0 *1 54.22,3.01 nfet
M$10 XBIAS.degb__t1 B1__t0 XBIAS.nb1__t0 GND_VCO__t30 nfet L=0.3U W=4U AS=1.6P
+ AD=1.6P PS=8.8U PD=8.8U
* device instance $11 r0 *1 66.82,3.11 nfet
M$11 XS1.nt__t1 VBN__t0 GND_VCO__t3 GND_VCO__t31 nfet L=0.5U W=4U AS=1.6P
+ AD=1.6P PS=8.8U PD=8.8U
* device instance $12 r0 *1 72.78,3.11 nfet
M$12 XS2.nt__t0 VBN__t4 GND_VCO__t5 GND_VCO__t32 nfet L=0.5U W=4U AS=1.6P
+ AD=1.6P PS=8.8U PD=8.8U
* device instance $13 r0 *1 78.74,3.11 nfet
M$13 XS3.nt__t0 VBN__t7 GND_VCO__t10 GND_VCO__t33 nfet L=0.5U W=4U AS=1.6P
+ AD=1.6P PS=8.8U PD=8.8U
* device instance $14 r0 *1 84.7,3.11 nfet
M$14 XS4.nt__t0 VBN__t5 GND_VCO__t6 GND_VCO__t34 nfet L=0.5U W=4U AS=1.6P
+ AD=1.6P PS=8.8U PD=8.8U
* device instance $15 r0 *1 90.66,3.11 nfet
M$15 XS5.nt__t0 VBN__t6 GND_VCO__t7 GND_VCO__t35 nfet L=0.5U W=4U AS=1.6P
+ AD=1.6P PS=8.8U PD=8.8U
* device instance $16 r0 *1 96.62,3.11 nfet
M$16 bufmid__t2 ring1__t4 GND_VCO__t8 GND_VCO__t36 nfet L=0.5U W=4U AS=1.6P
+ AD=1.6P PS=8.8U PD=8.8U
* device instance $17 r0 *1 102.58,3.11 nfet
M$17 CLK__t1 bufmid__t3 GND_VCO__t9 GND_VCO__t37 nfet L=0.5U W=4U AS=1.6P
+ AD=1.6P PS=8.8U PD=8.8U
* device instance $18 r0 *1 115.18,3.36 nfet
M$18 VBP__t9 XBIAS.VFIX__t1 XBIAS.dega__t1 GND_VCO__t38 nfet L=1U W=4U AS=1.6P
+ AD=1.6P PS=8.8U PD=8.8U
* device instance $19 r0 *1 121.14,3.36 nfet
M$19 VBP__t8 VCTRL__t0 XBIAS.degb__t2 GND_VCO__t39 nfet L=1U W=4U AS=1.6P
+ AD=1.6P PS=8.8U PD=8.8U
* device instance $20 r0 *1 127.1,3.36 nfet
M$20 VBN__t1 VBN__t2 GND_VCO__t4 GND_VCO__t40 nfet L=1U W=4U AS=1.6P AD=1.6P
+ PS=8.8U PD=8.8U
* device instance $21 r0 *1 141.7,3.36 nfet
M$21 XBIAS.vb2__t1 XBIAS.vb2__t2 XBIAS.n2s__t1 GND_VCO__t41 nfet L=1U W=8U
+ AS=3.2P AD=3.2P PS=16.8U PD=16.8U
* device instance $22 r0 *1 155.8,3.36 pfet
M$22 XBIAS.VFIX__t0 XBIAS.vb1__t0 VDD_VCO__t2 VDD_VCO__t1 pfet L=1U W=3U
+ AS=1.2P AD=1.2P PS=6.8U PD=6.8U
* device instance $23 r0 *1 168.4,3 pfet
M$23 ring1__t1 ring5__t1 XS1.nh__t0 VDD_VCO__t3 pfet L=0.28U W=5U AS=2P AD=2P
+ PS=10.8U PD=10.8U
* device instance $24 r0 *1 175.36,3 pfet
M$24 ring2__t0 ring1__t3 XS2.nh__t1 VDD_VCO__t27 pfet L=0.28U W=5U AS=2P AD=2P
+ PS=10.8U PD=10.8U
* device instance $25 r0 *1 182.32,3 pfet
M$25 ring3__t0 ring2__t1 XS3.nh__t1 VDD_VCO__t26 pfet L=0.28U W=5U AS=2P AD=2P
+ PS=10.8U PD=10.8U
* device instance $26 r0 *1 189.28,3 pfet
M$26 ring4__t0 ring3__t1 XS4.nh__t1 VDD_VCO__t28 pfet L=0.28U W=5U AS=2P AD=2P
+ PS=10.8U PD=10.8U
* device instance $27 r0 *1 196.24,3 pfet
M$27 ring5__t2 ring4__t1 XS5.nh__t1 VDD_VCO__t29 pfet L=0.28U W=5U AS=2P AD=2P
+ PS=10.8U PD=10.8U
* device instance $28 r0 *1 210.34,3.36 pfet
M$28 XBIAS.vb1__t1 XBIAS.vb1__t2 VDD_VCO__t5 VDD_VCO__t4 pfet L=1U W=6U AS=2.4P
+ AD=2.4P PS=12.8U PD=12.8U
* device instance $29 r0 *1 218.3,3.36 pfet
M$29 XBIAS.vb2__t3 XBIAS.vb1__t3 VDD_VCO__t24 VDD_VCO__t25 pfet L=1U W=6U
+ AS=2.4P AD=2.4P PS=12.8U PD=12.8U
* device instance $30 r0 *1 234.9,3.11 pfet
M$30 XS1.nh__t1 VBP__t0 VDD_VCO__t7 VDD_VCO__t6 pfet L=0.5U W=10U AS=4P AD=4P
+ PS=20.8U PD=20.8U
* device instance $31 r0 *1 246.86,3.11 pfet
M$31 XS2.nh__t0 VBP__t4 VDD_VCO__t12 VDD_VCO__t18 pfet L=0.5U W=10U AS=4P AD=4P
+ PS=20.8U PD=20.8U
* device instance $32 r0 *1 258.82,3.11 pfet
M$32 XS3.nh__t0 VBP__t5 VDD_VCO__t13 VDD_VCO__t19 pfet L=0.5U W=10U AS=4P AD=4P
+ PS=20.8U PD=20.8U
* device instance $33 r0 *1 270.78,3.11 pfet
M$33 XS4.nh__t0 VBP__t6 VDD_VCO__t14 VDD_VCO__t20 pfet L=0.5U W=10U AS=4P AD=4P
+ PS=20.8U PD=20.8U
* device instance $34 r0 *1 282.74,3.11 pfet
M$34 XS5.nh__t0 VBP__t7 VDD_VCO__t15 VDD_VCO__t21 pfet L=0.5U W=10U AS=4P AD=4P
+ PS=20.8U PD=20.8U
* device instance $35 r0 *1 294.7,3.11 pfet
M$35 bufmid__t0 ring1__t2 VDD_VCO__t17 VDD_VCO__t23 pfet L=0.5U W=10U AS=4P
+ AD=4P PS=20.8U PD=20.8U
* device instance $36 r0 *1 306.66,3.11 pfet
M$36 CLK__t0 bufmid__t1 VDD_VCO__t16 VDD_VCO__t22 pfet L=0.5U W=10U AS=4P AD=4P
+ PS=20.8U PD=20.8U
* device instance $37 r0 *1 325.26,3.36 pfet
M$37 VBP__t1 VBP__t2 VDD_VCO__t9 VDD_VCO__t8 pfet L=1U W=10U AS=4P AD=4P
+ PS=20.8U PD=20.8U
* device instance $38 r0 *1 337.22,3.36 pfet
M$38 VBN__t3 VBP__t3 VDD_VCO__t10 VDD_VCO__t11 pfet L=1U W=10U AS=4P AD=4P
+ PS=20.8U PD=20.8U
* device instance $39 r0 *1 380.02,0.7 rppd
R$39 XBIAS.n2s__t0 GND_VCO__t0 GND_VCO__t15 7800 rppd L=30U W=1U
* device instance $40 r0 *1 432.62,0.7 rppd
R$40 XBIAS.dega__t0 GND_VCO__t1 GND_VCO__t17 15600 rppd L=60U W=1U
* device instance $41 r0 *1 380.62,2.7 rppd
R$41 XBIAS.nb1__t1 GND_VCO__t14 GND_VCO__t16 7800 rppd L=30U W=1U
* device instance $42 r0 *1 433.22,2.7 rppd
R$42 XBIAS.degb__t3 GND_VCO__t13 GND_VCO__t18 15600 rppd L=60U W=1U
* device instance $43 r0 *1 433.82,4.7 rppd
R$43 XBIAS.nb0__t1 GND_VCO__t12 GND_VCO__t19 15600 rppd L=60U W=1U
* device instance $44 r0 *1 354.02,0.45 rhigh
R$44 VDD_VCO__t0 XBIAS.vb2__t0 GND_VCO__t20 21760 rhigh L=8U W=0.5U
* device instance B0_t0 r0 *1 0,0
RB0_t0 B0__t0 B0 1.5737
* device instance B0 r0 *1 0,0
CB0 B0 vsubs 4.8692e-16
* device instance B1_t0 r0 *1 0,0
RB1_t0 B1__t0 B1 1.7497
* device instance B1 r0 *1 0,0
CB1 B1 vsubs 5.3284e-16
* device instance CLK_t0 r0 *1 0,0
RCLK_t0 CLK__t0 CLK 34.24805
* device instance CLK_t1 r0 *1 0,0
RCLK_t1 CLK__t1 CLK 34.24805
* device instance CLK r0 *1 0,0
CCLK CLK vsubs 1.5141527e-14
* device instance GND_VCO_t0 r0 *1 0,0
RGND_VCO_t0 GND_VCO__t0 GND_VCO 9.23535718047
* device instance GND_VCO_t1 r0 *1 0,0
RGND_VCO_t1 GND_VCO__t1 GND_VCO 11.4170163737
* device instance GND_VCO_t2 r0 *1 0,0
RGND_VCO_t2 GND_VCO__t2 GND_VCO 5.33553304779
* device instance GND_VCO_t3 r0 *1 0,0
RGND_VCO_t3 GND_VCO__t3 GND_VCO 3.75602497276
* device instance GND_VCO_t4 r0 *1 0,0
RGND_VCO_t4 GND_VCO__t4 GND_VCO 1.25586589362
* device instance GND_VCO_t5 r0 *1 0,0
RGND_VCO_t5 GND_VCO__t5 GND_VCO 3.50881658718
* device instance GND_VCO_t6 r0 *1 0,0
RGND_VCO_t6 GND_VCO__t6 GND_VCO 3.01440018141
* device instance GND_VCO_t7 r0 *1 0,0
RGND_VCO_t7 GND_VCO__t7 GND_VCO 2.7671922265
* device instance GND_VCO_t8 r0 *1 0,0
RGND_VCO_t8 GND_VCO__t8 GND_VCO 2.51998450177
* device instance GND_VCO_t9 r0 *1 0,0
RGND_VCO_t9 GND_VCO__t9 GND_VCO 2.27277708234
* device instance GND_VCO_t10 r0 *1 0,0
RGND_VCO_t10 GND_VCO__t10 GND_VCO 3.26160831417
* device instance GND_VCO_t11 r0 *1 0,0
RGND_VCO_t11 GND_VCO__t11 GND_VCO 5.00702924054
* device instance GND_VCO_t12 r0 *1 0,0
RGND_VCO_t12 GND_VCO__t12 GND_VCO 11.466671133
* device instance GND_VCO_t13 r0 *1 0,0
RGND_VCO_t13 GND_VCO__t13 GND_VCO 11.4415428946
* device instance GND_VCO_t14 r0 *1 0,0
RGND_VCO_t14 GND_VCO__t14 GND_VCO 9.25979858155
* device instance GND_VCO_t15 r0 *1 0,0
RGND_VCO_t15 GND_VCO__t15 GND_VCO 9.23535718047
* device instance GND_VCO_t16 r0 *1 0,0
RGND_VCO_t16 GND_VCO__t16 GND_VCO 9.25979858155
* device instance GND_VCO_t17 r0 *1 0,0
RGND_VCO_t17 GND_VCO__t17 GND_VCO 11.4170163737
* device instance GND_VCO_t18 r0 *1 0,0
RGND_VCO_t18 GND_VCO__t18 GND_VCO 11.4415428946
* device instance GND_VCO_t19 r0 *1 0,0
RGND_VCO_t19 GND_VCO__t19 GND_VCO 11.466671133
* device instance GND_VCO_t20 r0 *1 0,0
RGND_VCO_t20 GND_VCO__t20 GND_VCO 8.15710981132
* device instance GND_VCO_t21 r0 *1 0,0
RGND_VCO_t21 GND_VCO__t21 GND_VCO 6.43217914037
* device instance GND_VCO_t22 r0 *1 0,0
RGND_VCO_t22 GND_VCO__t22 GND_VCO 6.26792613379
* device instance GND_VCO_t23 r0 *1 0,0
RGND_VCO_t23 GND_VCO__t23 GND_VCO 6.10367312927
* device instance GND_VCO_t24 r0 *1 0,0
RGND_VCO_t24 GND_VCO__t24 GND_VCO 5.93942012698
* device instance GND_VCO_t25 r0 *1 0,0
RGND_VCO_t25 GND_VCO__t25 GND_VCO 5.77516712711
* device instance GND_VCO_t26 r0 *1 0,0
RGND_VCO_t26 GND_VCO__t26 GND_VCO 5.33553304779
* device instance GND_VCO_t27 r0 *1 0,0
RGND_VCO_t27 GND_VCO__t27 GND_VCO 5.17128110792
* device instance GND_VCO_t28 r0 *1 0,0
RGND_VCO_t28 GND_VCO__t28 GND_VCO 5.00702924054
* device instance GND_VCO_t29 r0 *1 0,0
RGND_VCO_t29 GND_VCO__t29 GND_VCO 4.52584937862
* device instance GND_VCO_t30 r0 *1 0,0
RGND_VCO_t30 GND_VCO__t30 GND_VCO 4.27864039451
* device instance GND_VCO_t31 r0 *1 0,0
RGND_VCO_t31 GND_VCO__t31 GND_VCO 3.75602497276
* device instance GND_VCO_t32 r0 *1 0,0
RGND_VCO_t32 GND_VCO__t32 GND_VCO 3.50881658718
* device instance GND_VCO_t33 r0 *1 0,0
RGND_VCO_t33 GND_VCO__t33 GND_VCO 3.26160831417
* device instance GND_VCO_t34 r0 *1 0,0
RGND_VCO_t34 GND_VCO__t34 GND_VCO 3.01440018141
* device instance GND_VCO_t35 r0 *1 0,0
RGND_VCO_t35 GND_VCO__t35 GND_VCO 2.7671922265
* device instance GND_VCO_t36 r0 *1 0,0
RGND_VCO_t36 GND_VCO__t36 GND_VCO 2.51998450177
* device instance GND_VCO_t37 r0 *1 0,0
RGND_VCO_t37 GND_VCO__t37 GND_VCO 2.27277708234
* device instance GND_VCO_t38 r0 *1 0,0
RGND_VCO_t38 GND_VCO__t38 GND_VCO 1.75024239612
* device instance GND_VCO_t39 r0 *1 0,0
RGND_VCO_t39 GND_VCO__t39 GND_VCO 1.50305071136
* device instance GND_VCO_t40 r0 *1 0,0
RGND_VCO_t40 GND_VCO__t40 GND_VCO 1.25586589362
* device instance GND_VCO_t41 r0 *1 0,0
RGND_VCO_t41 GND_VCO__t41 GND_VCO 0.650424119578
* device instance GND_VCO r0 *1 0,0
CGND_VCO GND_VCO vsubs 5.7095189e-14
* device instance VBN_t0 r0 *1 0,0
RVBN_t0 VBN__t0 VBN 13.2754050945
* device instance VBN_t1 r0 *1 0,0
RVBN_t1 VBN__t1 VBN 0.934151951632
* device instance VBN_t2 r0 *1 0,0
RVBN_t2 VBN__t2 VBN 0.934151951632
* device instance VBN_t3 r0 *1 0,0
RVBN_t3 VBN__t3 VBN 50.4615685761
* device instance VBN_t4 r0 *1 0,0
RVBN_t4 VBN__t4 VBN 11.8705545591
* device instance VBN_t5 r0 *1 0,0
RVBN_t5 VBN__t5 VBN 9.06085551316
* device instance VBN_t6 r0 *1 0,0
RVBN_t6 VBN__t6 VBN 7.65600774578
* device instance VBN_t7 r0 *1 0,0
RVBN_t7 VBN__t7 VBN 10.465704608
* device instance VBN r0 *1 0,0
CVBN VBN vsubs 2.335499e-14
* device instance VBP_t0 r0 *1 0,0
RVBP_t0 VBP__t0 VBP 2.86041149546
* device instance VBP_t1 r0 *1 0,0
RVBP_t1 VBP__t1 VBP 12.4186941808
* device instance VBP_t2 r0 *1 0,0
RVBP_t2 VBP__t2 VBP 12.4186941808
* device instance VBP_t3 r0 *1 0,0
RVBP_t3 VBP__t3 VBP 14.4410129854
* device instance VBP_t4 r0 *1 0,0
RVBP_t4 VBP__t4 VBP 0.838278587219
* device instance VBP_t5 r0 *1 0,0
RVBP_t5 VBP__t5 VBP 1.18449783746
* device instance VBP_t6 r0 *1 0,0
RVBP_t6 VBP__t6 VBP 3.20670022528
* device instance VBP_t7 r0 *1 0,0
RVBP_t7 VBP__t7 VBP 5.22899460828
* device instance VBP_t8 r0 *1 0,0
RVBP_t8 VBP__t8 VBP 22.0960687434
* device instance VBP_t9 r0 *1 0,0
RVBP_t9 VBP__t9 VBP 23.1038471559
* device instance VBP r0 *1 0,0
CVBP VBP vsubs 2.1932054e-14
* device instance VCTRL_t0 r0 *1 0,0
RVCTRL_t0 VCTRL__t0 VCTRL 2.5271
* device instance VCTRL r0 *1 0,0
CVCTRL VCTRL vsubs 7.2911e-16
* device instance VDD_VCO_t0 r0 *1 0,0
RVDD_VCO_t0 VDD_VCO__t0 VDD_VCO 13.2154931971
* device instance VDD_VCO_t1 r0 *1 0,0
RVDD_VCO_t1 VDD_VCO__t1 VDD_VCO 12.3770703116
* device instance VDD_VCO_t2 r0 *1 0,0
RVDD_VCO_t2 VDD_VCO__t2 VDD_VCO 12.3770703116
* device instance VDD_VCO_t3 r0 *1 0,0
RVDD_VCO_t3 VDD_VCO__t3 VDD_VCO 10.7504973542
* device instance VDD_VCO_t4 r0 *1 0,0
RVDD_VCO_t4 VDD_VCO__t4 VDD_VCO 5.33659282708
* device instance VDD_VCO_t5 r0 *1 0,0
RVDD_VCO_t5 VDD_VCO__t5 VDD_VCO 5.33659282708
* device instance VDD_VCO_t6 r0 *1 0,0
RVDD_VCO_t6 VDD_VCO__t6 VDD_VCO 2.16603872637
* device instance VDD_VCO_t7 r0 *1 0,0
RVDD_VCO_t7 VDD_VCO__t7 VDD_VCO 2.16603872637
* device instance VDD_VCO_t8 r0 *1 0,0
RVDD_VCO_t8 VDD_VCO__t8 VDD_VCO 9.49856076809
* device instance VDD_VCO_t9 r0 *1 0,0
RVDD_VCO_t9 VDD_VCO__t9 VDD_VCO 9.49856076809
* device instance VDD_VCO_t10 r0 *1 0,0
RVDD_VCO_t10 VDD_VCO__t10 VDD_VCO 11.0424625883
* device instance VDD_VCO_t11 r0 *1 0,0
RVDD_VCO_t11 VDD_VCO__t11 VDD_VCO 11.0424625883
* device instance VDD_VCO_t12 r0 *1 0,0
RVDD_VCO_t12 VDD_VCO__t12 VDD_VCO 0.622133067733
* device instance VDD_VCO_t13 r0 *1 0,0
RVDD_VCO_t13 VDD_VCO__t13 VDD_VCO 0.921790502108
* device instance VDD_VCO_t14 r0 *1 0,0
RVDD_VCO_t14 VDD_VCO__t14 VDD_VCO 2.46569833751
* device instance VDD_VCO_t15 r0 *1 0,0
RVDD_VCO_t15 VDD_VCO__t15 VDD_VCO 4.00960861424
* device instance VDD_VCO_t16 r0 *1 0,0
RVDD_VCO_t16 VDD_VCO__t16 VDD_VCO 7.09743011892
* device instance VDD_VCO_t17 r0 *1 0,0
RVDD_VCO_t17 VDD_VCO__t17 VDD_VCO 5.55351929619
* device instance VDD_VCO_t18 r0 *1 0,0
RVDD_VCO_t18 VDD_VCO__t18 VDD_VCO 0.622133067733
* device instance VDD_VCO_t19 r0 *1 0,0
RVDD_VCO_t19 VDD_VCO__t19 VDD_VCO 0.921790502108
* device instance VDD_VCO_t20 r0 *1 0,0
RVDD_VCO_t20 VDD_VCO__t20 VDD_VCO 2.46569833751
* device instance VDD_VCO_t21 r0 *1 0,0
RVDD_VCO_t21 VDD_VCO__t21 VDD_VCO 4.00960861424
* device instance VDD_VCO_t22 r0 *1 0,0
RVDD_VCO_t22 VDD_VCO__t22 VDD_VCO 7.09743011892
* device instance VDD_VCO_t23 r0 *1 0,0
RVDD_VCO_t23 VDD_VCO__t23 VDD_VCO 5.55351929619
* device instance VDD_VCO_t24 r0 *1 0,0
RVDD_VCO_t24 VDD_VCO__t24 VDD_VCO 4.30906790163
* device instance VDD_VCO_t25 r0 *1 0,0
RVDD_VCO_t25 VDD_VCO__t25 VDD_VCO 4.30906790163
* device instance VDD_VCO_t26 r0 *1 0,0
RVDD_VCO_t26 VDD_VCO__t26 VDD_VCO 8.95357199204
* device instance VDD_VCO_t27 r0 *1 0,0
RVDD_VCO_t27 VDD_VCO__t27 VDD_VCO 9.85203462025
* device instance VDD_VCO_t28 r0 *1 0,0
RVDD_VCO_t28 VDD_VCO__t28 VDD_VCO 8.05510950495
* device instance VDD_VCO_t29 r0 *1 0,0
RVDD_VCO_t29 VDD_VCO__t29 VDD_VCO 7.1566472121
* device instance VDD_VCO r0 *1 0,0
CVDD_VCO VDD_VCO vsubs 5.1667827e-14
* device instance XBIAS_VFIX_t0 r0 *1 0,0
RXBIAS_VFIX_t0 XBIAS.VFIX__t0 XBIAS.VFIX 17.6193464612
* device instance XBIAS_VFIX_t1 r0 *1 0,0
RXBIAS_VFIX_t1 XBIAS.VFIX__t1 XBIAS.VFIX 7.63820353877
* device instance XBIAS_VFIX_t2 r0 *1 0,0
RXBIAS_VFIX_t2 XBIAS.VFIX__t2 XBIAS.VFIX 12.628775
* device instance XBIAS_VFIX_t3 r0 *1 0,0
RXBIAS_VFIX_t3 XBIAS.VFIX__t3 XBIAS.VFIX 12.628775
* device instance XBIAS_VFIX r0 *1 0,0
CXBIAS_VFIX XBIAS.VFIX vsubs 1.1432231e-14
* device instance XBIAS_dega_t0 r0 *1 0,0
RXBIAS_dega_t0 XBIAS.dega__t0 XBIAS.dega 46.9209
* device instance XBIAS_dega_t1 r0 *1 0,0
RXBIAS_dega_t1 XBIAS.dega__t1 XBIAS.dega 46.9209
* device instance XBIAS_dega r0 *1 0,0
CXBIAS_dega XBIAS.dega vsubs 2.10574e-14
* device instance XBIAS_degb_t0 r0 *1 0,0
RXBIAS_degb_t0 XBIAS.degb__t0 XBIAS.degb 26.602951611
* device instance XBIAS_degb_t1 r0 *1 0,0
RXBIAS_degb_t1 XBIAS.degb__t1 XBIAS.degb 25.2355209047
* device instance XBIAS_degb_t2 r0 *1 0,0
RXBIAS_degb_t2 XBIAS.degb__t2 XBIAS.degb 9.88205970044
* device instance XBIAS_degb_t3 r0 *1 0,0
RXBIAS_degb_t3 XBIAS.degb__t3 XBIAS.degb 61.7202677838
* device instance XBIAS_degb r0 *1 0,0
CXBIAS_degb XBIAS.degb vsubs 2.7676545e-14
* device instance XBIAS_n2s_t0 r0 *1 0,0
RXBIAS_n2s_t0 XBIAS.n2s__t0 XBIAS.n2s 39.0076
* device instance XBIAS_n2s_t1 r0 *1 0,0
RXBIAS_n2s_t1 XBIAS.n2s__t1 XBIAS.n2s 39.0076
* device instance XBIAS_n2s r0 *1 0,0
CXBIAS_n2s XBIAS.n2s vsubs 1.7558271e-14
* device instance XBIAS_nb0_t0 r0 *1 0,0
RXBIAS_nb0_t0 XBIAS.nb0__t0 XBIAS.nb0 56.8532
* device instance XBIAS_nb0_t1 r0 *1 0,0
RXBIAS_nb0_t1 XBIAS.nb0__t1 XBIAS.nb0 56.8532
* device instance XBIAS_nb0 r0 *1 0,0
CXBIAS_nb0 XBIAS.nb0 vsubs 2.5445401e-14
* device instance XBIAS_nb1_t0 r0 *1 0,0
RXBIAS_nb1_t0 XBIAS.nb1__t0 XBIAS.nb1 50.8455
* device instance XBIAS_nb1_t1 r0 *1 0,0
RXBIAS_nb1_t1 XBIAS.nb1__t1 XBIAS.nb1 50.8455
* device instance XBIAS_nb1 r0 *1 0,0
CXBIAS_nb1 XBIAS.nb1 vsubs 2.2817765e-14
* device instance XBIAS_vb1_t0 r0 *1 0,0
RXBIAS_vb1_t0 XBIAS.vb1__t0 XBIAS.vb1 2.41305296132
* device instance XBIAS_vb1_t1 r0 *1 0,0
RXBIAS_vb1_t1 XBIAS.vb1__t1 XBIAS.vb1 12.36770945
* device instance XBIAS_vb1_t2 r0 *1 0,0
RXBIAS_vb1_t2 XBIAS.vb1__t2 XBIAS.vb1 12.36770945
* device instance XBIAS_vb1_t3 r0 *1 0,0
RXBIAS_vb1_t3 XBIAS.vb1__t3 XBIAS.vb1 14.5249311
* device instance XBIAS_vb1_t4 r0 *1 0,0
RXBIAS_vb1_t4 XBIAS.vb1__t4 XBIAS.vb1 36.8472970387
* device instance XBIAS_vb1 r0 *1 0,0
CXBIAS_vb1 XBIAS.vb1 vsubs 1.7828352e-14
* device instance XBIAS_vb2_t0 r0 *1 0,0
RXBIAS_vb2_t0 XBIAS.vb2__t0 XBIAS.vb2 50.7738171961
* device instance XBIAS_vb2_t1 r0 *1 0,0
RXBIAS_vb2_t1 XBIAS.vb2__t1 XBIAS.vb2 10.0883100271
* device instance XBIAS_vb2_t2 r0 *1 0,0
RXBIAS_vb2_t2 XBIAS.vb2__t2 XBIAS.vb2 10.0883100271
* device instance XBIAS_vb2_t3 r0 *1 0,0
RXBIAS_vb2_t3 XBIAS.vb2__t3 XBIAS.vb2 11.8697681867
* device instance XBIAS_vb2_t4 r0 *1 0,0
RXBIAS_vb2_t4 XBIAS.vb2__t4 XBIAS.vb2 42.464494563
* device instance XBIAS_vb2 r0 *1 0,0
CXBIAS_vb2 XBIAS.vb2 vsubs 2.8251938e-14
* device instance XBIAS_vfixmid_t0 r0 *1 0,0
RXBIAS_vfixmid_t0 XBIAS.vfixmid__t0 XBIAS.vfixmid 4.104775
* device instance XBIAS_vfixmid_t1 r0 *1 0,0
RXBIAS_vfixmid_t1 XBIAS.vfixmid__t1 XBIAS.vfixmid 4.104775
* device instance XBIAS_vfixmid_t2 r0 *1 0,0
RXBIAS_vfixmid_t2 XBIAS.vfixmid__t2 XBIAS.vfixmid 8.20955
* device instance XBIAS_vfixmid r0 *1 0,0
CXBIAS_vfixmid XBIAS.vfixmid vsubs 4.036878e-15
* device instance XS1_nh_t0 r0 *1 0,0
RXS1_nh_t0 XS1.nh__t0 XS1.nh 17.2324
* device instance XS1_nh_t1 r0 *1 0,0
RXS1_nh_t1 XS1.nh__t1 XS1.nh 17.2324
* device instance XS1_nh r0 *1 0,0
CXS1_nh XS1.nh vsubs 7.844171e-15
* device instance XS1_nt_t0 r0 *1 0,0
RXS1_nt_t0 XS1.nt__t0 XS1.nt 15.43855
* device instance XS1_nt_t1 r0 *1 0,0
RXS1_nt_t1 XS1.nt__t1 XS1.nt 15.43855
* device instance XS1_nt r0 *1 0,0
CXS1_nt XS1.nt vsubs 7.135042e-15
* device instance XS2_nh_t0 r0 *1 0,0
RXS2_nh_t0 XS2.nh__t0 XS2.nh 18.3176
* device instance XS2_nh_t1 r0 *1 0,0
RXS2_nh_t1 XS2.nh__t1 XS2.nh 18.3176
* device instance XS2_nh r0 *1 0,0
CXS2_nh XS2.nh vsubs 8.354016e-15
* device instance XS2_nt_t0 r0 *1 0,0
RXS2_nt_t0 XS2.nt__t0 XS2.nt 16.0838
* device instance XS2_nt_t1 r0 *1 0,0
RXS2_nt_t1 XS2.nt__t1 XS2.nt 16.0838
* device instance XS2_nt r0 *1 0,0
CXS2_nt XS2.nt vsubs 7.45015e-15
* device instance XS3_nh_t0 r0 *1 0,0
RXS3_nh_t0 XS3.nh__t0 XS3.nh 19.40285
* device instance XS3_nh_t1 r0 *1 0,0
RXS3_nh_t1 XS3.nh__t1 XS3.nh 19.40285
* device instance XS3_nh r0 *1 0,0
CXS3_nh XS3.nh vsubs 8.86386e-15
* device instance XS3_nt_t0 r0 *1 0,0
RXS3_nt_t0 XS3.nt__t0 XS3.nt 16.72905
* device instance XS3_nt_t1 r0 *1 0,0
RXS3_nt_t1 XS3.nt__t1 XS3.nt 16.72905
* device instance XS3_nt r0 *1 0,0
CXS3_nt XS3.nt vsubs 7.765258e-15
* device instance XS4_nh_t0 r0 *1 0,0
RXS4_nh_t0 XS4.nh__t0 XS4.nh 20.4881
* device instance XS4_nh_t1 r0 *1 0,0
RXS4_nh_t1 XS4.nh__t1 XS4.nh 20.4881
* device instance XS4_nh r0 *1 0,0
CXS4_nh XS4.nh vsubs 9.373705e-15
* device instance XS4_nt_t0 r0 *1 0,0
RXS4_nt_t0 XS4.nt__t0 XS4.nt 17.3743
* device instance XS4_nt_t1 r0 *1 0,0
RXS4_nt_t1 XS4.nt__t1 XS4.nt 17.3743
* device instance XS4_nt r0 *1 0,0
CXS4_nt XS4.nt vsubs 8.080366e-15
* device instance XS5_nh_t0 r0 *1 0,0
RXS5_nh_t0 XS5.nh__t0 XS5.nh 21.5734
* device instance XS5_nh_t1 r0 *1 0,0
RXS5_nh_t1 XS5.nh__t1 XS5.nh 21.5734
* device instance XS5_nh r0 *1 0,0
CXS5_nh XS5.nh vsubs 9.88355e-15
* device instance XS5_nt_t0 r0 *1 0,0
RXS5_nt_t0 XS5.nt__t0 XS5.nt 18.01955
* device instance XS5_nt_t1 r0 *1 0,0
RXS5_nt_t1 XS5.nt__t1 XS5.nt 18.01955
* device instance XS5_nt r0 *1 0,0
CXS5_nt XS5.nt vsubs 8.395474e-15
* device instance bufmid_t0 r0 *1 0,0
Rbufmid_t0 bufmid__t0 bufmid 21.6327867118
* device instance bufmid_t1 r0 *1 0,0
Rbufmid_t1 bufmid__t1 bufmid 24.3689132882
* device instance bufmid_t2 r0 *1 0,0
Rbufmid_t2 bufmid__t2 bufmid 23.6825939129
* device instance bufmid_t3 r0 *1 0,0
Rbufmid_t3 bufmid__t3 bufmid 22.3191060871
* device instance bufmid r0 *1 0,0
Cbufmid bufmid vsubs 2.1083728e-14
* device instance ring1_t0 r0 *1 0,0
Rring1_t0 ring1__t0 ring1 29.1028784408
* device instance ring1_t1 r0 *1 0,0
Rring1_t1 ring1__t1 ring1 10.6372439717
* device instance ring1_t2 r0 *1 0,0
Rring1_t2 ring1__t2 ring1 40.8550456679
* device instance ring1_t3 r0 *1 0,0
Rring1_t3 ring1__t3 ring1 12.3024524984
* device instance ring1_t4 r0 *1 0,0
Rring1_t4 ring1__t4 ring1 6.53644744523
* device instance ring1_t5 r0 *1 0,0
Rring1_t5 ring1__t5 ring1 28.155431976
* device instance ring1 r0 *1 0,0
Cring1 ring1 vsubs 2.9409734e-14
* device instance ring2_t0 r0 *1 0,0
Rring2_t0 ring2__t0 ring2 19.455774449
* device instance ring2_t1 r0 *1 0,0
Rring2_t1 ring2__t1 ring2 21.110775551
* device instance ring2_t2 r0 *1 0,0
Rring2_t2 ring2__t2 ring2 20.754094279
* device instance ring2_t3 r0 *1 0,0
Rring2_t3 ring2__t3 ring2 19.812455721
* device instance ring2 r0 *1 0,0
Cring2 ring2 vsubs 1.8778821e-14
* device instance ring3_t0 r0 *1 0,0
Rring3_t0 ring3__t0 ring3 19.8501740783
* device instance ring3_t1 r0 *1 0,0
Rring3_t1 ring3__t1 ring3 21.5083259217
* device instance ring3_t2 r0 *1 0,0
Rring3_t2 ring3__t2 ring3 21.1509656106
* device instance ring3_t3 r0 *1 0,0
Rring3_t3 ring3__t3 ring3 20.2075343894
* device instance ring3 r0 *1 0,0
Cring3 ring3 vsubs 1.9149581e-14
* device instance ring4_t0 r0 *1 0,0
Rring4_t0 ring4__t0 ring4 20.244627231
* device instance ring4_t1 r0 *1 0,0
Rring4_t1 ring4__t1 ring4 21.905822769
* device instance ring4_t2 r0 *1 0,0
Rring4_t2 ring4__t2 ring4 21.5478064892
* device instance ring4_t3 r0 *1 0,0
Rring4_t3 ring4__t3 ring4 20.6026435108
* device instance ring4 r0 *1 0,0
Cring4 ring4 vsubs 1.9520341e-14
* device instance ring5_t0 r0 *1 0,0
Rring5_t0 ring5__t0 ring5 24.3955893754
* device instance ring5_t1 r0 *1 0,0
Rring5_t1 ring5__t1 ring5 18.7256982191
* device instance ring5_t2 r0 *1 0,0
Rring5_t2 ring5__t2 ring5 25.9532517809
* device instance ring5_t3 r0 *1 0,0
Rring5_t3 ring5__t3 ring5 20.2833606246
* device instance ring5 r0 *1 0,0
Cring5 ring5 vsubs 2.067766e-14
* device instance cc_CLK_GND_VCO r0 *1 0,0
Ccc_CLK_GND_VCO CLK GND_VCO 2.3394e-17
* device instance cc_CLK_VBN r0 *1 0,0
Ccc_CLK_VBN CLK VBN 1.21e-17
* device instance cc_CLK_VBP r0 *1 0,0
Ccc_CLK_VBP CLK VBP 4.2352e-17
* device instance cc_CLK_VCTRL r0 *1 0,0
Ccc_CLK_VCTRL CLK VCTRL 6.05e-18
* device instance cc_CLK_VDD_VCO r0 *1 0,0
Ccc_CLK_VDD_VCO CLK VDD_VCO 8.9947e-17
* device instance cc_CLK_XBIAS_VFIX r0 *1 0,0
Ccc_CLK_XBIAS_VFIX CLK XBIAS.VFIX 1.21e-17
* device instance cc_CLK_XBIAS_dega r0 *1 0,0
Ccc_CLK_XBIAS_dega CLK XBIAS.dega 6.05e-18
* device instance cc_CLK_XBIAS_degb r0 *1 0,0
Ccc_CLK_XBIAS_degb CLK XBIAS.degb 6.05e-18
* device instance cc_CLK_XBIAS_n2s r0 *1 0,0
Ccc_CLK_XBIAS_n2s CLK XBIAS.n2s 6.05e-18
* device instance cc_CLK_XBIAS_vb1 r0 *1 0,0
Ccc_CLK_XBIAS_vb1 CLK XBIAS.vb1 2.4201e-17
* device instance cc_CLK_XBIAS_vb2 r0 *1 0,0
Ccc_CLK_XBIAS_vb2 CLK XBIAS.vb2 1.8151e-17
* device instance cc_CLK_XS1_nh r0 *1 0,0
Ccc_CLK_XS1_nh CLK XS1.nh 1.21e-17
* device instance cc_CLK_XS2_nh r0 *1 0,0
Ccc_CLK_XS2_nh CLK XS2.nh 1.21e-17
* device instance cc_CLK_XS3_nh r0 *1 0,0
Ccc_CLK_XS3_nh CLK XS3.nh 1.21e-17
* device instance cc_CLK_XS4_nh r0 *1 0,0
Ccc_CLK_XS4_nh CLK XS4.nh 1.21e-17
* device instance cc_CLK_XS5_nh r0 *1 0,0
Ccc_CLK_XS5_nh CLK XS5.nh 1.21e-17
* device instance cc_CLK_bufmid r0 *1 0,0
Ccc_CLK_bufmid CLK bufmid 1.21e-17
* device instance cc_CLK_ring1 r0 *1 0,0
Ccc_CLK_ring1 CLK ring1 1.8151e-17
* device instance cc_CLK_ring2 r0 *1 0,0
Ccc_CLK_ring2 CLK ring2 1.21e-17
* device instance cc_CLK_ring3 r0 *1 0,0
Ccc_CLK_ring3 CLK ring3 1.21e-17
* device instance cc_CLK_ring4 r0 *1 0,0
Ccc_CLK_ring4 CLK ring4 1.21e-17
* device instance cc_CLK_ring5 r0 *1 0,0
Ccc_CLK_ring5 CLK ring5 1.21e-17
* device instance cc_GND_VCO_VBN r0 *1 0,0
Ccc_GND_VCO_VBN GND_VCO VBN 5.3646e-17
* device instance cc_GND_VCO_VBP r0 *1 0,0
Ccc_GND_VCO_VBP GND_VCO VBP 6.0502e-17
* device instance cc_GND_VCO_VCTRL r0 *1 0,0
Ccc_GND_VCO_VCTRL GND_VCO VCTRL 6.05e-18
* device instance cc_GND_VCO_VDD_VCO r0 *1 0,0
Ccc_GND_VCO_VDD_VCO GND_VCO VDD_VCO 1.08905e-16
* device instance cc_GND_VCO_XBIAS_VFIX r0 *1 0,0
Ccc_GND_VCO_XBIAS_VFIX GND_VCO XBIAS.VFIX 2.4201e-17
* device instance cc_GND_VCO_XBIAS_dega r0 *1 0,0
Ccc_GND_VCO_XBIAS_dega GND_VCO XBIAS.dega 1.21e-17
* device instance cc_GND_VCO_XBIAS_degb r0 *1 0,0
Ccc_GND_VCO_XBIAS_degb GND_VCO XBIAS.degb 2.4201e-17
* device instance cc_GND_VCO_XBIAS_n2s r0 *1 0,0
Ccc_GND_VCO_XBIAS_n2s GND_VCO XBIAS.n2s 1.21e-17
* device instance cc_GND_VCO_XBIAS_nb0 r0 *1 0,0
Ccc_GND_VCO_XBIAS_nb0 GND_VCO XBIAS.nb0 1.21e-17
* device instance cc_GND_VCO_XBIAS_nb1 r0 *1 0,0
Ccc_GND_VCO_XBIAS_nb1 GND_VCO XBIAS.nb1 1.21e-17
* device instance cc_GND_VCO_XBIAS_vb1 r0 *1 0,0
Ccc_GND_VCO_XBIAS_vb1 GND_VCO XBIAS.vb1 3.5495e-17
* device instance cc_GND_VCO_XBIAS_vb2 r0 *1 0,0
Ccc_GND_VCO_XBIAS_vb2 GND_VCO XBIAS.vb2 3.0251e-17
* device instance cc_GND_VCO_XBIAS_vfixmid r0 *1 0,0
Ccc_GND_VCO_XBIAS_vfixmid GND_VCO XBIAS.vfixmid 2.3394e-17
* device instance cc_GND_VCO_XS1_nh r0 *1 0,0
Ccc_GND_VCO_XS1_nh GND_VCO XS1.nh 1.21e-17
* device instance cc_GND_VCO_XS1_nt r0 *1 0,0
Ccc_GND_VCO_XS1_nt GND_VCO XS1.nt 1.7344e-17
* device instance cc_GND_VCO_XS2_nh r0 *1 0,0
Ccc_GND_VCO_XS2_nh GND_VCO XS2.nh 1.21e-17
* device instance cc_GND_VCO_XS2_nt r0 *1 0,0
Ccc_GND_VCO_XS2_nt GND_VCO XS2.nt 1.7344e-17
* device instance cc_GND_VCO_XS3_nh r0 *1 0,0
Ccc_GND_VCO_XS3_nh GND_VCO XS3.nh 1.21e-17
* device instance cc_GND_VCO_XS3_nt r0 *1 0,0
Ccc_GND_VCO_XS3_nt GND_VCO XS3.nt 1.7344e-17
* device instance cc_GND_VCO_XS4_nh r0 *1 0,0
Ccc_GND_VCO_XS4_nh GND_VCO XS4.nh 1.21e-17
* device instance cc_GND_VCO_XS4_nt r0 *1 0,0
Ccc_GND_VCO_XS4_nt GND_VCO XS4.nt 1.7344e-17
* device instance cc_GND_VCO_XS5_nh r0 *1 0,0
Ccc_GND_VCO_XS5_nh GND_VCO XS5.nh 1.21e-17
* device instance cc_GND_VCO_XS5_nt r0 *1 0,0
Ccc_GND_VCO_XS5_nt GND_VCO XS5.nt 1.7344e-17
* device instance cc_GND_VCO_bufmid r0 *1 0,0
Ccc_GND_VCO_bufmid GND_VCO bufmid 2.9445e-17
* device instance cc_GND_VCO_ring1 r0 *1 0,0
Ccc_GND_VCO_ring1 GND_VCO ring1 3.6302e-17
* device instance cc_GND_VCO_ring2 r0 *1 0,0
Ccc_GND_VCO_ring2 GND_VCO ring2 2.4201e-17
* device instance cc_GND_VCO_ring3 r0 *1 0,0
Ccc_GND_VCO_ring3 GND_VCO ring3 2.4201e-17
* device instance cc_GND_VCO_ring4 r0 *1 0,0
Ccc_GND_VCO_ring4 GND_VCO ring4 2.4201e-17
* device instance cc_GND_VCO_ring5 r0 *1 0,0
Ccc_GND_VCO_ring5 GND_VCO ring5 2.4201e-17
* device instance cc_VBN_VBP r0 *1 0,0
Ccc_VBN_VBP VBN VBP 6.0502e-17
* device instance cc_VBN_VCTRL r0 *1 0,0
Ccc_VBN_VCTRL VBN VCTRL 6.05e-18
* device instance cc_VBN_VDD_VCO r0 *1 0,0
Ccc_VBN_VDD_VCO VBN VDD_VCO 1.08098e-16
* device instance cc_VBN_XBIAS_VFIX r0 *1 0,0
Ccc_VBN_XBIAS_VFIX VBN XBIAS.VFIX 1.21e-17
* device instance cc_VBN_XBIAS_dega r0 *1 0,0
Ccc_VBN_XBIAS_dega VBN XBIAS.dega 6.05e-18
* device instance cc_VBN_XBIAS_degb r0 *1 0,0
Ccc_VBN_XBIAS_degb VBN XBIAS.degb 6.05e-18
* device instance cc_VBN_XBIAS_n2s r0 *1 0,0
Ccc_VBN_XBIAS_n2s VBN XBIAS.n2s 6.05e-18
* device instance cc_VBN_XBIAS_vb1 r0 *1 0,0
Ccc_VBN_XBIAS_vb1 VBN XBIAS.vb1 2.4201e-17
* device instance cc_VBN_XBIAS_vb2 r0 *1 0,0
Ccc_VBN_XBIAS_vb2 VBN XBIAS.vb2 1.8151e-17
* device instance cc_VBN_XS1_nh r0 *1 0,0
Ccc_VBN_XS1_nh VBN XS1.nh 1.21e-17
* device instance cc_VBN_XS1_nt r0 *1 0,0
Ccc_VBN_XS1_nt VBN XS1.nt 6.05e-18
* device instance cc_VBN_XS2_nh r0 *1 0,0
Ccc_VBN_XS2_nh VBN XS2.nh 1.21e-17
* device instance cc_VBN_XS2_nt r0 *1 0,0
Ccc_VBN_XS2_nt VBN XS2.nt 6.05e-18
* device instance cc_VBN_XS3_nh r0 *1 0,0
Ccc_VBN_XS3_nh VBN XS3.nh 1.21e-17
* device instance cc_VBN_XS3_nt r0 *1 0,0
Ccc_VBN_XS3_nt VBN XS3.nt 6.05e-18
* device instance cc_VBN_XS4_nh r0 *1 0,0
Ccc_VBN_XS4_nh VBN XS4.nh 1.21e-17
* device instance cc_VBN_XS4_nt r0 *1 0,0
Ccc_VBN_XS4_nt VBN XS4.nt 6.05e-18
* device instance cc_VBN_XS5_nh r0 *1 0,0
Ccc_VBN_XS5_nh VBN XS5.nh 1.21e-17
* device instance cc_VBN_XS5_nt r0 *1 0,0
Ccc_VBN_XS5_nt VBN XS5.nt 6.05e-18
* device instance cc_VBN_bufmid r0 *1 0,0
Ccc_VBN_bufmid VBN bufmid 2.4201e-17
* device instance cc_VBN_ring1 r0 *1 0,0
Ccc_VBN_ring1 VBN ring1 2.4201e-17
* device instance cc_VBN_ring2 r0 *1 0,0
Ccc_VBN_ring2 VBN ring2 1.21e-17
* device instance cc_VBN_ring3 r0 *1 0,0
Ccc_VBN_ring3 VBN ring3 1.21e-17
* device instance cc_VBN_ring4 r0 *1 0,0
Ccc_VBN_ring4 VBN ring4 1.21e-17
* device instance cc_VBN_ring5 r0 *1 0,0
Ccc_VBN_ring5 VBN ring5 1.21e-17
* device instance cc_VBP_VCTRL r0 *1 0,0
Ccc_VBP_VCTRL VBP VCTRL 6.05e-18
* device instance cc_VBP_VDD_VCO r0 *1 0,0
Ccc_VBP_VDD_VCO VBP VDD_VCO 1.02048e-16
* device instance cc_VBP_XBIAS_VFIX r0 *1 0,0
Ccc_VBP_XBIAS_VFIX VBP XBIAS.VFIX 6.05e-18
* device instance cc_VBP_XBIAS_dega r0 *1 0,0
Ccc_VBP_XBIAS_dega VBP XBIAS.dega 5.244e-18
* device instance cc_VBP_XBIAS_degb r0 *1 0,0
Ccc_VBP_XBIAS_degb VBP XBIAS.degb 1.1294e-17
* device instance cc_VBP_XBIAS_n2s r0 *1 0,0
Ccc_VBP_XBIAS_n2s VBP XBIAS.n2s 6.05e-18
* device instance cc_VBP_XBIAS_vb1 r0 *1 0,0
Ccc_VBP_XBIAS_vb1 VBP XBIAS.vb1 2.4201e-17
* device instance cc_VBP_XBIAS_vb2 r0 *1 0,0
Ccc_VBP_XBIAS_vb2 VBP XBIAS.vb2 1.8151e-17
* device instance cc_VBP_XS1_nh r0 *1 0,0
Ccc_VBP_XS1_nh VBP XS1.nh 1.21e-17
* device instance cc_VBP_XS2_nh r0 *1 0,0
Ccc_VBP_XS2_nh VBP XS2.nh 1.21e-17
* device instance cc_VBP_XS3_nh r0 *1 0,0
Ccc_VBP_XS3_nh VBP XS3.nh 1.21e-17
* device instance cc_VBP_XS4_nh r0 *1 0,0
Ccc_VBP_XS4_nh VBP XS4.nh 1.21e-17
* device instance cc_VBP_XS5_nh r0 *1 0,0
Ccc_VBP_XS5_nh VBP XS5.nh 1.21e-17
* device instance cc_VBP_bufmid r0 *1 0,0
Ccc_VBP_bufmid VBP bufmid 1.21e-17
* device instance cc_VBP_ring1 r0 *1 0,0
Ccc_VBP_ring1 VBP ring1 1.8151e-17
* device instance cc_VBP_ring2 r0 *1 0,0
Ccc_VBP_ring2 VBP ring2 1.21e-17
* device instance cc_VBP_ring3 r0 *1 0,0
Ccc_VBP_ring3 VBP ring3 1.21e-17
* device instance cc_VBP_ring4 r0 *1 0,0
Ccc_VBP_ring4 VBP ring4 1.21e-17
* device instance cc_VBP_ring5 r0 *1 0,0
Ccc_VBP_ring5 VBP ring5 1.21e-17
* device instance cc_VDD_VCO_XBIAS_VFIX r0 *1 0,0
Ccc_VDD_VCO_XBIAS_VFIX VDD_VCO XBIAS.VFIX 1.1294e-17
* device instance cc_VDD_VCO_XBIAS_vb1 r0 *1 0,0
Ccc_VDD_VCO_XBIAS_vb1 VDD_VCO XBIAS.vb1 2.9445e-17
* device instance cc_VDD_VCO_XBIAS_vb2 r0 *1 0,0
Ccc_VDD_VCO_XBIAS_vb2 VDD_VCO XBIAS.vb2 1.1294e-17
* device instance cc_VDD_VCO_XS1_nh r0 *1 0,0
Ccc_VDD_VCO_XS1_nh VDD_VCO XS1.nh 1.7344e-17
* device instance cc_VDD_VCO_XS2_nh r0 *1 0,0
Ccc_VDD_VCO_XS2_nh VDD_VCO XS2.nh 1.7344e-17
* device instance cc_VDD_VCO_XS3_nh r0 *1 0,0
Ccc_VDD_VCO_XS3_nh VDD_VCO XS3.nh 1.7344e-17
* device instance cc_VDD_VCO_XS4_nh r0 *1 0,0
Ccc_VDD_VCO_XS4_nh VDD_VCO XS4.nh 1.7344e-17
* device instance cc_VDD_VCO_XS5_nh r0 *1 0,0
Ccc_VDD_VCO_XS5_nh VDD_VCO XS5.nh 1.7344e-17
* device instance cc_VDD_VCO_bufmid r0 *1 0,0
Ccc_VDD_VCO_bufmid VDD_VCO bufmid 1.7344e-17
* device instance cc_VDD_VCO_ring1 r0 *1 0,0
Ccc_VDD_VCO_ring1 VDD_VCO ring1 1.8151e-17
* device instance cc_VDD_VCO_ring2 r0 *1 0,0
Ccc_VDD_VCO_ring2 VDD_VCO ring2 1.21e-17
* device instance cc_VDD_VCO_ring3 r0 *1 0,0
Ccc_VDD_VCO_ring3 VDD_VCO ring3 1.21e-17
* device instance cc_VDD_VCO_ring4 r0 *1 0,0
Ccc_VDD_VCO_ring4 VDD_VCO ring4 1.21e-17
* device instance cc_VDD_VCO_ring5 r0 *1 0,0
Ccc_VDD_VCO_ring5 VDD_VCO ring5 1.21e-17
* device instance cc_XBIAS_VFIX_XBIAS_dega r0 *1 0,0
Ccc_XBIAS_VFIX_XBIAS_dega XBIAS.VFIX XBIAS.dega 6.05e-18
* device instance cc_XBIAS_VFIX_XBIAS_degb r0 *1 0,0
Ccc_XBIAS_VFIX_XBIAS_degb XBIAS.VFIX XBIAS.degb 1.8151e-17
* device instance cc_XBIAS_VFIX_XBIAS_n2s r0 *1 0,0
Ccc_XBIAS_VFIX_XBIAS_n2s XBIAS.VFIX XBIAS.n2s 6.05e-18
* device instance cc_XBIAS_VFIX_XBIAS_nb0 r0 *1 0,0
Ccc_XBIAS_VFIX_XBIAS_nb0 XBIAS.VFIX XBIAS.nb0 6.05e-18
* device instance cc_XBIAS_VFIX_XBIAS_nb1 r0 *1 0,0
Ccc_XBIAS_VFIX_XBIAS_nb1 XBIAS.VFIX XBIAS.nb1 6.05e-18
* device instance cc_XBIAS_VFIX_XBIAS_vb1 r0 *1 0,0
Ccc_XBIAS_VFIX_XBIAS_vb1 XBIAS.VFIX XBIAS.vb1 6.05e-18
* device instance cc_XBIAS_VFIX_XBIAS_vb2 r0 *1 0,0
Ccc_XBIAS_VFIX_XBIAS_vb2 XBIAS.VFIX XBIAS.vb2 1.21e-17
* device instance cc_XBIAS_VFIX_XBIAS_vfixmid r0 *1 0,0
Ccc_XBIAS_VFIX_XBIAS_vfixmid XBIAS.VFIX XBIAS.vfixmid 2.3394e-17
* device instance cc_XBIAS_VFIX_XS1_nt r0 *1 0,0
Ccc_XBIAS_VFIX_XS1_nt XBIAS.VFIX XS1.nt 6.05e-18
* device instance cc_XBIAS_VFIX_XS2_nt r0 *1 0,0
Ccc_XBIAS_VFIX_XS2_nt XBIAS.VFIX XS2.nt 6.05e-18
* device instance cc_XBIAS_VFIX_XS3_nt r0 *1 0,0
Ccc_XBIAS_VFIX_XS3_nt XBIAS.VFIX XS3.nt 6.05e-18
* device instance cc_XBIAS_VFIX_XS4_nt r0 *1 0,0
Ccc_XBIAS_VFIX_XS4_nt XBIAS.VFIX XS4.nt 6.05e-18
* device instance cc_XBIAS_VFIX_XS5_nt r0 *1 0,0
Ccc_XBIAS_VFIX_XS5_nt XBIAS.VFIX XS5.nt 6.05e-18
* device instance cc_XBIAS_VFIX_bufmid r0 *1 0,0
Ccc_XBIAS_VFIX_bufmid XBIAS.VFIX bufmid 1.21e-17
* device instance cc_XBIAS_VFIX_ring1 r0 *1 0,0
Ccc_XBIAS_VFIX_ring1 XBIAS.VFIX ring1 6.05e-18
* device instance cc_XBIAS_dega_XBIAS_degb r0 *1 0,0
Ccc_XBIAS_dega_XBIAS_degb XBIAS.dega XBIAS.degb 6.05e-18
* device instance cc_XBIAS_dega_XBIAS_n2s r0 *1 0,0
Ccc_XBIAS_dega_XBIAS_n2s XBIAS.dega XBIAS.n2s 1.21e-17
* device instance cc_XBIAS_dega_XBIAS_nb1 r0 *1 0,0
Ccc_XBIAS_dega_XBIAS_nb1 XBIAS.dega XBIAS.nb1 6.05e-18
* device instance cc_XBIAS_dega_XBIAS_vb1 r0 *1 0,0
Ccc_XBIAS_dega_XBIAS_vb1 XBIAS.dega XBIAS.vb1 2.4201e-17
* device instance cc_XBIAS_dega_XBIAS_vb2 r0 *1 0,0
Ccc_XBIAS_dega_XBIAS_vb2 XBIAS.dega XBIAS.vb2 2.4201e-17
* device instance cc_XBIAS_dega_XS1_nh r0 *1 0,0
Ccc_XBIAS_dega_XS1_nh XBIAS.dega XS1.nh 1.21e-17
* device instance cc_XBIAS_dega_XS2_nh r0 *1 0,0
Ccc_XBIAS_dega_XS2_nh XBIAS.dega XS2.nh 1.21e-17
* device instance cc_XBIAS_dega_XS3_nh r0 *1 0,0
Ccc_XBIAS_dega_XS3_nh XBIAS.dega XS3.nh 1.21e-17
* device instance cc_XBIAS_dega_XS4_nh r0 *1 0,0
Ccc_XBIAS_dega_XS4_nh XBIAS.dega XS4.nh 1.21e-17
* device instance cc_XBIAS_dega_XS5_nh r0 *1 0,0
Ccc_XBIAS_dega_XS5_nh XBIAS.dega XS5.nh 1.21e-17
* device instance cc_XBIAS_dega_bufmid r0 *1 0,0
Ccc_XBIAS_dega_bufmid XBIAS.dega bufmid 1.21e-17
* device instance cc_XBIAS_dega_ring1 r0 *1 0,0
Ccc_XBIAS_dega_ring1 XBIAS.dega ring1 1.8151e-17
* device instance cc_XBIAS_dega_ring2 r0 *1 0,0
Ccc_XBIAS_dega_ring2 XBIAS.dega ring2 1.21e-17
* device instance cc_XBIAS_dega_ring3 r0 *1 0,0
Ccc_XBIAS_dega_ring3 XBIAS.dega ring3 1.21e-17
* device instance cc_XBIAS_dega_ring4 r0 *1 0,0
Ccc_XBIAS_dega_ring4 XBIAS.dega ring4 1.21e-17
* device instance cc_XBIAS_dega_ring5 r0 *1 0,0
Ccc_XBIAS_dega_ring5 XBIAS.dega ring5 1.21e-17
* device instance cc_XBIAS_degb_XBIAS_n2s r0 *1 0,0
Ccc_XBIAS_degb_XBIAS_n2s XBIAS.degb XBIAS.n2s 1.21e-17
* device instance cc_XBIAS_degb_XBIAS_nb0 r0 *1 0,0
Ccc_XBIAS_degb_XBIAS_nb0 XBIAS.degb XBIAS.nb0 5.244e-18
* device instance cc_XBIAS_degb_XBIAS_nb1 r0 *1 0,0
Ccc_XBIAS_degb_XBIAS_nb1 XBIAS.degb XBIAS.nb1 1.7344e-17
* device instance cc_XBIAS_degb_XBIAS_vb1 r0 *1 0,0
Ccc_XBIAS_degb_XBIAS_vb1 XBIAS.degb XBIAS.vb1 2.4201e-17
* device instance cc_XBIAS_degb_XBIAS_vb2 r0 *1 0,0
Ccc_XBIAS_degb_XBIAS_vb2 XBIAS.degb XBIAS.vb2 2.4201e-17
* device instance cc_XBIAS_degb_XS1_nh r0 *1 0,0
Ccc_XBIAS_degb_XS1_nh XBIAS.degb XS1.nh 1.21e-17
* device instance cc_XBIAS_degb_XS1_nt r0 *1 0,0
Ccc_XBIAS_degb_XS1_nt XBIAS.degb XS1.nt 6.05e-18
* device instance cc_XBIAS_degb_XS2_nh r0 *1 0,0
Ccc_XBIAS_degb_XS2_nh XBIAS.degb XS2.nh 1.21e-17
* device instance cc_XBIAS_degb_XS2_nt r0 *1 0,0
Ccc_XBIAS_degb_XS2_nt XBIAS.degb XS2.nt 6.05e-18
* device instance cc_XBIAS_degb_XS3_nh r0 *1 0,0
Ccc_XBIAS_degb_XS3_nh XBIAS.degb XS3.nh 1.21e-17
* device instance cc_XBIAS_degb_XS3_nt r0 *1 0,0
Ccc_XBIAS_degb_XS3_nt XBIAS.degb XS3.nt 6.05e-18
* device instance cc_XBIAS_degb_XS4_nh r0 *1 0,0
Ccc_XBIAS_degb_XS4_nh XBIAS.degb XS4.nh 1.21e-17
* device instance cc_XBIAS_degb_XS4_nt r0 *1 0,0
Ccc_XBIAS_degb_XS4_nt XBIAS.degb XS4.nt 6.05e-18
* device instance cc_XBIAS_degb_XS5_nh r0 *1 0,0
Ccc_XBIAS_degb_XS5_nh XBIAS.degb XS5.nh 1.21e-17
* device instance cc_XBIAS_degb_XS5_nt r0 *1 0,0
Ccc_XBIAS_degb_XS5_nt XBIAS.degb XS5.nt 6.05e-18
* device instance cc_XBIAS_degb_bufmid r0 *1 0,0
Ccc_XBIAS_degb_bufmid XBIAS.degb bufmid 2.4201e-17
* device instance cc_XBIAS_degb_ring1 r0 *1 0,0
Ccc_XBIAS_degb_ring1 XBIAS.degb ring1 2.4201e-17
* device instance cc_XBIAS_degb_ring2 r0 *1 0,0
Ccc_XBIAS_degb_ring2 XBIAS.degb ring2 1.21e-17
* device instance cc_XBIAS_degb_ring3 r0 *1 0,0
Ccc_XBIAS_degb_ring3 XBIAS.degb ring3 1.21e-17
* device instance cc_XBIAS_degb_ring4 r0 *1 0,0
Ccc_XBIAS_degb_ring4 XBIAS.degb ring4 1.21e-17
* device instance cc_XBIAS_degb_ring5 r0 *1 0,0
Ccc_XBIAS_degb_ring5 XBIAS.degb ring5 1.21e-17
* device instance cc_XBIAS_n2s_XBIAS_vb1 r0 *1 0,0
Ccc_XBIAS_n2s_XBIAS_vb1 XBIAS.n2s XBIAS.vb1 2.4201e-17
* device instance cc_XBIAS_n2s_XBIAS_vb2 r0 *1 0,0
Ccc_XBIAS_n2s_XBIAS_vb2 XBIAS.n2s XBIAS.vb2 2.3394e-17
* device instance cc_XBIAS_n2s_XS1_nh r0 *1 0,0
Ccc_XBIAS_n2s_XS1_nh XBIAS.n2s XS1.nh 1.21e-17
* device instance cc_XBIAS_n2s_XS2_nh r0 *1 0,0
Ccc_XBIAS_n2s_XS2_nh XBIAS.n2s XS2.nh 1.21e-17
* device instance cc_XBIAS_n2s_XS3_nh r0 *1 0,0
Ccc_XBIAS_n2s_XS3_nh XBIAS.n2s XS3.nh 1.21e-17
* device instance cc_XBIAS_n2s_XS4_nh r0 *1 0,0
Ccc_XBIAS_n2s_XS4_nh XBIAS.n2s XS4.nh 1.21e-17
* device instance cc_XBIAS_n2s_XS5_nh r0 *1 0,0
Ccc_XBIAS_n2s_XS5_nh XBIAS.n2s XS5.nh 1.21e-17
* device instance cc_XBIAS_n2s_bufmid r0 *1 0,0
Ccc_XBIAS_n2s_bufmid XBIAS.n2s bufmid 1.21e-17
* device instance cc_XBIAS_n2s_ring1 r0 *1 0,0
Ccc_XBIAS_n2s_ring1 XBIAS.n2s ring1 1.8151e-17
* device instance cc_XBIAS_n2s_ring2 r0 *1 0,0
Ccc_XBIAS_n2s_ring2 XBIAS.n2s ring2 1.21e-17
* device instance cc_XBIAS_n2s_ring3 r0 *1 0,0
Ccc_XBIAS_n2s_ring3 XBIAS.n2s ring3 1.21e-17
* device instance cc_XBIAS_n2s_ring4 r0 *1 0,0
Ccc_XBIAS_n2s_ring4 XBIAS.n2s ring4 1.21e-17
* device instance cc_XBIAS_n2s_ring5 r0 *1 0,0
Ccc_XBIAS_n2s_ring5 XBIAS.n2s ring5 1.21e-17
* device instance cc_XBIAS_nb0_XBIAS_nb1 r0 *1 0,0
Ccc_XBIAS_nb0_XBIAS_nb1 XBIAS.nb0 XBIAS.nb1 1.21e-17
* device instance cc_XBIAS_nb0_XBIAS_vb1 r0 *1 0,0
Ccc_XBIAS_nb0_XBIAS_vb1 XBIAS.nb0 XBIAS.vb1 2.4201e-17
* device instance cc_XBIAS_nb0_XBIAS_vb2 r0 *1 0,0
Ccc_XBIAS_nb0_XBIAS_vb2 XBIAS.nb0 XBIAS.vb2 2.4201e-17
* device instance cc_XBIAS_nb0_XS1_nh r0 *1 0,0
Ccc_XBIAS_nb0_XS1_nh XBIAS.nb0 XS1.nh 1.21e-17
* device instance cc_XBIAS_nb0_XS1_nt r0 *1 0,0
Ccc_XBIAS_nb0_XS1_nt XBIAS.nb0 XS1.nt 6.05e-18
* device instance cc_XBIAS_nb0_XS2_nh r0 *1 0,0
Ccc_XBIAS_nb0_XS2_nh XBIAS.nb0 XS2.nh 1.21e-17
* device instance cc_XBIAS_nb0_XS2_nt r0 *1 0,0
Ccc_XBIAS_nb0_XS2_nt XBIAS.nb0 XS2.nt 6.05e-18
* device instance cc_XBIAS_nb0_XS3_nh r0 *1 0,0
Ccc_XBIAS_nb0_XS3_nh XBIAS.nb0 XS3.nh 1.21e-17
* device instance cc_XBIAS_nb0_XS3_nt r0 *1 0,0
Ccc_XBIAS_nb0_XS3_nt XBIAS.nb0 XS3.nt 6.05e-18
* device instance cc_XBIAS_nb0_XS4_nh r0 *1 0,0
Ccc_XBIAS_nb0_XS4_nh XBIAS.nb0 XS4.nh 1.21e-17
* device instance cc_XBIAS_nb0_XS4_nt r0 *1 0,0
Ccc_XBIAS_nb0_XS4_nt XBIAS.nb0 XS4.nt 6.05e-18
* device instance cc_XBIAS_nb0_XS5_nh r0 *1 0,0
Ccc_XBIAS_nb0_XS5_nh XBIAS.nb0 XS5.nh 1.21e-17
* device instance cc_XBIAS_nb0_XS5_nt r0 *1 0,0
Ccc_XBIAS_nb0_XS5_nt XBIAS.nb0 XS5.nt 6.05e-18
* device instance cc_XBIAS_nb0_bufmid r0 *1 0,0
Ccc_XBIAS_nb0_bufmid XBIAS.nb0 bufmid 2.4201e-17
* device instance cc_XBIAS_nb0_ring1 r0 *1 0,0
Ccc_XBIAS_nb0_ring1 XBIAS.nb0 ring1 2.4201e-17
* device instance cc_XBIAS_nb0_ring2 r0 *1 0,0
Ccc_XBIAS_nb0_ring2 XBIAS.nb0 ring2 1.21e-17
* device instance cc_XBIAS_nb0_ring3 r0 *1 0,0
Ccc_XBIAS_nb0_ring3 XBIAS.nb0 ring3 1.21e-17
* device instance cc_XBIAS_nb0_ring4 r0 *1 0,0
Ccc_XBIAS_nb0_ring4 XBIAS.nb0 ring4 1.21e-17
* device instance cc_XBIAS_nb0_ring5 r0 *1 0,0
Ccc_XBIAS_nb0_ring5 XBIAS.nb0 ring5 1.21e-17
* device instance cc_XBIAS_nb1_XBIAS_vb1 r0 *1 0,0
Ccc_XBIAS_nb1_XBIAS_vb1 XBIAS.nb1 XBIAS.vb1 2.4201e-17
* device instance cc_XBIAS_nb1_XBIAS_vb2 r0 *1 0,0
Ccc_XBIAS_nb1_XBIAS_vb2 XBIAS.nb1 XBIAS.vb2 2.4201e-17
* device instance cc_XBIAS_nb1_XS1_nh r0 *1 0,0
Ccc_XBIAS_nb1_XS1_nh XBIAS.nb1 XS1.nh 1.21e-17
* device instance cc_XBIAS_nb1_XS1_nt r0 *1 0,0
Ccc_XBIAS_nb1_XS1_nt XBIAS.nb1 XS1.nt 6.05e-18
* device instance cc_XBIAS_nb1_XS2_nh r0 *1 0,0
Ccc_XBIAS_nb1_XS2_nh XBIAS.nb1 XS2.nh 1.21e-17
* device instance cc_XBIAS_nb1_XS2_nt r0 *1 0,0
Ccc_XBIAS_nb1_XS2_nt XBIAS.nb1 XS2.nt 6.05e-18
* device instance cc_XBIAS_nb1_XS3_nh r0 *1 0,0
Ccc_XBIAS_nb1_XS3_nh XBIAS.nb1 XS3.nh 1.21e-17
* device instance cc_XBIAS_nb1_XS3_nt r0 *1 0,0
Ccc_XBIAS_nb1_XS3_nt XBIAS.nb1 XS3.nt 6.05e-18
* device instance cc_XBIAS_nb1_XS4_nh r0 *1 0,0
Ccc_XBIAS_nb1_XS4_nh XBIAS.nb1 XS4.nh 1.21e-17
* device instance cc_XBIAS_nb1_XS4_nt r0 *1 0,0
Ccc_XBIAS_nb1_XS4_nt XBIAS.nb1 XS4.nt 6.05e-18
* device instance cc_XBIAS_nb1_XS5_nh r0 *1 0,0
Ccc_XBIAS_nb1_XS5_nh XBIAS.nb1 XS5.nh 1.21e-17
* device instance cc_XBIAS_nb1_XS5_nt r0 *1 0,0
Ccc_XBIAS_nb1_XS5_nt XBIAS.nb1 XS5.nt 6.05e-18
* device instance cc_XBIAS_nb1_bufmid r0 *1 0,0
Ccc_XBIAS_nb1_bufmid XBIAS.nb1 bufmid 2.4201e-17
* device instance cc_XBIAS_nb1_ring1 r0 *1 0,0
Ccc_XBIAS_nb1_ring1 XBIAS.nb1 ring1 2.4201e-17
* device instance cc_XBIAS_nb1_ring2 r0 *1 0,0
Ccc_XBIAS_nb1_ring2 XBIAS.nb1 ring2 1.21e-17
* device instance cc_XBIAS_nb1_ring3 r0 *1 0,0
Ccc_XBIAS_nb1_ring3 XBIAS.nb1 ring3 1.21e-17
* device instance cc_XBIAS_nb1_ring4 r0 *1 0,0
Ccc_XBIAS_nb1_ring4 XBIAS.nb1 ring4 1.21e-17
* device instance cc_XBIAS_nb1_ring5 r0 *1 0,0
Ccc_XBIAS_nb1_ring5 XBIAS.nb1 ring5 1.21e-17
* device instance cc_XBIAS_vb1_XBIAS_vb2 r0 *1 0,0
Ccc_XBIAS_vb1_XBIAS_vb2 XBIAS.vb1 XBIAS.vb2 1.21e-17
* device instance cc_XBIAS_vb1_XBIAS_vfixmid r0 *1 0,0
Ccc_XBIAS_vb1_XBIAS_vfixmid XBIAS.vb1 XBIAS.vfixmid 1.8151e-17
* device instance cc_XBIAS_vb1_XS1_nh r0 *1 0,0
Ccc_XBIAS_vb1_XS1_nh XBIAS.vb1 XS1.nh 6.05e-18
* device instance cc_XBIAS_vb1_XS1_nt r0 *1 0,0
Ccc_XBIAS_vb1_XS1_nt XBIAS.vb1 XS1.nt 6.05e-18
* device instance cc_XBIAS_vb1_XS2_nh r0 *1 0,0
Ccc_XBIAS_vb1_XS2_nh XBIAS.vb1 XS2.nh 6.05e-18
* device instance cc_XBIAS_vb1_XS2_nt r0 *1 0,0
Ccc_XBIAS_vb1_XS2_nt XBIAS.vb1 XS2.nt 6.05e-18
* device instance cc_XBIAS_vb1_XS3_nh r0 *1 0,0
Ccc_XBIAS_vb1_XS3_nh XBIAS.vb1 XS3.nh 6.05e-18
* device instance cc_XBIAS_vb1_XS3_nt r0 *1 0,0
Ccc_XBIAS_vb1_XS3_nt XBIAS.vb1 XS3.nt 6.05e-18
* device instance cc_XBIAS_vb1_XS4_nh r0 *1 0,0
Ccc_XBIAS_vb1_XS4_nh XBIAS.vb1 XS4.nh 6.05e-18
* device instance cc_XBIAS_vb1_XS4_nt r0 *1 0,0
Ccc_XBIAS_vb1_XS4_nt XBIAS.vb1 XS4.nt 6.05e-18
* device instance cc_XBIAS_vb1_XS5_nh r0 *1 0,0
Ccc_XBIAS_vb1_XS5_nh XBIAS.vb1 XS5.nh 6.05e-18
* device instance cc_XBIAS_vb1_XS5_nt r0 *1 0,0
Ccc_XBIAS_vb1_XS5_nt XBIAS.vb1 XS5.nt 6.05e-18
* device instance cc_XBIAS_vb1_bufmid r0 *1 0,0
Ccc_XBIAS_vb1_bufmid XBIAS.vb1 bufmid 1.21e-17
* device instance cc_XBIAS_vb1_ring1 r0 *1 0,0
Ccc_XBIAS_vb1_ring1 XBIAS.vb1 ring1 1.8151e-17
* device instance cc_XBIAS_vb1_ring2 r0 *1 0,0
Ccc_XBIAS_vb1_ring2 XBIAS.vb1 ring2 1.21e-17
* device instance cc_XBIAS_vb1_ring3 r0 *1 0,0
Ccc_XBIAS_vb1_ring3 XBIAS.vb1 ring3 1.21e-17
* device instance cc_XBIAS_vb1_ring4 r0 *1 0,0
Ccc_XBIAS_vb1_ring4 XBIAS.vb1 ring4 1.21e-17
* device instance cc_XBIAS_vb1_ring5 r0 *1 0,0
Ccc_XBIAS_vb1_ring5 XBIAS.vb1 ring5 1.21e-17
* device instance cc_XBIAS_vb2_XBIAS_vfixmid r0 *1 0,0
Ccc_XBIAS_vb2_XBIAS_vfixmid XBIAS.vb2 XBIAS.vfixmid 1.8151e-17
* device instance cc_XBIAS_vb2_XS1_nh r0 *1 0,0
Ccc_XBIAS_vb2_XS1_nh XBIAS.vb2 XS1.nh 1.21e-17
* device instance cc_XBIAS_vb2_XS1_nt r0 *1 0,0
Ccc_XBIAS_vb2_XS1_nt XBIAS.vb2 XS1.nt 6.05e-18
* device instance cc_XBIAS_vb2_XS2_nh r0 *1 0,0
Ccc_XBIAS_vb2_XS2_nh XBIAS.vb2 XS2.nh 1.21e-17
* device instance cc_XBIAS_vb2_XS2_nt r0 *1 0,0
Ccc_XBIAS_vb2_XS2_nt XBIAS.vb2 XS2.nt 6.05e-18
* device instance cc_XBIAS_vb2_XS3_nh r0 *1 0,0
Ccc_XBIAS_vb2_XS3_nh XBIAS.vb2 XS3.nh 1.21e-17
* device instance cc_XBIAS_vb2_XS3_nt r0 *1 0,0
Ccc_XBIAS_vb2_XS3_nt XBIAS.vb2 XS3.nt 6.05e-18
* device instance cc_XBIAS_vb2_XS4_nh r0 *1 0,0
Ccc_XBIAS_vb2_XS4_nh XBIAS.vb2 XS4.nh 1.21e-17
* device instance cc_XBIAS_vb2_XS4_nt r0 *1 0,0
Ccc_XBIAS_vb2_XS4_nt XBIAS.vb2 XS4.nt 6.05e-18
* device instance cc_XBIAS_vb2_XS5_nh r0 *1 0,0
Ccc_XBIAS_vb2_XS5_nh XBIAS.vb2 XS5.nh 1.21e-17
* device instance cc_XBIAS_vb2_XS5_nt r0 *1 0,0
Ccc_XBIAS_vb2_XS5_nt XBIAS.vb2 XS5.nt 6.05e-18
* device instance cc_XBIAS_vb2_bufmid r0 *1 0,0
Ccc_XBIAS_vb2_bufmid XBIAS.vb2 bufmid 2.4201e-17
* device instance cc_XBIAS_vb2_ring1 r0 *1 0,0
Ccc_XBIAS_vb2_ring1 XBIAS.vb2 ring1 2.4201e-17
* device instance cc_XBIAS_vb2_ring2 r0 *1 0,0
Ccc_XBIAS_vb2_ring2 XBIAS.vb2 ring2 1.21e-17
* device instance cc_XBIAS_vb2_ring3 r0 *1 0,0
Ccc_XBIAS_vb2_ring3 XBIAS.vb2 ring3 1.21e-17
* device instance cc_XBIAS_vb2_ring4 r0 *1 0,0
Ccc_XBIAS_vb2_ring4 XBIAS.vb2 ring4 1.21e-17
* device instance cc_XBIAS_vb2_ring5 r0 *1 0,0
Ccc_XBIAS_vb2_ring5 XBIAS.vb2 ring5 1.21e-17
* device instance cc_XS1_nh_XS2_nh r0 *1 0,0
Ccc_XS1_nh_XS2_nh XS1.nh XS2.nh 6.05e-18
* device instance cc_XS1_nh_XS3_nh r0 *1 0,0
Ccc_XS1_nh_XS3_nh XS1.nh XS3.nh 6.05e-18
* device instance cc_XS1_nh_XS4_nh r0 *1 0,0
Ccc_XS1_nh_XS4_nh XS1.nh XS4.nh 6.05e-18
* device instance cc_XS1_nh_XS5_nh r0 *1 0,0
Ccc_XS1_nh_XS5_nh XS1.nh XS5.nh 6.05e-18
* device instance cc_XS1_nh_ring1 r0 *1 0,0
Ccc_XS1_nh_ring1 XS1.nh ring1 1.7344e-17
* device instance cc_XS1_nh_ring2 r0 *1 0,0
Ccc_XS1_nh_ring2 XS1.nh ring2 1.21e-17
* device instance cc_XS1_nh_ring3 r0 *1 0,0
Ccc_XS1_nh_ring3 XS1.nh ring3 1.21e-17
* device instance cc_XS1_nh_ring4 r0 *1 0,0
Ccc_XS1_nh_ring4 XS1.nh ring4 1.21e-17
* device instance cc_XS1_nh_ring5 r0 *1 0,0
Ccc_XS1_nh_ring5 XS1.nh ring5 6.05e-18
* device instance cc_XS1_nt_XS2_nt r0 *1 0,0
Ccc_XS1_nt_XS2_nt XS1.nt XS2.nt 6.05e-18
* device instance cc_XS1_nt_XS3_nt r0 *1 0,0
Ccc_XS1_nt_XS3_nt XS1.nt XS3.nt 6.05e-18
* device instance cc_XS1_nt_XS4_nt r0 *1 0,0
Ccc_XS1_nt_XS4_nt XS1.nt XS4.nt 6.05e-18
* device instance cc_XS1_nt_XS5_nt r0 *1 0,0
Ccc_XS1_nt_XS5_nt XS1.nt XS5.nt 6.05e-18
* device instance cc_XS1_nt_ring1 r0 *1 0,0
Ccc_XS1_nt_ring1 XS1.nt ring1 1.7344e-17
* device instance cc_XS1_nt_ring2 r0 *1 0,0
Ccc_XS1_nt_ring2 XS1.nt ring2 1.21e-17
* device instance cc_XS1_nt_ring3 r0 *1 0,0
Ccc_XS1_nt_ring3 XS1.nt ring3 1.21e-17
* device instance cc_XS1_nt_ring4 r0 *1 0,0
Ccc_XS1_nt_ring4 XS1.nt ring4 1.21e-17
* device instance cc_XS1_nt_ring5 r0 *1 0,0
Ccc_XS1_nt_ring5 XS1.nt ring5 6.05e-18
* device instance cc_XS2_nh_XS3_nh r0 *1 0,0
Ccc_XS2_nh_XS3_nh XS2.nh XS3.nh 6.05e-18
* device instance cc_XS2_nh_XS4_nh r0 *1 0,0
Ccc_XS2_nh_XS4_nh XS2.nh XS4.nh 6.05e-18
* device instance cc_XS2_nh_XS5_nh r0 *1 0,0
Ccc_XS2_nh_XS5_nh XS2.nh XS5.nh 6.05e-18
* device instance cc_XS2_nh_ring2 r0 *1 0,0
Ccc_XS2_nh_ring2 XS2.nh ring2 1.7344e-17
* device instance cc_XS2_nh_ring3 r0 *1 0,0
Ccc_XS2_nh_ring3 XS2.nh ring3 1.21e-17
* device instance cc_XS2_nh_ring4 r0 *1 0,0
Ccc_XS2_nh_ring4 XS2.nh ring4 1.21e-17
* device instance cc_XS2_nh_ring5 r0 *1 0,0
Ccc_XS2_nh_ring5 XS2.nh ring5 6.05e-18
* device instance cc_XS2_nt_XS3_nt r0 *1 0,0
Ccc_XS2_nt_XS3_nt XS2.nt XS3.nt 6.05e-18
* device instance cc_XS2_nt_XS4_nt r0 *1 0,0
Ccc_XS2_nt_XS4_nt XS2.nt XS4.nt 6.05e-18
* device instance cc_XS2_nt_XS5_nt r0 *1 0,0
Ccc_XS2_nt_XS5_nt XS2.nt XS5.nt 6.05e-18
* device instance cc_XS2_nt_ring2 r0 *1 0,0
Ccc_XS2_nt_ring2 XS2.nt ring2 1.7344e-17
* device instance cc_XS2_nt_ring3 r0 *1 0,0
Ccc_XS2_nt_ring3 XS2.nt ring3 1.21e-17
* device instance cc_XS2_nt_ring4 r0 *1 0,0
Ccc_XS2_nt_ring4 XS2.nt ring4 1.21e-17
* device instance cc_XS2_nt_ring5 r0 *1 0,0
Ccc_XS2_nt_ring5 XS2.nt ring5 6.05e-18
* device instance cc_XS3_nh_XS4_nh r0 *1 0,0
Ccc_XS3_nh_XS4_nh XS3.nh XS4.nh 6.05e-18
* device instance cc_XS3_nh_XS5_nh r0 *1 0,0
Ccc_XS3_nh_XS5_nh XS3.nh XS5.nh 6.05e-18
* device instance cc_XS3_nh_ring3 r0 *1 0,0
Ccc_XS3_nh_ring3 XS3.nh ring3 1.7344e-17
* device instance cc_XS3_nh_ring4 r0 *1 0,0
Ccc_XS3_nh_ring4 XS3.nh ring4 1.21e-17
* device instance cc_XS3_nh_ring5 r0 *1 0,0
Ccc_XS3_nh_ring5 XS3.nh ring5 6.05e-18
* device instance cc_XS3_nt_XS4_nt r0 *1 0,0
Ccc_XS3_nt_XS4_nt XS3.nt XS4.nt 6.05e-18
* device instance cc_XS3_nt_XS5_nt r0 *1 0,0
Ccc_XS3_nt_XS5_nt XS3.nt XS5.nt 6.05e-18
* device instance cc_XS3_nt_ring3 r0 *1 0,0
Ccc_XS3_nt_ring3 XS3.nt ring3 1.7344e-17
* device instance cc_XS3_nt_ring4 r0 *1 0,0
Ccc_XS3_nt_ring4 XS3.nt ring4 1.21e-17
* device instance cc_XS3_nt_ring5 r0 *1 0,0
Ccc_XS3_nt_ring5 XS3.nt ring5 6.05e-18
* device instance cc_XS4_nh_XS5_nh r0 *1 0,0
Ccc_XS4_nh_XS5_nh XS4.nh XS5.nh 6.05e-18
* device instance cc_XS4_nh_ring4 r0 *1 0,0
Ccc_XS4_nh_ring4 XS4.nh ring4 1.7344e-17
* device instance cc_XS4_nh_ring5 r0 *1 0,0
Ccc_XS4_nh_ring5 XS4.nh ring5 6.05e-18
* device instance cc_XS4_nt_XS5_nt r0 *1 0,0
Ccc_XS4_nt_XS5_nt XS4.nt XS5.nt 6.05e-18
* device instance cc_XS4_nt_ring4 r0 *1 0,0
Ccc_XS4_nt_ring4 XS4.nt ring4 1.7344e-17
* device instance cc_XS4_nt_ring5 r0 *1 0,0
Ccc_XS4_nt_ring5 XS4.nt ring5 6.05e-18
* device instance cc_XS5_nh_ring5 r0 *1 0,0
Ccc_XS5_nh_ring5 XS5.nh ring5 1.1294e-17
* device instance cc_XS5_nt_ring5 r0 *1 0,0
Ccc_XS5_nt_ring5 XS5.nt ring5 1.1294e-17
* device instance cc_bufmid_ring1 r0 *1 0,0
Ccc_bufmid_ring1 bufmid ring1 1.8151e-17
* device instance cc_bufmid_ring2 r0 *1 0,0
Ccc_bufmid_ring2 bufmid ring2 1.21e-17
* device instance cc_bufmid_ring3 r0 *1 0,0
Ccc_bufmid_ring3 bufmid ring3 1.21e-17
* device instance cc_bufmid_ring4 r0 *1 0,0
Ccc_bufmid_ring4 bufmid ring4 1.21e-17
* device instance cc_bufmid_ring5 r0 *1 0,0
Ccc_bufmid_ring5 bufmid ring5 1.21e-17
* device instance cc_ring1_ring2 r0 *1 0,0
Ccc_ring1_ring2 ring1 ring2 2.4201e-17
* device instance cc_ring1_ring3 r0 *1 0,0
Ccc_ring1_ring3 ring1 ring3 2.4201e-17
* device instance cc_ring1_ring4 r0 *1 0,0
Ccc_ring1_ring4 ring1 ring4 2.4201e-17
* device instance cc_ring1_ring5 r0 *1 0,0
Ccc_ring1_ring5 ring1 ring5 1.8151e-17
* device instance cc_ring2_ring3 r0 *1 0,0
Ccc_ring2_ring3 ring2 ring3 1.21e-17
* device instance cc_ring2_ring4 r0 *1 0,0
Ccc_ring2_ring4 ring2 ring4 1.21e-17
* device instance cc_ring2_ring5 r0 *1 0,0
Ccc_ring2_ring5 ring2 ring5 1.21e-17
* device instance cc_ring3_ring4 r0 *1 0,0
Ccc_ring3_ring4 ring3 ring4 1.21e-17
* device instance cc_ring3_ring5 r0 *1 0,0
Ccc_ring3_ring5 ring3 ring5 1.21e-17
* device instance cc_ring4_ring5 r0 *1 0,0
Ccc_ring4_ring5 ring4 ring5 1.21e-17
* device instance vsubs_dctie r0 *1 0,0
Rvsubs_dctie vsubs 0 1e+12
.ENDS pll_vco
