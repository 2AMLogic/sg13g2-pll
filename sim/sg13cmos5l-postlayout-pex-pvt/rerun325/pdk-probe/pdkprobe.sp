* PDK provenance probe
Vdd a 0 dc 1
R1 a 0 1k
.control
op
shell sh probe.sh
.endc
.end
