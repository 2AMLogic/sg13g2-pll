* extracted by klt extract --deck sg13cmos5l
* parasitic model (--parasitics):
* - capacitance: net-to-ground for every net's own (non-coupled) area/perimeter, plus net-to-net for the vertical-overlap coupling `coupling` describes below -- a coupled net pair gets a direct capacitor between their two hub nodes, not just capacitors to the deck's ground/substrate net
* - coupling: vertical overlap (crossover) unconditionally -- where one net's conductor on an adjacent metal level sits directly over another *distinct* net's conductor, that overlap area is charged between the two nets instead of to ground (issue #760) -- plus lateral (same-layer, sidewall) coupling, but only for a net pair naming one of the caller's declared `--critical-net` nets (issue #976): facing-edge length within that layer's own minimum-spacing lookback is charged between the two nets, *additively* (not deducted from either net's substrate fringe term, unlike the vertical case -- a known simplification). Any same-layer pair with neither side named `--critical-net`, and fringe shielding in general, are still not modelled
* - resistance: single lumped series resistance per net, distributed as a star across that net's device terminals (issue #592) -- not a per-segment, distributed RC ladder, *unless* `--distributed-rc` names this net via `--critical-net` (issue #977, Epic #709 Phase 2b): then the net's terminals are ordered along their approximate physical spread and its total R/C is broken into a chain of per-segment resistors (segment length proportional to inter-terminal distance) with a ground capacitor at each terminal node (proportional to its adjacent segment length/2), instead of one star hub -- still an approximation (terminal position is a device-placement proxy, not true per-segment routing geometry), but a strictly finer-grained one than the single-hub star
* - frequency: quasi-static -- one frequency-independent R and C per net; no skin effect, no distributed transmission-line behavior
* - substrate tie: 1e+12 ohm to ground -- the substrate is capacitively floating in transient analysis (DC reference only); see --substrate-tie-ohms
.GLOBAL vsubs

* cell pll_vco
* pin B0
* pin B1
* pin CLK
* pin GND_VCO
* pin VBN
* pin VBP
* pin VCTRL
* pin VDD_VCO
* pin XBIAS_VFIX
* pin XBIAS_dega
* pin XBIAS_degb
* pin XBIAS_n2s
* pin XBIAS_nb0
* pin XBIAS_nb1
* pin XBIAS_vb1
* pin XBIAS_vb2
* pin XBIAS_vfixmid
* pin XS1_nh
* pin XS1_nt
* pin XS2_nh
* pin XS2_nt
* pin XS3_nh
* pin XS3_nt
* pin XS4_nh
* pin XS4_nt
* pin XS5_nh
* pin XS5_nt
* pin bufmid
* pin ring1
* pin ring2
* pin ring3
* pin ring4
* pin ring5
.SUBCKT pll_vco B0 B1 CLK GND_VCO VBN VBP VCTRL VDD_VCO XBIAS_VFIX XBIAS_dega
+ XBIAS_degb XBIAS_n2s XBIAS_nb0 XBIAS_nb1 XBIAS_vb1 XBIAS_vb2 XBIAS_vfixmid
+ XS1_nh XS1_nt XS2_nh XS2_nt XS3_nh XS3_nt XS4_nh XS4_nt XS5_nh XS5_nt bufmid
+ ring1 ring2 ring3 ring4 ring5
* device instance $1 r0 *1 2.3,3 nfet
X$1 ring1__t0 ring5__t0 XS1_nt__t0 GND_VCO__t21 sg13_hv_nmos L=0.28U W=2U
+ AS=0.8P AD=0.8P PS=4.8U PD=4.8U
* device instance $2 r0 *1 6.26,3 nfet
X$2 ring2__t2 ring1__t5 XS2_nt__t1 GND_VCO__t22 sg13_hv_nmos L=0.28U W=2U
+ AS=0.8P AD=0.8P PS=4.8U PD=4.8U
* device instance $3 r0 *1 10.22,3 nfet
X$3 ring3__t2 ring2__t3 XS3_nt__t1 GND_VCO__t23 sg13_hv_nmos L=0.28U W=2U
+ AS=0.8P AD=0.8P PS=4.8U PD=4.8U
* device instance $4 r0 *1 14.18,3 nfet
X$4 ring4__t2 ring3__t3 XS4_nt__t1 GND_VCO__t24 sg13_hv_nmos L=0.28U W=2U
+ AS=0.8P AD=0.8P PS=4.8U PD=4.8U
* device instance $5 r0 *1 18.14,3 nfet
X$5 ring5__t3 ring4__t3 XS5_nt__t1 GND_VCO__t25 sg13_hv_nmos L=0.28U W=2U
+ AS=0.8P AD=0.8P PS=4.8U PD=4.8U
* device instance $6 r0 *1 28.74,3.36 nfet
X$6 XBIAS_vb1__t4 XBIAS_vb2__t4 GND_VCO__t2 GND_VCO__t26 sg13_hv_nmos L=1U W=2U
+ AS=0.8P AD=0.8P PS=4.8U PD=4.8U
* device instance $7 r0 *1 32.7,3.36 nfet
X$7 XBIAS_VFIX__t3 XBIAS_VFIX__t2 XBIAS_vfixmid__t2 GND_VCO__t27 sg13_hv_nmos
+ L=1U W=2U AS=0.8P AD=0.8P PS=4.8U PD=4.8U
* device instance $8 r0 *1 36.66,3.36 nfet
X$8 XBIAS_vfixmid__t0 XBIAS_vfixmid__t1 GND_VCO__t11 GND_VCO__t28 sg13_hv_nmos
+ L=1U W=2U AS=0.8P AD=0.8P PS=4.8U PD=4.8U
* device instance $9 r0 *1 48.26,3.01 nfet
X$9 XBIAS_degb__t0 B0__t0 XBIAS_nb0__t0 GND_VCO__t29 sg13_hv_nmos L=0.3U W=4U
+ AS=1.6P AD=1.6P PS=8.8U PD=8.8U
* device instance $10 r0 *1 54.22,3.01 nfet
X$10 XBIAS_degb__t1 B1__t0 XBIAS_nb1__t0 GND_VCO__t30 sg13_hv_nmos L=0.3U W=4U
+ AS=1.6P AD=1.6P PS=8.8U PD=8.8U
* device instance $11 r0 *1 66.82,3.11 nfet
X$11 XS1_nt__t1 VBN__t0 GND_VCO__t3 GND_VCO__t31 sg13_hv_nmos L=0.5U W=4U
+ AS=1.6P AD=1.6P PS=8.8U PD=8.8U
* device instance $12 r0 *1 72.78,3.11 nfet
X$12 XS2_nt__t0 VBN__t4 GND_VCO__t5 GND_VCO__t32 sg13_hv_nmos L=0.5U W=4U
+ AS=1.6P AD=1.6P PS=8.8U PD=8.8U
* device instance $13 r0 *1 78.74,3.11 nfet
X$13 XS3_nt__t0 VBN__t7 GND_VCO__t10 GND_VCO__t33 sg13_hv_nmos L=0.5U W=4U
+ AS=1.6P AD=1.6P PS=8.8U PD=8.8U
* device instance $14 r0 *1 84.7,3.11 nfet
X$14 XS4_nt__t0 VBN__t5 GND_VCO__t6 GND_VCO__t34 sg13_hv_nmos L=0.5U W=4U
+ AS=1.6P AD=1.6P PS=8.8U PD=8.8U
* device instance $15 r0 *1 90.66,3.11 nfet
X$15 XS5_nt__t0 VBN__t6 GND_VCO__t7 GND_VCO__t35 sg13_hv_nmos L=0.5U W=4U
+ AS=1.6P AD=1.6P PS=8.8U PD=8.8U
* device instance $16 r0 *1 96.62,3.11 nfet
X$16 bufmid__t2 ring1__t4 GND_VCO__t8 GND_VCO__t36 sg13_hv_nmos L=0.5U W=4U
+ AS=1.6P AD=1.6P PS=8.8U PD=8.8U
* device instance $17 r0 *1 102.58,3.11 nfet
X$17 CLK__t1 bufmid__t3 GND_VCO__t9 GND_VCO__t37 sg13_hv_nmos L=0.5U W=4U
+ AS=1.6P AD=1.6P PS=8.8U PD=8.8U
* device instance $18 r0 *1 115.18,3.36 nfet
X$18 VBP__t9 XBIAS_VFIX__t1 XBIAS_dega__t1 GND_VCO__t38 sg13_hv_nmos L=1U W=4U
+ AS=1.6P AD=1.6P PS=8.8U PD=8.8U
* device instance $19 r0 *1 121.14,3.36 nfet
X$19 VBP__t8 VCTRL__t0 XBIAS_degb__t2 GND_VCO__t39 sg13_hv_nmos L=1U W=4U
+ AS=1.6P AD=1.6P PS=8.8U PD=8.8U
* device instance $20 r0 *1 127.1,3.36 nfet
X$20 VBN__t1 VBN__t2 GND_VCO__t4 GND_VCO__t40 sg13_hv_nmos L=1U W=4U AS=1.6P
+ AD=1.6P PS=8.8U PD=8.8U
* device instance $21 r0 *1 141.7,3.36 nfet
X$21 XBIAS_vb2__t1 XBIAS_vb2__t2 XBIAS_n2s__t1 GND_VCO__t41 sg13_hv_nmos L=1U
+ W=8U AS=3.2P AD=3.2P PS=16.8U PD=16.8U
* device instance $22 r0 *1 155.8,3.36 pfet
X$22 XBIAS_VFIX__t0 XBIAS_vb1__t0 VDD_VCO__t2 VDD_VCO__t1 sg13_hv_pmos L=1U
+ W=3U AS=1.2P AD=1.2P PS=6.8U PD=6.8U
* device instance $23 r0 *1 168.4,3 pfet
X$23 ring1__t1 ring5__t1 XS1_nh__t0 VDD_VCO__t3 sg13_hv_pmos L=0.28U W=5U AS=2P
+ AD=2P PS=10.8U PD=10.8U
* device instance $24 r0 *1 175.36,3 pfet
X$24 ring2__t0 ring1__t3 XS2_nh__t1 VDD_VCO__t27 sg13_hv_pmos L=0.28U W=5U
+ AS=2P AD=2P PS=10.8U PD=10.8U
* device instance $25 r0 *1 182.32,3 pfet
X$25 ring3__t0 ring2__t1 XS3_nh__t1 VDD_VCO__t26 sg13_hv_pmos L=0.28U W=5U
+ AS=2P AD=2P PS=10.8U PD=10.8U
* device instance $26 r0 *1 189.28,3 pfet
X$26 ring4__t0 ring3__t1 XS4_nh__t1 VDD_VCO__t28 sg13_hv_pmos L=0.28U W=5U
+ AS=2P AD=2P PS=10.8U PD=10.8U
* device instance $27 r0 *1 196.24,3 pfet
X$27 ring5__t2 ring4__t1 XS5_nh__t1 VDD_VCO__t29 sg13_hv_pmos L=0.28U W=5U
+ AS=2P AD=2P PS=10.8U PD=10.8U
* device instance $28 r0 *1 210.34,3.36 pfet
X$28 XBIAS_vb1__t1 XBIAS_vb1__t2 VDD_VCO__t5 VDD_VCO__t4 sg13_hv_pmos L=1U W=6U
+ AS=2.4P AD=2.4P PS=12.8U PD=12.8U
* device instance $29 r0 *1 218.3,3.36 pfet
X$29 XBIAS_vb2__t3 XBIAS_vb1__t3 VDD_VCO__t24 VDD_VCO__t25 sg13_hv_pmos L=1U
+ W=6U AS=2.4P AD=2.4P PS=12.8U PD=12.8U
* device instance $30 r0 *1 234.9,3.11 pfet
X$30 XS1_nh__t1 VBP__t0 VDD_VCO__t7 VDD_VCO__t6 sg13_hv_pmos L=0.5U W=10U AS=4P
+ AD=4P PS=20.8U PD=20.8U
* device instance $31 r0 *1 246.86,3.11 pfet
X$31 XS2_nh__t0 VBP__t4 VDD_VCO__t12 VDD_VCO__t18 sg13_hv_pmos L=0.5U W=10U
+ AS=4P AD=4P PS=20.8U PD=20.8U
* device instance $32 r0 *1 258.82,3.11 pfet
X$32 XS3_nh__t0 VBP__t5 VDD_VCO__t13 VDD_VCO__t19 sg13_hv_pmos L=0.5U W=10U
+ AS=4P AD=4P PS=20.8U PD=20.8U
* device instance $33 r0 *1 270.78,3.11 pfet
X$33 XS4_nh__t0 VBP__t6 VDD_VCO__t14 VDD_VCO__t20 sg13_hv_pmos L=0.5U W=10U
+ AS=4P AD=4P PS=20.8U PD=20.8U
* device instance $34 r0 *1 282.74,3.11 pfet
X$34 XS5_nh__t0 VBP__t7 VDD_VCO__t15 VDD_VCO__t21 sg13_hv_pmos L=0.5U W=10U
+ AS=4P AD=4P PS=20.8U PD=20.8U
* device instance $35 r0 *1 294.7,3.11 pfet
X$35 bufmid__t0 ring1__t2 VDD_VCO__t17 VDD_VCO__t23 sg13_hv_pmos L=0.5U W=10U
+ AS=4P AD=4P PS=20.8U PD=20.8U
* device instance $36 r0 *1 306.66,3.11 pfet
X$36 CLK__t0 bufmid__t1 VDD_VCO__t16 VDD_VCO__t22 sg13_hv_pmos L=0.5U W=10U
+ AS=4P AD=4P PS=20.8U PD=20.8U
* device instance $37 r0 *1 325.26,3.36 pfet
X$37 VBP__t1 VBP__t2 VDD_VCO__t9 VDD_VCO__t8 sg13_hv_pmos L=1U W=10U AS=4P
+ AD=4P PS=20.8U PD=20.8U
* device instance $38 r0 *1 337.22,3.36 pfet
X$38 VBN__t3 VBP__t3 VDD_VCO__t10 VDD_VCO__t11 sg13_hv_pmos L=1U W=10U AS=4P
+ AD=4P PS=20.8U PD=20.8U
* device instance $39 r0 *1 380.02,0.7 rppd
X$39 XBIAS_n2s__t0 GND_VCO__t0 GND_VCO__t15 rppd r=7823.47912525 L=30U W=1U
* device instance $40 r0 *1 432.62,0.7 rppd
X$40 XBIAS_dega__t0 GND_VCO__t1 GND_VCO__t17 rppd r=15576.9582505 L=60U W=1U
* device instance $41 r0 *1 380.62,2.7 rppd
X$41 XBIAS_nb1__t1 GND_VCO__t14 GND_VCO__t16 rppd r=7823.47912525 L=30U W=1U
* device instance $42 r0 *1 433.22,2.7 rppd
X$42 XBIAS_degb__t3 GND_VCO__t13 GND_VCO__t18 rppd r=15576.9582505 L=60U W=1U
* device instance $43 r0 *1 433.82,4.7 rppd
X$43 XBIAS_nb0__t1 GND_VCO__t12 GND_VCO__t19 rppd r=15576.9582505 L=60U W=1U
* device instance $44 r0 *1 354.02,0.45 rhigh
X$44 VDD_VCO__t0 XBIAS_vb2__t0 GND_VCO__t20 rhigh r=23972.173913 L=8U W=0.5U
* device instance B0_t0 r0 *1 0,0
RB0_t0 B0__t0 B0 1.5737
* device instance B0 r0 *1 0,0
*CB0 B0 vsubs 4.8692e-16
* device instance B1_t0 r0 *1 0,0
RB1_t0 B1__t0 B1 1.7497
* device instance B1 r0 *1 0,0
*CB1 B1 vsubs 5.3284e-16
* device instance CLK_t0 r0 *1 0,0
RCLK_t0 CLK__t0 CLK 34.04315
* device instance CLK_t1 r0 *1 0,0
RCLK_t1 CLK__t1 CLK 34.04315
* device instance CLK r0 *1 0,0
*CCLK CLK vsubs 1.5141527e-14
* device instance GND_VCO_t0 r0 *1 0,0
RGND_VCO_t0 GND_VCO__t0 GND_VCO 9.04003413714
* device instance GND_VCO_t1 r0 *1 0,0
RGND_VCO_t1 GND_VCO__t1 GND_VCO 11.1755523632
* device instance GND_VCO_t2 r0 *1 0,0
RGND_VCO_t2 GND_VCO__t2 GND_VCO 5.22268927442
* device instance GND_VCO_t3 r0 *1 0,0
RGND_VCO_t3 GND_VCO__t3 GND_VCO 3.6765869809
* device instance GND_VCO_t4 r0 *1 0,0
RGND_VCO_t4 GND_VCO__t4 GND_VCO 1.2293049774
* device instance GND_VCO_t5 r0 *1 0,0
RGND_VCO_t5 GND_VCO__t5 GND_VCO 3.43460692524
* device instance GND_VCO_t6 r0 *1 0,0
RGND_VCO_t6 GND_VCO__t6 GND_VCO 2.95064717157
* device instance GND_VCO_t7 r0 *1 0,0
RGND_VCO_t7 GND_VCO__t7 GND_VCO 2.70866753746
* device instance GND_VCO_t8 r0 *1 0,0
RGND_VCO_t8 GND_VCO__t8 GND_VCO 2.46668812867
* device instance GND_VCO_t9 r0 *1 0,0
RGND_VCO_t9 GND_VCO__t9 GND_VCO 2.22470901872
* device instance GND_VCO_t10 r0 *1 0,0
RGND_VCO_t10 GND_VCO__t10 GND_VCO 3.19262697976
* device instance GND_VCO_t11 r0 *1 0,0
RGND_VCO_t11 GND_VCO__t11 GND_VCO 4.90113315334
* device instance GND_VCO_t12 r0 *1 0,0
RGND_VCO_t12 GND_VCO__t12 GND_VCO 11.2241569499
* device instance GND_VCO_t13 r0 *1 0,0
RGND_VCO_t13 GND_VCO__t13 GND_VCO 11.1995601608
* device instance GND_VCO_t14 r0 *1 0,0
RGND_VCO_t14 GND_VCO__t14 GND_VCO 9.06395861519
* device instance GND_VCO_t15 r0 *1 0,0
RGND_VCO_t15 GND_VCO__t15 GND_VCO 9.04003413714
* device instance GND_VCO_t16 r0 *1 0,0
RGND_VCO_t16 GND_VCO__t16 GND_VCO 9.06395861519
* device instance GND_VCO_t17 r0 *1 0,0
RGND_VCO_t17 GND_VCO__t17 GND_VCO 11.1755523632
* device instance GND_VCO_t18 r0 *1 0,0
RGND_VCO_t18 GND_VCO__t18 GND_VCO 11.1995601608
* device instance GND_VCO_t19 r0 *1 0,0
RGND_VCO_t19 GND_VCO__t19 GND_VCO 11.2241569499
* device instance GND_VCO_t20 r0 *1 0,0
RGND_VCO_t20 GND_VCO__t20 GND_VCO 7.98459114399
* device instance GND_VCO_t21 r0 *1 0,0
RGND_VCO_t21 GND_VCO__t21 GND_VCO 6.29614186749
* device instance GND_VCO_t22 r0 *1 0,0
RGND_VCO_t22 GND_VCO__t22 GND_VCO 6.13536272732
* device instance GND_VCO_t23 r0 *1 0,0
RGND_VCO_t23 GND_VCO__t23 GND_VCO 5.97458358917
* device instance GND_VCO_t24 r0 *1 0,0
RGND_VCO_t24 GND_VCO__t24 GND_VCO 5.8138044532
* device instance GND_VCO_t25 r0 *1 0,0
RGND_VCO_t25 GND_VCO__t25 GND_VCO 5.6530253196
* device instance GND_VCO_t26 r0 *1 0,0
RGND_VCO_t26 GND_VCO__t26 GND_VCO 5.22268927442
* device instance GND_VCO_t27 r0 *1 0,0
RGND_VCO_t27 GND_VCO__t27 GND_VCO 5.0619111784
* device instance GND_VCO_t28 r0 *1 0,0
RGND_VCO_t28 GND_VCO__t28 GND_VCO 4.90113315334
* device instance GND_VCO_t29 r0 *1 0,0
RGND_VCO_t29 GND_VCO__t29 GND_VCO 4.43012999744
* device instance GND_VCO_t30 r0 *1 0,0
RGND_VCO_t30 GND_VCO__t30 GND_VCO 4.18814935591
* device instance GND_VCO_t31 r0 *1 0,0
RGND_VCO_t31 GND_VCO__t31 GND_VCO 3.6765869809
* device instance GND_VCO_t32 r0 *1 0,0
RGND_VCO_t32 GND_VCO__t32 GND_VCO 3.43460692524
* device instance GND_VCO_t33 r0 *1 0,0
RGND_VCO_t33 GND_VCO__t33 GND_VCO 3.19262697976
* device instance GND_VCO_t34 r0 *1 0,0
RGND_VCO_t34 GND_VCO__t34 GND_VCO 2.95064717157
* device instance GND_VCO_t35 r0 *1 0,0
RGND_VCO_t35 GND_VCO__t35 GND_VCO 2.70866753746
* device instance GND_VCO_t36 r0 *1 0,0
RGND_VCO_t36 GND_VCO__t36 GND_VCO 2.46668812867
* device instance GND_VCO_t37 r0 *1 0,0
RGND_VCO_t37 GND_VCO__t37 GND_VCO 2.22470901872
* device instance GND_VCO_t38 r0 *1 0,0
RGND_VCO_t38 GND_VCO__t38 GND_VCO 1.71322567173
* device instance GND_VCO_t39 r0 *1 0,0
RGND_VCO_t39 GND_VCO__t39 GND_VCO 1.47126196368
* device instance GND_VCO_t40 r0 *1 0,0
RGND_VCO_t40 GND_VCO__t40 GND_VCO 1.2293049774
* device instance GND_VCO_t41 r0 *1 0,0
RGND_VCO_t41 GND_VCO__t41 GND_VCO 0.636667984757
* device instance GND_VCO r0 *1 0,0
*CGND_VCO GND_VCO vsubs 5.7095189e-14
* device instance VBN_t0 r0 *1 0,0
RVBN_t0 VBN__t0 VBN 12.846110542
* device instance VBN_t1 r0 *1 0,0
RVBN_t1 VBN__t1 VBN 0.903943732654
* device instance VBN_t2 r0 *1 0,0
RVBN_t2 VBN__t2 VBN 0.903943732654
* device instance VBN_t3 r0 *1 0,0
RVBN_t3 VBN__t3 VBN 48.8297632677
* device instance VBN_t4 r0 *1 0,0
RVBN_t4 VBN__t4 VBN 11.4866894814
* device instance VBN_t5 r0 *1 0,0
RVBN_t5 VBN__t5 VBN 8.76784931969
* device instance VBN_t6 r0 *1 0,0
RVBN_t6 VBN__t6 VBN 7.40843093766
* device instance VBN_t7 r0 *1 0,0
RVBN_t7 VBN__t7 VBN 10.1272689863
* device instance VBN r0 *1 0,0
*CVBN VBN vsubs 2.335499e-14
* device instance VBP_t0 r0 *1 0,0
RVBP_t0 VBP__t0 VBP 2.73503823451
* device instance VBP_t1 r0 *1 0,0
RVBP_t1 VBP__t1 VBP 11.8743766277
* device instance VBP_t2 r0 *1 0,0
RVBP_t2 VBP__t2 VBP 11.8743766277
* device instance VBP_t3 r0 *1 0,0
RVBP_t3 VBP__t3 VBP 13.8080561915
* device instance VBP_t4 r0 *1 0,0
RVBP_t4 VBP__t4 VBP 0.801536419099
* device instance VBP_t5 r0 *1 0,0
RVBP_t5 VBP__t5 VBP 1.13258070711
* device instance VBP_t6 r0 *1 0,0
RVBP_t6 VBP__t6 VBP 3.06614895678
* device instance VBP_t7 r0 *1 0,0
RVBP_t7 VBP__t7 VBP 4.99980516944
* device instance VBP_t8 r0 *1 0,0
RVBP_t8 VBP__t8 VBP 21.1275870418
* device instance VBP_t9 r0 *1 0,0
RVBP_t9 VBP__t9 VBP 22.0911940244
* device instance VBP r0 *1 0,0
*CVBP VBP vsubs 2.1932054e-14
* device instance VCTRL_t0 r0 *1 0,0
RVCTRL_t0 VCTRL__t0 VCTRL 2.5271
* device instance VCTRL r0 *1 0,0
*CVCTRL VCTRL vsubs 7.2911e-16
* device instance VDD_VCO_t0 r0 *1 0,0
RVDD_VCO_t0 VDD_VCO__t0 VDD_VCO 13.2940861352
* device instance VDD_VCO_t1 r0 *1 0,0
RVDD_VCO_t1 VDD_VCO__t1 VDD_VCO 12.4506771234
* device instance VDD_VCO_t2 r0 *1 0,0
RVDD_VCO_t2 VDD_VCO__t2 VDD_VCO 12.4506771234
* device instance VDD_VCO_t3 r0 *1 0,0
RVDD_VCO_t3 VDD_VCO__t3 VDD_VCO 10.8144308874
* device instance VDD_VCO_t4 r0 *1 0,0
RVDD_VCO_t4 VDD_VCO__t4 VDD_VCO 5.36832970618
* device instance VDD_VCO_t5 r0 *1 0,0
RVDD_VCO_t5 VDD_VCO__t5 VDD_VCO 5.36832970618
* device instance VDD_VCO_t6 r0 *1 0,0
RVDD_VCO_t6 VDD_VCO__t6 VDD_VCO 2.17892022425
* device instance VDD_VCO_t7 r0 *1 0,0
RVDD_VCO_t7 VDD_VCO__t7 VDD_VCO 2.17892022425
* device instance VDD_VCO_t8 r0 *1 0,0
RVDD_VCO_t8 VDD_VCO__t8 VDD_VCO 9.55504899652
* device instance VDD_VCO_t9 r0 *1 0,0
RVDD_VCO_t9 VDD_VCO__t9 VDD_VCO 9.55504899652
* device instance VDD_VCO_t10 r0 *1 0,0
RVDD_VCO_t10 VDD_VCO__t10 VDD_VCO 11.1081324476
* device instance VDD_VCO_t11 r0 *1 0,0
RVDD_VCO_t11 VDD_VCO__t11 VDD_VCO 11.1081324476
* device instance VDD_VCO_t12 r0 *1 0,0
RVDD_VCO_t12 VDD_VCO__t12 VDD_VCO 0.62583291192
* device instance VDD_VCO_t13 r0 *1 0,0
RVDD_VCO_t13 VDD_VCO__t13 VDD_VCO 0.927272418128
* device instance VDD_VCO_t14 r0 *1 0,0
RVDD_VCO_t14 VDD_VCO__t14 VDD_VCO 2.48036192016
* device instance VDD_VCO_t15 r0 *1 0,0
RVDD_VCO_t15 VDD_VCO__t15 VDD_VCO 4.03345387805
* device instance VDD_VCO_t16 r0 *1 0,0
RVDD_VCO_t16 VDD_VCO__t16 VDD_VCO 7.13963875069
* device instance VDD_VCO_t17 r0 *1 0,0
RVDD_VCO_t17 VDD_VCO__t17 VDD_VCO 5.58654624356
* device instance VDD_VCO_t18 r0 *1 0,0
RVDD_VCO_t18 VDD_VCO__t18 VDD_VCO 0.62583291192
* device instance VDD_VCO_t19 r0 *1 0,0
RVDD_VCO_t19 VDD_VCO__t19 VDD_VCO 0.927272418128
* device instance VDD_VCO_t20 r0 *1 0,0
RVDD_VCO_t20 VDD_VCO__t20 VDD_VCO 2.48036192016
* device instance VDD_VCO_t21 r0 *1 0,0
RVDD_VCO_t21 VDD_VCO__t21 VDD_VCO 4.03345387805
* device instance VDD_VCO_t22 r0 *1 0,0
RVDD_VCO_t22 VDD_VCO__t22 VDD_VCO 7.13963875069
* device instance VDD_VCO_t23 r0 *1 0,0
RVDD_VCO_t23 VDD_VCO__t23 VDD_VCO 5.58654624356
* device instance VDD_VCO_t24 r0 *1 0,0
RVDD_VCO_t24 VDD_VCO__t24 VDD_VCO 4.33469405888
* device instance VDD_VCO_t25 r0 *1 0,0
RVDD_VCO_t25 VDD_VCO__t25 VDD_VCO 4.33469405888
* device instance VDD_VCO_t26 r0 *1 0,0
RVDD_VCO_t26 VDD_VCO__t26 VDD_VCO 9.00681915573
* device instance VDD_VCO_t27 r0 *1 0,0
RVDD_VCO_t27 VDD_VCO__t27 VDD_VCO 9.91062496838
* device instance VDD_VCO_t28 r0 *1 0,0
RVDD_VCO_t28 VDD_VCO__t28 VDD_VCO 8.10301348502
* device instance VDD_VCO_t29 r0 *1 0,0
RVDD_VCO_t29 VDD_VCO__t29 VDD_VCO 7.19920800972
* device instance VDD_VCO r0 *1 0,0
*CVDD_VCO VDD_VCO vsubs 5.1667827e-14
* device instance XBIAS_VFIX_t0 r0 *1 0,0
RXBIAS_VFIX_t0 XBIAS_VFIX__t0 XBIAS_VFIX 17.1232223636
* device instance XBIAS_VFIX_t1 r0 *1 0,0
RXBIAS_VFIX_t1 XBIAS_VFIX__t1 XBIAS_VFIX 7.42312763644
* device instance XBIAS_VFIX_t2 r0 *1 0,0
RXBIAS_VFIX_t2 XBIAS_VFIX__t2 XBIAS_VFIX 12.273175
* device instance XBIAS_VFIX_t3 r0 *1 0,0
RXBIAS_VFIX_t3 XBIAS_VFIX__t3 XBIAS_VFIX 12.273175
* device instance XBIAS_VFIX r0 *1 0,0
*CXBIAS_VFIX XBIAS_VFIX vsubs 1.1432231e-14
* device instance XBIAS_dega_t0 r0 *1 0,0
RXBIAS_dega_t0 XBIAS_dega__t0 XBIAS_dega 46.7308
* device instance XBIAS_dega_t1 r0 *1 0,0
RXBIAS_dega_t1 XBIAS_dega__t1 XBIAS_dega 46.7308
* device instance XBIAS_dega r0 *1 0,0
*CXBIAS_dega XBIAS_dega vsubs 2.10574e-14
* device instance XBIAS_degb_t0 r0 *1 0,0
RXBIAS_degb_t0 XBIAS_degb__t0 XBIAS_degb 26.3498760794
* device instance XBIAS_degb_t1 r0 *1 0,0
RXBIAS_degb_t1 XBIAS_degb__t1 XBIAS_degb 24.9954538265
* device instance XBIAS_degb_t2 r0 *1 0,0
RXBIAS_degb_t2 XBIAS_degb__t2 XBIAS_degb 9.78805105252
* device instance XBIAS_degb_t3 r0 *1 0,0
RXBIAS_degb_t3 XBIAS_degb__t3 XBIAS_degb 61.1331190416
* device instance XBIAS_degb r0 *1 0,0
*CXBIAS_degb XBIAS_degb vsubs 2.7676545e-14
* device instance XBIAS_n2s_t0 r0 *1 0,0
RXBIAS_n2s_t0 XBIAS_n2s__t0 XBIAS_n2s 38.81805
* device instance XBIAS_n2s_t1 r0 *1 0,0
RXBIAS_n2s_t1 XBIAS_n2s__t1 XBIAS_n2s 38.81805
* device instance XBIAS_n2s r0 *1 0,0
*CXBIAS_n2s XBIAS_n2s vsubs 1.7558271e-14
* device instance XBIAS_nb0_t0 r0 *1 0,0
RXBIAS_nb0_t0 XBIAS_nb0__t0 XBIAS_nb0 56.6631
* device instance XBIAS_nb0_t1 r0 *1 0,0
RXBIAS_nb0_t1 XBIAS_nb0__t1 XBIAS_nb0 56.6631
* device instance XBIAS_nb0 r0 *1 0,0
*CXBIAS_nb0 XBIAS_nb0 vsubs 2.5445401e-14
* device instance XBIAS_nb1_t0 r0 *1 0,0
RXBIAS_nb1_t0 XBIAS_nb1__t0 XBIAS_nb1 50.6556
* device instance XBIAS_nb1_t1 r0 *1 0,0
RXBIAS_nb1_t1 XBIAS_nb1__t1 XBIAS_nb1 50.6556
* device instance XBIAS_nb1 r0 *1 0,0
*CXBIAS_nb1 XBIAS_nb1 vsubs 2.2817765e-14
* device instance XBIAS_vb1_t0 r0 *1 0,0
RXBIAS_vb1_t0 XBIAS_vb1__t0 XBIAS_vb1 2.3546325234
* device instance XBIAS_vb1_t1 r0 *1 0,0
RXBIAS_vb1_t1 XBIAS_vb1__t1 XBIAS_vb1 12.0682850222
* device instance XBIAS_vb1_t2 r0 *1 0,0
RXBIAS_vb1_t2 XBIAS_vb1__t2 XBIAS_vb1 12.0682850222
* device instance XBIAS_vb1_t3 r0 *1 0,0
RXBIAS_vb1_t3 XBIAS_vb1__t3 XBIAS_vb1 14.1732799555
* device instance XBIAS_vb1_t4 r0 *1 0,0
RXBIAS_vb1_t4 XBIAS_vb1__t4 XBIAS_vb1 35.9552174766
* device instance XBIAS_vb1 r0 *1 0,0
*CXBIAS_vb1 XBIAS_vb1 vsubs 1.7828352e-14
* device instance XBIAS_vb2_t0 r0 *1 0,0
RXBIAS_vb2_t0 XBIAS_vb2__t0 XBIAS_vb2 50.0237481066
* device instance XBIAS_vb2_t1 r0 *1 0,0
RXBIAS_vb2_t1 XBIAS_vb2__t1 XBIAS_vb2 9.93927790902
* device instance XBIAS_vb2_t2 r0 *1 0,0
RXBIAS_vb2_t2 XBIAS_vb2__t2 XBIAS_vb2 9.93927790902
* device instance XBIAS_vb2_t3 r0 *1 0,0
RXBIAS_vb2_t3 XBIAS_vb2__t3 XBIAS_vb2 11.6944190263
* device instance XBIAS_vb2_t4 r0 *1 0,0
RXBIAS_vb2_t4 XBIAS_vb2__t4 XBIAS_vb2 41.8371770491
* device instance XBIAS_vb2 r0 *1 0,0
*CXBIAS_vb2 XBIAS_vb2 vsubs 2.8251938e-14
* device instance XBIAS_vfixmid_t0 r0 *1 0,0
RXBIAS_vfixmid_t0 XBIAS_vfixmid__t0 XBIAS_vfixmid 3.873775
* device instance XBIAS_vfixmid_t1 r0 *1 0,0
RXBIAS_vfixmid_t1 XBIAS_vfixmid__t1 XBIAS_vfixmid 3.873775
* device instance XBIAS_vfixmid_t2 r0 *1 0,0
RXBIAS_vfixmid_t2 XBIAS_vfixmid__t2 XBIAS_vfixmid 7.74755
* device instance XBIAS_vfixmid r0 *1 0,0
*CXBIAS_vfixmid XBIAS_vfixmid vsubs 4.036878e-15
* device instance XS1_nh_t0 r0 *1 0,0
RXS1_nh_t0 XS1_nh__t0 XS1_nh 17.03015
* device instance XS1_nh_t1 r0 *1 0,0
RXS1_nh_t1 XS1_nh__t1 XS1_nh 17.03015
* device instance XS1_nh r0 *1 0,0
*CXS1_nh XS1_nh vsubs 7.844171e-15
* device instance XS1_nt_t0 r0 *1 0,0
RXS1_nt_t0 XS1_nt__t0 XS1_nt 15.2319
* device instance XS1_nt_t1 r0 *1 0,0
RXS1_nt_t1 XS1_nt__t1 XS1_nt 15.2319
* device instance XS1_nt r0 *1 0,0
*CXS1_nt XS1_nt vsubs 7.135042e-15
* device instance XS2_nh_t0 r0 *1 0,0
RXS2_nh_t0 XS2_nh__t0 XS2_nh 18.1155
* device instance XS2_nh_t1 r0 *1 0,0
RXS2_nh_t1 XS2_nh__t1 XS2_nh 18.1155
* device instance XS2_nh r0 *1 0,0
*CXS2_nh XS2_nh vsubs 8.354016e-15
* device instance XS2_nt_t0 r0 *1 0,0
RXS2_nt_t0 XS2_nt__t0 XS2_nt 15.87725
* device instance XS2_nt_t1 r0 *1 0,0
RXS2_nt_t1 XS2_nt__t1 XS2_nt 15.87725
* device instance XS2_nt r0 *1 0,0
*CXS2_nt XS2_nt vsubs 7.45015e-15
* device instance XS3_nh_t0 r0 *1 0,0
RXS3_nh_t0 XS3_nh__t0 XS3_nh 19.2008
* device instance XS3_nh_t1 r0 *1 0,0
RXS3_nh_t1 XS3_nh__t1 XS3_nh 19.2008
* device instance XS3_nh r0 *1 0,0
*CXS3_nh XS3_nh vsubs 8.86386e-15
* device instance XS3_nt_t0 r0 *1 0,0
RXS3_nt_t0 XS3_nt__t0 XS3_nt 16.52255
* device instance XS3_nt_t1 r0 *1 0,0
RXS3_nt_t1 XS3_nt__t1 XS3_nt 16.52255
* device instance XS3_nt r0 *1 0,0
*CXS3_nt XS3_nt vsubs 7.765258e-15
* device instance XS4_nh_t0 r0 *1 0,0
RXS4_nh_t0 XS4_nh__t0 XS4_nh 20.28615
* device instance XS4_nh_t1 r0 *1 0,0
RXS4_nh_t1 XS4_nh__t1 XS4_nh 20.28615
* device instance XS4_nh r0 *1 0,0
*CXS4_nh XS4_nh vsubs 9.373705e-15
* device instance XS4_nt_t0 r0 *1 0,0
RXS4_nt_t0 XS4_nt__t0 XS4_nt 17.1679
* device instance XS4_nt_t1 r0 *1 0,0
RXS4_nt_t1 XS4_nt__t1 XS4_nt 17.1679
* device instance XS4_nt r0 *1 0,0
*CXS4_nt XS4_nt vsubs 8.080366e-15
* device instance XS5_nh_t0 r0 *1 0,0
RXS5_nh_t0 XS5_nh__t0 XS5_nh 21.3715
* device instance XS5_nh_t1 r0 *1 0,0
RXS5_nh_t1 XS5_nh__t1 XS5_nh 21.3715
* device instance XS5_nh r0 *1 0,0
*CXS5_nh XS5_nh vsubs 9.88355e-15
* device instance XS5_nt_t0 r0 *1 0,0
RXS5_nt_t0 XS5_nt__t0 XS5_nt 17.81325
* device instance XS5_nt_t1 r0 *1 0,0
RXS5_nt_t1 XS5_nt__t1 XS5_nt 17.81325
* device instance XS5_nt r0 *1 0,0
*CXS5_nt XS5_nt vsubs 8.395474e-15
* device instance bufmid_t0 r0 *1 0,0
Rbufmid_t0 bufmid__t0 bufmid 21.3068490949
* device instance bufmid_t1 r0 *1 0,0
Rbufmid_t1 bufmid__t1 bufmid 24.0017509051
* device instance bufmid_t2 r0 *1 0,0
Rbufmid_t2 bufmid__t2 bufmid 23.3257721902
* device instance bufmid_t3 r0 *1 0,0
Rbufmid_t3 bufmid__t3 bufmid 21.9828278098
* device instance bufmid r0 *1 0,0
*Cbufmid bufmid vsubs 2.1083728e-14
* device instance ring1_t0 r0 *1 0,0
Rring1_t0 ring1__t0 ring1 28.5550332542
* device instance ring1_t1 r0 *1 0,0
Rring1_t1 ring1__t1 ring1 10.4370038848
* device instance ring1_t2 r0 *1 0,0
Rring1_t2 ring1__t2 ring1 40.0859725962
* device instance ring1_t3 r0 *1 0,0
Rring1_t3 ring1__t3 ring1 12.070865805
* device instance ring1_t4 r0 *1 0,0
Rring1_t4 ring1__t4 ring1 6.41340252795
* device instance ring1_t5 r0 *1 0,0
Rring1_t5 ring1__t5 ring1 27.6254219319
* device instance ring1 r0 *1 0,0
*Cring1 ring1 vsubs 2.9409734e-14
* device instance ring2_t0 r0 *1 0,0
Rring2_t0 ring2__t0 ring2 19.1192621219
* device instance ring2_t1 r0 *1 0,0
Rring2_t1 ring2__t1 ring2 20.7456378781
* device instance ring2_t2 r0 *1 0,0
Rring2_t2 ring2__t2 ring2 20.3951258617
* device instance ring2_t3 r0 *1 0,0
Rring2_t3 ring2__t3 ring2 19.4697741383
* device instance ring2 r0 *1 0,0
*Cring2 ring2 vsubs 1.8778821e-14
* device instance ring3_t0 r0 *1 0,0
Rring3_t0 ring3__t0 ring3 19.5134384101
* device instance ring3_t1 r0 *1 0,0
Rring3_t1 ring3__t1 ring3 21.1434615899
* device instance ring3_t2 r0 *1 0,0
Rring3_t2 ring3__t2 ring3 20.7921634908
* device instance ring3_t3 r0 *1 0,0
Rring3_t3 ring3__t3 ring3 19.8647365092
* device instance ring3 r0 *1 0,0
*Cring3 ring3 vsubs 1.9149581e-14
* device instance ring4_t0 r0 *1 0,0
Rring4_t0 ring4__t0 ring4 19.9076766591
* device instance ring4_t1 r0 *1 0,0
Rring4_t1 ring4__t1 ring4 21.5412233409
* device instance ring4_t2 r0 *1 0,0
Rring4_t2 ring4__t2 ring4 21.1891658664
* device instance ring4_t3 r0 *1 0,0
Rring4_t3 ring4__t3 ring4 20.2597341336
* device instance ring4 r0 *1 0,0
*Cring4 ring4 vsubs 1.9520341e-14
* device instance ring5_t0 r0 *1 0,0
Rring5_t0 ring5__t0 ring5 24.0125565166
* device instance ring5_t1 r0 *1 0,0
Rring5_t1 ring5__t1 ring5 18.4316877891
* device instance ring5_t2 r0 *1 0,0
Rring5_t2 ring5__t2 ring5 25.5457622109
* device instance ring5_t3 r0 *1 0,0
Rring5_t3 ring5__t3 ring5 19.9648934834
* device instance ring5 r0 *1 0,0
*Cring5 ring5 vsubs 2.067766e-14
* device instance cc_CLK_GND_VCO r0 *1 0,0
*Ccc_CLK_GND_VCO CLK GND_VCO 2.3394e-17
* device instance cc_CLK_VBN r0 *1 0,0
*Ccc_CLK_VBN CLK VBN 1.21e-17
* device instance cc_CLK_VBP r0 *1 0,0
*Ccc_CLK_VBP CLK VBP 4.2352e-17
* device instance cc_CLK_VCTRL r0 *1 0,0
*Ccc_CLK_VCTRL CLK VCTRL 6.05e-18
* device instance cc_CLK_VDD_VCO r0 *1 0,0
*Ccc_CLK_VDD_VCO CLK VDD_VCO 8.9947e-17
* device instance cc_CLK_XBIAS_VFIX r0 *1 0,0
*Ccc_CLK_XBIAS_VFIX CLK XBIAS_VFIX 1.21e-17
* device instance cc_CLK_XBIAS_dega r0 *1 0,0
*Ccc_CLK_XBIAS_dega CLK XBIAS_dega 6.05e-18
* device instance cc_CLK_XBIAS_degb r0 *1 0,0
*Ccc_CLK_XBIAS_degb CLK XBIAS_degb 6.05e-18
* device instance cc_CLK_XBIAS_n2s r0 *1 0,0
*Ccc_CLK_XBIAS_n2s CLK XBIAS_n2s 6.05e-18
* device instance cc_CLK_XBIAS_vb1 r0 *1 0,0
*Ccc_CLK_XBIAS_vb1 CLK XBIAS_vb1 2.4201e-17
* device instance cc_CLK_XBIAS_vb2 r0 *1 0,0
*Ccc_CLK_XBIAS_vb2 CLK XBIAS_vb2 1.8151e-17
* device instance cc_CLK_XS1_nh r0 *1 0,0
*Ccc_CLK_XS1_nh CLK XS1_nh 1.21e-17
* device instance cc_CLK_XS2_nh r0 *1 0,0
*Ccc_CLK_XS2_nh CLK XS2_nh 1.21e-17
* device instance cc_CLK_XS3_nh r0 *1 0,0
*Ccc_CLK_XS3_nh CLK XS3_nh 1.21e-17
* device instance cc_CLK_XS4_nh r0 *1 0,0
*Ccc_CLK_XS4_nh CLK XS4_nh 1.21e-17
* device instance cc_CLK_XS5_nh r0 *1 0,0
*Ccc_CLK_XS5_nh CLK XS5_nh 1.21e-17
* device instance cc_CLK_bufmid r0 *1 0,0
*Ccc_CLK_bufmid CLK bufmid 1.21e-17
* device instance cc_CLK_ring1 r0 *1 0,0
*Ccc_CLK_ring1 CLK ring1 1.8151e-17
* device instance cc_CLK_ring2 r0 *1 0,0
*Ccc_CLK_ring2 CLK ring2 1.21e-17
* device instance cc_CLK_ring3 r0 *1 0,0
*Ccc_CLK_ring3 CLK ring3 1.21e-17
* device instance cc_CLK_ring4 r0 *1 0,0
*Ccc_CLK_ring4 CLK ring4 1.21e-17
* device instance cc_CLK_ring5 r0 *1 0,0
*Ccc_CLK_ring5 CLK ring5 1.21e-17
* device instance cc_GND_VCO_VBN r0 *1 0,0
*Ccc_GND_VCO_VBN GND_VCO VBN 5.3646e-17
* device instance cc_GND_VCO_VBP r0 *1 0,0
*Ccc_GND_VCO_VBP GND_VCO VBP 6.0502e-17
* device instance cc_GND_VCO_VCTRL r0 *1 0,0
*Ccc_GND_VCO_VCTRL GND_VCO VCTRL 6.05e-18
* device instance cc_GND_VCO_VDD_VCO r0 *1 0,0
*Ccc_GND_VCO_VDD_VCO GND_VCO VDD_VCO 1.08905e-16
* device instance cc_GND_VCO_XBIAS_VFIX r0 *1 0,0
*Ccc_GND_VCO_XBIAS_VFIX GND_VCO XBIAS_VFIX 2.4201e-17
* device instance cc_GND_VCO_XBIAS_dega r0 *1 0,0
*Ccc_GND_VCO_XBIAS_dega GND_VCO XBIAS_dega 1.21e-17
* device instance cc_GND_VCO_XBIAS_degb r0 *1 0,0
*Ccc_GND_VCO_XBIAS_degb GND_VCO XBIAS_degb 2.4201e-17
* device instance cc_GND_VCO_XBIAS_n2s r0 *1 0,0
*Ccc_GND_VCO_XBIAS_n2s GND_VCO XBIAS_n2s 1.21e-17
* device instance cc_GND_VCO_XBIAS_nb0 r0 *1 0,0
*Ccc_GND_VCO_XBIAS_nb0 GND_VCO XBIAS_nb0 1.21e-17
* device instance cc_GND_VCO_XBIAS_nb1 r0 *1 0,0
*Ccc_GND_VCO_XBIAS_nb1 GND_VCO XBIAS_nb1 1.21e-17
* device instance cc_GND_VCO_XBIAS_vb1 r0 *1 0,0
*Ccc_GND_VCO_XBIAS_vb1 GND_VCO XBIAS_vb1 3.5495e-17
* device instance cc_GND_VCO_XBIAS_vb2 r0 *1 0,0
*Ccc_GND_VCO_XBIAS_vb2 GND_VCO XBIAS_vb2 3.0251e-17
* device instance cc_GND_VCO_XBIAS_vfixmid r0 *1 0,0
*Ccc_GND_VCO_XBIAS_vfixmid GND_VCO XBIAS_vfixmid 2.3394e-17
* device instance cc_GND_VCO_XS1_nh r0 *1 0,0
*Ccc_GND_VCO_XS1_nh GND_VCO XS1_nh 1.21e-17
* device instance cc_GND_VCO_XS1_nt r0 *1 0,0
*Ccc_GND_VCO_XS1_nt GND_VCO XS1_nt 1.7344e-17
* device instance cc_GND_VCO_XS2_nh r0 *1 0,0
*Ccc_GND_VCO_XS2_nh GND_VCO XS2_nh 1.21e-17
* device instance cc_GND_VCO_XS2_nt r0 *1 0,0
*Ccc_GND_VCO_XS2_nt GND_VCO XS2_nt 1.7344e-17
* device instance cc_GND_VCO_XS3_nh r0 *1 0,0
*Ccc_GND_VCO_XS3_nh GND_VCO XS3_nh 1.21e-17
* device instance cc_GND_VCO_XS3_nt r0 *1 0,0
*Ccc_GND_VCO_XS3_nt GND_VCO XS3_nt 1.7344e-17
* device instance cc_GND_VCO_XS4_nh r0 *1 0,0
*Ccc_GND_VCO_XS4_nh GND_VCO XS4_nh 1.21e-17
* device instance cc_GND_VCO_XS4_nt r0 *1 0,0
*Ccc_GND_VCO_XS4_nt GND_VCO XS4_nt 1.7344e-17
* device instance cc_GND_VCO_XS5_nh r0 *1 0,0
*Ccc_GND_VCO_XS5_nh GND_VCO XS5_nh 1.21e-17
* device instance cc_GND_VCO_XS5_nt r0 *1 0,0
*Ccc_GND_VCO_XS5_nt GND_VCO XS5_nt 1.7344e-17
* device instance cc_GND_VCO_bufmid r0 *1 0,0
*Ccc_GND_VCO_bufmid GND_VCO bufmid 2.9445e-17
* device instance cc_GND_VCO_ring1 r0 *1 0,0
*Ccc_GND_VCO_ring1 GND_VCO ring1 3.6302e-17
* device instance cc_GND_VCO_ring2 r0 *1 0,0
*Ccc_GND_VCO_ring2 GND_VCO ring2 2.4201e-17
* device instance cc_GND_VCO_ring3 r0 *1 0,0
*Ccc_GND_VCO_ring3 GND_VCO ring3 2.4201e-17
* device instance cc_GND_VCO_ring4 r0 *1 0,0
*Ccc_GND_VCO_ring4 GND_VCO ring4 2.4201e-17
* device instance cc_GND_VCO_ring5 r0 *1 0,0
*Ccc_GND_VCO_ring5 GND_VCO ring5 2.4201e-17
* device instance cc_VBN_VBP r0 *1 0,0
*Ccc_VBN_VBP VBN VBP 6.0502e-17
* device instance cc_VBN_VCTRL r0 *1 0,0
*Ccc_VBN_VCTRL VBN VCTRL 6.05e-18
* device instance cc_VBN_VDD_VCO r0 *1 0,0
*Ccc_VBN_VDD_VCO VBN VDD_VCO 1.08098e-16
* device instance cc_VBN_XBIAS_VFIX r0 *1 0,0
*Ccc_VBN_XBIAS_VFIX VBN XBIAS_VFIX 1.21e-17
* device instance cc_VBN_XBIAS_dega r0 *1 0,0
*Ccc_VBN_XBIAS_dega VBN XBIAS_dega 6.05e-18
* device instance cc_VBN_XBIAS_degb r0 *1 0,0
*Ccc_VBN_XBIAS_degb VBN XBIAS_degb 6.05e-18
* device instance cc_VBN_XBIAS_n2s r0 *1 0,0
*Ccc_VBN_XBIAS_n2s VBN XBIAS_n2s 6.05e-18
* device instance cc_VBN_XBIAS_vb1 r0 *1 0,0
*Ccc_VBN_XBIAS_vb1 VBN XBIAS_vb1 2.4201e-17
* device instance cc_VBN_XBIAS_vb2 r0 *1 0,0
*Ccc_VBN_XBIAS_vb2 VBN XBIAS_vb2 1.8151e-17
* device instance cc_VBN_XS1_nh r0 *1 0,0
*Ccc_VBN_XS1_nh VBN XS1_nh 1.21e-17
* device instance cc_VBN_XS1_nt r0 *1 0,0
*Ccc_VBN_XS1_nt VBN XS1_nt 6.05e-18
* device instance cc_VBN_XS2_nh r0 *1 0,0
*Ccc_VBN_XS2_nh VBN XS2_nh 1.21e-17
* device instance cc_VBN_XS2_nt r0 *1 0,0
*Ccc_VBN_XS2_nt VBN XS2_nt 6.05e-18
* device instance cc_VBN_XS3_nh r0 *1 0,0
*Ccc_VBN_XS3_nh VBN XS3_nh 1.21e-17
* device instance cc_VBN_XS3_nt r0 *1 0,0
*Ccc_VBN_XS3_nt VBN XS3_nt 6.05e-18
* device instance cc_VBN_XS4_nh r0 *1 0,0
*Ccc_VBN_XS4_nh VBN XS4_nh 1.21e-17
* device instance cc_VBN_XS4_nt r0 *1 0,0
*Ccc_VBN_XS4_nt VBN XS4_nt 6.05e-18
* device instance cc_VBN_XS5_nh r0 *1 0,0
*Ccc_VBN_XS5_nh VBN XS5_nh 1.21e-17
* device instance cc_VBN_XS5_nt r0 *1 0,0
*Ccc_VBN_XS5_nt VBN XS5_nt 6.05e-18
* device instance cc_VBN_bufmid r0 *1 0,0
*Ccc_VBN_bufmid VBN bufmid 2.4201e-17
* device instance cc_VBN_ring1 r0 *1 0,0
*Ccc_VBN_ring1 VBN ring1 2.4201e-17
* device instance cc_VBN_ring2 r0 *1 0,0
*Ccc_VBN_ring2 VBN ring2 1.21e-17
* device instance cc_VBN_ring3 r0 *1 0,0
*Ccc_VBN_ring3 VBN ring3 1.21e-17
* device instance cc_VBN_ring4 r0 *1 0,0
*Ccc_VBN_ring4 VBN ring4 1.21e-17
* device instance cc_VBN_ring5 r0 *1 0,0
*Ccc_VBN_ring5 VBN ring5 1.21e-17
* device instance cc_VBP_VCTRL r0 *1 0,0
*Ccc_VBP_VCTRL VBP VCTRL 6.05e-18
* device instance cc_VBP_VDD_VCO r0 *1 0,0
*Ccc_VBP_VDD_VCO VBP VDD_VCO 1.02048e-16
* device instance cc_VBP_XBIAS_VFIX r0 *1 0,0
*Ccc_VBP_XBIAS_VFIX VBP XBIAS_VFIX 6.05e-18
* device instance cc_VBP_XBIAS_dega r0 *1 0,0
*Ccc_VBP_XBIAS_dega VBP XBIAS_dega 5.244e-18
* device instance cc_VBP_XBIAS_degb r0 *1 0,0
*Ccc_VBP_XBIAS_degb VBP XBIAS_degb 1.1294e-17
* device instance cc_VBP_XBIAS_n2s r0 *1 0,0
*Ccc_VBP_XBIAS_n2s VBP XBIAS_n2s 6.05e-18
* device instance cc_VBP_XBIAS_vb1 r0 *1 0,0
*Ccc_VBP_XBIAS_vb1 VBP XBIAS_vb1 2.4201e-17
* device instance cc_VBP_XBIAS_vb2 r0 *1 0,0
*Ccc_VBP_XBIAS_vb2 VBP XBIAS_vb2 1.8151e-17
* device instance cc_VBP_XS1_nh r0 *1 0,0
*Ccc_VBP_XS1_nh VBP XS1_nh 1.21e-17
* device instance cc_VBP_XS2_nh r0 *1 0,0
*Ccc_VBP_XS2_nh VBP XS2_nh 1.21e-17
* device instance cc_VBP_XS3_nh r0 *1 0,0
*Ccc_VBP_XS3_nh VBP XS3_nh 1.21e-17
* device instance cc_VBP_XS4_nh r0 *1 0,0
*Ccc_VBP_XS4_nh VBP XS4_nh 1.21e-17
* device instance cc_VBP_XS5_nh r0 *1 0,0
*Ccc_VBP_XS5_nh VBP XS5_nh 1.21e-17
* device instance cc_VBP_bufmid r0 *1 0,0
*Ccc_VBP_bufmid VBP bufmid 1.21e-17
* device instance cc_VBP_ring1 r0 *1 0,0
*Ccc_VBP_ring1 VBP ring1 1.8151e-17
* device instance cc_VBP_ring2 r0 *1 0,0
*Ccc_VBP_ring2 VBP ring2 1.21e-17
* device instance cc_VBP_ring3 r0 *1 0,0
*Ccc_VBP_ring3 VBP ring3 1.21e-17
* device instance cc_VBP_ring4 r0 *1 0,0
*Ccc_VBP_ring4 VBP ring4 1.21e-17
* device instance cc_VBP_ring5 r0 *1 0,0
*Ccc_VBP_ring5 VBP ring5 1.21e-17
* device instance cc_VDD_VCO_XBIAS_VFIX r0 *1 0,0
*Ccc_VDD_VCO_XBIAS_VFIX VDD_VCO XBIAS_VFIX 1.1294e-17
* device instance cc_VDD_VCO_XBIAS_vb1 r0 *1 0,0
*Ccc_VDD_VCO_XBIAS_vb1 VDD_VCO XBIAS_vb1 2.9445e-17
* device instance cc_VDD_VCO_XBIAS_vb2 r0 *1 0,0
*Ccc_VDD_VCO_XBIAS_vb2 VDD_VCO XBIAS_vb2 1.1294e-17
* device instance cc_VDD_VCO_XS1_nh r0 *1 0,0
*Ccc_VDD_VCO_XS1_nh VDD_VCO XS1_nh 1.7344e-17
* device instance cc_VDD_VCO_XS2_nh r0 *1 0,0
*Ccc_VDD_VCO_XS2_nh VDD_VCO XS2_nh 1.7344e-17
* device instance cc_VDD_VCO_XS3_nh r0 *1 0,0
*Ccc_VDD_VCO_XS3_nh VDD_VCO XS3_nh 1.7344e-17
* device instance cc_VDD_VCO_XS4_nh r0 *1 0,0
*Ccc_VDD_VCO_XS4_nh VDD_VCO XS4_nh 1.7344e-17
* device instance cc_VDD_VCO_XS5_nh r0 *1 0,0
*Ccc_VDD_VCO_XS5_nh VDD_VCO XS5_nh 1.7344e-17
* device instance cc_VDD_VCO_bufmid r0 *1 0,0
*Ccc_VDD_VCO_bufmid VDD_VCO bufmid 1.7344e-17
* device instance cc_VDD_VCO_ring1 r0 *1 0,0
*Ccc_VDD_VCO_ring1 VDD_VCO ring1 1.8151e-17
* device instance cc_VDD_VCO_ring2 r0 *1 0,0
*Ccc_VDD_VCO_ring2 VDD_VCO ring2 1.21e-17
* device instance cc_VDD_VCO_ring3 r0 *1 0,0
*Ccc_VDD_VCO_ring3 VDD_VCO ring3 1.21e-17
* device instance cc_VDD_VCO_ring4 r0 *1 0,0
*Ccc_VDD_VCO_ring4 VDD_VCO ring4 1.21e-17
* device instance cc_VDD_VCO_ring5 r0 *1 0,0
*Ccc_VDD_VCO_ring5 VDD_VCO ring5 1.21e-17
* device instance cc_XBIAS_VFIX_XBIAS_dega r0 *1 0,0
*Ccc_XBIAS_VFIX_XBIAS_dega XBIAS_VFIX XBIAS_dega 6.05e-18
* device instance cc_XBIAS_VFIX_XBIAS_degb r0 *1 0,0
*Ccc_XBIAS_VFIX_XBIAS_degb XBIAS_VFIX XBIAS_degb 1.8151e-17
* device instance cc_XBIAS_VFIX_XBIAS_n2s r0 *1 0,0
*Ccc_XBIAS_VFIX_XBIAS_n2s XBIAS_VFIX XBIAS_n2s 6.05e-18
* device instance cc_XBIAS_VFIX_XBIAS_nb0 r0 *1 0,0
*Ccc_XBIAS_VFIX_XBIAS_nb0 XBIAS_VFIX XBIAS_nb0 6.05e-18
* device instance cc_XBIAS_VFIX_XBIAS_nb1 r0 *1 0,0
*Ccc_XBIAS_VFIX_XBIAS_nb1 XBIAS_VFIX XBIAS_nb1 6.05e-18
* device instance cc_XBIAS_VFIX_XBIAS_vb1 r0 *1 0,0
*Ccc_XBIAS_VFIX_XBIAS_vb1 XBIAS_VFIX XBIAS_vb1 6.05e-18
* device instance cc_XBIAS_VFIX_XBIAS_vb2 r0 *1 0,0
*Ccc_XBIAS_VFIX_XBIAS_vb2 XBIAS_VFIX XBIAS_vb2 1.21e-17
* device instance cc_XBIAS_VFIX_XBIAS_vfixmid r0 *1 0,0
*Ccc_XBIAS_VFIX_XBIAS_vfixmid XBIAS_VFIX XBIAS_vfixmid 2.3394e-17
* device instance cc_XBIAS_VFIX_XS1_nt r0 *1 0,0
*Ccc_XBIAS_VFIX_XS1_nt XBIAS_VFIX XS1_nt 6.05e-18
* device instance cc_XBIAS_VFIX_XS2_nt r0 *1 0,0
*Ccc_XBIAS_VFIX_XS2_nt XBIAS_VFIX XS2_nt 6.05e-18
* device instance cc_XBIAS_VFIX_XS3_nt r0 *1 0,0
*Ccc_XBIAS_VFIX_XS3_nt XBIAS_VFIX XS3_nt 6.05e-18
* device instance cc_XBIAS_VFIX_XS4_nt r0 *1 0,0
*Ccc_XBIAS_VFIX_XS4_nt XBIAS_VFIX XS4_nt 6.05e-18
* device instance cc_XBIAS_VFIX_XS5_nt r0 *1 0,0
*Ccc_XBIAS_VFIX_XS5_nt XBIAS_VFIX XS5_nt 6.05e-18
* device instance cc_XBIAS_VFIX_bufmid r0 *1 0,0
*Ccc_XBIAS_VFIX_bufmid XBIAS_VFIX bufmid 1.21e-17
* device instance cc_XBIAS_VFIX_ring1 r0 *1 0,0
*Ccc_XBIAS_VFIX_ring1 XBIAS_VFIX ring1 6.05e-18
* device instance cc_XBIAS_dega_XBIAS_degb r0 *1 0,0
*Ccc_XBIAS_dega_XBIAS_degb XBIAS_dega XBIAS_degb 6.05e-18
* device instance cc_XBIAS_dega_XBIAS_n2s r0 *1 0,0
*Ccc_XBIAS_dega_XBIAS_n2s XBIAS_dega XBIAS_n2s 1.21e-17
* device instance cc_XBIAS_dega_XBIAS_nb1 r0 *1 0,0
*Ccc_XBIAS_dega_XBIAS_nb1 XBIAS_dega XBIAS_nb1 6.05e-18
* device instance cc_XBIAS_dega_XBIAS_vb1 r0 *1 0,0
*Ccc_XBIAS_dega_XBIAS_vb1 XBIAS_dega XBIAS_vb1 2.4201e-17
* device instance cc_XBIAS_dega_XBIAS_vb2 r0 *1 0,0
*Ccc_XBIAS_dega_XBIAS_vb2 XBIAS_dega XBIAS_vb2 2.4201e-17
* device instance cc_XBIAS_dega_XS1_nh r0 *1 0,0
*Ccc_XBIAS_dega_XS1_nh XBIAS_dega XS1_nh 1.21e-17
* device instance cc_XBIAS_dega_XS2_nh r0 *1 0,0
*Ccc_XBIAS_dega_XS2_nh XBIAS_dega XS2_nh 1.21e-17
* device instance cc_XBIAS_dega_XS3_nh r0 *1 0,0
*Ccc_XBIAS_dega_XS3_nh XBIAS_dega XS3_nh 1.21e-17
* device instance cc_XBIAS_dega_XS4_nh r0 *1 0,0
*Ccc_XBIAS_dega_XS4_nh XBIAS_dega XS4_nh 1.21e-17
* device instance cc_XBIAS_dega_XS5_nh r0 *1 0,0
*Ccc_XBIAS_dega_XS5_nh XBIAS_dega XS5_nh 1.21e-17
* device instance cc_XBIAS_dega_bufmid r0 *1 0,0
*Ccc_XBIAS_dega_bufmid XBIAS_dega bufmid 1.21e-17
* device instance cc_XBIAS_dega_ring1 r0 *1 0,0
*Ccc_XBIAS_dega_ring1 XBIAS_dega ring1 1.8151e-17
* device instance cc_XBIAS_dega_ring2 r0 *1 0,0
*Ccc_XBIAS_dega_ring2 XBIAS_dega ring2 1.21e-17
* device instance cc_XBIAS_dega_ring3 r0 *1 0,0
*Ccc_XBIAS_dega_ring3 XBIAS_dega ring3 1.21e-17
* device instance cc_XBIAS_dega_ring4 r0 *1 0,0
*Ccc_XBIAS_dega_ring4 XBIAS_dega ring4 1.21e-17
* device instance cc_XBIAS_dega_ring5 r0 *1 0,0
*Ccc_XBIAS_dega_ring5 XBIAS_dega ring5 1.21e-17
* device instance cc_XBIAS_degb_XBIAS_n2s r0 *1 0,0
*Ccc_XBIAS_degb_XBIAS_n2s XBIAS_degb XBIAS_n2s 1.21e-17
* device instance cc_XBIAS_degb_XBIAS_nb0 r0 *1 0,0
*Ccc_XBIAS_degb_XBIAS_nb0 XBIAS_degb XBIAS_nb0 5.244e-18
* device instance cc_XBIAS_degb_XBIAS_nb1 r0 *1 0,0
*Ccc_XBIAS_degb_XBIAS_nb1 XBIAS_degb XBIAS_nb1 1.7344e-17
* device instance cc_XBIAS_degb_XBIAS_vb1 r0 *1 0,0
*Ccc_XBIAS_degb_XBIAS_vb1 XBIAS_degb XBIAS_vb1 2.4201e-17
* device instance cc_XBIAS_degb_XBIAS_vb2 r0 *1 0,0
*Ccc_XBIAS_degb_XBIAS_vb2 XBIAS_degb XBIAS_vb2 2.4201e-17
* device instance cc_XBIAS_degb_XS1_nh r0 *1 0,0
*Ccc_XBIAS_degb_XS1_nh XBIAS_degb XS1_nh 1.21e-17
* device instance cc_XBIAS_degb_XS1_nt r0 *1 0,0
*Ccc_XBIAS_degb_XS1_nt XBIAS_degb XS1_nt 6.05e-18
* device instance cc_XBIAS_degb_XS2_nh r0 *1 0,0
*Ccc_XBIAS_degb_XS2_nh XBIAS_degb XS2_nh 1.21e-17
* device instance cc_XBIAS_degb_XS2_nt r0 *1 0,0
*Ccc_XBIAS_degb_XS2_nt XBIAS_degb XS2_nt 6.05e-18
* device instance cc_XBIAS_degb_XS3_nh r0 *1 0,0
*Ccc_XBIAS_degb_XS3_nh XBIAS_degb XS3_nh 1.21e-17
* device instance cc_XBIAS_degb_XS3_nt r0 *1 0,0
*Ccc_XBIAS_degb_XS3_nt XBIAS_degb XS3_nt 6.05e-18
* device instance cc_XBIAS_degb_XS4_nh r0 *1 0,0
*Ccc_XBIAS_degb_XS4_nh XBIAS_degb XS4_nh 1.21e-17
* device instance cc_XBIAS_degb_XS4_nt r0 *1 0,0
*Ccc_XBIAS_degb_XS4_nt XBIAS_degb XS4_nt 6.05e-18
* device instance cc_XBIAS_degb_XS5_nh r0 *1 0,0
*Ccc_XBIAS_degb_XS5_nh XBIAS_degb XS5_nh 1.21e-17
* device instance cc_XBIAS_degb_XS5_nt r0 *1 0,0
*Ccc_XBIAS_degb_XS5_nt XBIAS_degb XS5_nt 6.05e-18
* device instance cc_XBIAS_degb_bufmid r0 *1 0,0
*Ccc_XBIAS_degb_bufmid XBIAS_degb bufmid 2.4201e-17
* device instance cc_XBIAS_degb_ring1 r0 *1 0,0
*Ccc_XBIAS_degb_ring1 XBIAS_degb ring1 2.4201e-17
* device instance cc_XBIAS_degb_ring2 r0 *1 0,0
*Ccc_XBIAS_degb_ring2 XBIAS_degb ring2 1.21e-17
* device instance cc_XBIAS_degb_ring3 r0 *1 0,0
*Ccc_XBIAS_degb_ring3 XBIAS_degb ring3 1.21e-17
* device instance cc_XBIAS_degb_ring4 r0 *1 0,0
*Ccc_XBIAS_degb_ring4 XBIAS_degb ring4 1.21e-17
* device instance cc_XBIAS_degb_ring5 r0 *1 0,0
*Ccc_XBIAS_degb_ring5 XBIAS_degb ring5 1.21e-17
* device instance cc_XBIAS_n2s_XBIAS_vb1 r0 *1 0,0
*Ccc_XBIAS_n2s_XBIAS_vb1 XBIAS_n2s XBIAS_vb1 2.4201e-17
* device instance cc_XBIAS_n2s_XBIAS_vb2 r0 *1 0,0
*Ccc_XBIAS_n2s_XBIAS_vb2 XBIAS_n2s XBIAS_vb2 2.3394e-17
* device instance cc_XBIAS_n2s_XS1_nh r0 *1 0,0
*Ccc_XBIAS_n2s_XS1_nh XBIAS_n2s XS1_nh 1.21e-17
* device instance cc_XBIAS_n2s_XS2_nh r0 *1 0,0
*Ccc_XBIAS_n2s_XS2_nh XBIAS_n2s XS2_nh 1.21e-17
* device instance cc_XBIAS_n2s_XS3_nh r0 *1 0,0
*Ccc_XBIAS_n2s_XS3_nh XBIAS_n2s XS3_nh 1.21e-17
* device instance cc_XBIAS_n2s_XS4_nh r0 *1 0,0
*Ccc_XBIAS_n2s_XS4_nh XBIAS_n2s XS4_nh 1.21e-17
* device instance cc_XBIAS_n2s_XS5_nh r0 *1 0,0
*Ccc_XBIAS_n2s_XS5_nh XBIAS_n2s XS5_nh 1.21e-17
* device instance cc_XBIAS_n2s_bufmid r0 *1 0,0
*Ccc_XBIAS_n2s_bufmid XBIAS_n2s bufmid 1.21e-17
* device instance cc_XBIAS_n2s_ring1 r0 *1 0,0
*Ccc_XBIAS_n2s_ring1 XBIAS_n2s ring1 1.8151e-17
* device instance cc_XBIAS_n2s_ring2 r0 *1 0,0
*Ccc_XBIAS_n2s_ring2 XBIAS_n2s ring2 1.21e-17
* device instance cc_XBIAS_n2s_ring3 r0 *1 0,0
*Ccc_XBIAS_n2s_ring3 XBIAS_n2s ring3 1.21e-17
* device instance cc_XBIAS_n2s_ring4 r0 *1 0,0
*Ccc_XBIAS_n2s_ring4 XBIAS_n2s ring4 1.21e-17
* device instance cc_XBIAS_n2s_ring5 r0 *1 0,0
*Ccc_XBIAS_n2s_ring5 XBIAS_n2s ring5 1.21e-17
* device instance cc_XBIAS_nb0_XBIAS_nb1 r0 *1 0,0
*Ccc_XBIAS_nb0_XBIAS_nb1 XBIAS_nb0 XBIAS_nb1 1.21e-17
* device instance cc_XBIAS_nb0_XBIAS_vb1 r0 *1 0,0
*Ccc_XBIAS_nb0_XBIAS_vb1 XBIAS_nb0 XBIAS_vb1 2.4201e-17
* device instance cc_XBIAS_nb0_XBIAS_vb2 r0 *1 0,0
*Ccc_XBIAS_nb0_XBIAS_vb2 XBIAS_nb0 XBIAS_vb2 2.4201e-17
* device instance cc_XBIAS_nb0_XS1_nh r0 *1 0,0
*Ccc_XBIAS_nb0_XS1_nh XBIAS_nb0 XS1_nh 1.21e-17
* device instance cc_XBIAS_nb0_XS1_nt r0 *1 0,0
*Ccc_XBIAS_nb0_XS1_nt XBIAS_nb0 XS1_nt 6.05e-18
* device instance cc_XBIAS_nb0_XS2_nh r0 *1 0,0
*Ccc_XBIAS_nb0_XS2_nh XBIAS_nb0 XS2_nh 1.21e-17
* device instance cc_XBIAS_nb0_XS2_nt r0 *1 0,0
*Ccc_XBIAS_nb0_XS2_nt XBIAS_nb0 XS2_nt 6.05e-18
* device instance cc_XBIAS_nb0_XS3_nh r0 *1 0,0
*Ccc_XBIAS_nb0_XS3_nh XBIAS_nb0 XS3_nh 1.21e-17
* device instance cc_XBIAS_nb0_XS3_nt r0 *1 0,0
*Ccc_XBIAS_nb0_XS3_nt XBIAS_nb0 XS3_nt 6.05e-18
* device instance cc_XBIAS_nb0_XS4_nh r0 *1 0,0
*Ccc_XBIAS_nb0_XS4_nh XBIAS_nb0 XS4_nh 1.21e-17
* device instance cc_XBIAS_nb0_XS4_nt r0 *1 0,0
*Ccc_XBIAS_nb0_XS4_nt XBIAS_nb0 XS4_nt 6.05e-18
* device instance cc_XBIAS_nb0_XS5_nh r0 *1 0,0
*Ccc_XBIAS_nb0_XS5_nh XBIAS_nb0 XS5_nh 1.21e-17
* device instance cc_XBIAS_nb0_XS5_nt r0 *1 0,0
*Ccc_XBIAS_nb0_XS5_nt XBIAS_nb0 XS5_nt 6.05e-18
* device instance cc_XBIAS_nb0_bufmid r0 *1 0,0
*Ccc_XBIAS_nb0_bufmid XBIAS_nb0 bufmid 2.4201e-17
* device instance cc_XBIAS_nb0_ring1 r0 *1 0,0
*Ccc_XBIAS_nb0_ring1 XBIAS_nb0 ring1 2.4201e-17
* device instance cc_XBIAS_nb0_ring2 r0 *1 0,0
*Ccc_XBIAS_nb0_ring2 XBIAS_nb0 ring2 1.21e-17
* device instance cc_XBIAS_nb0_ring3 r0 *1 0,0
*Ccc_XBIAS_nb0_ring3 XBIAS_nb0 ring3 1.21e-17
* device instance cc_XBIAS_nb0_ring4 r0 *1 0,0
*Ccc_XBIAS_nb0_ring4 XBIAS_nb0 ring4 1.21e-17
* device instance cc_XBIAS_nb0_ring5 r0 *1 0,0
*Ccc_XBIAS_nb0_ring5 XBIAS_nb0 ring5 1.21e-17
* device instance cc_XBIAS_nb1_XBIAS_vb1 r0 *1 0,0
*Ccc_XBIAS_nb1_XBIAS_vb1 XBIAS_nb1 XBIAS_vb1 2.4201e-17
* device instance cc_XBIAS_nb1_XBIAS_vb2 r0 *1 0,0
*Ccc_XBIAS_nb1_XBIAS_vb2 XBIAS_nb1 XBIAS_vb2 2.4201e-17
* device instance cc_XBIAS_nb1_XS1_nh r0 *1 0,0
*Ccc_XBIAS_nb1_XS1_nh XBIAS_nb1 XS1_nh 1.21e-17
* device instance cc_XBIAS_nb1_XS1_nt r0 *1 0,0
*Ccc_XBIAS_nb1_XS1_nt XBIAS_nb1 XS1_nt 6.05e-18
* device instance cc_XBIAS_nb1_XS2_nh r0 *1 0,0
*Ccc_XBIAS_nb1_XS2_nh XBIAS_nb1 XS2_nh 1.21e-17
* device instance cc_XBIAS_nb1_XS2_nt r0 *1 0,0
*Ccc_XBIAS_nb1_XS2_nt XBIAS_nb1 XS2_nt 6.05e-18
* device instance cc_XBIAS_nb1_XS3_nh r0 *1 0,0
*Ccc_XBIAS_nb1_XS3_nh XBIAS_nb1 XS3_nh 1.21e-17
* device instance cc_XBIAS_nb1_XS3_nt r0 *1 0,0
*Ccc_XBIAS_nb1_XS3_nt XBIAS_nb1 XS3_nt 6.05e-18
* device instance cc_XBIAS_nb1_XS4_nh r0 *1 0,0
*Ccc_XBIAS_nb1_XS4_nh XBIAS_nb1 XS4_nh 1.21e-17
* device instance cc_XBIAS_nb1_XS4_nt r0 *1 0,0
*Ccc_XBIAS_nb1_XS4_nt XBIAS_nb1 XS4_nt 6.05e-18
* device instance cc_XBIAS_nb1_XS5_nh r0 *1 0,0
*Ccc_XBIAS_nb1_XS5_nh XBIAS_nb1 XS5_nh 1.21e-17
* device instance cc_XBIAS_nb1_XS5_nt r0 *1 0,0
*Ccc_XBIAS_nb1_XS5_nt XBIAS_nb1 XS5_nt 6.05e-18
* device instance cc_XBIAS_nb1_bufmid r0 *1 0,0
*Ccc_XBIAS_nb1_bufmid XBIAS_nb1 bufmid 2.4201e-17
* device instance cc_XBIAS_nb1_ring1 r0 *1 0,0
*Ccc_XBIAS_nb1_ring1 XBIAS_nb1 ring1 2.4201e-17
* device instance cc_XBIAS_nb1_ring2 r0 *1 0,0
*Ccc_XBIAS_nb1_ring2 XBIAS_nb1 ring2 1.21e-17
* device instance cc_XBIAS_nb1_ring3 r0 *1 0,0
*Ccc_XBIAS_nb1_ring3 XBIAS_nb1 ring3 1.21e-17
* device instance cc_XBIAS_nb1_ring4 r0 *1 0,0
*Ccc_XBIAS_nb1_ring4 XBIAS_nb1 ring4 1.21e-17
* device instance cc_XBIAS_nb1_ring5 r0 *1 0,0
*Ccc_XBIAS_nb1_ring5 XBIAS_nb1 ring5 1.21e-17
* device instance cc_XBIAS_vb1_XBIAS_vb2 r0 *1 0,0
*Ccc_XBIAS_vb1_XBIAS_vb2 XBIAS_vb1 XBIAS_vb2 1.21e-17
* device instance cc_XBIAS_vb1_XBIAS_vfixmid r0 *1 0,0
*Ccc_XBIAS_vb1_XBIAS_vfixmid XBIAS_vb1 XBIAS_vfixmid 1.8151e-17
* device instance cc_XBIAS_vb1_XS1_nh r0 *1 0,0
*Ccc_XBIAS_vb1_XS1_nh XBIAS_vb1 XS1_nh 6.05e-18
* device instance cc_XBIAS_vb1_XS1_nt r0 *1 0,0
*Ccc_XBIAS_vb1_XS1_nt XBIAS_vb1 XS1_nt 6.05e-18
* device instance cc_XBIAS_vb1_XS2_nh r0 *1 0,0
*Ccc_XBIAS_vb1_XS2_nh XBIAS_vb1 XS2_nh 6.05e-18
* device instance cc_XBIAS_vb1_XS2_nt r0 *1 0,0
*Ccc_XBIAS_vb1_XS2_nt XBIAS_vb1 XS2_nt 6.05e-18
* device instance cc_XBIAS_vb1_XS3_nh r0 *1 0,0
*Ccc_XBIAS_vb1_XS3_nh XBIAS_vb1 XS3_nh 6.05e-18
* device instance cc_XBIAS_vb1_XS3_nt r0 *1 0,0
*Ccc_XBIAS_vb1_XS3_nt XBIAS_vb1 XS3_nt 6.05e-18
* device instance cc_XBIAS_vb1_XS4_nh r0 *1 0,0
*Ccc_XBIAS_vb1_XS4_nh XBIAS_vb1 XS4_nh 6.05e-18
* device instance cc_XBIAS_vb1_XS4_nt r0 *1 0,0
*Ccc_XBIAS_vb1_XS4_nt XBIAS_vb1 XS4_nt 6.05e-18
* device instance cc_XBIAS_vb1_XS5_nh r0 *1 0,0
*Ccc_XBIAS_vb1_XS5_nh XBIAS_vb1 XS5_nh 6.05e-18
* device instance cc_XBIAS_vb1_XS5_nt r0 *1 0,0
*Ccc_XBIAS_vb1_XS5_nt XBIAS_vb1 XS5_nt 6.05e-18
* device instance cc_XBIAS_vb1_bufmid r0 *1 0,0
*Ccc_XBIAS_vb1_bufmid XBIAS_vb1 bufmid 1.21e-17
* device instance cc_XBIAS_vb1_ring1 r0 *1 0,0
*Ccc_XBIAS_vb1_ring1 XBIAS_vb1 ring1 1.8151e-17
* device instance cc_XBIAS_vb1_ring2 r0 *1 0,0
*Ccc_XBIAS_vb1_ring2 XBIAS_vb1 ring2 1.21e-17
* device instance cc_XBIAS_vb1_ring3 r0 *1 0,0
*Ccc_XBIAS_vb1_ring3 XBIAS_vb1 ring3 1.21e-17
* device instance cc_XBIAS_vb1_ring4 r0 *1 0,0
*Ccc_XBIAS_vb1_ring4 XBIAS_vb1 ring4 1.21e-17
* device instance cc_XBIAS_vb1_ring5 r0 *1 0,0
*Ccc_XBIAS_vb1_ring5 XBIAS_vb1 ring5 1.21e-17
* device instance cc_XBIAS_vb2_XBIAS_vfixmid r0 *1 0,0
*Ccc_XBIAS_vb2_XBIAS_vfixmid XBIAS_vb2 XBIAS_vfixmid 1.8151e-17
* device instance cc_XBIAS_vb2_XS1_nh r0 *1 0,0
*Ccc_XBIAS_vb2_XS1_nh XBIAS_vb2 XS1_nh 1.21e-17
* device instance cc_XBIAS_vb2_XS1_nt r0 *1 0,0
*Ccc_XBIAS_vb2_XS1_nt XBIAS_vb2 XS1_nt 6.05e-18
* device instance cc_XBIAS_vb2_XS2_nh r0 *1 0,0
*Ccc_XBIAS_vb2_XS2_nh XBIAS_vb2 XS2_nh 1.21e-17
* device instance cc_XBIAS_vb2_XS2_nt r0 *1 0,0
*Ccc_XBIAS_vb2_XS2_nt XBIAS_vb2 XS2_nt 6.05e-18
* device instance cc_XBIAS_vb2_XS3_nh r0 *1 0,0
*Ccc_XBIAS_vb2_XS3_nh XBIAS_vb2 XS3_nh 1.21e-17
* device instance cc_XBIAS_vb2_XS3_nt r0 *1 0,0
*Ccc_XBIAS_vb2_XS3_nt XBIAS_vb2 XS3_nt 6.05e-18
* device instance cc_XBIAS_vb2_XS4_nh r0 *1 0,0
*Ccc_XBIAS_vb2_XS4_nh XBIAS_vb2 XS4_nh 1.21e-17
* device instance cc_XBIAS_vb2_XS4_nt r0 *1 0,0
*Ccc_XBIAS_vb2_XS4_nt XBIAS_vb2 XS4_nt 6.05e-18
* device instance cc_XBIAS_vb2_XS5_nh r0 *1 0,0
*Ccc_XBIAS_vb2_XS5_nh XBIAS_vb2 XS5_nh 1.21e-17
* device instance cc_XBIAS_vb2_XS5_nt r0 *1 0,0
*Ccc_XBIAS_vb2_XS5_nt XBIAS_vb2 XS5_nt 6.05e-18
* device instance cc_XBIAS_vb2_bufmid r0 *1 0,0
*Ccc_XBIAS_vb2_bufmid XBIAS_vb2 bufmid 2.4201e-17
* device instance cc_XBIAS_vb2_ring1 r0 *1 0,0
*Ccc_XBIAS_vb2_ring1 XBIAS_vb2 ring1 2.4201e-17
* device instance cc_XBIAS_vb2_ring2 r0 *1 0,0
*Ccc_XBIAS_vb2_ring2 XBIAS_vb2 ring2 1.21e-17
* device instance cc_XBIAS_vb2_ring3 r0 *1 0,0
*Ccc_XBIAS_vb2_ring3 XBIAS_vb2 ring3 1.21e-17
* device instance cc_XBIAS_vb2_ring4 r0 *1 0,0
*Ccc_XBIAS_vb2_ring4 XBIAS_vb2 ring4 1.21e-17
* device instance cc_XBIAS_vb2_ring5 r0 *1 0,0
*Ccc_XBIAS_vb2_ring5 XBIAS_vb2 ring5 1.21e-17
* device instance cc_XS1_nh_XS2_nh r0 *1 0,0
*Ccc_XS1_nh_XS2_nh XS1_nh XS2_nh 6.05e-18
* device instance cc_XS1_nh_XS3_nh r0 *1 0,0
*Ccc_XS1_nh_XS3_nh XS1_nh XS3_nh 6.05e-18
* device instance cc_XS1_nh_XS4_nh r0 *1 0,0
*Ccc_XS1_nh_XS4_nh XS1_nh XS4_nh 6.05e-18
* device instance cc_XS1_nh_XS5_nh r0 *1 0,0
*Ccc_XS1_nh_XS5_nh XS1_nh XS5_nh 6.05e-18
* device instance cc_XS1_nh_ring1 r0 *1 0,0
*Ccc_XS1_nh_ring1 XS1_nh ring1 1.7344e-17
* device instance cc_XS1_nh_ring2 r0 *1 0,0
*Ccc_XS1_nh_ring2 XS1_nh ring2 1.21e-17
* device instance cc_XS1_nh_ring3 r0 *1 0,0
*Ccc_XS1_nh_ring3 XS1_nh ring3 1.21e-17
* device instance cc_XS1_nh_ring4 r0 *1 0,0
*Ccc_XS1_nh_ring4 XS1_nh ring4 1.21e-17
* device instance cc_XS1_nh_ring5 r0 *1 0,0
*Ccc_XS1_nh_ring5 XS1_nh ring5 6.05e-18
* device instance cc_XS1_nt_XS2_nt r0 *1 0,0
*Ccc_XS1_nt_XS2_nt XS1_nt XS2_nt 6.05e-18
* device instance cc_XS1_nt_XS3_nt r0 *1 0,0
*Ccc_XS1_nt_XS3_nt XS1_nt XS3_nt 6.05e-18
* device instance cc_XS1_nt_XS4_nt r0 *1 0,0
*Ccc_XS1_nt_XS4_nt XS1_nt XS4_nt 6.05e-18
* device instance cc_XS1_nt_XS5_nt r0 *1 0,0
*Ccc_XS1_nt_XS5_nt XS1_nt XS5_nt 6.05e-18
* device instance cc_XS1_nt_ring1 r0 *1 0,0
*Ccc_XS1_nt_ring1 XS1_nt ring1 1.7344e-17
* device instance cc_XS1_nt_ring2 r0 *1 0,0
*Ccc_XS1_nt_ring2 XS1_nt ring2 1.21e-17
* device instance cc_XS1_nt_ring3 r0 *1 0,0
*Ccc_XS1_nt_ring3 XS1_nt ring3 1.21e-17
* device instance cc_XS1_nt_ring4 r0 *1 0,0
*Ccc_XS1_nt_ring4 XS1_nt ring4 1.21e-17
* device instance cc_XS1_nt_ring5 r0 *1 0,0
*Ccc_XS1_nt_ring5 XS1_nt ring5 6.05e-18
* device instance cc_XS2_nh_XS3_nh r0 *1 0,0
*Ccc_XS2_nh_XS3_nh XS2_nh XS3_nh 6.05e-18
* device instance cc_XS2_nh_XS4_nh r0 *1 0,0
*Ccc_XS2_nh_XS4_nh XS2_nh XS4_nh 6.05e-18
* device instance cc_XS2_nh_XS5_nh r0 *1 0,0
*Ccc_XS2_nh_XS5_nh XS2_nh XS5_nh 6.05e-18
* device instance cc_XS2_nh_ring2 r0 *1 0,0
*Ccc_XS2_nh_ring2 XS2_nh ring2 1.7344e-17
* device instance cc_XS2_nh_ring3 r0 *1 0,0
*Ccc_XS2_nh_ring3 XS2_nh ring3 1.21e-17
* device instance cc_XS2_nh_ring4 r0 *1 0,0
*Ccc_XS2_nh_ring4 XS2_nh ring4 1.21e-17
* device instance cc_XS2_nh_ring5 r0 *1 0,0
*Ccc_XS2_nh_ring5 XS2_nh ring5 6.05e-18
* device instance cc_XS2_nt_XS3_nt r0 *1 0,0
*Ccc_XS2_nt_XS3_nt XS2_nt XS3_nt 6.05e-18
* device instance cc_XS2_nt_XS4_nt r0 *1 0,0
*Ccc_XS2_nt_XS4_nt XS2_nt XS4_nt 6.05e-18
* device instance cc_XS2_nt_XS5_nt r0 *1 0,0
*Ccc_XS2_nt_XS5_nt XS2_nt XS5_nt 6.05e-18
* device instance cc_XS2_nt_ring2 r0 *1 0,0
*Ccc_XS2_nt_ring2 XS2_nt ring2 1.7344e-17
* device instance cc_XS2_nt_ring3 r0 *1 0,0
*Ccc_XS2_nt_ring3 XS2_nt ring3 1.21e-17
* device instance cc_XS2_nt_ring4 r0 *1 0,0
*Ccc_XS2_nt_ring4 XS2_nt ring4 1.21e-17
* device instance cc_XS2_nt_ring5 r0 *1 0,0
*Ccc_XS2_nt_ring5 XS2_nt ring5 6.05e-18
* device instance cc_XS3_nh_XS4_nh r0 *1 0,0
*Ccc_XS3_nh_XS4_nh XS3_nh XS4_nh 6.05e-18
* device instance cc_XS3_nh_XS5_nh r0 *1 0,0
*Ccc_XS3_nh_XS5_nh XS3_nh XS5_nh 6.05e-18
* device instance cc_XS3_nh_ring3 r0 *1 0,0
*Ccc_XS3_nh_ring3 XS3_nh ring3 1.7344e-17
* device instance cc_XS3_nh_ring4 r0 *1 0,0
*Ccc_XS3_nh_ring4 XS3_nh ring4 1.21e-17
* device instance cc_XS3_nh_ring5 r0 *1 0,0
*Ccc_XS3_nh_ring5 XS3_nh ring5 6.05e-18
* device instance cc_XS3_nt_XS4_nt r0 *1 0,0
*Ccc_XS3_nt_XS4_nt XS3_nt XS4_nt 6.05e-18
* device instance cc_XS3_nt_XS5_nt r0 *1 0,0
*Ccc_XS3_nt_XS5_nt XS3_nt XS5_nt 6.05e-18
* device instance cc_XS3_nt_ring3 r0 *1 0,0
*Ccc_XS3_nt_ring3 XS3_nt ring3 1.7344e-17
* device instance cc_XS3_nt_ring4 r0 *1 0,0
*Ccc_XS3_nt_ring4 XS3_nt ring4 1.21e-17
* device instance cc_XS3_nt_ring5 r0 *1 0,0
*Ccc_XS3_nt_ring5 XS3_nt ring5 6.05e-18
* device instance cc_XS4_nh_XS5_nh r0 *1 0,0
*Ccc_XS4_nh_XS5_nh XS4_nh XS5_nh 6.05e-18
* device instance cc_XS4_nh_ring4 r0 *1 0,0
*Ccc_XS4_nh_ring4 XS4_nh ring4 1.7344e-17
* device instance cc_XS4_nh_ring5 r0 *1 0,0
*Ccc_XS4_nh_ring5 XS4_nh ring5 6.05e-18
* device instance cc_XS4_nt_XS5_nt r0 *1 0,0
*Ccc_XS4_nt_XS5_nt XS4_nt XS5_nt 6.05e-18
* device instance cc_XS4_nt_ring4 r0 *1 0,0
*Ccc_XS4_nt_ring4 XS4_nt ring4 1.7344e-17
* device instance cc_XS4_nt_ring5 r0 *1 0,0
*Ccc_XS4_nt_ring5 XS4_nt ring5 6.05e-18
* device instance cc_XS5_nh_ring5 r0 *1 0,0
*Ccc_XS5_nh_ring5 XS5_nh ring5 1.1294e-17
* device instance cc_XS5_nt_ring5 r0 *1 0,0
*Ccc_XS5_nt_ring5 XS5_nt ring5 1.1294e-17
* device instance cc_bufmid_ring1 r0 *1 0,0
*Ccc_bufmid_ring1 bufmid ring1 1.8151e-17
* device instance cc_bufmid_ring2 r0 *1 0,0
*Ccc_bufmid_ring2 bufmid ring2 1.21e-17
* device instance cc_bufmid_ring3 r0 *1 0,0
*Ccc_bufmid_ring3 bufmid ring3 1.21e-17
* device instance cc_bufmid_ring4 r0 *1 0,0
*Ccc_bufmid_ring4 bufmid ring4 1.21e-17
* device instance cc_bufmid_ring5 r0 *1 0,0
*Ccc_bufmid_ring5 bufmid ring5 1.21e-17
* device instance cc_ring1_ring2 r0 *1 0,0
*Ccc_ring1_ring2 ring1 ring2 2.4201e-17
* device instance cc_ring1_ring3 r0 *1 0,0
*Ccc_ring1_ring3 ring1 ring3 2.4201e-17
* device instance cc_ring1_ring4 r0 *1 0,0
*Ccc_ring1_ring4 ring1 ring4 2.4201e-17
* device instance cc_ring1_ring5 r0 *1 0,0
*Ccc_ring1_ring5 ring1 ring5 1.8151e-17
* device instance cc_ring2_ring3 r0 *1 0,0
*Ccc_ring2_ring3 ring2 ring3 1.21e-17
* device instance cc_ring2_ring4 r0 *1 0,0
*Ccc_ring2_ring4 ring2 ring4 1.21e-17
* device instance cc_ring2_ring5 r0 *1 0,0
*Ccc_ring2_ring5 ring2 ring5 1.21e-17
* device instance cc_ring3_ring4 r0 *1 0,0
*Ccc_ring3_ring4 ring3 ring4 1.21e-17
* device instance cc_ring3_ring5 r0 *1 0,0
*Ccc_ring3_ring5 ring3 ring5 1.21e-17
* device instance cc_ring4_ring5 r0 *1 0,0
*Ccc_ring4_ring5 ring4 ring5 1.21e-17
* device instance vsubs_dctie r0 *1 0,0
Rvsubs_dctie vsubs 0 1e+12
.ENDS pll_vco
