* extracted by klt extract --deck sg13cmos5l
* parasitic model (--parasitics):
* - capacitance: net-to-ground for every net's own (non-coupled) area/perimeter, plus net-to-net for the vertical-overlap coupling `coupling` describes below -- a coupled net pair gets a direct capacitor between their two hub nodes, not just capacitors to the deck's ground/substrate net
* - coupling: vertical overlap (crossover) unconditionally -- where one net's conductor on an adjacent metal level sits directly over another *distinct* net's conductor, that overlap area is charged between the two nets instead of to ground (issue #760) -- plus lateral (same-layer, sidewall) coupling, but only for a net pair naming one of the caller's declared `--critical-net` nets (issue #976): facing-edge length within that layer's own minimum-spacing lookback is charged between the two nets, *additively* (not deducted from either net's substrate fringe term, unlike the vertical case -- a known simplification). Any same-layer pair with neither side named `--critical-net`, and fringe shielding in general, are still not modelled
* - resistance: single lumped series resistance per net, distributed as a star across that net's device terminals (issue #592) -- not a per-segment, distributed RC ladder, *unless* `--distributed-rc` names this net via `--critical-net` (issue #977, Epic #709 Phase 2b): then the net's terminals are ordered along their approximate physical spread and its total R/C is broken into a chain of per-segment resistors (segment length proportional to inter-terminal distance) with a ground capacitor at each terminal node (proportional to its adjacent segment length/2), instead of one star hub -- still an approximation (terminal position is a device-placement proxy, not true per-segment routing geometry), but a strictly finer-grained one than the single-hub star
* - frequency: quasi-static -- one frequency-independent R and C per net; no skin effect, no distributed transmission-line behavior
* - substrate tie: 1e+12 ohm to ground -- the substrate is capacitively floating in transient analysis (DC reference only); see --substrate-tie-ohms
.GLOBAL vsubs

* cell pll_divider_chain
* pin CKIN
* pin CKIN_VCO
* pin DIVOUT
* pin FB
* pin P0
* pin P1
* pin P2
* pin P3
* pin P4
* pin P5
* pin VDD_DIV
* pin VSS
* pin XD0_XDFFM_CLKB
* pin XD0_XDFFM_M
* pin XD0_XDFFM_MB
* pin XD0_XDFFM_S
* pin XD0_XDFFM_SB
* pin XD0_XDFFQ_CLKB
* pin XD0_XDFFQ_M
* pin XD0_XDFFQ_MB
* pin XD0_XDFFQ_S
* pin XD0_XDFFQ_SB
* pin XD0_XN2_mid1
* pin XD0_XN3_mid1
* pin XD0_XN3_mid2
* pin XD0_XNOR_midp
* pin XD0_dmodout
* pin XD0_dq
* pin XD0_nm
* pin XD0_nt
* pin XD0_t1
* pin XD1_XDFFM_CLKB
* pin XD1_XDFFM_M
* pin XD1_XDFFM_MB
* pin XD1_XDFFM_S
* pin XD1_XDFFM_SB
* pin XD1_XDFFQ_CLKB
* pin XD1_XDFFQ_M
* pin XD1_XDFFQ_MB
* pin XD1_XDFFQ_S
* pin XD1_XDFFQ_SB
* pin XD1_XN2_mid1
* pin XD1_XN3_mid1
* pin XD1_XN3_mid2
* pin XD1_XNOR_midp
* pin XD1_dmodout
* pin XD1_dq
* pin XD1_nm
* pin XD1_nt
* pin XD1_t1
* pin XD2_XDFFM_CLKB
* pin XD2_XDFFM_M
* pin XD2_XDFFM_MB
* pin XD2_XDFFM_S
* pin XD2_XDFFM_SB
* pin XD2_XDFFQ_CLKB
* pin XD2_XDFFQ_M
* pin XD2_XDFFQ_MB
* pin XD2_XDFFQ_S
* pin XD2_XDFFQ_SB
* pin XD2_XN2_mid1
* pin XD2_XN3_mid1
* pin XD2_XN3_mid2
* pin XD2_XNOR_midp
* pin XD2_dmodout
* pin XD2_dq
* pin XD2_nm
* pin XD2_nt
* pin XD2_t1
* pin XD3_XDFFM_CLKB
* pin XD3_XDFFM_M
* pin XD3_XDFFM_MB
* pin XD3_XDFFM_S
* pin XD3_XDFFM_SB
* pin XD3_XDFFQ_CLKB
* pin XD3_XDFFQ_M
* pin XD3_XDFFQ_MB
* pin XD3_XDFFQ_S
* pin XD3_XDFFQ_SB
* pin XD3_XN2_mid1
* pin XD3_XN3_mid1
* pin XD3_XN3_mid2
* pin XD3_XNOR_midp
* pin XD3_dmodout
* pin XD3_dq
* pin XD3_nm
* pin XD3_nt
* pin XD3_t1
* pin XD4_XDFFM_CLKB
* pin XD4_XDFFM_M
* pin XD4_XDFFM_MB
* pin XD4_XDFFM_S
* pin XD4_XDFFM_SB
* pin XD4_XDFFQ_CLKB
* pin XD4_XDFFQ_M
* pin XD4_XDFFQ_MB
* pin XD4_XDFFQ_S
* pin XD4_XDFFQ_SB
* pin XD4_XN2_mid1
* pin XD4_XN3_mid1
* pin XD4_XN3_mid2
* pin XD4_XNOR_midp
* pin XD4_dmodout
* pin XD4_dq
* pin XD4_nm
* pin XD4_nt
* pin XD4_t1
* pin XD5_XDFFM_CLKB
* pin XD5_XDFFM_M
* pin XD5_XDFFM_MB
* pin XD5_XDFFM_S
* pin XD5_XDFFM_SB
* pin XD5_XDFFQ_CLKB
* pin XD5_XDFFQ_M
* pin XD5_XDFFQ_MB
* pin XD5_XDFFQ_S
* pin XD5_XDFFQ_SB
* pin XD5_XN2_mid1
* pin XD5_XN3_mid1
* pin XD5_XN3_mid2
* pin XD5_XNOR_midp
* pin XD5_dmodout
* pin XD5_dq
* pin XD5_nm
* pin XD5_nt
* pin XD5_t1
* pin XFRT_CLKB
* pin XFRT_M
* pin XFRT_MB
* pin XFRT_S
* pin XFRT_SB
* pin ck1
* pin ck2
* pin ck3
* pin ck4
* pin ck5
* pin mod0
* pin mod1
* pin mod2
* pin mod3
* pin mod4
* pin net1
.SUBCKT pll_divider_chain CKIN CKIN_VCO DIVOUT FB P0 P1 P2 P3 P4 P5 VDD_DIV VSS
+ XD0_XDFFM_CLKB XD0_XDFFM_M XD0_XDFFM_MB XD0_XDFFM_S XD0_XDFFM_SB
+ XD0_XDFFQ_CLKB XD0_XDFFQ_M XD0_XDFFQ_MB XD0_XDFFQ_S XD0_XDFFQ_SB XD0_XN2_mid1
+ XD0_XN3_mid1 XD0_XN3_mid2 XD0_XNOR_midp XD0_dmodout XD0_dq XD0_nm XD0_nt
+ XD0_t1 XD1_XDFFM_CLKB XD1_XDFFM_M XD1_XDFFM_MB XD1_XDFFM_S XD1_XDFFM_SB
+ XD1_XDFFQ_CLKB XD1_XDFFQ_M XD1_XDFFQ_MB XD1_XDFFQ_S XD1_XDFFQ_SB XD1_XN2_mid1
+ XD1_XN3_mid1 XD1_XN3_mid2 XD1_XNOR_midp XD1_dmodout XD1_dq XD1_nm XD1_nt
+ XD1_t1 XD2_XDFFM_CLKB XD2_XDFFM_M XD2_XDFFM_MB XD2_XDFFM_S XD2_XDFFM_SB
+ XD2_XDFFQ_CLKB XD2_XDFFQ_M XD2_XDFFQ_MB XD2_XDFFQ_S XD2_XDFFQ_SB XD2_XN2_mid1
+ XD2_XN3_mid1 XD2_XN3_mid2 XD2_XNOR_midp XD2_dmodout XD2_dq XD2_nm XD2_nt
+ XD2_t1 XD3_XDFFM_CLKB XD3_XDFFM_M XD3_XDFFM_MB XD3_XDFFM_S XD3_XDFFM_SB
+ XD3_XDFFQ_CLKB XD3_XDFFQ_M XD3_XDFFQ_MB XD3_XDFFQ_S XD3_XDFFQ_SB XD3_XN2_mid1
+ XD3_XN3_mid1 XD3_XN3_mid2 XD3_XNOR_midp XD3_dmodout XD3_dq XD3_nm XD3_nt
+ XD3_t1 XD4_XDFFM_CLKB XD4_XDFFM_M XD4_XDFFM_MB XD4_XDFFM_S XD4_XDFFM_SB
+ XD4_XDFFQ_CLKB XD4_XDFFQ_M XD4_XDFFQ_MB XD4_XDFFQ_S XD4_XDFFQ_SB XD4_XN2_mid1
+ XD4_XN3_mid1 XD4_XN3_mid2 XD4_XNOR_midp XD4_dmodout XD4_dq XD4_nm XD4_nt
+ XD4_t1 XD5_XDFFM_CLKB XD5_XDFFM_M XD5_XDFFM_MB XD5_XDFFM_S XD5_XDFFM_SB
+ XD5_XDFFQ_CLKB XD5_XDFFQ_M XD5_XDFFQ_MB XD5_XDFFQ_S XD5_XDFFQ_SB XD5_XN2_mid1
+ XD5_XN3_mid1 XD5_XN3_mid2 XD5_XNOR_midp XD5_dmodout XD5_dq XD5_nm XD5_nt
+ XD5_t1 XFRT_CLKB XFRT_M XFRT_MB XFRT_S XFRT_SB ck1 ck2 ck3 ck4 ck5 mod0 mod1
+ mod2 mod3 mod4 net1
* device instance $1 r0 *1 2.3,3.11 nfet
X$1 XD0_nt__t5 mod0__t4 XD0_XN3_mid1__t0 VSS__t88 sg13_hv_nmos L=0.5U W=2U
+ AS=0.8P AD=0.8P PS=4.8U PD=4.8U
* device instance $2 r0 *1 6.26,3.11 nfet
X$2 XD0_XN3_mid1__t1 P0__t1 XD0_XN3_mid2__t1 VSS__t89 sg13_hv_nmos L=0.5U W=2U
+ AS=0.8P AD=0.8P PS=4.8U PD=4.8U
* device instance $3 r0 *1 10.22,3.11 nfet
X$3 XD0_XN3_mid2__t0 net1__t2 VSS__t7 VSS__t90 sg13_hv_nmos L=0.5U W=2U AS=0.8P
+ AD=0.8P PS=4.8U PD=4.8U
* device instance $4 r0 *1 14.18,3.11 nfet
X$4 XD0_t1__t3 XD0_nt__t4 VSS__t8 VSS__t91 sg13_hv_nmos L=0.5U W=2U AS=0.8P
+ AD=0.8P PS=4.8U PD=4.8U
* device instance $5 r0 *1 18.14,3.11 nfet
X$5 XD0_dq__t2 ck1__t9 VSS__t9 VSS__t92 sg13_hv_nmos L=0.5U W=2U AS=0.8P
+ AD=0.8P PS=4.8U PD=4.8U
* device instance $6 r0 *1 22.1,3.11 nfet
X$6 XD0_dq__t3 XD0_t1__t2 VSS__t10 VSS__t93 sg13_hv_nmos L=0.5U W=2U AS=0.8P
+ AD=0.8P PS=4.8U PD=4.8U
* device instance $7 r0 *1 26.06,3.11 nfet
X$7 XD0_XDFFQ_CLKB__t5 CKIN__t6 VSS__t29 VSS__t94 sg13_hv_nmos L=0.5U W=2U
+ AS=0.8P AD=0.8P PS=4.8U PD=4.8U
* device instance $8 r0 *1 30.02,3.11 nfet
X$8 XD0_dq__t4 XD0_XDFFQ_CLKB__t3 XD0_XDFFQ_M__t6 VSS__t95 sg13_hv_nmos L=0.5U
+ W=2U AS=0.8P AD=0.8P PS=4.8U PD=4.8U
* device instance $9 r0 *1 33.98,3.11 nfet
X$9 XD0_XDFFQ_MB__t2 XD0_XDFFQ_M__t0 VSS__t36 VSS__t96 sg13_hv_nmos L=0.5U W=2U
+ AS=0.8P AD=0.8P PS=4.8U PD=4.8U
* device instance $10 r0 *1 37.94,3.11 nfet
X$10 XD0_XDFFQ_MB__t3 CKIN__t7 XD0_XDFFQ_M__t7 VSS__t97 sg13_hv_nmos L=0.5U
+ W=2U AS=0.8P AD=0.8P PS=4.8U PD=4.8U
* device instance $11 r0 *1 41.9,3.11 nfet
X$11 XD0_XDFFQ_M__t5 CKIN__t8 XD0_XDFFQ_S__t4 VSS__t98 sg13_hv_nmos L=0.5U W=2U
+ AS=0.8P AD=0.8P PS=4.8U PD=4.8U
* device instance $12 r0 *1 45.86,3.11 nfet
X$12 XD0_XDFFQ_SB__t4 XD0_XDFFQ_S__t3 VSS__t37 VSS__t99 sg13_hv_nmos L=0.5U
+ W=2U AS=0.8P AD=0.8P PS=4.8U PD=4.8U
* device instance $13 r0 *1 49.82,3.11 nfet
X$13 XD0_XDFFQ_SB__t5 XD0_XDFFQ_CLKB__t4 XD0_XDFFQ_S__t5 VSS__t100 sg13_hv_nmos
+ L=0.5U W=2U AS=0.8P AD=0.8P PS=4.8U PD=4.8U
* device instance $14 r0 *1 53.78,3.11 nfet
X$14 ck1__t17 XD0_XDFFQ_SB__t3 VSS__t38 VSS__t101 sg13_hv_nmos L=0.5U W=2U
+ AS=0.8P AD=0.8P PS=4.8U PD=4.8U
* device instance $15 r0 *1 57.74,3.11 nfet
X$15 XD0_nm__t4 mod0__t6 XD0_XN2_mid1__t1 VSS__t102 sg13_hv_nmos L=0.5U W=2U
+ AS=0.8P AD=0.8P PS=4.8U PD=4.8U
* device instance $16 r0 *1 61.7,3.11 nfet
X$16 XD0_XN2_mid1__t0 ck1__t16 VSS__t39 VSS__t103 sg13_hv_nmos L=0.5U W=2U
+ AS=0.8P AD=0.8P PS=4.8U PD=4.8U
* device instance $17 r0 *1 65.66,3.11 nfet
X$17 XD0_dmodout__t3 XD0_nm__t3 VSS__t44 VSS__t104 sg13_hv_nmos L=0.5U W=2U
+ AS=0.8P AD=0.8P PS=4.8U PD=4.8U
* device instance $18 r0 *1 69.62,3.11 nfet
X$18 XD0_XDFFM_CLKB__t5 CKIN__t9 VSS__t40 VSS__t105 sg13_hv_nmos L=0.5U W=2U
+ AS=0.8P AD=0.8P PS=4.8U PD=4.8U
* device instance $19 r0 *1 73.58,3.11 nfet
X$19 XD0_dmodout__t2 XD0_XDFFM_CLKB__t3 XD0_XDFFM_M__t6 VSS__t106 sg13_hv_nmos
+ L=0.5U W=2U AS=0.8P AD=0.8P PS=4.8U PD=4.8U
* device instance $20 r0 *1 77.54,3.11 nfet
X$20 XD0_XDFFM_MB__t2 XD0_XDFFM_M__t4 VSS__t41 VSS__t107 sg13_hv_nmos L=0.5U
+ W=2U AS=0.8P AD=0.8P PS=4.8U PD=4.8U
* device instance $21 r0 *1 81.5,3.11 nfet
X$21 XD0_XDFFM_MB__t3 CKIN__t10 XD0_XDFFM_M__t7 VSS__t108 sg13_hv_nmos L=0.5U
+ W=2U AS=0.8P AD=0.8P PS=4.8U PD=4.8U
* device instance $22 r0 *1 85.46,3.11 nfet
X$22 XD0_XDFFM_M__t5 CKIN__t11 XD0_XDFFM_S__t4 VSS__t109 sg13_hv_nmos L=0.5U
+ W=2U AS=0.8P AD=0.8P PS=4.8U PD=4.8U
* device instance $23 r0 *1 89.42,3.11 nfet
X$23 XD0_XDFFM_SB__t4 XD0_XDFFM_S__t3 VSS__t42 VSS__t110 sg13_hv_nmos L=0.5U
+ W=2U AS=0.8P AD=0.8P PS=4.8U PD=4.8U
* device instance $24 r0 *1 93.38,3.11 nfet
X$24 XD0_XDFFM_SB__t5 XD0_XDFFM_CLKB__t4 XD0_XDFFM_S__t5 VSS__t111 sg13_hv_nmos
+ L=0.5U W=2U AS=0.8P AD=0.8P PS=4.8U PD=4.8U
* device instance $25 r0 *1 97.34,3.11 nfet
X$25 net1__t3 XD0_XDFFM_SB__t3 VSS__t43 VSS__t112 sg13_hv_nmos L=0.5U W=2U
+ AS=0.8P AD=0.8P PS=4.8U PD=4.8U
* device instance $26 r0 *1 101.3,3.11 nfet
X$26 XD1_nt__t5 mod1__t6 XD1_XN3_mid1__t1 VSS__t113 sg13_hv_nmos L=0.5U W=2U
+ AS=0.8P AD=0.8P PS=4.8U PD=4.8U
* device instance $27 r0 *1 105.26,3.11 nfet
X$27 XD1_XN3_mid1__t0 P1__t1 XD1_XN3_mid2__t1 VSS__t114 sg13_hv_nmos L=0.5U
+ W=2U AS=0.8P AD=0.8P PS=4.8U PD=4.8U
* device instance $28 r0 *1 109.22,3.11 nfet
X$28 XD1_XN3_mid2__t0 mod0__t5 VSS__t23 VSS__t115 sg13_hv_nmos L=0.5U W=2U
+ AS=0.8P AD=0.8P PS=4.8U PD=4.8U
* device instance $29 r0 *1 113.18,3.11 nfet
X$29 XD1_t1__t3 XD1_nt__t4 VSS__t24 VSS__t116 sg13_hv_nmos L=0.5U W=2U AS=0.8P
+ AD=0.8P PS=4.8U PD=4.8U
* device instance $30 r0 *1 117.14,3.11 nfet
X$30 XD1_dq__t2 ck2__t9 VSS__t25 VSS__t117 sg13_hv_nmos L=0.5U W=2U AS=0.8P
+ AD=0.8P PS=4.8U PD=4.8U
* device instance $31 r0 *1 121.1,3.11 nfet
X$31 XD1_dq__t3 XD1_t1__t2 VSS__t26 VSS__t118 sg13_hv_nmos L=0.5U W=2U AS=0.8P
+ AD=0.8P PS=4.8U PD=4.8U
* device instance $32 r0 *1 125.06,3.11 nfet
X$32 XD1_XDFFQ_CLKB__t5 ck1__t11 VSS__t27 VSS__t119 sg13_hv_nmos L=0.5U W=2U
+ AS=0.8P AD=0.8P PS=4.8U PD=4.8U
* device instance $33 r0 *1 129.02,3.11 nfet
X$33 XD1_dq__t4 XD1_XDFFQ_CLKB__t3 XD1_XDFFQ_M__t6 VSS__t120 sg13_hv_nmos
+ L=0.5U W=2U AS=0.8P AD=0.8P PS=4.8U PD=4.8U
* device instance $34 r0 *1 132.98,3.11 nfet
X$34 XD1_XDFFQ_MB__t2 XD1_XDFFQ_M__t4 VSS__t28 VSS__t121 sg13_hv_nmos L=0.5U
+ W=2U AS=0.8P AD=0.8P PS=4.8U PD=4.8U
* device instance $35 r0 *1 136.94,3.11 nfet
X$35 XD1_XDFFQ_MB__t3 ck1__t12 XD1_XDFFQ_M__t7 VSS__t122 sg13_hv_nmos L=0.5U
+ W=2U AS=0.8P AD=0.8P PS=4.8U PD=4.8U
* device instance $36 r0 *1 140.9,3.11 nfet
X$36 XD1_XDFFQ_M__t5 ck1__t13 XD1_XDFFQ_S__t4 VSS__t123 sg13_hv_nmos L=0.5U
+ W=2U AS=0.8P AD=0.8P PS=4.8U PD=4.8U
* device instance $37 r0 *1 144.86,3.11 nfet
X$37 XD1_XDFFQ_SB__t5 XD1_XDFFQ_S__t3 VSS__t35 VSS__t124 sg13_hv_nmos L=0.5U
+ W=2U AS=0.8P AD=0.8P PS=4.8U PD=4.8U
* device instance $38 r0 *1 148.82,3.11 nfet
X$38 XD1_XDFFQ_SB__t4 XD1_XDFFQ_CLKB__t4 XD1_XDFFQ_S__t5 VSS__t125 sg13_hv_nmos
+ L=0.5U W=2U AS=0.8P AD=0.8P PS=4.8U PD=4.8U
* device instance $39 r0 *1 152.78,3.11 nfet
X$39 ck2__t17 XD1_XDFFQ_SB__t3 VSS__t30 VSS__t126 sg13_hv_nmos L=0.5U W=2U
+ AS=0.8P AD=0.8P PS=4.8U PD=4.8U
* device instance $40 r0 *1 156.74,3.11 nfet
X$40 XD1_nm__t4 mod1__t5 XD1_XN2_mid1__t1 VSS__t127 sg13_hv_nmos L=0.5U W=2U
+ AS=0.8P AD=0.8P PS=4.8U PD=4.8U
* device instance $41 r0 *1 160.7,3.11 nfet
X$41 XD1_XN2_mid1__t0 ck2__t10 VSS__t31 VSS__t128 sg13_hv_nmos L=0.5U W=2U
+ AS=0.8P AD=0.8P PS=4.8U PD=4.8U
* device instance $42 r0 *1 164.66,3.11 nfet
X$42 XD1_dmodout__t2 XD1_nm__t3 VSS__t32 VSS__t129 sg13_hv_nmos L=0.5U W=2U
+ AS=0.8P AD=0.8P PS=4.8U PD=4.8U
* device instance $43 r0 *1 168.62,3.11 nfet
X$43 XD1_XDFFM_CLKB__t5 ck1__t14 VSS__t33 VSS__t130 sg13_hv_nmos L=0.5U W=2U
+ AS=0.8P AD=0.8P PS=4.8U PD=4.8U
* device instance $44 r0 *1 172.58,3.11 nfet
X$44 XD1_dmodout__t3 XD1_XDFFM_CLKB__t4 XD1_XDFFM_M__t6 VSS__t131 sg13_hv_nmos
+ L=0.5U W=2U AS=0.8P AD=0.8P PS=4.8U PD=4.8U
* device instance $45 r0 *1 176.54,3.11 nfet
X$45 XD1_XDFFM_MB__t2 XD1_XDFFM_M__t4 VSS__t34 VSS__t132 sg13_hv_nmos L=0.5U
+ W=2U AS=0.8P AD=0.8P PS=4.8U PD=4.8U
* device instance $46 r0 *1 180.5,3.11 nfet
X$46 XD1_XDFFM_MB__t3 ck1__t15 XD1_XDFFM_M__t7 VSS__t133 sg13_hv_nmos L=0.5U
+ W=2U AS=0.8P AD=0.8P PS=4.8U PD=4.8U
* device instance $47 r0 *1 184.46,3.11 nfet
X$47 XD1_XDFFM_M__t5 ck1__t10 XD1_XDFFM_S__t5 VSS__t134 sg13_hv_nmos L=0.5U
+ W=2U AS=0.8P AD=0.8P PS=4.8U PD=4.8U
* device instance $48 r0 *1 188.42,3.11 nfet
X$48 XD1_XDFFM_SB__t4 XD1_XDFFM_S__t3 VSS__t5 VSS__t135 sg13_hv_nmos L=0.5U
+ W=2U AS=0.8P AD=0.8P PS=4.8U PD=4.8U
* device instance $49 r0 *1 192.38,3.11 nfet
X$49 XD1_XDFFM_SB__t5 XD1_XDFFM_CLKB__t3 XD1_XDFFM_S__t4 VSS__t136 sg13_hv_nmos
+ L=0.5U W=2U AS=0.8P AD=0.8P PS=4.8U PD=4.8U
* device instance $50 r0 *1 196.34,3.11 nfet
X$50 mod0__t7 XD1_XDFFM_SB__t3 VSS__t6 VSS__t137 sg13_hv_nmos L=0.5U W=2U
+ AS=0.8P AD=0.8P PS=4.8U PD=4.8U
* device instance $51 r0 *1 200.3,3.11 nfet
X$51 XD2_nt__t5 mod2__t4 XD2_XN3_mid1__t1 VSS__t138 sg13_hv_nmos L=0.5U W=2U
+ AS=0.8P AD=0.8P PS=4.8U PD=4.8U
* device instance $52 r0 *1 204.26,3.11 nfet
X$52 XD2_XN3_mid1__t0 P2__t1 XD2_XN3_mid2__t1 VSS__t139 sg13_hv_nmos L=0.5U
+ W=2U AS=0.8P AD=0.8P PS=4.8U PD=4.8U
* device instance $53 r0 *1 208.22,3.11 nfet
X$53 XD2_XN3_mid2__t0 mod1__t4 VSS__t2 VSS__t140 sg13_hv_nmos L=0.5U W=2U
+ AS=0.8P AD=0.8P PS=4.8U PD=4.8U
* device instance $54 r0 *1 212.18,3.11 nfet
X$54 XD2_t1__t3 XD2_nt__t4 VSS__t3 VSS__t141 sg13_hv_nmos L=0.5U W=2U AS=0.8P
+ AD=0.8P PS=4.8U PD=4.8U
* device instance $55 r0 *1 216.14,3.11 nfet
X$55 XD2_dq__t2 ck3__t10 VSS__t4 VSS__t142 sg13_hv_nmos L=0.5U W=2U AS=0.8P
+ AD=0.8P PS=4.8U PD=4.8U
* device instance $56 r0 *1 220.1,3.11 nfet
X$56 XD2_dq__t3 XD2_t1__t2 VSS__t68 VSS__t143 sg13_hv_nmos L=0.5U W=2U AS=0.8P
+ AD=0.8P PS=4.8U PD=4.8U
* device instance $57 r0 *1 224.06,3.11 nfet
X$57 XD2_XDFFQ_CLKB__t5 ck2__t12 VSS__t69 VSS__t144 sg13_hv_nmos L=0.5U W=2U
+ AS=0.8P AD=0.8P PS=4.8U PD=4.8U
* device instance $58 r0 *1 228.02,3.11 nfet
X$58 XD2_dq__t4 XD2_XDFFQ_CLKB__t3 XD2_XDFFQ_M__t6 VSS__t145 sg13_hv_nmos
+ L=0.5U W=2U AS=0.8P AD=0.8P PS=4.8U PD=4.8U
* device instance $59 r0 *1 231.98,3.11 nfet
X$59 XD2_XDFFQ_MB__t2 XD2_XDFFQ_M__t4 VSS__t70 VSS__t146 sg13_hv_nmos L=0.5U
+ W=2U AS=0.8P AD=0.8P PS=4.8U PD=4.8U
* device instance $60 r0 *1 235.94,3.11 nfet
X$60 XD2_XDFFQ_MB__t3 ck2__t13 XD2_XDFFQ_M__t7 VSS__t147 sg13_hv_nmos L=0.5U
+ W=2U AS=0.8P AD=0.8P PS=4.8U PD=4.8U
* device instance $61 r0 *1 239.9,3.11 nfet
X$61 XD2_XDFFQ_M__t5 ck2__t14 XD2_XDFFQ_S__t4 VSS__t148 sg13_hv_nmos L=0.5U
+ W=2U AS=0.8P AD=0.8P PS=4.8U PD=4.8U
* device instance $62 r0 *1 243.86,3.11 nfet
X$62 XD2_XDFFQ_SB__t5 XD2_XDFFQ_S__t3 VSS__t76 VSS__t149 sg13_hv_nmos L=0.5U
+ W=2U AS=0.8P AD=0.8P PS=4.8U PD=4.8U
* device instance $63 r0 *1 247.82,3.11 nfet
X$63 XD2_XDFFQ_SB__t4 XD2_XDFFQ_CLKB__t4 XD2_XDFFQ_S__t5 VSS__t150 sg13_hv_nmos
+ L=0.5U W=2U AS=0.8P AD=0.8P PS=4.8U PD=4.8U
* device instance $64 r0 *1 251.78,3.11 nfet
X$64 ck3__t17 XD2_XDFFQ_SB__t3 VSS__t71 VSS__t151 sg13_hv_nmos L=0.5U W=2U
+ AS=0.8P AD=0.8P PS=4.8U PD=4.8U
* device instance $65 r0 *1 255.74,3.11 nfet
X$65 XD2_nm__t4 mod2__t6 XD2_XN2_mid1__t1 VSS__t152 sg13_hv_nmos L=0.5U W=2U
+ AS=0.8P AD=0.8P PS=4.8U PD=4.8U
* device instance $66 r0 *1 259.7,3.11 nfet
X$66 XD2_XN2_mid1__t0 ck3__t14 VSS__t72 VSS__t153 sg13_hv_nmos L=0.5U W=2U
+ AS=0.8P AD=0.8P PS=4.8U PD=4.8U
* device instance $67 r0 *1 263.66,3.11 nfet
X$67 XD2_dmodout__t2 XD2_nm__t3 VSS__t73 VSS__t154 sg13_hv_nmos L=0.5U W=2U
+ AS=0.8P AD=0.8P PS=4.8U PD=4.8U
* device instance $68 r0 *1 267.62,3.11 nfet
X$68 XD2_XDFFM_CLKB__t5 ck2__t15 VSS__t74 VSS__t155 sg13_hv_nmos L=0.5U W=2U
+ AS=0.8P AD=0.8P PS=4.8U PD=4.8U
* device instance $69 r0 *1 271.58,3.11 nfet
X$69 XD2_dmodout__t3 XD2_XDFFM_CLKB__t4 XD2_XDFFM_M__t6 VSS__t156 sg13_hv_nmos
+ L=0.5U W=2U AS=0.8P AD=0.8P PS=4.8U PD=4.8U
* device instance $70 r0 *1 275.54,3.11 nfet
X$70 XD2_XDFFM_MB__t2 XD2_XDFFM_M__t4 VSS__t75 VSS__t157 sg13_hv_nmos L=0.5U
+ W=2U AS=0.8P AD=0.8P PS=4.8U PD=4.8U
* device instance $71 r0 *1 279.5,3.11 nfet
X$71 XD2_XDFFM_MB__t3 ck2__t16 XD2_XDFFM_M__t7 VSS__t158 sg13_hv_nmos L=0.5U
+ W=2U AS=0.8P AD=0.8P PS=4.8U PD=4.8U
* device instance $72 r0 *1 283.46,3.11 nfet
X$72 XD2_XDFFM_M__t5 ck2__t11 XD2_XDFFM_S__t5 VSS__t159 sg13_hv_nmos L=0.5U
+ W=2U AS=0.8P AD=0.8P PS=4.8U PD=4.8U
* device instance $73 r0 *1 287.42,3.11 nfet
X$73 XD2_XDFFM_SB__t4 XD2_XDFFM_S__t3 VSS__t11 VSS__t160 sg13_hv_nmos L=0.5U
+ W=2U AS=0.8P AD=0.8P PS=4.8U PD=4.8U
* device instance $74 r0 *1 291.38,3.11 nfet
X$74 XD2_XDFFM_SB__t5 XD2_XDFFM_CLKB__t3 XD2_XDFFM_S__t4 VSS__t161 sg13_hv_nmos
+ L=0.5U W=2U AS=0.8P AD=0.8P PS=4.8U PD=4.8U
* device instance $75 r0 *1 295.34,3.11 nfet
X$75 mod1__t7 XD2_XDFFM_SB__t3 VSS__t12 VSS__t162 sg13_hv_nmos L=0.5U W=2U
+ AS=0.8P AD=0.8P PS=4.8U PD=4.8U
* device instance $76 r0 *1 299.3,3.11 nfet
X$76 XD3_nt__t5 mod3__t4 XD3_XN3_mid1__t1 VSS__t163 sg13_hv_nmos L=0.5U W=2U
+ AS=0.8P AD=0.8P PS=4.8U PD=4.8U
* device instance $77 r0 *1 303.26,3.11 nfet
X$77 XD3_XN3_mid1__t0 P3__t1 XD3_XN3_mid2__t1 VSS__t164 sg13_hv_nmos L=0.5U
+ W=2U AS=0.8P AD=0.8P PS=4.8U PD=4.8U
* device instance $78 r0 *1 307.22,3.11 nfet
X$78 XD3_XN3_mid2__t0 mod2__t5 VSS__t13 VSS__t165 sg13_hv_nmos L=0.5U W=2U
+ AS=0.8P AD=0.8P PS=4.8U PD=4.8U
* device instance $79 r0 *1 311.18,3.11 nfet
X$79 XD3_t1__t3 XD3_nt__t4 VSS__t14 VSS__t166 sg13_hv_nmos L=0.5U W=2U AS=0.8P
+ AD=0.8P PS=4.8U PD=4.8U
* device instance $80 r0 *1 315.14,3.11 nfet
X$80 XD3_dq__t2 ck4__t9 VSS__t15 VSS__t167 sg13_hv_nmos L=0.5U W=2U AS=0.8P
+ AD=0.8P PS=4.8U PD=4.8U
* device instance $81 r0 *1 319.1,3.11 nfet
X$81 XD3_dq__t3 XD3_t1__t2 VSS__t16 VSS__t168 sg13_hv_nmos L=0.5U W=2U AS=0.8P
+ AD=0.8P PS=4.8U PD=4.8U
* device instance $82 r0 *1 323.06,3.11 nfet
X$82 XD3_XDFFQ_CLKB__t5 ck3__t13 VSS__t22 VSS__t169 sg13_hv_nmos L=0.5U W=2U
+ AS=0.8P AD=0.8P PS=4.8U PD=4.8U
* device instance $83 r0 *1 327.02,3.11 nfet
X$83 XD3_dq__t4 XD3_XDFFQ_CLKB__t3 XD3_XDFFQ_M__t6 VSS__t170 sg13_hv_nmos
+ L=0.5U W=2U AS=0.8P AD=0.8P PS=4.8U PD=4.8U
* device instance $84 r0 *1 330.98,3.11 nfet
X$84 XD3_XDFFQ_MB__t2 XD3_XDFFQ_M__t4 VSS__t18 VSS__t171 sg13_hv_nmos L=0.5U
+ W=2U AS=0.8P AD=0.8P PS=4.8U PD=4.8U
* device instance $85 r0 *1 334.94,3.11 nfet
X$85 XD3_XDFFQ_MB__t3 ck3__t11 XD3_XDFFQ_M__t7 VSS__t172 sg13_hv_nmos L=0.5U
+ W=2U AS=0.8P AD=0.8P PS=4.8U PD=4.8U
* device instance $86 r0 *1 338.9,3.11 nfet
X$86 XD3_XDFFQ_M__t5 ck3__t12 XD3_XDFFQ_S__t4 VSS__t173 sg13_hv_nmos L=0.5U
+ W=2U AS=0.8P AD=0.8P PS=4.8U PD=4.8U
* device instance $87 r0 *1 342.86,3.11 nfet
X$87 XD3_XDFFQ_SB__t4 XD3_XDFFQ_S__t3 VSS__t19 VSS__t174 sg13_hv_nmos L=0.5U
+ W=2U AS=0.8P AD=0.8P PS=4.8U PD=4.8U
* device instance $88 r0 *1 346.82,3.11 nfet
X$88 XD3_XDFFQ_SB__t5 XD3_XDFFQ_CLKB__t4 XD3_XDFFQ_S__t5 VSS__t175 sg13_hv_nmos
+ L=0.5U W=2U AS=0.8P AD=0.8P PS=4.8U PD=4.8U
* device instance $89 r0 *1 350.78,3.11 nfet
X$89 ck4__t17 XD3_XDFFQ_SB__t3 VSS__t20 VSS__t176 sg13_hv_nmos L=0.5U W=2U
+ AS=0.8P AD=0.8P PS=4.8U PD=4.8U
* device instance $90 r0 *1 354.74,3.11 nfet
X$90 XD3_nm__t4 mod3__t5 XD3_XN2_mid1__t1 VSS__t177 sg13_hv_nmos L=0.5U W=2U
+ AS=0.8P AD=0.8P PS=4.8U PD=4.8U
* device instance $91 r0 *1 358.7,3.11 nfet
X$91 XD3_XN2_mid1__t0 ck4__t10 VSS__t21 VSS__t178 sg13_hv_nmos L=0.5U W=2U
+ AS=0.8P AD=0.8P PS=4.8U PD=4.8U
* device instance $92 r0 *1 362.66,3.11 nfet
X$92 XD3_dmodout__t3 XD3_nm__t3 VSS__t17 VSS__t179 sg13_hv_nmos L=0.5U W=2U
+ AS=0.8P AD=0.8P PS=4.8U PD=4.8U
* device instance $93 r0 *1 366.62,3.11 nfet
X$93 XD3_XDFFM_CLKB__t5 ck3__t9 VSS__t0 VSS__t180 sg13_hv_nmos L=0.5U W=2U
+ AS=0.8P AD=0.8P PS=4.8U PD=4.8U
* device instance $94 r0 *1 370.58,3.11 nfet
X$94 XD3_dmodout__t2 XD3_XDFFM_CLKB__t3 XD3_XDFFM_M__t6 VSS__t181 sg13_hv_nmos
+ L=0.5U W=2U AS=0.8P AD=0.8P PS=4.8U PD=4.8U
* device instance $95 r0 *1 374.54,3.11 nfet
X$95 XD3_XDFFM_MB__t2 XD3_XDFFM_M__t4 VSS__t1 VSS__t182 sg13_hv_nmos L=0.5U
+ W=2U AS=0.8P AD=0.8P PS=4.8U PD=4.8U
* device instance $96 r0 *1 378.5,3.11 nfet
X$96 XD3_XDFFM_MB__t3 ck3__t16 XD3_XDFFM_M__t7 VSS__t183 sg13_hv_nmos L=0.5U
+ W=2U AS=0.8P AD=0.8P PS=4.8U PD=4.8U
* device instance $97 r0 *1 382.46,3.11 nfet
X$97 XD3_XDFFM_M__t5 ck3__t15 XD3_XDFFM_S__t4 VSS__t184 sg13_hv_nmos L=0.5U
+ W=2U AS=0.8P AD=0.8P PS=4.8U PD=4.8U
* device instance $98 r0 *1 386.42,3.11 nfet
X$98 XD3_XDFFM_SB__t4 XD3_XDFFM_S__t3 VSS__t83 VSS__t185 sg13_hv_nmos L=0.5U
+ W=2U AS=0.8P AD=0.8P PS=4.8U PD=4.8U
* device instance $99 r0 *1 390.38,3.11 nfet
X$99 XD3_XDFFM_SB__t5 XD3_XDFFM_CLKB__t4 XD3_XDFFM_S__t5 VSS__t186 sg13_hv_nmos
+ L=0.5U W=2U AS=0.8P AD=0.8P PS=4.8U PD=4.8U
* device instance $100 r0 *1 394.34,3.11 nfet
X$100 mod2__t7 XD3_XDFFM_SB__t3 VSS__t84 VSS__t187 sg13_hv_nmos L=0.5U W=2U
+ AS=0.8P AD=0.8P PS=4.8U PD=4.8U
* device instance $101 r0 *1 398.3,3.11 nfet
X$101 XD4_nt__t5 mod4__t6 XD4_XN3_mid1__t1 VSS__t188 sg13_hv_nmos L=0.5U W=2U
+ AS=0.8P AD=0.8P PS=4.8U PD=4.8U
* device instance $102 r0 *1 402.26,3.11 nfet
X$102 XD4_XN3_mid1__t0 P4__t1 XD4_XN3_mid2__t1 VSS__t189 sg13_hv_nmos L=0.5U
+ W=2U AS=0.8P AD=0.8P PS=4.8U PD=4.8U
* device instance $103 r0 *1 406.22,3.11 nfet
X$103 XD4_XN3_mid2__t0 mod3__t6 VSS__t85 VSS__t190 sg13_hv_nmos L=0.5U W=2U
+ AS=0.8P AD=0.8P PS=4.8U PD=4.8U
* device instance $104 r0 *1 410.18,3.11 nfet
X$104 XD4_t1__t3 XD4_nt__t4 VSS__t86 VSS__t191 sg13_hv_nmos L=0.5U W=2U AS=0.8P
+ AD=0.8P PS=4.8U PD=4.8U
* device instance $105 r0 *1 414.14,3.11 nfet
X$105 XD4_dq__t4 ck5__t16 VSS__t87 VSS__t192 sg13_hv_nmos L=0.5U W=2U AS=0.8P
+ AD=0.8P PS=4.8U PD=4.8U
* device instance $106 r0 *1 418.1,3.11 nfet
X$106 XD4_dq__t3 XD4_t1__t2 VSS__t82 VSS__t193 sg13_hv_nmos L=0.5U W=2U AS=0.8P
+ AD=0.8P PS=4.8U PD=4.8U
* device instance $107 r0 *1 422.06,3.11 nfet
X$107 XD4_XDFFQ_CLKB__t5 ck4__t16 VSS__t66 VSS__t194 sg13_hv_nmos L=0.5U W=2U
+ AS=0.8P AD=0.8P PS=4.8U PD=4.8U
* device instance $108 r0 *1 426.02,3.11 nfet
X$108 XD4_dq__t2 XD4_XDFFQ_CLKB__t4 XD4_XDFFQ_M__t7 VSS__t195 sg13_hv_nmos
+ L=0.5U W=2U AS=0.8P AD=0.8P PS=4.8U PD=4.8U
* device instance $109 r0 *1 429.98,3.11 nfet
X$109 XD4_XDFFQ_MB__t3 XD4_XDFFQ_M__t4 VSS__t67 VSS__t196 sg13_hv_nmos L=0.5U
+ W=2U AS=0.8P AD=0.8P PS=4.8U PD=4.8U
* device instance $110 r0 *1 433.94,3.11 nfet
X$110 XD4_XDFFQ_MB__t2 ck4__t11 XD4_XDFFQ_M__t6 VSS__t197 sg13_hv_nmos L=0.5U
+ W=2U AS=0.8P AD=0.8P PS=4.8U PD=4.8U
* device instance $111 r0 *1 437.9,3.11 nfet
X$111 XD4_XDFFQ_M__t5 ck4__t12 XD4_XDFFQ_S__t4 VSS__t198 sg13_hv_nmos L=0.5U
+ W=2U AS=0.8P AD=0.8P PS=4.8U PD=4.8U
* device instance $112 r0 *1 441.86,3.11 nfet
X$112 XD4_XDFFQ_SB__t4 XD4_XDFFQ_S__t3 VSS__t55 VSS__t199 sg13_hv_nmos L=0.5U
+ W=2U AS=0.8P AD=0.8P PS=4.8U PD=4.8U
* device instance $113 r0 *1 445.82,3.11 nfet
X$113 XD4_XDFFQ_SB__t5 XD4_XDFFQ_CLKB__t3 XD4_XDFFQ_S__t5 VSS__t200
+ sg13_hv_nmos L=0.5U W=2U AS=0.8P AD=0.8P PS=4.8U PD=4.8U
* device instance $114 r0 *1 449.78,3.11 nfet
X$114 ck5__t17 XD4_XDFFQ_SB__t3 VSS__t56 VSS__t201 sg13_hv_nmos L=0.5U W=2U
+ AS=0.8P AD=0.8P PS=4.8U PD=4.8U
* device instance $115 r0 *1 453.74,3.11 nfet
X$115 XD4_nm__t4 mod4__t4 XD4_XN2_mid1__t1 VSS__t202 sg13_hv_nmos L=0.5U W=2U
+ AS=0.8P AD=0.8P PS=4.8U PD=4.8U
* device instance $116 r0 *1 457.7,3.11 nfet
X$116 XD4_XN2_mid1__t0 ck5__t15 VSS__t57 VSS__t203 sg13_hv_nmos L=0.5U W=2U
+ AS=0.8P AD=0.8P PS=4.8U PD=4.8U
* device instance $117 r0 *1 461.66,3.11 nfet
X$117 XD4_dmodout__t2 XD4_nm__t3 VSS__t58 VSS__t204 sg13_hv_nmos L=0.5U W=2U
+ AS=0.8P AD=0.8P PS=4.8U PD=4.8U
* device instance $118 r0 *1 465.62,3.11 nfet
X$118 XD4_XDFFM_CLKB__t5 ck4__t13 VSS__t59 VSS__t205 sg13_hv_nmos L=0.5U W=2U
+ AS=0.8P AD=0.8P PS=4.8U PD=4.8U
* device instance $119 r0 *1 469.58,3.11 nfet
X$119 XD4_dmodout__t3 XD4_XDFFM_CLKB__t3 XD4_XDFFM_M__t6 VSS__t206 sg13_hv_nmos
+ L=0.5U W=2U AS=0.8P AD=0.8P PS=4.8U PD=4.8U
* device instance $120 r0 *1 473.54,3.11 nfet
X$120 XD4_XDFFM_MB__t3 XD4_XDFFM_M__t4 VSS__t65 VSS__t207 sg13_hv_nmos L=0.5U
+ W=2U AS=0.8P AD=0.8P PS=4.8U PD=4.8U
* device instance $121 r0 *1 477.5,3.11 nfet
X$121 XD4_XDFFM_MB__t2 ck4__t14 XD4_XDFFM_M__t7 VSS__t208 sg13_hv_nmos L=0.5U
+ W=2U AS=0.8P AD=0.8P PS=4.8U PD=4.8U
* device instance $122 r0 *1 481.46,3.11 nfet
X$122 XD4_XDFFM_M__t5 ck4__t15 XD4_XDFFM_S__t4 VSS__t209 sg13_hv_nmos L=0.5U
+ W=2U AS=0.8P AD=0.8P PS=4.8U PD=4.8U
* device instance $123 r0 *1 485.42,3.11 nfet
X$123 XD4_XDFFM_SB__t4 XD4_XDFFM_S__t3 VSS__t61 VSS__t210 sg13_hv_nmos L=0.5U
+ W=2U AS=0.8P AD=0.8P PS=4.8U PD=4.8U
* device instance $124 r0 *1 489.38,3.11 nfet
X$124 XD4_XDFFM_SB__t5 XD4_XDFFM_CLKB__t4 XD4_XDFFM_S__t5 VSS__t211
+ sg13_hv_nmos L=0.5U W=2U AS=0.8P AD=0.8P PS=4.8U PD=4.8U
* device instance $125 r0 *1 493.34,3.11 nfet
X$125 mod3__t7 XD4_XDFFM_SB__t3 VSS__t62 VSS__t212 sg13_hv_nmos L=0.5U W=2U
+ AS=0.8P AD=0.8P PS=4.8U PD=4.8U
* device instance $126 r0 *1 497.3,3.11 nfet
X$126 XD5_nt__t5 VDD_DIV__t261 XD5_XN3_mid1__t1 VSS__t213 sg13_hv_nmos L=0.5U
+ W=2U AS=0.8P AD=0.8P PS=4.8U PD=4.8U
* device instance $127 r0 *1 501.26,3.11 nfet
X$127 XD5_XN3_mid1__t0 P5__t1 XD5_XN3_mid2__t1 VSS__t214 sg13_hv_nmos L=0.5U
+ W=2U AS=0.8P AD=0.8P PS=4.8U PD=4.8U
* device instance $128 r0 *1 505.22,3.11 nfet
X$128 XD5_XN3_mid2__t0 mod4__t5 VSS__t63 VSS__t215 sg13_hv_nmos L=0.5U W=2U
+ AS=0.8P AD=0.8P PS=4.8U PD=4.8U
* device instance $129 r0 *1 509.18,3.11 nfet
X$129 XD5_t1__t3 XD5_nt__t4 VSS__t64 VSS__t216 sg13_hv_nmos L=0.5U W=2U AS=0.8P
+ AD=0.8P PS=4.8U PD=4.8U
* device instance $130 r0 *1 513.14,3.11 nfet
X$130 XD5_dq__t4 DIVOUT__t5 VSS__t60 VSS__t217 sg13_hv_nmos L=0.5U W=2U AS=0.8P
+ AD=0.8P PS=4.8U PD=4.8U
* device instance $131 r0 *1 517.1,3.11 nfet
X$131 XD5_dq__t2 XD5_t1__t2 VSS__t45 VSS__t218 sg13_hv_nmos L=0.5U W=2U AS=0.8P
+ AD=0.8P PS=4.8U PD=4.8U
* device instance $132 r0 *1 521.06,3.11 nfet
X$132 XD5_XDFFQ_CLKB__t5 ck5__t9 VSS__t46 VSS__t219 sg13_hv_nmos L=0.5U W=2U
+ AS=0.8P AD=0.8P PS=4.8U PD=4.8U
* device instance $133 r0 *1 525.02,3.11 nfet
X$133 XD5_dq__t3 XD5_XDFFQ_CLKB__t3 XD5_XDFFQ_M__t6 VSS__t220 sg13_hv_nmos
+ L=0.5U W=2U AS=0.8P AD=0.8P PS=4.8U PD=4.8U
* device instance $134 r0 *1 528.98,3.11 nfet
X$134 XD5_XDFFQ_MB__t2 XD5_XDFFQ_M__t4 VSS__t47 VSS__t221 sg13_hv_nmos L=0.5U
+ W=2U AS=0.8P AD=0.8P PS=4.8U PD=4.8U
* device instance $135 r0 *1 532.94,3.11 nfet
X$135 XD5_XDFFQ_MB__t3 ck5__t10 XD5_XDFFQ_M__t7 VSS__t222 sg13_hv_nmos L=0.5U
+ W=2U AS=0.8P AD=0.8P PS=4.8U PD=4.8U
* device instance $136 r0 *1 536.9,3.11 nfet
X$136 XD5_XDFFQ_M__t5 ck5__t11 XD5_XDFFQ_S__t4 VSS__t223 sg13_hv_nmos L=0.5U
+ W=2U AS=0.8P AD=0.8P PS=4.8U PD=4.8U
* device instance $137 r0 *1 540.86,3.11 nfet
X$137 XD5_XDFFQ_SB__t4 XD5_XDFFQ_S__t3 VSS__t48 VSS__t224 sg13_hv_nmos L=0.5U
+ W=2U AS=0.8P AD=0.8P PS=4.8U PD=4.8U
* device instance $138 r0 *1 544.82,3.11 nfet
X$138 XD5_XDFFQ_SB__t5 XD5_XDFFQ_CLKB__t4 XD5_XDFFQ_S__t5 VSS__t225
+ sg13_hv_nmos L=0.5U W=2U AS=0.8P AD=0.8P PS=4.8U PD=4.8U
* device instance $139 r0 *1 548.78,3.11 nfet
X$139 DIVOUT__t6 XD5_XDFFQ_SB__t3 VSS__t49 VSS__t226 sg13_hv_nmos L=0.5U W=2U
+ AS=0.8P AD=0.8P PS=4.8U PD=4.8U
* device instance $140 r0 *1 552.74,3.11 nfet
X$140 XD5_nm__t4 VDD_DIV__t260 XD5_XN2_mid1__t1 VSS__t227 sg13_hv_nmos L=0.5U
+ W=2U AS=0.8P AD=0.8P PS=4.8U PD=4.8U
* device instance $141 r0 *1 556.7,3.11 nfet
X$141 XD5_XN2_mid1__t0 DIVOUT__t4 VSS__t50 VSS__t228 sg13_hv_nmos L=0.5U W=2U
+ AS=0.8P AD=0.8P PS=4.8U PD=4.8U
* device instance $142 r0 *1 560.66,3.11 nfet
X$142 XD5_dmodout__t2 XD5_nm__t3 VSS__t51 VSS__t229 sg13_hv_nmos L=0.5U W=2U
+ AS=0.8P AD=0.8P PS=4.8U PD=4.8U
* device instance $143 r0 *1 564.62,3.11 nfet
X$143 XD5_XDFFM_CLKB__t5 ck5__t12 VSS__t52 VSS__t230 sg13_hv_nmos L=0.5U W=2U
+ AS=0.8P AD=0.8P PS=4.8U PD=4.8U
* device instance $144 r0 *1 568.58,3.11 nfet
X$144 XD5_dmodout__t3 XD5_XDFFM_CLKB__t3 XD5_XDFFM_M__t6 VSS__t231 sg13_hv_nmos
+ L=0.5U W=2U AS=0.8P AD=0.8P PS=4.8U PD=4.8U
* device instance $145 r0 *1 572.54,3.11 nfet
X$145 XD5_XDFFM_MB__t2 XD5_XDFFM_M__t4 VSS__t53 VSS__t232 sg13_hv_nmos L=0.5U
+ W=2U AS=0.8P AD=0.8P PS=4.8U PD=4.8U
* device instance $146 r0 *1 576.5,3.11 nfet
X$146 XD5_XDFFM_MB__t3 ck5__t13 XD5_XDFFM_M__t7 VSS__t233 sg13_hv_nmos L=0.5U
+ W=2U AS=0.8P AD=0.8P PS=4.8U PD=4.8U
* device instance $147 r0 *1 580.46,3.11 nfet
X$147 XD5_XDFFM_M__t5 ck5__t14 XD5_XDFFM_S__t4 VSS__t234 sg13_hv_nmos L=0.5U
+ W=2U AS=0.8P AD=0.8P PS=4.8U PD=4.8U
* device instance $148 r0 *1 584.42,3.11 nfet
X$148 XD5_XDFFM_SB__t4 XD5_XDFFM_S__t3 VSS__t54 VSS__t235 sg13_hv_nmos L=0.5U
+ W=2U AS=0.8P AD=0.8P PS=4.8U PD=4.8U
* device instance $149 r0 *1 588.38,3.11 nfet
X$149 XD5_XDFFM_SB__t5 XD5_XDFFM_CLKB__t4 XD5_XDFFM_S__t5 VSS__t236
+ sg13_hv_nmos L=0.5U W=2U AS=0.8P AD=0.8P PS=4.8U PD=4.8U
* device instance $150 r0 *1 592.34,3.11 nfet
X$150 mod4__t7 XD5_XDFFM_SB__t3 VSS__t77 VSS__t237 sg13_hv_nmos L=0.5U W=2U
+ AS=0.8P AD=0.8P PS=4.8U PD=4.8U
* device instance $151 r0 *1 596.3,3.11 nfet
X$151 XFRT_CLKB__t5 CKIN_VCO__t3 VSS__t78 VSS__t238 sg13_hv_nmos L=0.5U W=2U
+ AS=0.8P AD=0.8P PS=4.8U PD=4.8U
* device instance $152 r0 *1 600.26,3.11 nfet
X$152 DIVOUT__t7 XFRT_CLKB__t3 XFRT_M__t6 VSS__t239 sg13_hv_nmos L=0.5U W=2U
+ AS=0.8P AD=0.8P PS=4.8U PD=4.8U
* device instance $153 r0 *1 604.22,3.11 nfet
X$153 XFRT_MB__t2 XFRT_M__t4 VSS__t79 VSS__t240 sg13_hv_nmos L=0.5U W=2U
+ AS=0.8P AD=0.8P PS=4.8U PD=4.8U
* device instance $154 r0 *1 608.18,3.11 nfet
X$154 XFRT_MB__t3 CKIN_VCO__t4 XFRT_M__t7 VSS__t241 sg13_hv_nmos L=0.5U W=2U
+ AS=0.8P AD=0.8P PS=4.8U PD=4.8U
* device instance $155 r0 *1 612.14,3.11 nfet
X$155 XFRT_M__t5 CKIN_VCO__t5 XFRT_S__t4 VSS__t242 sg13_hv_nmos L=0.5U W=2U
+ AS=0.8P AD=0.8P PS=4.8U PD=4.8U
* device instance $156 r0 *1 616.1,3.11 nfet
X$156 XFRT_SB__t4 XFRT_S__t3 VSS__t80 VSS__t243 sg13_hv_nmos L=0.5U W=2U
+ AS=0.8P AD=0.8P PS=4.8U PD=4.8U
* device instance $157 r0 *1 620.06,3.11 nfet
X$157 XFRT_SB__t5 XFRT_CLKB__t4 XFRT_S__t5 VSS__t244 sg13_hv_nmos L=0.5U W=2U
+ AS=0.8P AD=0.8P PS=4.8U PD=4.8U
* device instance $158 r0 *1 624.02,3.11 nfet
X$158 FB__t1 XFRT_SB__t3 VSS__t81 VSS__t245 sg13_hv_nmos L=0.5U W=2U AS=0.8P
+ AD=0.8P PS=4.8U PD=4.8U
* device instance $159 r0 *1 636.12,3.11 pfet
X$159 XD0_nt__t3 mod0__t2 VDD_DIV__t1 VDD_DIV__t0 sg13_hv_pmos L=0.5U W=5U
+ AS=2P AD=2P PS=10.8U PD=10.8U
* device instance $160 r0 *1 643.08,3.11 pfet
X$160 XD0_nt__t1 P0__t0 VDD_DIV__t45 VDD_DIV__t167 sg13_hv_pmos L=0.5U W=5U
+ AS=2P AD=2P PS=10.8U PD=10.8U
* device instance $161 r0 *1 650.04,3.11 pfet
X$161 XD0_nt__t2 net1__t0 VDD_DIV__t46 VDD_DIV__t168 sg13_hv_pmos L=0.5U W=5U
+ AS=2P AD=2P PS=10.8U PD=10.8U
* device instance $162 r0 *1 657,3.11 pfet
X$162 XD0_t1__t1 XD0_nt__t0 VDD_DIV__t47 VDD_DIV__t169 sg13_hv_pmos L=0.5U W=5U
+ AS=2P AD=2P PS=10.8U PD=10.8U
* device instance $163 r0 *1 663.96,3.11 pfet
X$163 XD0_XNOR_midp__t0 ck1__t3 VDD_DIV__t53 VDD_DIV__t180 sg13_hv_pmos L=0.5U
+ W=5U AS=2P AD=2P PS=10.8U PD=10.8U
* device instance $164 r0 *1 670.92,3.11 pfet
X$164 XD0_dq__t0 XD0_t1__t0 XD0_XNOR_midp__t1 VDD_DIV__t171 sg13_hv_pmos L=0.5U
+ W=5U AS=2P AD=2P PS=10.8U PD=10.8U
* device instance $165 r0 *1 677.88,3.11 pfet
X$165 XD0_XDFFQ_CLKB__t2 CKIN__t3 VDD_DIV__t49 VDD_DIV__t172 sg13_hv_pmos
+ L=0.5U W=5U AS=2P AD=2P PS=10.8U PD=10.8U
* device instance $166 r0 *1 684.84,3.11 pfet
X$166 XD0_XDFFQ_M__t2 CKIN__t4 XD0_dq__t1 VDD_DIV__t173 sg13_hv_pmos L=0.5U
+ W=5U AS=2P AD=2P PS=10.8U PD=10.8U
* device instance $167 r0 *1 691.8,3.11 pfet
X$167 XD0_XDFFQ_MB__t0 XD0_XDFFQ_M__t1 VDD_DIV__t50 VDD_DIV__t174 sg13_hv_pmos
+ L=0.5U W=5U AS=2P AD=2P PS=10.8U PD=10.8U
* device instance $168 r0 *1 698.76,3.11 pfet
X$168 XD0_XDFFQ_M__t3 XD0_XDFFQ_CLKB__t0 XD0_XDFFQ_MB__t1 VDD_DIV__t175
+ sg13_hv_pmos L=0.5U W=5U AS=2P AD=2P PS=10.8U PD=10.8U
* device instance $169 r0 *1 705.72,3.11 pfet
X$169 XD0_XDFFQ_S__t1 XD0_XDFFQ_CLKB__t1 XD0_XDFFQ_M__t4 VDD_DIV__t176
+ sg13_hv_pmos L=0.5U W=5U AS=2P AD=2P PS=10.8U PD=10.8U
* device instance $170 r0 *1 712.68,3.11 pfet
X$170 XD0_XDFFQ_SB__t1 XD0_XDFFQ_S__t0 VDD_DIV__t51 VDD_DIV__t177 sg13_hv_pmos
+ L=0.5U W=5U AS=2P AD=2P PS=10.8U PD=10.8U
* device instance $171 r0 *1 719.64,3.11 pfet
X$171 XD0_XDFFQ_S__t2 CKIN__t5 XD0_XDFFQ_SB__t2 VDD_DIV__t178 sg13_hv_pmos
+ L=0.5U W=5U AS=2P AD=2P PS=10.8U PD=10.8U
* device instance $172 r0 *1 726.6,3.11 pfet
X$172 ck1__t8 XD0_XDFFQ_SB__t0 VDD_DIV__t52 VDD_DIV__t179 sg13_hv_pmos L=0.5U
+ W=5U AS=2P AD=2P PS=10.8U PD=10.8U
* device instance $173 r0 *1 733.56,3.11 pfet
X$173 XD0_nm__t2 mod0__t1 VDD_DIV__t48 VDD_DIV__t170 sg13_hv_pmos L=0.5U W=5U
+ AS=2P AD=2P PS=10.8U PD=10.8U
* device instance $174 r0 *1 740.52,3.11 pfet
X$174 XD0_nm__t1 ck1__t0 VDD_DIV__t29 VDD_DIV__t142 sg13_hv_pmos L=0.5U W=5U
+ AS=2P AD=2P PS=10.8U PD=10.8U
* device instance $175 r0 *1 747.48,3.11 pfet
X$175 XD0_dmodout__t0 XD0_nm__t0 VDD_DIV__t30 VDD_DIV__t143 sg13_hv_pmos L=0.5U
+ W=5U AS=2P AD=2P PS=10.8U PD=10.8U
* device instance $176 r0 *1 754.44,3.11 pfet
X$176 XD0_XDFFM_CLKB__t2 CKIN__t0 VDD_DIV__t31 VDD_DIV__t144 sg13_hv_pmos
+ L=0.5U W=5U AS=2P AD=2P PS=10.8U PD=10.8U
* device instance $177 r0 *1 761.4,3.11 pfet
X$177 XD0_XDFFM_M__t1 CKIN__t1 XD0_dmodout__t1 VDD_DIV__t145 sg13_hv_pmos
+ L=0.5U W=5U AS=2P AD=2P PS=10.8U PD=10.8U
* device instance $178 r0 *1 768.36,3.11 pfet
X$178 XD0_XDFFM_MB__t0 XD0_XDFFM_M__t0 VDD_DIV__t32 VDD_DIV__t146 sg13_hv_pmos
+ L=0.5U W=5U AS=2P AD=2P PS=10.8U PD=10.8U
* device instance $179 r0 *1 775.32,3.11 pfet
X$179 XD0_XDFFM_M__t2 XD0_XDFFM_CLKB__t0 XD0_XDFFM_MB__t1 VDD_DIV__t147
+ sg13_hv_pmos L=0.5U W=5U AS=2P AD=2P PS=10.8U PD=10.8U
* device instance $180 r0 *1 782.28,3.11 pfet
X$180 XD0_XDFFM_S__t1 XD0_XDFFM_CLKB__t1 XD0_XDFFM_M__t3 VDD_DIV__t148
+ sg13_hv_pmos L=0.5U W=5U AS=2P AD=2P PS=10.8U PD=10.8U
* device instance $181 r0 *1 789.24,3.11 pfet
X$181 XD0_XDFFM_SB__t1 XD0_XDFFM_S__t0 VDD_DIV__t33 VDD_DIV__t149 sg13_hv_pmos
+ L=0.5U W=5U AS=2P AD=2P PS=10.8U PD=10.8U
* device instance $182 r0 *1 796.2,3.11 pfet
X$182 XD0_XDFFM_S__t2 CKIN__t2 XD0_XDFFM_SB__t2 VDD_DIV__t160 sg13_hv_pmos
+ L=0.5U W=5U AS=2P AD=2P PS=10.8U PD=10.8U
* device instance $183 r0 *1 803.16,3.11 pfet
X$183 net1__t1 XD0_XDFFM_SB__t0 VDD_DIV__t35 VDD_DIV__t151 sg13_hv_pmos L=0.5U
+ W=5U AS=2P AD=2P PS=10.8U PD=10.8U
* device instance $184 r0 *1 810.12,3.11 pfet
X$184 XD1_nt__t1 mod1__t1 VDD_DIV__t36 VDD_DIV__t152 sg13_hv_pmos L=0.5U W=5U
+ AS=2P AD=2P PS=10.8U PD=10.8U
* device instance $185 r0 *1 817.08,3.11 pfet
X$185 XD1_nt__t2 P1__t0 VDD_DIV__t37 VDD_DIV__t153 sg13_hv_pmos L=0.5U W=5U
+ AS=2P AD=2P PS=10.8U PD=10.8U
* device instance $186 r0 *1 824.04,3.11 pfet
X$186 XD1_nt__t3 mod0__t0 VDD_DIV__t38 VDD_DIV__t154 sg13_hv_pmos L=0.5U W=5U
+ AS=2P AD=2P PS=10.8U PD=10.8U
* device instance $187 r0 *1 831,3.11 pfet
X$187 XD1_t1__t1 XD1_nt__t0 VDD_DIV__t39 VDD_DIV__t155 sg13_hv_pmos L=0.5U W=5U
+ AS=2P AD=2P PS=10.8U PD=10.8U
* device instance $188 r0 *1 837.96,3.11 pfet
X$188 XD1_XNOR_midp__t0 ck2__t6 VDD_DIV__t40 VDD_DIV__t156 sg13_hv_pmos L=0.5U
+ W=5U AS=2P AD=2P PS=10.8U PD=10.8U
* device instance $189 r0 *1 844.92,3.11 pfet
X$189 XD1_dq__t0 XD1_t1__t0 XD1_XNOR_midp__t1 VDD_DIV__t157 sg13_hv_pmos L=0.5U
+ W=5U AS=2P AD=2P PS=10.8U PD=10.8U
* device instance $190 r0 *1 851.88,3.11 pfet
X$190 XD1_XDFFQ_CLKB__t2 ck1__t1 VDD_DIV__t41 VDD_DIV__t158 sg13_hv_pmos L=0.5U
+ W=5U AS=2P AD=2P PS=10.8U PD=10.8U
* device instance $191 r0 *1 858.84,3.11 pfet
X$191 XD1_XDFFQ_M__t1 ck1__t2 XD1_dq__t1 VDD_DIV__t159 sg13_hv_pmos L=0.5U W=5U
+ AS=2P AD=2P PS=10.8U PD=10.8U
* device instance $192 r0 *1 865.8,3.11 pfet
X$192 XD1_XDFFQ_MB__t0 XD1_XDFFQ_M__t0 VDD_DIV__t11 VDD_DIV__t111 sg13_hv_pmos
+ L=0.5U W=5U AS=2P AD=2P PS=10.8U PD=10.8U
* device instance $193 r0 *1 872.76,3.11 pfet
X$193 XD1_XDFFQ_M__t2 XD1_XDFFQ_CLKB__t0 XD1_XDFFQ_MB__t1 VDD_DIV__t165
+ sg13_hv_pmos L=0.5U W=5U AS=2P AD=2P PS=10.8U PD=10.8U
* device instance $194 r0 *1 879.72,3.11 pfet
X$194 XD1_XDFFQ_S__t1 XD1_XDFFQ_CLKB__t1 XD1_XDFFQ_M__t3 VDD_DIV__t166
+ sg13_hv_pmos L=0.5U W=5U AS=2P AD=2P PS=10.8U PD=10.8U
* device instance $195 r0 *1 886.68,3.11 pfet
X$195 XD1_XDFFQ_SB__t1 XD1_XDFFQ_S__t0 VDD_DIV__t81 VDD_DIV__t224 sg13_hv_pmos
+ L=0.5U W=5U AS=2P AD=2P PS=10.8U PD=10.8U
* device instance $196 r0 *1 893.64,3.11 pfet
X$196 XD1_XDFFQ_S__t2 ck1__t4 XD1_XDFFQ_SB__t2 VDD_DIV__t225 sg13_hv_pmos
+ L=0.5U W=5U AS=2P AD=2P PS=10.8U PD=10.8U
* device instance $197 r0 *1 900.6,3.11 pfet
X$197 ck2__t8 XD1_XDFFQ_SB__t0 VDD_DIV__t82 VDD_DIV__t226 sg13_hv_pmos L=0.5U
+ W=5U AS=2P AD=2P PS=10.8U PD=10.8U
* device instance $198 r0 *1 907.56,3.11 pfet
X$198 XD1_nm__t1 mod1__t2 VDD_DIV__t83 VDD_DIV__t227 sg13_hv_pmos L=0.5U W=5U
+ AS=2P AD=2P PS=10.8U PD=10.8U
* device instance $199 r0 *1 914.52,3.11 pfet
X$199 XD1_nm__t2 ck2__t7 VDD_DIV__t84 VDD_DIV__t228 sg13_hv_pmos L=0.5U W=5U
+ AS=2P AD=2P PS=10.8U PD=10.8U
* device instance $200 r0 *1 921.48,3.11 pfet
X$200 XD1_dmodout__t0 XD1_nm__t0 VDD_DIV__t91 VDD_DIV__t239 sg13_hv_pmos L=0.5U
+ W=5U AS=2P AD=2P PS=10.8U PD=10.8U
* device instance $201 r0 *1 928.44,3.11 pfet
X$201 XD1_XDFFM_CLKB__t2 ck1__t5 VDD_DIV__t86 VDD_DIV__t230 sg13_hv_pmos L=0.5U
+ W=5U AS=2P AD=2P PS=10.8U PD=10.8U
* device instance $202 r0 *1 935.4,3.11 pfet
X$202 XD1_XDFFM_M__t1 ck1__t6 XD1_dmodout__t1 VDD_DIV__t231 sg13_hv_pmos L=0.5U
+ W=5U AS=2P AD=2P PS=10.8U PD=10.8U
* device instance $203 r0 *1 942.36,3.11 pfet
X$203 XD1_XDFFM_MB__t0 XD1_XDFFM_M__t0 VDD_DIV__t87 VDD_DIV__t232 sg13_hv_pmos
+ L=0.5U W=5U AS=2P AD=2P PS=10.8U PD=10.8U
* device instance $204 r0 *1 949.32,3.11 pfet
X$204 XD1_XDFFM_M__t2 XD1_XDFFM_CLKB__t0 XD1_XDFFM_MB__t1 VDD_DIV__t233
+ sg13_hv_pmos L=0.5U W=5U AS=2P AD=2P PS=10.8U PD=10.8U
* device instance $205 r0 *1 956.28,3.11 pfet
X$205 XD1_XDFFM_S__t1 XD1_XDFFM_CLKB__t1 XD1_XDFFM_M__t3 VDD_DIV__t234
+ sg13_hv_pmos L=0.5U W=5U AS=2P AD=2P PS=10.8U PD=10.8U
* device instance $206 r0 *1 963.24,3.11 pfet
X$206 XD1_XDFFM_SB__t1 XD1_XDFFM_S__t0 VDD_DIV__t88 VDD_DIV__t235 sg13_hv_pmos
+ L=0.5U W=5U AS=2P AD=2P PS=10.8U PD=10.8U
* device instance $207 r0 *1 970.2,3.11 pfet
X$207 XD1_XDFFM_S__t2 ck1__t7 XD1_XDFFM_SB__t2 VDD_DIV__t236 sg13_hv_pmos
+ L=0.5U W=5U AS=2P AD=2P PS=10.8U PD=10.8U
* device instance $208 r0 *1 977.16,3.11 pfet
X$208 mod0__t3 XD1_XDFFM_SB__t0 VDD_DIV__t89 VDD_DIV__t237 sg13_hv_pmos L=0.5U
+ W=5U AS=2P AD=2P PS=10.8U PD=10.8U
* device instance $209 r0 *1 984.12,3.11 pfet
X$209 XD2_nt__t3 mod2__t2 VDD_DIV__t90 VDD_DIV__t238 sg13_hv_pmos L=0.5U W=5U
+ AS=2P AD=2P PS=10.8U PD=10.8U
* device instance $210 r0 *1 991.08,3.11 pfet
X$210 XD2_nt__t2 P2__t0 VDD_DIV__t59 VDD_DIV__t189 sg13_hv_pmos L=0.5U W=5U
+ AS=2P AD=2P PS=10.8U PD=10.8U
* device instance $211 r0 *1 998.04,3.11 pfet
X$211 XD2_nt__t1 mod1__t0 VDD_DIV__t17 VDD_DIV__t122 sg13_hv_pmos L=0.5U W=5U
+ AS=2P AD=2P PS=10.8U PD=10.8U
* device instance $212 r0 *1 1005,3.11 pfet
X$212 XD2_t1__t1 XD2_nt__t0 VDD_DIV__t18 VDD_DIV__t123 sg13_hv_pmos L=0.5U W=5U
+ AS=2P AD=2P PS=10.8U PD=10.8U
* device instance $213 r0 *1 1011.96,3.11 pfet
X$213 XD2_XNOR_midp__t0 ck3__t3 VDD_DIV__t19 VDD_DIV__t124 sg13_hv_pmos L=0.5U
+ W=5U AS=2P AD=2P PS=10.8U PD=10.8U
* device instance $214 r0 *1 1018.92,3.11 pfet
X$214 XD2_dq__t0 XD2_t1__t0 XD2_XNOR_midp__t1 VDD_DIV__t125 sg13_hv_pmos L=0.5U
+ W=5U AS=2P AD=2P PS=10.8U PD=10.8U
* device instance $215 r0 *1 1025.88,3.11 pfet
X$215 XD2_XDFFQ_CLKB__t2 ck2__t1 VDD_DIV__t20 VDD_DIV__t126 sg13_hv_pmos L=0.5U
+ W=5U AS=2P AD=2P PS=10.8U PD=10.8U
* device instance $216 r0 *1 1032.84,3.11 pfet
X$216 XD2_XDFFQ_M__t1 ck2__t2 XD2_dq__t1 VDD_DIV__t127 sg13_hv_pmos L=0.5U W=5U
+ AS=2P AD=2P PS=10.8U PD=10.8U
* device instance $217 r0 *1 1039.8,3.11 pfet
X$217 XD2_XDFFQ_MB__t0 XD2_XDFFQ_M__t0 VDD_DIV__t21 VDD_DIV__t128 sg13_hv_pmos
+ L=0.5U W=5U AS=2P AD=2P PS=10.8U PD=10.8U
* device instance $218 r0 *1 1046.76,3.11 pfet
X$218 XD2_XDFFQ_M__t2 XD2_XDFFQ_CLKB__t0 XD2_XDFFQ_MB__t1 VDD_DIV__t129
+ sg13_hv_pmos L=0.5U W=5U AS=2P AD=2P PS=10.8U PD=10.8U
* device instance $219 r0 *1 1053.72,3.11 pfet
X$219 XD2_XDFFQ_S__t1 XD2_XDFFQ_CLKB__t1 XD2_XDFFQ_M__t3 VDD_DIV__t130
+ sg13_hv_pmos L=0.5U W=5U AS=2P AD=2P PS=10.8U PD=10.8U
* device instance $220 r0 *1 1060.68,3.11 pfet
X$220 XD2_XDFFQ_SB__t1 XD2_XDFFQ_S__t0 VDD_DIV__t28 VDD_DIV__t141 sg13_hv_pmos
+ L=0.5U W=5U AS=2P AD=2P PS=10.8U PD=10.8U
* device instance $221 r0 *1 1067.64,3.11 pfet
X$221 XD2_XDFFQ_S__t2 ck2__t3 XD2_XDFFQ_SB__t2 VDD_DIV__t132 sg13_hv_pmos
+ L=0.5U W=5U AS=2P AD=2P PS=10.8U PD=10.8U
* device instance $222 r0 *1 1074.6,3.11 pfet
X$222 ck3__t8 XD2_XDFFQ_SB__t0 VDD_DIV__t22 VDD_DIV__t133 sg13_hv_pmos L=0.5U
+ W=5U AS=2P AD=2P PS=10.8U PD=10.8U
* device instance $223 r0 *1 1081.56,3.11 pfet
X$223 XD2_nm__t1 mod2__t1 VDD_DIV__t23 VDD_DIV__t134 sg13_hv_pmos L=0.5U W=5U
+ AS=2P AD=2P PS=10.8U PD=10.8U
* device instance $224 r0 *1 1088.52,3.11 pfet
X$224 XD2_nm__t2 ck3__t4 VDD_DIV__t24 VDD_DIV__t135 sg13_hv_pmos L=0.5U W=5U
+ AS=2P AD=2P PS=10.8U PD=10.8U
* device instance $225 r0 *1 1095.48,3.11 pfet
X$225 XD2_dmodout__t0 XD2_nm__t0 VDD_DIV__t25 VDD_DIV__t136 sg13_hv_pmos L=0.5U
+ W=5U AS=2P AD=2P PS=10.8U PD=10.8U
* device instance $226 r0 *1 1102.44,3.11 pfet
X$226 XD2_XDFFM_CLKB__t2 ck2__t4 VDD_DIV__t26 VDD_DIV__t137 sg13_hv_pmos L=0.5U
+ W=5U AS=2P AD=2P PS=10.8U PD=10.8U
* device instance $227 r0 *1 1109.4,3.11 pfet
X$227 XD2_XDFFM_M__t1 ck2__t5 XD2_dmodout__t1 VDD_DIV__t138 sg13_hv_pmos L=0.5U
+ W=5U AS=2P AD=2P PS=10.8U PD=10.8U
* device instance $228 r0 *1 1116.36,3.11 pfet
X$228 XD2_XDFFM_MB__t0 XD2_XDFFM_M__t0 VDD_DIV__t27 VDD_DIV__t139 sg13_hv_pmos
+ L=0.5U W=5U AS=2P AD=2P PS=10.8U PD=10.8U
* device instance $229 r0 *1 1123.32,3.11 pfet
X$229 XD2_XDFFM_M__t2 XD2_XDFFM_CLKB__t1 XD2_XDFFM_MB__t1 VDD_DIV__t140
+ sg13_hv_pmos L=0.5U W=5U AS=2P AD=2P PS=10.8U PD=10.8U
* device instance $230 r0 *1 1130.28,3.11 pfet
X$230 XD2_XDFFM_S__t2 XD2_XDFFM_CLKB__t0 XD2_XDFFM_M__t3 VDD_DIV__t131
+ sg13_hv_pmos L=0.5U W=5U AS=2P AD=2P PS=10.8U PD=10.8U
* device instance $231 r0 *1 1137.24,3.11 pfet
X$231 XD2_XDFFM_SB__t1 XD2_XDFFM_S__t0 VDD_DIV__t4 VDD_DIV__t103 sg13_hv_pmos
+ L=0.5U W=5U AS=2P AD=2P PS=10.8U PD=10.8U
* device instance $232 r0 *1 1144.2,3.11 pfet
X$232 XD2_XDFFM_S__t1 ck2__t0 XD2_XDFFM_SB__t2 VDD_DIV__t104 sg13_hv_pmos
+ L=0.5U W=5U AS=2P AD=2P PS=10.8U PD=10.8U
* device instance $233 r0 *1 1151.16,3.11 pfet
X$233 mod1__t3 XD2_XDFFM_SB__t0 VDD_DIV__t5 VDD_DIV__t105 sg13_hv_pmos L=0.5U
+ W=5U AS=2P AD=2P PS=10.8U PD=10.8U
* device instance $234 r0 *1 1158.12,3.11 pfet
X$234 XD3_nt__t1 mod3__t0 VDD_DIV__t6 VDD_DIV__t106 sg13_hv_pmos L=0.5U W=5U
+ AS=2P AD=2P PS=10.8U PD=10.8U
* device instance $235 r0 *1 1165.08,3.11 pfet
X$235 XD3_nt__t2 P3__t0 VDD_DIV__t7 VDD_DIV__t107 sg13_hv_pmos L=0.5U W=5U
+ AS=2P AD=2P PS=10.8U PD=10.8U
* device instance $236 r0 *1 1172.04,3.11 pfet
X$236 XD3_nt__t3 mod2__t0 VDD_DIV__t8 VDD_DIV__t108 sg13_hv_pmos L=0.5U W=5U
+ AS=2P AD=2P PS=10.8U PD=10.8U
* device instance $237 r0 *1 1179,3.11 pfet
X$237 XD3_t1__t1 XD3_nt__t0 VDD_DIV__t9 VDD_DIV__t109 sg13_hv_pmos L=0.5U W=5U
+ AS=2P AD=2P PS=10.8U PD=10.8U
* device instance $238 r0 *1 1185.96,3.11 pfet
X$238 XD3_XNOR_midp__t0 ck4__t0 VDD_DIV__t10 VDD_DIV__t110 sg13_hv_pmos L=0.5U
+ W=5U AS=2P AD=2P PS=10.8U PD=10.8U
* device instance $239 r0 *1 1192.92,3.11 pfet
X$239 XD3_dq__t0 XD3_t1__t0 XD3_XNOR_midp__t1 VDD_DIV__t121 sg13_hv_pmos L=0.5U
+ W=5U AS=2P AD=2P PS=10.8U PD=10.8U
* device instance $240 r0 *1 1199.88,3.11 pfet
X$240 XD3_XDFFQ_CLKB__t2 ck3__t0 VDD_DIV__t12 VDD_DIV__t112 sg13_hv_pmos L=0.5U
+ W=5U AS=2P AD=2P PS=10.8U PD=10.8U
* device instance $241 r0 *1 1206.84,3.11 pfet
X$241 XD3_XDFFQ_M__t1 ck3__t1 XD3_dq__t1 VDD_DIV__t113 sg13_hv_pmos L=0.5U W=5U
+ AS=2P AD=2P PS=10.8U PD=10.8U
* device instance $242 r0 *1 1213.8,3.11 pfet
X$242 XD3_XDFFQ_MB__t0 XD3_XDFFQ_M__t0 VDD_DIV__t13 VDD_DIV__t114 sg13_hv_pmos
+ L=0.5U W=5U AS=2P AD=2P PS=10.8U PD=10.8U
* device instance $243 r0 *1 1220.76,3.11 pfet
X$243 XD3_XDFFQ_M__t2 XD3_XDFFQ_CLKB__t0 XD3_XDFFQ_MB__t1 VDD_DIV__t115
+ sg13_hv_pmos L=0.5U W=5U AS=2P AD=2P PS=10.8U PD=10.8U
* device instance $244 r0 *1 1227.72,3.11 pfet
X$244 XD3_XDFFQ_S__t1 XD3_XDFFQ_CLKB__t1 XD3_XDFFQ_M__t3 VDD_DIV__t116
+ sg13_hv_pmos L=0.5U W=5U AS=2P AD=2P PS=10.8U PD=10.8U
* device instance $245 r0 *1 1234.68,3.11 pfet
X$245 XD3_XDFFQ_SB__t1 XD3_XDFFQ_S__t0 VDD_DIV__t14 VDD_DIV__t117 sg13_hv_pmos
+ L=0.5U W=5U AS=2P AD=2P PS=10.8U PD=10.8U
* device instance $246 r0 *1 1241.64,3.11 pfet
X$246 XD3_XDFFQ_S__t2 ck3__t2 XD3_XDFFQ_SB__t2 VDD_DIV__t118 sg13_hv_pmos
+ L=0.5U W=5U AS=2P AD=2P PS=10.8U PD=10.8U
* device instance $247 r0 *1 1248.6,3.11 pfet
X$247 ck4__t8 XD3_XDFFQ_SB__t0 VDD_DIV__t15 VDD_DIV__t119 sg13_hv_pmos L=0.5U
+ W=5U AS=2P AD=2P PS=10.8U PD=10.8U
* device instance $248 r0 *1 1255.56,3.11 pfet
X$248 XD3_nm__t1 mod3__t1 VDD_DIV__t16 VDD_DIV__t120 sg13_hv_pmos L=0.5U W=5U
+ AS=2P AD=2P PS=10.8U PD=10.8U
* device instance $249 r0 *1 1262.52,3.11 pfet
X$249 XD3_nm__t2 ck4__t1 VDD_DIV__t34 VDD_DIV__t150 sg13_hv_pmos L=0.5U W=5U
+ AS=2P AD=2P PS=10.8U PD=10.8U
* device instance $250 r0 *1 1269.48,3.11 pfet
X$250 XD3_dmodout__t0 XD3_nm__t0 VDD_DIV__t42 VDD_DIV__t161 sg13_hv_pmos L=0.5U
+ W=5U AS=2P AD=2P PS=10.8U PD=10.8U
* device instance $251 r0 *1 1276.44,3.11 pfet
X$251 XD3_XDFFM_CLKB__t2 ck3__t5 VDD_DIV__t43 VDD_DIV__t162 sg13_hv_pmos L=0.5U
+ W=5U AS=2P AD=2P PS=10.8U PD=10.8U
* device instance $252 r0 *1 1283.4,3.11 pfet
X$252 XD3_XDFFM_M__t1 ck3__t6 XD3_dmodout__t1 VDD_DIV__t163 sg13_hv_pmos L=0.5U
+ W=5U AS=2P AD=2P PS=10.8U PD=10.8U
* device instance $253 r0 *1 1290.36,3.11 pfet
X$253 XD3_XDFFM_MB__t0 XD3_XDFFM_M__t0 VDD_DIV__t44 VDD_DIV__t164 sg13_hv_pmos
+ L=0.5U W=5U AS=2P AD=2P PS=10.8U PD=10.8U
* device instance $254 r0 *1 1297.32,3.11 pfet
X$254 XD3_XDFFM_M__t2 XD3_XDFFM_CLKB__t0 XD3_XDFFM_MB__t1 VDD_DIV__t200
+ sg13_hv_pmos L=0.5U W=5U AS=2P AD=2P PS=10.8U PD=10.8U
* device instance $255 r0 *1 1304.28,3.11 pfet
X$255 XD3_XDFFM_S__t1 XD3_XDFFM_CLKB__t1 XD3_XDFFM_M__t3 VDD_DIV__t201
+ sg13_hv_pmos L=0.5U W=5U AS=2P AD=2P PS=10.8U PD=10.8U
* device instance $256 r0 *1 1311.24,3.11 pfet
X$256 XD3_XDFFM_SB__t1 XD3_XDFFM_S__t0 VDD_DIV__t67 VDD_DIV__t202 sg13_hv_pmos
+ L=0.5U W=5U AS=2P AD=2P PS=10.8U PD=10.8U
* device instance $257 r0 *1 1318.2,3.11 pfet
X$257 XD3_XDFFM_S__t2 ck3__t7 XD3_XDFFM_SB__t2 VDD_DIV__t203 sg13_hv_pmos
+ L=0.5U W=5U AS=2P AD=2P PS=10.8U PD=10.8U
* device instance $258 r0 *1 1325.16,3.11 pfet
X$258 mod2__t3 XD3_XDFFM_SB__t0 VDD_DIV__t68 VDD_DIV__t204 sg13_hv_pmos L=0.5U
+ W=5U AS=2P AD=2P PS=10.8U PD=10.8U
* device instance $259 r0 *1 1332.12,3.11 pfet
X$259 XD4_nt__t1 mod4__t1 VDD_DIV__t69 VDD_DIV__t205 sg13_hv_pmos L=0.5U W=5U
+ AS=2P AD=2P PS=10.8U PD=10.8U
* device instance $260 r0 *1 1339.08,3.11 pfet
X$260 XD4_nt__t2 P4__t0 VDD_DIV__t70 VDD_DIV__t206 sg13_hv_pmos L=0.5U W=5U
+ AS=2P AD=2P PS=10.8U PD=10.8U
* device instance $261 r0 *1 1346.04,3.11 pfet
X$261 XD4_nt__t3 mod3__t2 VDD_DIV__t71 VDD_DIV__t207 sg13_hv_pmos L=0.5U W=5U
+ AS=2P AD=2P PS=10.8U PD=10.8U
* device instance $262 r0 *1 1353,3.11 pfet
X$262 XD4_t1__t1 XD4_nt__t0 VDD_DIV__t72 VDD_DIV__t208 sg13_hv_pmos L=0.5U W=5U
+ AS=2P AD=2P PS=10.8U PD=10.8U
* device instance $263 r0 *1 1359.96,3.11 pfet
X$263 XD4_XNOR_midp__t0 ck5__t3 VDD_DIV__t78 VDD_DIV__t219 sg13_hv_pmos L=0.5U
+ W=5U AS=2P AD=2P PS=10.8U PD=10.8U
* device instance $264 r0 *1 1366.92,3.11 pfet
X$264 XD4_dq__t0 XD4_t1__t0 XD4_XNOR_midp__t1 VDD_DIV__t210 sg13_hv_pmos L=0.5U
+ W=5U AS=2P AD=2P PS=10.8U PD=10.8U
* device instance $265 r0 *1 1373.88,3.11 pfet
X$265 XD4_XDFFQ_CLKB__t2 ck4__t5 VDD_DIV__t74 VDD_DIV__t211 sg13_hv_pmos L=0.5U
+ W=5U AS=2P AD=2P PS=10.8U PD=10.8U
* device instance $266 r0 *1 1380.84,3.11 pfet
X$266 XD4_XDFFQ_M__t1 ck4__t6 XD4_dq__t1 VDD_DIV__t212 sg13_hv_pmos L=0.5U W=5U
+ AS=2P AD=2P PS=10.8U PD=10.8U
* device instance $267 r0 *1 1387.8,3.11 pfet
X$267 XD4_XDFFQ_MB__t0 XD4_XDFFQ_M__t0 VDD_DIV__t75 VDD_DIV__t213 sg13_hv_pmos
+ L=0.5U W=5U AS=2P AD=2P PS=10.8U PD=10.8U
* device instance $268 r0 *1 1394.76,3.11 pfet
X$268 XD4_XDFFQ_M__t2 XD4_XDFFQ_CLKB__t0 XD4_XDFFQ_MB__t1 VDD_DIV__t214
+ sg13_hv_pmos L=0.5U W=5U AS=2P AD=2P PS=10.8U PD=10.8U
* device instance $269 r0 *1 1401.72,3.11 pfet
X$269 XD4_XDFFQ_S__t1 XD4_XDFFQ_CLKB__t1 XD4_XDFFQ_M__t3 VDD_DIV__t215
+ sg13_hv_pmos L=0.5U W=5U AS=2P AD=2P PS=10.8U PD=10.8U
* device instance $270 r0 *1 1408.68,3.11 pfet
X$270 XD4_XDFFQ_SB__t1 XD4_XDFFQ_S__t0 VDD_DIV__t76 VDD_DIV__t216 sg13_hv_pmos
+ L=0.5U W=5U AS=2P AD=2P PS=10.8U PD=10.8U
* device instance $271 r0 *1 1415.64,3.11 pfet
X$271 XD4_XDFFQ_S__t2 ck4__t7 XD4_XDFFQ_SB__t2 VDD_DIV__t217 sg13_hv_pmos
+ L=0.5U W=5U AS=2P AD=2P PS=10.8U PD=10.8U
* device instance $272 r0 *1 1422.6,3.11 pfet
X$272 ck5__t8 XD4_XDFFQ_SB__t0 VDD_DIV__t77 VDD_DIV__t218 sg13_hv_pmos L=0.5U
+ W=5U AS=2P AD=2P PS=10.8U PD=10.8U
* device instance $273 r0 *1 1429.56,3.11 pfet
X$273 XD4_nm__t2 mod4__t2 VDD_DIV__t73 VDD_DIV__t209 sg13_hv_pmos L=0.5U W=5U
+ AS=2P AD=2P PS=10.8U PD=10.8U
* device instance $274 r0 *1 1436.52,3.11 pfet
X$274 XD4_nm__t1 ck5__t0 VDD_DIV__t54 VDD_DIV__t181 sg13_hv_pmos L=0.5U W=5U
+ AS=2P AD=2P PS=10.8U PD=10.8U
* device instance $275 r0 *1 1443.48,3.11 pfet
X$275 XD4_dmodout__t0 XD4_nm__t0 VDD_DIV__t55 VDD_DIV__t182 sg13_hv_pmos L=0.5U
+ W=5U AS=2P AD=2P PS=10.8U PD=10.8U
* device instance $276 r0 *1 1450.44,3.11 pfet
X$276 XD4_XDFFM_CLKB__t2 ck4__t2 VDD_DIV__t56 VDD_DIV__t183 sg13_hv_pmos L=0.5U
+ W=5U AS=2P AD=2P PS=10.8U PD=10.8U
* device instance $277 r0 *1 1457.4,3.11 pfet
X$277 XD4_XDFFM_M__t1 ck4__t3 XD4_dmodout__t1 VDD_DIV__t184 sg13_hv_pmos L=0.5U
+ W=5U AS=2P AD=2P PS=10.8U PD=10.8U
* device instance $278 r0 *1 1464.36,3.11 pfet
X$278 XD4_XDFFM_MB__t0 XD4_XDFFM_M__t0 VDD_DIV__t57 VDD_DIV__t185 sg13_hv_pmos
+ L=0.5U W=5U AS=2P AD=2P PS=10.8U PD=10.8U
* device instance $279 r0 *1 1471.32,3.11 pfet
X$279 XD4_XDFFM_M__t2 XD4_XDFFM_CLKB__t0 XD4_XDFFM_MB__t1 VDD_DIV__t186
+ sg13_hv_pmos L=0.5U W=5U AS=2P AD=2P PS=10.8U PD=10.8U
* device instance $280 r0 *1 1478.28,3.11 pfet
X$280 XD4_XDFFM_S__t1 XD4_XDFFM_CLKB__t1 XD4_XDFFM_M__t3 VDD_DIV__t187
+ sg13_hv_pmos L=0.5U W=5U AS=2P AD=2P PS=10.8U PD=10.8U
* device instance $281 r0 *1 1485.24,3.11 pfet
X$281 XD4_XDFFM_SB__t1 XD4_XDFFM_S__t0 VDD_DIV__t58 VDD_DIV__t188 sg13_hv_pmos
+ L=0.5U W=5U AS=2P AD=2P PS=10.8U PD=10.8U
* device instance $282 r0 *1 1492.2,3.11 pfet
X$282 XD4_XDFFM_S__t2 ck4__t4 XD4_XDFFM_SB__t2 VDD_DIV__t199 sg13_hv_pmos
+ L=0.5U W=5U AS=2P AD=2P PS=10.8U PD=10.8U
* device instance $283 r0 *1 1499.16,3.11 pfet
X$283 mod3__t3 XD4_XDFFM_SB__t0 VDD_DIV__t60 VDD_DIV__t190 sg13_hv_pmos L=0.5U
+ W=5U AS=2P AD=2P PS=10.8U PD=10.8U
* device instance $284 r0 *1 1506.12,3.11 pfet
X$284 XD5_nt__t1 VDD_DIV__t2 VDD_DIV__t61 VDD_DIV__t191 sg13_hv_pmos L=0.5U
+ W=5U AS=2P AD=2P PS=10.8U PD=10.8U
* device instance $285 r0 *1 1513.08,3.11 pfet
X$285 XD5_nt__t2 P5__t0 VDD_DIV__t62 VDD_DIV__t192 sg13_hv_pmos L=0.5U W=5U
+ AS=2P AD=2P PS=10.8U PD=10.8U
* device instance $286 r0 *1 1520.04,3.11 pfet
X$286 XD5_nt__t3 mod4__t0 VDD_DIV__t63 VDD_DIV__t193 sg13_hv_pmos L=0.5U W=5U
+ AS=2P AD=2P PS=10.8U PD=10.8U
* device instance $287 r0 *1 1527,3.11 pfet
X$287 XD5_t1__t1 XD5_nt__t0 VDD_DIV__t64 VDD_DIV__t194 sg13_hv_pmos L=0.5U W=5U
+ AS=2P AD=2P PS=10.8U PD=10.8U
* device instance $288 r0 *1 1533.96,3.11 pfet
X$288 XD5_XNOR_midp__t0 DIVOUT__t0 VDD_DIV__t65 VDD_DIV__t195 sg13_hv_pmos
+ L=0.5U W=5U AS=2P AD=2P PS=10.8U PD=10.8U
* device instance $289 r0 *1 1540.92,3.11 pfet
X$289 XD5_dq__t0 XD5_t1__t0 XD5_XNOR_midp__t1 VDD_DIV__t196 sg13_hv_pmos L=0.5U
+ W=5U AS=2P AD=2P PS=10.8U PD=10.8U
* device instance $290 r0 *1 1547.88,3.11 pfet
X$290 XD5_XDFFQ_CLKB__t2 ck5__t1 VDD_DIV__t66 VDD_DIV__t197 sg13_hv_pmos L=0.5U
+ W=5U AS=2P AD=2P PS=10.8U PD=10.8U
* device instance $291 r0 *1 1554.84,3.11 pfet
X$291 XD5_XDFFQ_M__t1 ck5__t2 XD5_dq__t1 VDD_DIV__t198 sg13_hv_pmos L=0.5U W=5U
+ AS=2P AD=2P PS=10.8U PD=10.8U
* device instance $292 r0 *1 1561.8,3.11 pfet
X$292 XD5_XDFFQ_MB__t0 XD5_XDFFQ_M__t0 VDD_DIV__t85 VDD_DIV__t229 sg13_hv_pmos
+ L=0.5U W=5U AS=2P AD=2P PS=10.8U PD=10.8U
* device instance $293 r0 *1 1568.76,3.11 pfet
X$293 XD5_XDFFQ_M__t2 XD5_XDFFQ_CLKB__t0 XD5_XDFFQ_MB__t1 VDD_DIV__t240
+ sg13_hv_pmos L=0.5U W=5U AS=2P AD=2P PS=10.8U PD=10.8U
* device instance $294 r0 *1 1575.72,3.11 pfet
X$294 XD5_XDFFQ_S__t1 XD5_XDFFQ_CLKB__t1 XD5_XDFFQ_M__t3 VDD_DIV__t241
+ sg13_hv_pmos L=0.5U W=5U AS=2P AD=2P PS=10.8U PD=10.8U
* device instance $295 r0 *1 1582.68,3.11 pfet
X$295 XD5_XDFFQ_SB__t1 XD5_XDFFQ_S__t0 VDD_DIV__t92 VDD_DIV__t242 sg13_hv_pmos
+ L=0.5U W=5U AS=2P AD=2P PS=10.8U PD=10.8U
* device instance $296 r0 *1 1589.64,3.11 pfet
X$296 XD5_XDFFQ_S__t2 ck5__t4 XD5_XDFFQ_SB__t2 VDD_DIV__t243 sg13_hv_pmos
+ L=0.5U W=5U AS=2P AD=2P PS=10.8U PD=10.8U
* device instance $297 r0 *1 1596.6,3.11 pfet
X$297 DIVOUT__t2 XD5_XDFFQ_SB__t0 VDD_DIV__t93 VDD_DIV__t244 sg13_hv_pmos
+ L=0.5U W=5U AS=2P AD=2P PS=10.8U PD=10.8U
* device instance $298 r0 *1 1603.56,3.11 pfet
X$298 XD5_nm__t1 VDD_DIV__t3 VDD_DIV__t94 VDD_DIV__t245 sg13_hv_pmos L=0.5U
+ W=5U AS=2P AD=2P PS=10.8U PD=10.8U
* device instance $299 r0 *1 1610.52,3.11 pfet
X$299 XD5_nm__t2 DIVOUT__t1 VDD_DIV__t95 VDD_DIV__t246 sg13_hv_pmos L=0.5U W=5U
+ AS=2P AD=2P PS=10.8U PD=10.8U
* device instance $300 r0 *1 1617.48,3.11 pfet
X$300 XD5_dmodout__t0 XD5_nm__t0 VDD_DIV__t96 VDD_DIV__t247 sg13_hv_pmos L=0.5U
+ W=5U AS=2P AD=2P PS=10.8U PD=10.8U
* device instance $301 r0 *1 1624.44,3.11 pfet
X$301 XD5_XDFFM_CLKB__t2 ck5__t5 VDD_DIV__t97 VDD_DIV__t248 sg13_hv_pmos L=0.5U
+ W=5U AS=2P AD=2P PS=10.8U PD=10.8U
* device instance $302 r0 *1 1631.4,3.11 pfet
X$302 XD5_XDFFM_M__t2 ck5__t7 XD5_dmodout__t1 VDD_DIV__t259 sg13_hv_pmos L=0.5U
+ W=5U AS=2P AD=2P PS=10.8U PD=10.8U
* device instance $303 r0 *1 1638.36,3.11 pfet
X$303 XD5_XDFFM_MB__t0 XD5_XDFFM_M__t0 VDD_DIV__t98 VDD_DIV__t250 sg13_hv_pmos
+ L=0.5U W=5U AS=2P AD=2P PS=10.8U PD=10.8U
* device instance $304 r0 *1 1645.32,3.11 pfet
X$304 XD5_XDFFM_M__t1 XD5_XDFFM_CLKB__t0 XD5_XDFFM_MB__t1 VDD_DIV__t251
+ sg13_hv_pmos L=0.5U W=5U AS=2P AD=2P PS=10.8U PD=10.8U
* device instance $305 r0 *1 1652.28,3.11 pfet
X$305 XD5_XDFFM_S__t1 XD5_XDFFM_CLKB__t1 XD5_XDFFM_M__t3 VDD_DIV__t252
+ sg13_hv_pmos L=0.5U W=5U AS=2P AD=2P PS=10.8U PD=10.8U
* device instance $306 r0 *1 1659.24,3.11 pfet
X$306 XD5_XDFFM_SB__t1 XD5_XDFFM_S__t0 VDD_DIV__t99 VDD_DIV__t253 sg13_hv_pmos
+ L=0.5U W=5U AS=2P AD=2P PS=10.8U PD=10.8U
* device instance $307 r0 *1 1666.2,3.11 pfet
X$307 XD5_XDFFM_S__t2 ck5__t6 XD5_XDFFM_SB__t2 VDD_DIV__t254 sg13_hv_pmos
+ L=0.5U W=5U AS=2P AD=2P PS=10.8U PD=10.8U
* device instance $308 r0 *1 1673.16,3.11 pfet
X$308 mod4__t3 XD5_XDFFM_SB__t0 VDD_DIV__t100 VDD_DIV__t255 sg13_hv_pmos L=0.5U
+ W=5U AS=2P AD=2P PS=10.8U PD=10.8U
* device instance $309 r0 *1 1680.12,3.11 pfet
X$309 XFRT_CLKB__t2 CKIN_VCO__t1 VDD_DIV__t101 VDD_DIV__t256 sg13_hv_pmos
+ L=0.5U W=5U AS=2P AD=2P PS=10.8U PD=10.8U
* device instance $310 r0 *1 1687.08,3.11 pfet
X$310 XFRT_M__t2 CKIN_VCO__t2 DIVOUT__t3 VDD_DIV__t257 sg13_hv_pmos L=0.5U W=5U
+ AS=2P AD=2P PS=10.8U PD=10.8U
* device instance $311 r0 *1 1694.04,3.11 pfet
X$311 XFRT_MB__t0 XFRT_M__t0 VDD_DIV__t102 VDD_DIV__t258 sg13_hv_pmos L=0.5U
+ W=5U AS=2P AD=2P PS=10.8U PD=10.8U
* device instance $312 r0 *1 1701,3.11 pfet
X$312 XFRT_M__t1 XFRT_CLKB__t1 XFRT_MB__t1 VDD_DIV__t249 sg13_hv_pmos L=0.5U
+ W=5U AS=2P AD=2P PS=10.8U PD=10.8U
* device instance $313 r0 *1 1707.96,3.11 pfet
X$313 XFRT_S__t1 XFRT_CLKB__t0 XFRT_M__t3 VDD_DIV__t220 sg13_hv_pmos L=0.5U
+ W=5U AS=2P AD=2P PS=10.8U PD=10.8U
* device instance $314 r0 *1 1714.92,3.11 pfet
X$314 XFRT_SB__t1 XFRT_S__t0 VDD_DIV__t79 VDD_DIV__t221 sg13_hv_pmos L=0.5U
+ W=5U AS=2P AD=2P PS=10.8U PD=10.8U
* device instance $315 r0 *1 1721.88,3.11 pfet
X$315 XFRT_S__t2 CKIN_VCO__t0 XFRT_SB__t2 VDD_DIV__t222 sg13_hv_pmos L=0.5U
+ W=5U AS=2P AD=2P PS=10.8U PD=10.8U
* device instance $316 r0 *1 1728.84,3.11 pfet
X$316 FB__t0 XFRT_SB__t0 VDD_DIV__t80 VDD_DIV__t223 sg13_hv_pmos L=0.5U W=5U
+ AS=2P AD=2P PS=10.8U PD=10.8U
* device instance CKIN_t0 r0 *1 0,0
RCKIN_t0 CKIN__t0 CKIN 21.3621720888
* device instance CKIN_t1 r0 *1 0,0
RCKIN_t1 CKIN__t1 CKIN 21.7755185379
* device instance CKIN_t2 r0 *1 0,0
RCKIN_t2 CKIN__t2 CKIN 23.8422507833
* device instance CKIN_t3 r0 *1 0,0
RCKIN_t3 CKIN__t3 CKIN 16.8153611488
* device instance CKIN_t4 r0 *1 0,0
RCKIN_t4 CKIN__t4 CKIN 17.2287075979
* device instance CKIN_t5 r0 *1 0,0
RCKIN_t5 CKIN__t5 CKIN 19.2954398433
* device instance CKIN_t6 r0 *1 0,0
RCKIN_t6 CKIN__t6 CKIN 21.8954840303
* device instance CKIN_t7 r0 *1 0,0
RCKIN_t7 CKIN__t7 CKIN 21.1899444017
* device instance CKIN_t8 r0 *1 0,0
RCKIN_t8 CKIN__t8 CKIN 20.9547645255
* device instance CKIN_t9 r0 *1 0,0
RCKIN_t9 CKIN__t9 CKIN 19.308505392
* device instance CKIN_t10 r0 *1 0,0
RCKIN_t10 CKIN__t10 CKIN 18.6029657634
* device instance CKIN_t11 r0 *1 0,0
RCKIN_t11 CKIN__t11 CKIN 18.3677858872
* device instance CKIN r0 *1 0,0
CCKIN CKIN vsubs 5.4048321e-14
* device instance CKIN_VCO_t0 r0 *1 0,0
RCKIN_VCO_t0 CKIN_VCO__t0 CKIN_VCO 59.0417226188
* device instance CKIN_VCO_t1 r0 *1 0,0
RCKIN_VCO_t1 CKIN_VCO__t1 CKIN_VCO 54.7231856062
* device instance CKIN_VCO_t2 r0 *1 0,0
RCKIN_VCO_t2 CKIN_VCO__t2 CKIN_VCO 55.442941775
* device instance CKIN_VCO_t3 r0 *1 0,0
RCKIN_VCO_t3 CKIN_VCO__t3 CKIN_VCO 57.3581550286
* device instance CKIN_VCO_t4 r0 *1 0,0
RCKIN_VCO_t4 CKIN_VCO__t4 CKIN_VCO 56.1296057061
* device instance CKIN_VCO_t5 r0 *1 0,0
RCKIN_VCO_t5 CKIN_VCO__t5 CKIN_VCO 55.7200892653
* device instance CKIN_VCO r0 *1 0,0
CCKIN_VCO CKIN_VCO vsubs 7.5090819e-14
* device instance DIVOUT_t0 r0 *1 0,0
RDIVOUT_t0 DIVOUT__t0 DIVOUT 38.9985944874
* device instance DIVOUT_t1 r0 *1 0,0
RDIVOUT_t1 DIVOUT__t1 DIVOUT 45.588451453
* device instance DIVOUT_t2 r0 *1 0,0
RDIVOUT_t2 DIVOUT__t2 DIVOUT 44.3902956411
* device instance DIVOUT_t3 r0 *1 0,0
RDIVOUT_t3 DIVOUT__t3 DIVOUT 52.1783084185
* device instance DIVOUT_t4 r0 *1 0,0
RDIVOUT_t4 DIVOUT__t4 DIVOUT 45.1184851647
* device instance DIVOUT_t5 r0 *1 0,0
RDIVOUT_t5 DIVOUT__t5 DIVOUT 48.8678865416
* device instance DIVOUT_t6 r0 *1 0,0
RDIVOUT_t6 DIVOUT__t6 DIVOUT 45.8001945059
* device instance DIVOUT_t7 r0 *1 0,0
RDIVOUT_t7 DIVOUT__t7 DIVOUT 41.3690837877
* device instance DIVOUT r0 *1 0,0
CDIVOUT DIVOUT vsubs 8.0420769e-14
* device instance FB_t0 r0 *1 0,0
RFB_t0 FB__t0 FB 164.86745
* device instance FB_t1 r0 *1 0,0
RFB_t1 FB__t1 FB 164.86745
* device instance FB r0 *1 0,0
CFB FB vsubs 7.2643492e-14
* device instance P0_t0 r0 *1 0,0
RP0_t0 P0__t0 P0 95.1852
* device instance P0_t1 r0 *1 0,0
RP0_t1 P0__t1 P0 95.1852
* device instance P0 r0 *1 0,0
CP0 P0 vsubs 4.1920864e-14
* device instance P1_t0 r0 *1 0,0
RP1_t0 P1__t0 P1 106.3612
* device instance P1_t1 r0 *1 0,0
RP1_t1 P1__t1 P1 106.3612
* device instance P1 r0 *1 0,0
CP1 P1 vsubs 4.6880563e-14
* device instance P2_t0 r0 *1 0,0
RP2_t0 P2__t0 P2 117.5372
* device instance P2_t1 r0 *1 0,0
RP2_t1 P2__t1 P2 117.5372
* device instance P2 r0 *1 0,0
CP2 P2 vsubs 5.1840262e-14
* device instance P3_t0 r0 *1 0,0
RP3_t0 P3__t0 P3 128.7132
* device instance P3_t1 r0 *1 0,0
RP3_t1 P3__t1 P3 128.7132
* device instance P3 r0 *1 0,0
CP3 P3 vsubs 5.6799961e-14
* device instance P4_t0 r0 *1 0,0
RP4_t0 P4__t0 P4 139.8892
* device instance P4_t1 r0 *1 0,0
RP4_t1 P4__t1 P4 139.8892
* device instance P4 r0 *1 0,0
CP4 P4 vsubs 6.175966e-14
* device instance P5_t0 r0 *1 0,0
RP5_t0 P5__t0 P5 151.0652
* device instance P5_t1 r0 *1 0,0
RP5_t1 P5__t1 P5 151.0652
* device instance P5 r0 *1 0,0
CP5 P5 vsubs 6.6719359e-14
* device instance VDD_DIV_t0 r0 *1 0,0
RVDD_DIV_t0 VDD_DIV__t0 VDD_DIV 8.42212989506
* device instance VDD_DIV_t1 r0 *1 0,0
RVDD_DIV_t1 VDD_DIV__t1 VDD_DIV 8.42212989506
* device instance VDD_DIV_t2 r0 *1 0,0
RVDD_DIV_t2 VDD_DIV__t2 VDD_DIV 5.16591576553
* device instance VDD_DIV_t3 r0 *1 0,0
RVDD_DIV_t3 VDD_DIV__t3 VDD_DIV 6.68777687952
* device instance VDD_DIV_t4 r0 *1 0,0
RVDD_DIV_t4 VDD_DIV__t4 VDD_DIV 0.595415594558
* device instance VDD_DIV_t5 r0 *1 0,0
RVDD_DIV_t5 VDD_DIV__t5 VDD_DIV 0.378006863988
* device instance VDD_DIV_t6 r0 *1 0,0
RVDD_DIV_t6 VDD_DIV__t6 VDD_DIV 0.269302498703
* device instance VDD_DIV_t7 r0 *1 0,0
RVDD_DIV_t7 VDD_DIV__t7 VDD_DIV 0.160598133419
* device instance VDD_DIV_t8 r0 *1 0,0
RVDD_DIV_t8 VDD_DIV__t8 VDD_DIV 0.051893768134
* device instance VDD_DIV_t9 r0 *1 0,0
RVDD_DIV_t9 VDD_DIV__t9 VDD_DIV 0.0568105971507
* device instance VDD_DIV_t10 r0 *1 0,0
RVDD_DIV_t10 VDD_DIV__t10 VDD_DIV 0.165514962435
* device instance VDD_DIV_t11 r0 *1 0,0
RVDD_DIV_t11 VDD_DIV__t11 VDD_DIV 4.83488584066
* device instance VDD_DIV_t12 r0 *1 0,0
RVDD_DIV_t12 VDD_DIV__t12 VDD_DIV 0.382923693005
* device instance VDD_DIV_t13 r0 *1 0,0
RVDD_DIV_t13 VDD_DIV__t13 VDD_DIV 0.600332423574
* device instance VDD_DIV_t14 r0 *1 0,0
RVDD_DIV_t14 VDD_DIV__t14 VDD_DIV 0.926445519428
* device instance VDD_DIV_t15 r0 *1 0,0
RVDD_DIV_t15 VDD_DIV__t15 VDD_DIV 1.14385425
* device instance VDD_DIV_t16 r0 *1 0,0
RVDD_DIV_t16 VDD_DIV__t16 VDD_DIV 1.25255861528
* device instance VDD_DIV_t17 r0 *1 0,0
RVDD_DIV_t17 VDD_DIV__t17 VDD_DIV 2.76950290025
* device instance VDD_DIV_t18 r0 *1 0,0
RVDD_DIV_t18 VDD_DIV__t18 VDD_DIV 2.66079853497
* device instance VDD_DIV_t19 r0 *1 0,0
RVDD_DIV_t19 VDD_DIV__t19 VDD_DIV 2.55209416968
* device instance VDD_DIV_t20 r0 *1 0,0
RVDD_DIV_t20 VDD_DIV__t20 VDD_DIV 2.33468543911
* device instance VDD_DIV_t21 r0 *1 0,0
RVDD_DIV_t21 VDD_DIV__t21 VDD_DIV 2.11727670854
* device instance VDD_DIV_t22 r0 *1 0,0
RVDD_DIV_t22 VDD_DIV__t22 VDD_DIV 1.57375488212
* device instance VDD_DIV_t23 r0 *1 0,0
RVDD_DIV_t23 VDD_DIV__t23 VDD_DIV 1.46505051684
* device instance VDD_DIV_t24 r0 *1 0,0
RVDD_DIV_t24 VDD_DIV__t24 VDD_DIV 1.35634615155
* device instance VDD_DIV_t25 r0 *1 0,0
RVDD_DIV_t25 VDD_DIV__t25 VDD_DIV 1.24764178627
* device instance VDD_DIV_t26 r0 *1 0,0
RVDD_DIV_t26 VDD_DIV__t26 VDD_DIV 1.13893742098
* device instance VDD_DIV_t27 r0 *1 0,0
RVDD_DIV_t27 VDD_DIV__t27 VDD_DIV 0.921528690412
* device instance VDD_DIV_t28 r0 *1 0,0
RVDD_DIV_t28 VDD_DIV__t28 VDD_DIV 1.79116361269
* device instance VDD_DIV_t29 r0 *1 0,0
RVDD_DIV_t29 VDD_DIV__t29 VDD_DIV 6.79156441579
* device instance VDD_DIV_t30 r0 *1 0,0
RVDD_DIV_t30 VDD_DIV__t30 VDD_DIV 6.6828600505
* device instance VDD_DIV_t31 r0 *1 0,0
RVDD_DIV_t31 VDD_DIV__t31 VDD_DIV 6.57415568522
* device instance VDD_DIV_t32 r0 *1 0,0
RVDD_DIV_t32 VDD_DIV__t32 VDD_DIV 6.35674695465
* device instance VDD_DIV_t33 r0 *1 0,0
RVDD_DIV_t33 VDD_DIV__t33 VDD_DIV 6.03063385879
* device instance VDD_DIV_t34 r0 *1 0,0
RVDD_DIV_t34 VDD_DIV__t34 VDD_DIV 1.36126298057
* device instance VDD_DIV_t35 r0 *1 0,0
RVDD_DIV_t35 VDD_DIV__t35 VDD_DIV 5.81322512822
* device instance VDD_DIV_t36 r0 *1 0,0
RVDD_DIV_t36 VDD_DIV__t36 VDD_DIV 5.70452076294
* device instance VDD_DIV_t37 r0 *1 0,0
RVDD_DIV_t37 VDD_DIV__t37 VDD_DIV 5.59581639765
* device instance VDD_DIV_t38 r0 *1 0,0
RVDD_DIV_t38 VDD_DIV__t38 VDD_DIV 5.48711203237
* device instance VDD_DIV_t39 r0 *1 0,0
RVDD_DIV_t39 VDD_DIV__t39 VDD_DIV 5.37840766708
* device instance VDD_DIV_t40 r0 *1 0,0
RVDD_DIV_t40 VDD_DIV__t40 VDD_DIV 5.2697033018
* device instance VDD_DIV_t41 r0 *1 0,0
RVDD_DIV_t41 VDD_DIV__t41 VDD_DIV 5.05229457123
* device instance VDD_DIV_t42 r0 *1 0,0
RVDD_DIV_t42 VDD_DIV__t42 VDD_DIV 1.46996734585
* device instance VDD_DIV_t43 r0 *1 0,0
RVDD_DIV_t43 VDD_DIV__t43 VDD_DIV 1.57867171114
* device instance VDD_DIV_t44 r0 *1 0,0
RVDD_DIV_t44 VDD_DIV__t44 VDD_DIV 1.79608044171
* device instance VDD_DIV_t45 r0 *1 0,0
RVDD_DIV_t45 VDD_DIV__t45 VDD_DIV 8.31342552977
* device instance VDD_DIV_t46 r0 *1 0,0
RVDD_DIV_t46 VDD_DIV__t46 VDD_DIV 8.20472116449
* device instance VDD_DIV_t47 r0 *1 0,0
RVDD_DIV_t47 VDD_DIV__t47 VDD_DIV 8.0960167992
* device instance VDD_DIV_t48 r0 *1 0,0
RVDD_DIV_t48 VDD_DIV__t48 VDD_DIV 6.90026878107
* device instance VDD_DIV_t49 r0 *1 0,0
RVDD_DIV_t49 VDD_DIV__t49 VDD_DIV 7.76990370335
* device instance VDD_DIV_t50 r0 *1 0,0
RVDD_DIV_t50 VDD_DIV__t50 VDD_DIV 7.55249497278
* device instance VDD_DIV_t51 r0 *1 0,0
RVDD_DIV_t51 VDD_DIV__t51 VDD_DIV 7.22638187692
* device instance VDD_DIV_t52 r0 *1 0,0
RVDD_DIV_t52 VDD_DIV__t52 VDD_DIV 7.00897314636
* device instance VDD_DIV_t53 r0 *1 0,0
RVDD_DIV_t53 VDD_DIV__t53 VDD_DIV 7.98731243392
* device instance VDD_DIV_t54 r0 *1 0,0
RVDD_DIV_t54 VDD_DIV__t54 VDD_DIV 4.07887211269
* device instance VDD_DIV_t55 r0 *1 0,0
RVDD_DIV_t55 VDD_DIV__t55 VDD_DIV 4.18757647797
* device instance VDD_DIV_t56 r0 *1 0,0
RVDD_DIV_t56 VDD_DIV__t56 VDD_DIV 4.29628084325
* device instance VDD_DIV_t57 r0 *1 0,0
RVDD_DIV_t57 VDD_DIV__t57 VDD_DIV 4.51368957382
* device instance VDD_DIV_t58 r0 *1 0,0
RVDD_DIV_t58 VDD_DIV__t58 VDD_DIV 4.83980266968
* device instance VDD_DIV_t59 r0 *1 0,0
RVDD_DIV_t59 VDD_DIV__t59 VDD_DIV 2.87820726554
* device instance VDD_DIV_t60 r0 *1 0,0
RVDD_DIV_t60 VDD_DIV__t60 VDD_DIV 5.05721140025
* device instance VDD_DIV_t61 r0 *1 0,0
RVDD_DIV_t61 VDD_DIV__t61 VDD_DIV 5.16591576553
* device instance VDD_DIV_t62 r0 *1 0,0
RVDD_DIV_t62 VDD_DIV__t62 VDD_DIV 5.27462013082
* device instance VDD_DIV_t63 r0 *1 0,0
RVDD_DIV_t63 VDD_DIV__t63 VDD_DIV 5.3833244961
* device instance VDD_DIV_t64 r0 *1 0,0
RVDD_DIV_t64 VDD_DIV__t64 VDD_DIV 5.49202886139
* device instance VDD_DIV_t65 r0 *1 0,0
RVDD_DIV_t65 VDD_DIV__t65 VDD_DIV 5.60073322667
* device instance VDD_DIV_t66 r0 *1 0,0
RVDD_DIV_t66 VDD_DIV__t66 VDD_DIV 5.81814195724
* device instance VDD_DIV_t67 r0 *1 0,0
RVDD_DIV_t67 VDD_DIV__t67 VDD_DIV 2.12219353756
* device instance VDD_DIV_t68 r0 *1 0,0
RVDD_DIV_t68 VDD_DIV__t68 VDD_DIV 2.33960226813
* device instance VDD_DIV_t69 r0 *1 0,0
RVDD_DIV_t69 VDD_DIV__t69 VDD_DIV 2.44830663341
* device instance VDD_DIV_t70 r0 *1 0,0
RVDD_DIV_t70 VDD_DIV__t70 VDD_DIV 2.5570109987
* device instance VDD_DIV_t71 r0 *1 0,0
RVDD_DIV_t71 VDD_DIV__t71 VDD_DIV 2.66571536398
* device instance VDD_DIV_t72 r0 *1 0,0
RVDD_DIV_t72 VDD_DIV__t72 VDD_DIV 2.77441972927
* device instance VDD_DIV_t73 r0 *1 0,0
RVDD_DIV_t73 VDD_DIV__t73 VDD_DIV 3.9701677474
* device instance VDD_DIV_t74 r0 *1 0,0
RVDD_DIV_t74 VDD_DIV__t74 VDD_DIV 3.10053282512
* device instance VDD_DIV_t75 r0 *1 0,0
RVDD_DIV_t75 VDD_DIV__t75 VDD_DIV 3.31794155569
* device instance VDD_DIV_t76 r0 *1 0,0
RVDD_DIV_t76 VDD_DIV__t76 VDD_DIV 3.64405465155
* device instance VDD_DIV_t77 r0 *1 0,0
RVDD_DIV_t77 VDD_DIV__t77 VDD_DIV 3.86146338212
* device instance VDD_DIV_t78 r0 *1 0,0
RVDD_DIV_t78 VDD_DIV__t78 VDD_DIV 2.88312409455
* device instance VDD_DIV_t79 r0 *1 0,0
RVDD_DIV_t79 VDD_DIV__t79 VDD_DIV 8.42704672407
* device instance VDD_DIV_t80 r0 *1 0,0
RVDD_DIV_t80 VDD_DIV__t80 VDD_DIV 8.64445545464
* device instance VDD_DIV_t81 r0 *1 0,0
RVDD_DIV_t81 VDD_DIV__t81 VDD_DIV 4.50877274481
* device instance VDD_DIV_t82 r0 *1 0,0
RVDD_DIV_t82 VDD_DIV__t82 VDD_DIV 4.29136401424
* device instance VDD_DIV_t83 r0 *1 0,0
RVDD_DIV_t83 VDD_DIV__t83 VDD_DIV 4.18265964895
* device instance VDD_DIV_t84 r0 *1 0,0
RVDD_DIV_t84 VDD_DIV__t84 VDD_DIV 4.07395528367
* device instance VDD_DIV_t85 r0 *1 0,0
RVDD_DIV_t85 VDD_DIV__t85 VDD_DIV 6.03555068781
* device instance VDD_DIV_t86 r0 *1 0,0
RVDD_DIV_t86 VDD_DIV__t86 VDD_DIV 3.8565465531
* device instance VDD_DIV_t87 r0 *1 0,0
RVDD_DIV_t87 VDD_DIV__t87 VDD_DIV 3.63913782253
* device instance VDD_DIV_t88 r0 *1 0,0
RVDD_DIV_t88 VDD_DIV__t88 VDD_DIV 3.31302472668
* device instance VDD_DIV_t89 r0 *1 0,0
RVDD_DIV_t89 VDD_DIV__t89 VDD_DIV 3.09561599611
* device instance VDD_DIV_t90 r0 *1 0,0
RVDD_DIV_t90 VDD_DIV__t90 VDD_DIV 2.98691163082
* device instance VDD_DIV_t91 r0 *1 0,0
RVDD_DIV_t91 VDD_DIV__t91 VDD_DIV 3.96525091838
* device instance VDD_DIV_t92 r0 *1 0,0
RVDD_DIV_t92 VDD_DIV__t92 VDD_DIV 6.36166378366
* device instance VDD_DIV_t93 r0 *1 0,0
RVDD_DIV_t93 VDD_DIV__t93 VDD_DIV 6.57907251423
* device instance VDD_DIV_t94 r0 *1 0,0
RVDD_DIV_t94 VDD_DIV__t94 VDD_DIV 6.68777687952
* device instance VDD_DIV_t95 r0 *1 0,0
RVDD_DIV_t95 VDD_DIV__t95 VDD_DIV 6.7964812448
* device instance VDD_DIV_t96 r0 *1 0,0
RVDD_DIV_t96 VDD_DIV__t96 VDD_DIV 6.90518561009
* device instance VDD_DIV_t97 r0 *1 0,0
RVDD_DIV_t97 VDD_DIV__t97 VDD_DIV 7.01388997537
* device instance VDD_DIV_t98 r0 *1 0,0
RVDD_DIV_t98 VDD_DIV__t98 VDD_DIV 7.23129870594
* device instance VDD_DIV_t99 r0 *1 0,0
RVDD_DIV_t99 VDD_DIV__t99 VDD_DIV 7.5574118018
* device instance VDD_DIV_t100 r0 *1 0,0
RVDD_DIV_t100 VDD_DIV__t100 VDD_DIV 7.77482053237
* device instance VDD_DIV_t101 r0 *1 0,0
RVDD_DIV_t101 VDD_DIV__t101 VDD_DIV 7.88352489765
* device instance VDD_DIV_t102 r0 *1 0,0
RVDD_DIV_t102 VDD_DIV__t102 VDD_DIV 8.10093362822
* device instance VDD_DIV_t103 r0 *1 0,0
RVDD_DIV_t103 VDD_DIV__t103 VDD_DIV 0.595415594558
* device instance VDD_DIV_t104 r0 *1 0,0
RVDD_DIV_t104 VDD_DIV__t104 VDD_DIV 0.486711229273
* device instance VDD_DIV_t105 r0 *1 0,0
RVDD_DIV_t105 VDD_DIV__t105 VDD_DIV 0.378006863988
* device instance VDD_DIV_t106 r0 *1 0,0
RVDD_DIV_t106 VDD_DIV__t106 VDD_DIV 0.269302498703
* device instance VDD_DIV_t107 r0 *1 0,0
RVDD_DIV_t107 VDD_DIV__t107 VDD_DIV 0.160598133419
* device instance VDD_DIV_t108 r0 *1 0,0
RVDD_DIV_t108 VDD_DIV__t108 VDD_DIV 0.051893768134
* device instance VDD_DIV_t109 r0 *1 0,0
RVDD_DIV_t109 VDD_DIV__t109 VDD_DIV 0.0568105971507
* device instance VDD_DIV_t110 r0 *1 0,0
RVDD_DIV_t110 VDD_DIV__t110 VDD_DIV 0.165514962435
* device instance VDD_DIV_t111 r0 *1 0,0
RVDD_DIV_t111 VDD_DIV__t111 VDD_DIV 4.83488584066
* device instance VDD_DIV_t112 r0 *1 0,0
RVDD_DIV_t112 VDD_DIV__t112 VDD_DIV 0.382923693005
* device instance VDD_DIV_t113 r0 *1 0,0
RVDD_DIV_t113 VDD_DIV__t113 VDD_DIV 0.49162805829
* device instance VDD_DIV_t114 r0 *1 0,0
RVDD_DIV_t114 VDD_DIV__t114 VDD_DIV 0.600332423574
* device instance VDD_DIV_t115 r0 *1 0,0
RVDD_DIV_t115 VDD_DIV__t115 VDD_DIV 0.709036788859
* device instance VDD_DIV_t116 r0 *1 0,0
RVDD_DIV_t116 VDD_DIV__t116 VDD_DIV 0.817741154144
* device instance VDD_DIV_t117 r0 *1 0,0
RVDD_DIV_t117 VDD_DIV__t117 VDD_DIV 0.926445519428
* device instance VDD_DIV_t118 r0 *1 0,0
RVDD_DIV_t118 VDD_DIV__t118 VDD_DIV 1.03514988471
* device instance VDD_DIV_t119 r0 *1 0,0
RVDD_DIV_t119 VDD_DIV__t119 VDD_DIV 1.14385425
* device instance VDD_DIV_t120 r0 *1 0,0
RVDD_DIV_t120 VDD_DIV__t120 VDD_DIV 1.25255861528
* device instance VDD_DIV_t121 r0 *1 0,0
RVDD_DIV_t121 VDD_DIV__t121 VDD_DIV 0.27421932772
* device instance VDD_DIV_t122 r0 *1 0,0
RVDD_DIV_t122 VDD_DIV__t122 VDD_DIV 2.76950290025
* device instance VDD_DIV_t123 r0 *1 0,0
RVDD_DIV_t123 VDD_DIV__t123 VDD_DIV 2.66079853497
* device instance VDD_DIV_t124 r0 *1 0,0
RVDD_DIV_t124 VDD_DIV__t124 VDD_DIV 2.55209416968
* device instance VDD_DIV_t125 r0 *1 0,0
RVDD_DIV_t125 VDD_DIV__t125 VDD_DIV 2.4433898044
* device instance VDD_DIV_t126 r0 *1 0,0
RVDD_DIV_t126 VDD_DIV__t126 VDD_DIV 2.33468543911
* device instance VDD_DIV_t127 r0 *1 0,0
RVDD_DIV_t127 VDD_DIV__t127 VDD_DIV 2.22598107383
* device instance VDD_DIV_t128 r0 *1 0,0
RVDD_DIV_t128 VDD_DIV__t128 VDD_DIV 2.11727670854
* device instance VDD_DIV_t129 r0 *1 0,0
RVDD_DIV_t129 VDD_DIV__t129 VDD_DIV 2.00857234326
* device instance VDD_DIV_t130 r0 *1 0,0
RVDD_DIV_t130 VDD_DIV__t130 VDD_DIV 1.89986797797
* device instance VDD_DIV_t131 r0 *1 0,0
RVDD_DIV_t131 VDD_DIV__t131 VDD_DIV 0.704119959842
* device instance VDD_DIV_t132 r0 *1 0,0
RVDD_DIV_t132 VDD_DIV__t132 VDD_DIV 1.6824592474
* device instance VDD_DIV_t133 r0 *1 0,0
RVDD_DIV_t133 VDD_DIV__t133 VDD_DIV 1.57375488212
* device instance VDD_DIV_t134 r0 *1 0,0
RVDD_DIV_t134 VDD_DIV__t134 VDD_DIV 1.46505051684
* device instance VDD_DIV_t135 r0 *1 0,0
RVDD_DIV_t135 VDD_DIV__t135 VDD_DIV 1.35634615155
* device instance VDD_DIV_t136 r0 *1 0,0
RVDD_DIV_t136 VDD_DIV__t136 VDD_DIV 1.24764178627
* device instance VDD_DIV_t137 r0 *1 0,0
RVDD_DIV_t137 VDD_DIV__t137 VDD_DIV 1.13893742098
* device instance VDD_DIV_t138 r0 *1 0,0
RVDD_DIV_t138 VDD_DIV__t138 VDD_DIV 1.0302330557
* device instance VDD_DIV_t139 r0 *1 0,0
RVDD_DIV_t139 VDD_DIV__t139 VDD_DIV 0.921528690412
* device instance VDD_DIV_t140 r0 *1 0,0
RVDD_DIV_t140 VDD_DIV__t140 VDD_DIV 0.812824325127
* device instance VDD_DIV_t141 r0 *1 0,0
RVDD_DIV_t141 VDD_DIV__t141 VDD_DIV 1.79116361269
* device instance VDD_DIV_t142 r0 *1 0,0
RVDD_DIV_t142 VDD_DIV__t142 VDD_DIV 6.79156441579
* device instance VDD_DIV_t143 r0 *1 0,0
RVDD_DIV_t143 VDD_DIV__t143 VDD_DIV 6.6828600505
* device instance VDD_DIV_t144 r0 *1 0,0
RVDD_DIV_t144 VDD_DIV__t144 VDD_DIV 6.57415568522
* device instance VDD_DIV_t145 r0 *1 0,0
RVDD_DIV_t145 VDD_DIV__t145 VDD_DIV 6.46545131993
* device instance VDD_DIV_t146 r0 *1 0,0
RVDD_DIV_t146 VDD_DIV__t146 VDD_DIV 6.35674695465
* device instance VDD_DIV_t147 r0 *1 0,0
RVDD_DIV_t147 VDD_DIV__t147 VDD_DIV 6.24804258936
* device instance VDD_DIV_t148 r0 *1 0,0
RVDD_DIV_t148 VDD_DIV__t148 VDD_DIV 6.13933822408
* device instance VDD_DIV_t149 r0 *1 0,0
RVDD_DIV_t149 VDD_DIV__t149 VDD_DIV 6.03063385879
* device instance VDD_DIV_t150 r0 *1 0,0
RVDD_DIV_t150 VDD_DIV__t150 VDD_DIV 1.36126298057
* device instance VDD_DIV_t151 r0 *1 0,0
RVDD_DIV_t151 VDD_DIV__t151 VDD_DIV 5.81322512822
* device instance VDD_DIV_t152 r0 *1 0,0
RVDD_DIV_t152 VDD_DIV__t152 VDD_DIV 5.70452076294
* device instance VDD_DIV_t153 r0 *1 0,0
RVDD_DIV_t153 VDD_DIV__t153 VDD_DIV 5.59581639765
* device instance VDD_DIV_t154 r0 *1 0,0
RVDD_DIV_t154 VDD_DIV__t154 VDD_DIV 5.48711203237
* device instance VDD_DIV_t155 r0 *1 0,0
RVDD_DIV_t155 VDD_DIV__t155 VDD_DIV 5.37840766708
* device instance VDD_DIV_t156 r0 *1 0,0
RVDD_DIV_t156 VDD_DIV__t156 VDD_DIV 5.2697033018
* device instance VDD_DIV_t157 r0 *1 0,0
RVDD_DIV_t157 VDD_DIV__t157 VDD_DIV 5.16099893652
* device instance VDD_DIV_t158 r0 *1 0,0
RVDD_DIV_t158 VDD_DIV__t158 VDD_DIV 5.05229457123
* device instance VDD_DIV_t159 r0 *1 0,0
RVDD_DIV_t159 VDD_DIV__t159 VDD_DIV 4.94359020595
* device instance VDD_DIV_t160 r0 *1 0,0
RVDD_DIV_t160 VDD_DIV__t160 VDD_DIV 5.92192949351
* device instance VDD_DIV_t161 r0 *1 0,0
RVDD_DIV_t161 VDD_DIV__t161 VDD_DIV 1.46996734585
* device instance VDD_DIV_t162 r0 *1 0,0
RVDD_DIV_t162 VDD_DIV__t162 VDD_DIV 1.57867171114
* device instance VDD_DIV_t163 r0 *1 0,0
RVDD_DIV_t163 VDD_DIV__t163 VDD_DIV 1.68737607642
* device instance VDD_DIV_t164 r0 *1 0,0
RVDD_DIV_t164 VDD_DIV__t164 VDD_DIV 1.79608044171
* device instance VDD_DIV_t165 r0 *1 0,0
RVDD_DIV_t165 VDD_DIV__t165 VDD_DIV 4.72618147538
* device instance VDD_DIV_t166 r0 *1 0,0
RVDD_DIV_t166 VDD_DIV__t166 VDD_DIV 4.61747711009
* device instance VDD_DIV_t167 r0 *1 0,0
RVDD_DIV_t167 VDD_DIV__t167 VDD_DIV 8.31342552977
* device instance VDD_DIV_t168 r0 *1 0,0
RVDD_DIV_t168 VDD_DIV__t168 VDD_DIV 8.20472116449
* device instance VDD_DIV_t169 r0 *1 0,0
RVDD_DIV_t169 VDD_DIV__t169 VDD_DIV 8.0960167992
* device instance VDD_DIV_t170 r0 *1 0,0
RVDD_DIV_t170 VDD_DIV__t170 VDD_DIV 6.90026878107
* device instance VDD_DIV_t171 r0 *1 0,0
RVDD_DIV_t171 VDD_DIV__t171 VDD_DIV 7.87860806863
* device instance VDD_DIV_t172 r0 *1 0,0
RVDD_DIV_t172 VDD_DIV__t172 VDD_DIV 7.76990370335
* device instance VDD_DIV_t173 r0 *1 0,0
RVDD_DIV_t173 VDD_DIV__t173 VDD_DIV 7.66119933806
* device instance VDD_DIV_t174 r0 *1 0,0
RVDD_DIV_t174 VDD_DIV__t174 VDD_DIV 7.55249497278
* device instance VDD_DIV_t175 r0 *1 0,0
RVDD_DIV_t175 VDD_DIV__t175 VDD_DIV 7.44379060749
* device instance VDD_DIV_t176 r0 *1 0,0
RVDD_DIV_t176 VDD_DIV__t176 VDD_DIV 7.33508624221
* device instance VDD_DIV_t177 r0 *1 0,0
RVDD_DIV_t177 VDD_DIV__t177 VDD_DIV 7.22638187692
* device instance VDD_DIV_t178 r0 *1 0,0
RVDD_DIV_t178 VDD_DIV__t178 VDD_DIV 7.11767751164
* device instance VDD_DIV_t179 r0 *1 0,0
RVDD_DIV_t179 VDD_DIV__t179 VDD_DIV 7.00897314636
* device instance VDD_DIV_t180 r0 *1 0,0
RVDD_DIV_t180 VDD_DIV__t180 VDD_DIV 7.98731243392
* device instance VDD_DIV_t181 r0 *1 0,0
RVDD_DIV_t181 VDD_DIV__t181 VDD_DIV 4.07887211269
* device instance VDD_DIV_t182 r0 *1 0,0
RVDD_DIV_t182 VDD_DIV__t182 VDD_DIV 4.18757647797
* device instance VDD_DIV_t183 r0 *1 0,0
RVDD_DIV_t183 VDD_DIV__t183 VDD_DIV 4.29628084325
* device instance VDD_DIV_t184 r0 *1 0,0
RVDD_DIV_t184 VDD_DIV__t184 VDD_DIV 4.40498520854
* device instance VDD_DIV_t185 r0 *1 0,0
RVDD_DIV_t185 VDD_DIV__t185 VDD_DIV 4.51368957382
* device instance VDD_DIV_t186 r0 *1 0,0
RVDD_DIV_t186 VDD_DIV__t186 VDD_DIV 4.62239393911
* device instance VDD_DIV_t187 r0 *1 0,0
RVDD_DIV_t187 VDD_DIV__t187 VDD_DIV 4.73109830439
* device instance VDD_DIV_t188 r0 *1 0,0
RVDD_DIV_t188 VDD_DIV__t188 VDD_DIV 4.83980266968
* device instance VDD_DIV_t189 r0 *1 0,0
RVDD_DIV_t189 VDD_DIV__t189 VDD_DIV 2.87820726554
* device instance VDD_DIV_t190 r0 *1 0,0
RVDD_DIV_t190 VDD_DIV__t190 VDD_DIV 5.05721140025
* device instance VDD_DIV_t191 r0 *1 0,0
RVDD_DIV_t191 VDD_DIV__t191 VDD_DIV 5.16591576553
* device instance VDD_DIV_t192 r0 *1 0,0
RVDD_DIV_t192 VDD_DIV__t192 VDD_DIV 5.27462013082
* device instance VDD_DIV_t193 r0 *1 0,0
RVDD_DIV_t193 VDD_DIV__t193 VDD_DIV 5.3833244961
* device instance VDD_DIV_t194 r0 *1 0,0
RVDD_DIV_t194 VDD_DIV__t194 VDD_DIV 5.49202886139
* device instance VDD_DIV_t195 r0 *1 0,0
RVDD_DIV_t195 VDD_DIV__t195 VDD_DIV 5.60073322667
* device instance VDD_DIV_t196 r0 *1 0,0
RVDD_DIV_t196 VDD_DIV__t196 VDD_DIV 5.70943759196
* device instance VDD_DIV_t197 r0 *1 0,0
RVDD_DIV_t197 VDD_DIV__t197 VDD_DIV 5.81814195724
* device instance VDD_DIV_t198 r0 *1 0,0
RVDD_DIV_t198 VDD_DIV__t198 VDD_DIV 5.92684632253
* device instance VDD_DIV_t199 r0 *1 0,0
RVDD_DIV_t199 VDD_DIV__t199 VDD_DIV 4.94850703496
* device instance VDD_DIV_t200 r0 *1 0,0
RVDD_DIV_t200 VDD_DIV__t200 VDD_DIV 1.90478480699
* device instance VDD_DIV_t201 r0 *1 0,0
RVDD_DIV_t201 VDD_DIV__t201 VDD_DIV 2.01348917228
* device instance VDD_DIV_t202 r0 *1 0,0
RVDD_DIV_t202 VDD_DIV__t202 VDD_DIV 2.12219353756
* device instance VDD_DIV_t203 r0 *1 0,0
RVDD_DIV_t203 VDD_DIV__t203 VDD_DIV 2.23089790284
* device instance VDD_DIV_t204 r0 *1 0,0
RVDD_DIV_t204 VDD_DIV__t204 VDD_DIV 2.33960226813
* device instance VDD_DIV_t205 r0 *1 0,0
RVDD_DIV_t205 VDD_DIV__t205 VDD_DIV 2.44830663341
* device instance VDD_DIV_t206 r0 *1 0,0
RVDD_DIV_t206 VDD_DIV__t206 VDD_DIV 2.5570109987
* device instance VDD_DIV_t207 r0 *1 0,0
RVDD_DIV_t207 VDD_DIV__t207 VDD_DIV 2.66571536398
* device instance VDD_DIV_t208 r0 *1 0,0
RVDD_DIV_t208 VDD_DIV__t208 VDD_DIV 2.77441972927
* device instance VDD_DIV_t209 r0 *1 0,0
RVDD_DIV_t209 VDD_DIV__t209 VDD_DIV 3.9701677474
* device instance VDD_DIV_t210 r0 *1 0,0
RVDD_DIV_t210 VDD_DIV__t210 VDD_DIV 2.99182845984
* device instance VDD_DIV_t211 r0 *1 0,0
RVDD_DIV_t211 VDD_DIV__t211 VDD_DIV 3.10053282512
* device instance VDD_DIV_t212 r0 *1 0,0
RVDD_DIV_t212 VDD_DIV__t212 VDD_DIV 3.20923719041
* device instance VDD_DIV_t213 r0 *1 0,0
RVDD_DIV_t213 VDD_DIV__t213 VDD_DIV 3.31794155569
* device instance VDD_DIV_t214 r0 *1 0,0
RVDD_DIV_t214 VDD_DIV__t214 VDD_DIV 3.42664592098
* device instance VDD_DIV_t215 r0 *1 0,0
RVDD_DIV_t215 VDD_DIV__t215 VDD_DIV 3.53535028626
* device instance VDD_DIV_t216 r0 *1 0,0
RVDD_DIV_t216 VDD_DIV__t216 VDD_DIV 3.64405465155
* device instance VDD_DIV_t217 r0 *1 0,0
RVDD_DIV_t217 VDD_DIV__t217 VDD_DIV 3.75275901683
* device instance VDD_DIV_t218 r0 *1 0,0
RVDD_DIV_t218 VDD_DIV__t218 VDD_DIV 3.86146338212
* device instance VDD_DIV_t219 r0 *1 0,0
RVDD_DIV_t219 VDD_DIV__t219 VDD_DIV 2.88312409455
* device instance VDD_DIV_t220 r0 *1 0,0
RVDD_DIV_t220 VDD_DIV__t220 VDD_DIV 8.31834235879
* device instance VDD_DIV_t221 r0 *1 0,0
RVDD_DIV_t221 VDD_DIV__t221 VDD_DIV 8.42704672407
* device instance VDD_DIV_t222 r0 *1 0,0
RVDD_DIV_t222 VDD_DIV__t222 VDD_DIV 8.53575108936
* device instance VDD_DIV_t223 r0 *1 0,0
RVDD_DIV_t223 VDD_DIV__t223 VDD_DIV 8.64445545464
* device instance VDD_DIV_t224 r0 *1 0,0
RVDD_DIV_t224 VDD_DIV__t224 VDD_DIV 4.50877274481
* device instance VDD_DIV_t225 r0 *1 0,0
RVDD_DIV_t225 VDD_DIV__t225 VDD_DIV 4.40006837952
* device instance VDD_DIV_t226 r0 *1 0,0
RVDD_DIV_t226 VDD_DIV__t226 VDD_DIV 4.29136401424
* device instance VDD_DIV_t227 r0 *1 0,0
RVDD_DIV_t227 VDD_DIV__t227 VDD_DIV 4.18265964895
* device instance VDD_DIV_t228 r0 *1 0,0
RVDD_DIV_t228 VDD_DIV__t228 VDD_DIV 4.07395528367
* device instance VDD_DIV_t229 r0 *1 0,0
RVDD_DIV_t229 VDD_DIV__t229 VDD_DIV 6.03555068781
* device instance VDD_DIV_t230 r0 *1 0,0
RVDD_DIV_t230 VDD_DIV__t230 VDD_DIV 3.8565465531
* device instance VDD_DIV_t231 r0 *1 0,0
RVDD_DIV_t231 VDD_DIV__t231 VDD_DIV 3.74784218781
* device instance VDD_DIV_t232 r0 *1 0,0
RVDD_DIV_t232 VDD_DIV__t232 VDD_DIV 3.63913782253
* device instance VDD_DIV_t233 r0 *1 0,0
RVDD_DIV_t233 VDD_DIV__t233 VDD_DIV 3.53043345724
* device instance VDD_DIV_t234 r0 *1 0,0
RVDD_DIV_t234 VDD_DIV__t234 VDD_DIV 3.42172909196
* device instance VDD_DIV_t235 r0 *1 0,0
RVDD_DIV_t235 VDD_DIV__t235 VDD_DIV 3.31302472668
* device instance VDD_DIV_t236 r0 *1 0,0
RVDD_DIV_t236 VDD_DIV__t236 VDD_DIV 3.20432036139
* device instance VDD_DIV_t237 r0 *1 0,0
RVDD_DIV_t237 VDD_DIV__t237 VDD_DIV 3.09561599611
* device instance VDD_DIV_t238 r0 *1 0,0
RVDD_DIV_t238 VDD_DIV__t238 VDD_DIV 2.98691163082
* device instance VDD_DIV_t239 r0 *1 0,0
RVDD_DIV_t239 VDD_DIV__t239 VDD_DIV 3.96525091838
* device instance VDD_DIV_t240 r0 *1 0,0
RVDD_DIV_t240 VDD_DIV__t240 VDD_DIV 6.14425505309
* device instance VDD_DIV_t241 r0 *1 0,0
RVDD_DIV_t241 VDD_DIV__t241 VDD_DIV 6.25295941838
* device instance VDD_DIV_t242 r0 *1 0,0
RVDD_DIV_t242 VDD_DIV__t242 VDD_DIV 6.36166378366
* device instance VDD_DIV_t243 r0 *1 0,0
RVDD_DIV_t243 VDD_DIV__t243 VDD_DIV 6.47036814895
* device instance VDD_DIV_t244 r0 *1 0,0
RVDD_DIV_t244 VDD_DIV__t244 VDD_DIV 6.57907251423
* device instance VDD_DIV_t245 r0 *1 0,0
RVDD_DIV_t245 VDD_DIV__t245 VDD_DIV 6.68777687952
* device instance VDD_DIV_t246 r0 *1 0,0
RVDD_DIV_t246 VDD_DIV__t246 VDD_DIV 6.7964812448
* device instance VDD_DIV_t247 r0 *1 0,0
RVDD_DIV_t247 VDD_DIV__t247 VDD_DIV 6.90518561009
* device instance VDD_DIV_t248 r0 *1 0,0
RVDD_DIV_t248 VDD_DIV__t248 VDD_DIV 7.01388997537
* device instance VDD_DIV_t249 r0 *1 0,0
RVDD_DIV_t249 VDD_DIV__t249 VDD_DIV 8.2096379935
* device instance VDD_DIV_t250 r0 *1 0,0
RVDD_DIV_t250 VDD_DIV__t250 VDD_DIV 7.23129870594
* device instance VDD_DIV_t251 r0 *1 0,0
RVDD_DIV_t251 VDD_DIV__t251 VDD_DIV 7.34000307123
* device instance VDD_DIV_t252 r0 *1 0,0
RVDD_DIV_t252 VDD_DIV__t252 VDD_DIV 7.44870743651
* device instance VDD_DIV_t253 r0 *1 0,0
RVDD_DIV_t253 VDD_DIV__t253 VDD_DIV 7.5574118018
* device instance VDD_DIV_t254 r0 *1 0,0
RVDD_DIV_t254 VDD_DIV__t254 VDD_DIV 7.66611616708
* device instance VDD_DIV_t255 r0 *1 0,0
RVDD_DIV_t255 VDD_DIV__t255 VDD_DIV 7.77482053237
* device instance VDD_DIV_t256 r0 *1 0,0
RVDD_DIV_t256 VDD_DIV__t256 VDD_DIV 7.88352489765
* device instance VDD_DIV_t257 r0 *1 0,0
RVDD_DIV_t257 VDD_DIV__t257 VDD_DIV 7.99222926293
* device instance VDD_DIV_t258 r0 *1 0,0
RVDD_DIV_t258 VDD_DIV__t258 VDD_DIV 8.10093362822
* device instance VDD_DIV_t259 r0 *1 0,0
RVDD_DIV_t259 VDD_DIV__t259 VDD_DIV 7.12259434066
* device instance VDD_DIV_t260 r0 *1 0,0
RVDD_DIV_t260 VDD_DIV__t260 VDD_DIV 9.72439569641
* device instance VDD_DIV_t261 r0 *1 0,0
RVDD_DIV_t261 VDD_DIV__t261 VDD_DIV 10.5902821923
* device instance VDD_DIV r0 *1 0,0
CVDD_DIV VDD_DIV vsubs 3.16785294e-13
* device instance VSS_t0 r0 *1 0,0
RVSS_t0 VSS__t0 VSS 0.966986172782
* device instance VSS_t1 r0 *1 0,0
RVSS_t1 VSS__t1 VSS 1.10795126819
* device instance VSS_t2 r0 *1 0,0
RVSS_t2 VSS__t2 VSS 1.85231573542
* device instance VSS_t3 r0 *1 0,0
RVSS_t3 VSS__t3 VSS 1.78183318771
* device instance VSS_t4 r0 *1 0,0
RVSS_t4 VSS__t4 VSS 1.71135064001
* device instance VSS_t5 r0 *1 0,0
RVSS_t5 VSS__t5 VSS 2.20472847394
* device instance VSS_t6 r0 *1 0,0
RVSS_t6 VSS__t6 VSS 2.06376337853
* device instance VSS_t7 r0 *1 0,0
RVSS_t7 VSS__t7 VSS 5.37644312067
* device instance VSS_t8 r0 *1 0,0
RVSS_t8 VSS__t8 VSS 5.30596057296
* device instance VSS_t9 r0 *1 0,0
RVSS_t9 VSS__t9 VSS 5.23547802526
* device instance VSS_t10 r0 *1 0,0
RVSS_t10 VSS__t10 VSS 5.16499547755
* device instance VSS_t11 r0 *1 0,0
RVSS_t11 VSS__t11 VSS 0.442664781318
* device instance VSS_t12 r0 *1 0,0
RVSS_t12 VSS__t12 VSS 0.301699685908
* device instance VSS_t13 r0 *1 0,0
RVSS_t13 VSS__t13 VSS 0.090252042793
* device instance VSS_t14 r0 *1 0,0
RVSS_t14 VSS__t14 VSS 0.019769495088
* device instance VSS_t15 r0 *1 0,0
RVSS_t15 VSS__t15 VSS 0.050713052617
* device instance VSS_t16 r0 *1 0,0
RVSS_t16 VSS__t16 VSS 0.121195600322
* device instance VSS_t17 r0 *1 0,0
RVSS_t17 VSS__t17 VSS 0.896503625077
* device instance VSS_t18 r0 *1 0,0
RVSS_t18 VSS__t18 VSS 0.332643243437
* device instance VSS_t19 r0 *1 0,0
RVSS_t19 VSS__t19 VSS 0.544090886552
* device instance VSS_t20 r0 *1 0,0
RVSS_t20 VSS__t20 VSS 0.685055981962
* device instance VSS_t21 r0 *1 0,0
RVSS_t21 VSS__t21 VSS 0.826021077372
* device instance VSS_t22 r0 *1 0,0
RVSS_t22 VSS__t22 VSS 0.191678148027
* device instance VSS_t23 r0 *1 0,0
RVSS_t23 VSS__t23 VSS 3.61437942804
* device instance VSS_t24 r0 *1 0,0
RVSS_t24 VSS__t24 VSS 3.54389688034
* device instance VSS_t25 r0 *1 0,0
RVSS_t25 VSS__t25 VSS 3.47341433263
* device instance VSS_t26 r0 *1 0,0
RVSS_t26 VSS__t26 VSS 3.40293178493
* device instance VSS_t27 r0 *1 0,0
RVSS_t27 VSS__t27 VSS 3.33244923722
* device instance VSS_t28 r0 *1 0,0
RVSS_t28 VSS__t28 VSS 3.19148414181
* device instance VSS_t29 r0 *1 0,0
RVSS_t29 VSS__t29 VSS 5.09451292985
* device instance VSS_t30 r0 *1 0,0
RVSS_t30 VSS__t30 VSS 2.83907140329
* device instance VSS_t31 r0 *1 0,0
RVSS_t31 VSS__t31 VSS 2.69810630788
* device instance VSS_t32 r0 *1 0,0
RVSS_t32 VSS__t32 VSS 2.62762376017
* device instance VSS_t33 r0 *1 0,0
RVSS_t33 VSS__t33 VSS 2.55714121247
* device instance VSS_t34 r0 *1 0,0
RVSS_t34 VSS__t34 VSS 2.41617611706
* device instance VSS_t35 r0 *1 0,0
RVSS_t35 VSS__t35 VSS 2.9800364987
* device instance VSS_t36 r0 *1 0,0
RVSS_t36 VSS__t36 VSS 4.95354783444
* device instance VSS_t37 r0 *1 0,0
RVSS_t37 VSS__t37 VSS 4.74210019132
* device instance VSS_t38 r0 *1 0,0
RVSS_t38 VSS__t38 VSS 4.60113509591
* device instance VSS_t39 r0 *1 0,0
RVSS_t39 VSS__t39 VSS 4.4601700005
* device instance VSS_t40 r0 *1 0,0
RVSS_t40 VSS__t40 VSS 4.31920490509
* device instance VSS_t41 r0 *1 0,0
RVSS_t41 VSS__t41 VSS 4.17823980968
* device instance VSS_t42 r0 *1 0,0
RVSS_t42 VSS__t42 VSS 3.96679216657
* device instance VSS_t43 r0 *1 0,0
RVSS_t43 VSS__t43 VSS 3.82582707116
* device instance VSS_t44 r0 *1 0,0
RVSS_t44 VSS__t44 VSS 4.3896874528
* device instance VSS_t45 r0 *1 0,0
RVSS_t45 VSS__t45 VSS 3.64532298557
* device instance VSS_t46 r0 *1 0,0
RVSS_t46 VSS__t46 VSS 3.71580553328
* device instance VSS_t47 r0 *1 0,0
RVSS_t47 VSS__t47 VSS 3.85677062869
* device instance VSS_t48 r0 *1 0,0
RVSS_t48 VSS__t48 VSS 4.0682182718
* device instance VSS_t49 r0 *1 0,0
RVSS_t49 VSS__t49 VSS 4.20918336721
* device instance VSS_t50 r0 *1 0,0
RVSS_t50 VSS__t50 VSS 4.35014846262
* device instance VSS_t51 r0 *1 0,0
RVSS_t51 VSS__t51 VSS 4.42063101033
* device instance VSS_t52 r0 *1 0,0
RVSS_t52 VSS__t52 VSS 4.49111355803
* device instance VSS_t53 r0 *1 0,0
RVSS_t53 VSS__t53 VSS 4.63207865344
* device instance VSS_t54 r0 *1 0,0
RVSS_t54 VSS__t54 VSS 4.84352629656
* device instance VSS_t55 r0 *1 0,0
RVSS_t55 VSS__t55 VSS 2.30615457918
* device instance VSS_t56 r0 *1 0,0
RVSS_t56 VSS__t56 VSS 2.44711967459
* device instance VSS_t57 r0 *1 0,0
RVSS_t57 VSS__t57 VSS 2.58808477
* device instance VSS_t58 r0 *1 0,0
RVSS_t58 VSS__t58 VSS 2.6585673177
* device instance VSS_t59 r0 *1 0,0
RVSS_t59 VSS__t59 VSS 2.72904986541
* device instance VSS_t60 r0 *1 0,0
RVSS_t60 VSS__t60 VSS 3.57484043787
* device instance VSS_t61 r0 *1 0,0
RVSS_t61 VSS__t61 VSS 3.08146260393
* device instance VSS_t62 r0 *1 0,0
RVSS_t62 VSS__t62 VSS 3.22242769934
* device instance VSS_t63 r0 *1 0,0
RVSS_t63 VSS__t63 VSS 3.43387534246
* device instance VSS_t64 r0 *1 0,0
RVSS_t64 VSS__t64 VSS 3.50435789016
* device instance VSS_t65 r0 *1 0,0
RVSS_t65 VSS__t65 VSS 2.87001496082
* device instance VSS_t66 r0 *1 0,0
RVSS_t66 VSS__t66 VSS 1.95374184065
* device instance VSS_t67 r0 *1 0,0
RVSS_t67 VSS__t67 VSS 2.09470693606
* device instance VSS_t68 r0 *1 0,0
RVSS_t68 VSS__t68 VSS 1.6408680923
* device instance VSS_t69 r0 *1 0,0
RVSS_t69 VSS__t69 VSS 1.5703855446
* device instance VSS_t70 r0 *1 0,0
RVSS_t70 VSS__t70 VSS 1.42942044919
* device instance VSS_t71 r0 *1 0,0
RVSS_t71 VSS__t71 VSS 1.07700771066
* device instance VSS_t72 r0 *1 0,0
RVSS_t72 VSS__t72 VSS 0.936042615253
* device instance VSS_t73 r0 *1 0,0
RVSS_t73 VSS__t73 VSS 0.865560067548
* device instance VSS_t74 r0 *1 0,0
RVSS_t74 VSS__t74 VSS 0.795077519843
* device instance VSS_t75 r0 *1 0,0
RVSS_t75 VSS__t75 VSS 0.654112424433
* device instance VSS_t76 r0 *1 0,0
RVSS_t76 VSS__t76 VSS 1.21797280607
* device instance VSS_t77 r0 *1 0,0
RVSS_t77 VSS__t77 VSS 4.98449139197
* device instance VSS_t78 r0 *1 0,0
RVSS_t78 VSS__t78 VSS 5.05497393967
* device instance VSS_t79 r0 *1 0,0
RVSS_t79 VSS__t79 VSS 5.19593903508
* device instance VSS_t80 r0 *1 0,0
RVSS_t80 VSS__t80 VSS 5.4073866782
* device instance VSS_t81 r0 *1 0,0
RVSS_t81 VSS__t81 VSS 5.54835177361
* device instance VSS_t82 r0 *1 0,0
RVSS_t82 VSS__t82 VSS 1.88325929295
* device instance VSS_t83 r0 *1 0,0
RVSS_t83 VSS__t83 VSS 1.31939891131
* device instance VSS_t84 r0 *1 0,0
RVSS_t84 VSS__t84 VSS 1.46036400672
* device instance VSS_t85 r0 *1 0,0
RVSS_t85 VSS__t85 VSS 1.67181164983
* device instance VSS_t86 r0 *1 0,0
RVSS_t86 VSS__t86 VSS 1.74229419754
* device instance VSS_t87 r0 *1 0,0
RVSS_t87 VSS__t87 VSS 1.81277674524
* device instance VSS_t88 r0 *1 0,0
RVSS_t88 VSS__t88 VSS 5.51740821608
* device instance VSS_t89 r0 *1 0,0
RVSS_t89 VSS__t89 VSS 5.44692566837
* device instance VSS_t90 r0 *1 0,0
RVSS_t90 VSS__t90 VSS 5.37644312067
* device instance VSS_t91 r0 *1 0,0
RVSS_t91 VSS__t91 VSS 5.30596057296
* device instance VSS_t92 r0 *1 0,0
RVSS_t92 VSS__t92 VSS 5.23547802526
* device instance VSS_t93 r0 *1 0,0
RVSS_t93 VSS__t93 VSS 5.16499547755
* device instance VSS_t94 r0 *1 0,0
RVSS_t94 VSS__t94 VSS 5.09451292985
* device instance VSS_t95 r0 *1 0,0
RVSS_t95 VSS__t95 VSS 5.02403038214
* device instance VSS_t96 r0 *1 0,0
RVSS_t96 VSS__t96 VSS 4.95354783444
* device instance VSS_t97 r0 *1 0,0
RVSS_t97 VSS__t97 VSS 4.88306528673
* device instance VSS_t98 r0 *1 0,0
RVSS_t98 VSS__t98 VSS 4.81258273903
* device instance VSS_t99 r0 *1 0,0
RVSS_t99 VSS__t99 VSS 4.74210019132
* device instance VSS_t100 r0 *1 0,0
RVSS_t100 VSS__t100 VSS 4.67161764362
* device instance VSS_t101 r0 *1 0,0
RVSS_t101 VSS__t101 VSS 4.60113509591
* device instance VSS_t102 r0 *1 0,0
RVSS_t102 VSS__t102 VSS 4.53065254821
* device instance VSS_t103 r0 *1 0,0
RVSS_t103 VSS__t103 VSS 4.4601700005
* device instance VSS_t104 r0 *1 0,0
RVSS_t104 VSS__t104 VSS 4.3896874528
* device instance VSS_t105 r0 *1 0,0
RVSS_t105 VSS__t105 VSS 4.31920490509
* device instance VSS_t106 r0 *1 0,0
RVSS_t106 VSS__t106 VSS 4.24872235739
* device instance VSS_t107 r0 *1 0,0
RVSS_t107 VSS__t107 VSS 4.17823980968
* device instance VSS_t108 r0 *1 0,0
RVSS_t108 VSS__t108 VSS 4.10775726198
* device instance VSS_t109 r0 *1 0,0
RVSS_t109 VSS__t109 VSS 4.03727471427
* device instance VSS_t110 r0 *1 0,0
RVSS_t110 VSS__t110 VSS 3.96679216657
* device instance VSS_t111 r0 *1 0,0
RVSS_t111 VSS__t111 VSS 3.89630961886
* device instance VSS_t112 r0 *1 0,0
RVSS_t112 VSS__t112 VSS 3.82582707116
* device instance VSS_t113 r0 *1 0,0
RVSS_t113 VSS__t113 VSS 3.75534452345
* device instance VSS_t114 r0 *1 0,0
RVSS_t114 VSS__t114 VSS 3.68486197575
* device instance VSS_t115 r0 *1 0,0
RVSS_t115 VSS__t115 VSS 3.61437942804
* device instance VSS_t116 r0 *1 0,0
RVSS_t116 VSS__t116 VSS 3.54389688034
* device instance VSS_t117 r0 *1 0,0
RVSS_t117 VSS__t117 VSS 3.47341433263
* device instance VSS_t118 r0 *1 0,0
RVSS_t118 VSS__t118 VSS 3.40293178493
* device instance VSS_t119 r0 *1 0,0
RVSS_t119 VSS__t119 VSS 3.33244923722
* device instance VSS_t120 r0 *1 0,0
RVSS_t120 VSS__t120 VSS 3.26196668952
* device instance VSS_t121 r0 *1 0,0
RVSS_t121 VSS__t121 VSS 3.19148414181
* device instance VSS_t122 r0 *1 0,0
RVSS_t122 VSS__t122 VSS 3.12100159411
* device instance VSS_t123 r0 *1 0,0
RVSS_t123 VSS__t123 VSS 3.0505190464
* device instance VSS_t124 r0 *1 0,0
RVSS_t124 VSS__t124 VSS 2.9800364987
* device instance VSS_t125 r0 *1 0,0
RVSS_t125 VSS__t125 VSS 2.90955395099
* device instance VSS_t126 r0 *1 0,0
RVSS_t126 VSS__t126 VSS 2.83907140329
* device instance VSS_t127 r0 *1 0,0
RVSS_t127 VSS__t127 VSS 2.76858885558
* device instance VSS_t128 r0 *1 0,0
RVSS_t128 VSS__t128 VSS 2.69810630788
* device instance VSS_t129 r0 *1 0,0
RVSS_t129 VSS__t129 VSS 2.62762376017
* device instance VSS_t130 r0 *1 0,0
RVSS_t130 VSS__t130 VSS 2.55714121247
* device instance VSS_t131 r0 *1 0,0
RVSS_t131 VSS__t131 VSS 2.48665866476
* device instance VSS_t132 r0 *1 0,0
RVSS_t132 VSS__t132 VSS 2.41617611706
* device instance VSS_t133 r0 *1 0,0
RVSS_t133 VSS__t133 VSS 2.34569356935
* device instance VSS_t134 r0 *1 0,0
RVSS_t134 VSS__t134 VSS 2.27521102165
* device instance VSS_t135 r0 *1 0,0
RVSS_t135 VSS__t135 VSS 2.20472847394
* device instance VSS_t136 r0 *1 0,0
RVSS_t136 VSS__t136 VSS 2.13424592624
* device instance VSS_t137 r0 *1 0,0
RVSS_t137 VSS__t137 VSS 2.06376337853
* device instance VSS_t138 r0 *1 0,0
RVSS_t138 VSS__t138 VSS 1.99328083083
* device instance VSS_t139 r0 *1 0,0
RVSS_t139 VSS__t139 VSS 1.92279828312
* device instance VSS_t140 r0 *1 0,0
RVSS_t140 VSS__t140 VSS 1.85231573542
* device instance VSS_t141 r0 *1 0,0
RVSS_t141 VSS__t141 VSS 1.78183318771
* device instance VSS_t142 r0 *1 0,0
RVSS_t142 VSS__t142 VSS 1.71135064001
* device instance VSS_t143 r0 *1 0,0
RVSS_t143 VSS__t143 VSS 1.6408680923
* device instance VSS_t144 r0 *1 0,0
RVSS_t144 VSS__t144 VSS 1.5703855446
* device instance VSS_t145 r0 *1 0,0
RVSS_t145 VSS__t145 VSS 1.49990299689
* device instance VSS_t146 r0 *1 0,0
RVSS_t146 VSS__t146 VSS 1.42942044919
* device instance VSS_t147 r0 *1 0,0
RVSS_t147 VSS__t147 VSS 1.35893790148
* device instance VSS_t148 r0 *1 0,0
RVSS_t148 VSS__t148 VSS 1.28845535378
* device instance VSS_t149 r0 *1 0,0
RVSS_t149 VSS__t149 VSS 1.21797280607
* device instance VSS_t150 r0 *1 0,0
RVSS_t150 VSS__t150 VSS 1.14749025837
* device instance VSS_t151 r0 *1 0,0
RVSS_t151 VSS__t151 VSS 1.07700771066
* device instance VSS_t152 r0 *1 0,0
RVSS_t152 VSS__t152 VSS 1.00652516296
* device instance VSS_t153 r0 *1 0,0
RVSS_t153 VSS__t153 VSS 0.936042615253
* device instance VSS_t154 r0 *1 0,0
RVSS_t154 VSS__t154 VSS 0.865560067548
* device instance VSS_t155 r0 *1 0,0
RVSS_t155 VSS__t155 VSS 0.795077519843
* device instance VSS_t156 r0 *1 0,0
RVSS_t156 VSS__t156 VSS 0.724594972138
* device instance VSS_t157 r0 *1 0,0
RVSS_t157 VSS__t157 VSS 0.654112424433
* device instance VSS_t158 r0 *1 0,0
RVSS_t158 VSS__t158 VSS 0.583629876728
* device instance VSS_t159 r0 *1 0,0
RVSS_t159 VSS__t159 VSS 0.513147329023
* device instance VSS_t160 r0 *1 0,0
RVSS_t160 VSS__t160 VSS 0.442664781318
* device instance VSS_t161 r0 *1 0,0
RVSS_t161 VSS__t161 VSS 0.372182233613
* device instance VSS_t162 r0 *1 0,0
RVSS_t162 VSS__t162 VSS 0.301699685908
* device instance VSS_t163 r0 *1 0,0
RVSS_t163 VSS__t163 VSS 0.231217138203
* device instance VSS_t164 r0 *1 0,0
RVSS_t164 VSS__t164 VSS 0.160734590498
* device instance VSS_t165 r0 *1 0,0
RVSS_t165 VSS__t165 VSS 0.090252042793
* device instance VSS_t166 r0 *1 0,0
RVSS_t166 VSS__t166 VSS 0.019769495088
* device instance VSS_t167 r0 *1 0,0
RVSS_t167 VSS__t167 VSS 0.050713052617
* device instance VSS_t168 r0 *1 0,0
RVSS_t168 VSS__t168 VSS 0.121195600322
* device instance VSS_t169 r0 *1 0,0
RVSS_t169 VSS__t169 VSS 0.191678148027
* device instance VSS_t170 r0 *1 0,0
RVSS_t170 VSS__t170 VSS 0.262160695732
* device instance VSS_t171 r0 *1 0,0
RVSS_t171 VSS__t171 VSS 0.332643243437
* device instance VSS_t172 r0 *1 0,0
RVSS_t172 VSS__t172 VSS 0.403125791142
* device instance VSS_t173 r0 *1 0,0
RVSS_t173 VSS__t173 VSS 0.473608338847
* device instance VSS_t174 r0 *1 0,0
RVSS_t174 VSS__t174 VSS 0.544090886552
* device instance VSS_t175 r0 *1 0,0
RVSS_t175 VSS__t175 VSS 0.614573434257
* device instance VSS_t176 r0 *1 0,0
RVSS_t176 VSS__t176 VSS 0.685055981962
* device instance VSS_t177 r0 *1 0,0
RVSS_t177 VSS__t177 VSS 0.755538529667
* device instance VSS_t178 r0 *1 0,0
RVSS_t178 VSS__t178 VSS 0.826021077372
* device instance VSS_t179 r0 *1 0,0
RVSS_t179 VSS__t179 VSS 0.896503625077
* device instance VSS_t180 r0 *1 0,0
RVSS_t180 VSS__t180 VSS 0.966986172782
* device instance VSS_t181 r0 *1 0,0
RVSS_t181 VSS__t181 VSS 1.03746872049
* device instance VSS_t182 r0 *1 0,0
RVSS_t182 VSS__t182 VSS 1.10795126819
* device instance VSS_t183 r0 *1 0,0
RVSS_t183 VSS__t183 VSS 1.1784338159
* device instance VSS_t184 r0 *1 0,0
RVSS_t184 VSS__t184 VSS 1.2489163636
* device instance VSS_t185 r0 *1 0,0
RVSS_t185 VSS__t185 VSS 1.31939891131
* device instance VSS_t186 r0 *1 0,0
RVSS_t186 VSS__t186 VSS 1.38988145901
* device instance VSS_t187 r0 *1 0,0
RVSS_t187 VSS__t187 VSS 1.46036400672
* device instance VSS_t188 r0 *1 0,0
RVSS_t188 VSS__t188 VSS 1.53084655442
* device instance VSS_t189 r0 *1 0,0
RVSS_t189 VSS__t189 VSS 1.60132910213
* device instance VSS_t190 r0 *1 0,0
RVSS_t190 VSS__t190 VSS 1.67181164983
* device instance VSS_t191 r0 *1 0,0
RVSS_t191 VSS__t191 VSS 1.74229419754
* device instance VSS_t192 r0 *1 0,0
RVSS_t192 VSS__t192 VSS 1.81277674524
* device instance VSS_t193 r0 *1 0,0
RVSS_t193 VSS__t193 VSS 1.88325929295
* device instance VSS_t194 r0 *1 0,0
RVSS_t194 VSS__t194 VSS 1.95374184065
* device instance VSS_t195 r0 *1 0,0
RVSS_t195 VSS__t195 VSS 2.02422438836
* device instance VSS_t196 r0 *1 0,0
RVSS_t196 VSS__t196 VSS 2.09470693606
* device instance VSS_t197 r0 *1 0,0
RVSS_t197 VSS__t197 VSS 2.16518948377
* device instance VSS_t198 r0 *1 0,0
RVSS_t198 VSS__t198 VSS 2.23567203147
* device instance VSS_t199 r0 *1 0,0
RVSS_t199 VSS__t199 VSS 2.30615457918
* device instance VSS_t200 r0 *1 0,0
RVSS_t200 VSS__t200 VSS 2.37663712688
* device instance VSS_t201 r0 *1 0,0
RVSS_t201 VSS__t201 VSS 2.44711967459
* device instance VSS_t202 r0 *1 0,0
RVSS_t202 VSS__t202 VSS 2.51760222229
* device instance VSS_t203 r0 *1 0,0
RVSS_t203 VSS__t203 VSS 2.58808477
* device instance VSS_t204 r0 *1 0,0
RVSS_t204 VSS__t204 VSS 2.6585673177
* device instance VSS_t205 r0 *1 0,0
RVSS_t205 VSS__t205 VSS 2.72904986541
* device instance VSS_t206 r0 *1 0,0
RVSS_t206 VSS__t206 VSS 2.79953241311
* device instance VSS_t207 r0 *1 0,0
RVSS_t207 VSS__t207 VSS 2.87001496082
* device instance VSS_t208 r0 *1 0,0
RVSS_t208 VSS__t208 VSS 2.94049750852
* device instance VSS_t209 r0 *1 0,0
RVSS_t209 VSS__t209 VSS 3.01098005623
* device instance VSS_t210 r0 *1 0,0
RVSS_t210 VSS__t210 VSS 3.08146260393
* device instance VSS_t211 r0 *1 0,0
RVSS_t211 VSS__t211 VSS 3.15194515164
* device instance VSS_t212 r0 *1 0,0
RVSS_t212 VSS__t212 VSS 3.22242769934
* device instance VSS_t213 r0 *1 0,0
RVSS_t213 VSS__t213 VSS 3.29291024705
* device instance VSS_t214 r0 *1 0,0
RVSS_t214 VSS__t214 VSS 3.36339279475
* device instance VSS_t215 r0 *1 0,0
RVSS_t215 VSS__t215 VSS 3.43387534246
* device instance VSS_t216 r0 *1 0,0
RVSS_t216 VSS__t216 VSS 3.50435789016
* device instance VSS_t217 r0 *1 0,0
RVSS_t217 VSS__t217 VSS 3.57484043787
* device instance VSS_t218 r0 *1 0,0
RVSS_t218 VSS__t218 VSS 3.64532298557
* device instance VSS_t219 r0 *1 0,0
RVSS_t219 VSS__t219 VSS 3.71580553328
* device instance VSS_t220 r0 *1 0,0
RVSS_t220 VSS__t220 VSS 3.78628808098
* device instance VSS_t221 r0 *1 0,0
RVSS_t221 VSS__t221 VSS 3.85677062869
* device instance VSS_t222 r0 *1 0,0
RVSS_t222 VSS__t222 VSS 3.92725317639
* device instance VSS_t223 r0 *1 0,0
RVSS_t223 VSS__t223 VSS 3.9977357241
* device instance VSS_t224 r0 *1 0,0
RVSS_t224 VSS__t224 VSS 4.0682182718
* device instance VSS_t225 r0 *1 0,0
RVSS_t225 VSS__t225 VSS 4.13870081951
* device instance VSS_t226 r0 *1 0,0
RVSS_t226 VSS__t226 VSS 4.20918336721
* device instance VSS_t227 r0 *1 0,0
RVSS_t227 VSS__t227 VSS 4.27966591492
* device instance VSS_t228 r0 *1 0,0
RVSS_t228 VSS__t228 VSS 4.35014846262
* device instance VSS_t229 r0 *1 0,0
RVSS_t229 VSS__t229 VSS 4.42063101033
* device instance VSS_t230 r0 *1 0,0
RVSS_t230 VSS__t230 VSS 4.49111355803
* device instance VSS_t231 r0 *1 0,0
RVSS_t231 VSS__t231 VSS 4.56159610574
* device instance VSS_t232 r0 *1 0,0
RVSS_t232 VSS__t232 VSS 4.63207865344
* device instance VSS_t233 r0 *1 0,0
RVSS_t233 VSS__t233 VSS 4.70256120115
* device instance VSS_t234 r0 *1 0,0
RVSS_t234 VSS__t234 VSS 4.77304374885
* device instance VSS_t235 r0 *1 0,0
RVSS_t235 VSS__t235 VSS 4.84352629656
* device instance VSS_t236 r0 *1 0,0
RVSS_t236 VSS__t236 VSS 4.91400884426
* device instance VSS_t237 r0 *1 0,0
RVSS_t237 VSS__t237 VSS 4.98449139197
* device instance VSS_t238 r0 *1 0,0
RVSS_t238 VSS__t238 VSS 5.05497393967
* device instance VSS_t239 r0 *1 0,0
RVSS_t239 VSS__t239 VSS 5.12545648738
* device instance VSS_t240 r0 *1 0,0
RVSS_t240 VSS__t240 VSS 5.19593903508
* device instance VSS_t241 r0 *1 0,0
RVSS_t241 VSS__t241 VSS 5.26642158279
* device instance VSS_t242 r0 *1 0,0
RVSS_t242 VSS__t242 VSS 5.33690413049
* device instance VSS_t243 r0 *1 0,0
RVSS_t243 VSS__t243 VSS 5.4073866782
* device instance VSS_t244 r0 *1 0,0
RVSS_t244 VSS__t244 VSS 5.4778692259
* device instance VSS_t245 r0 *1 0,0
RVSS_t245 VSS__t245 VSS 5.54835177361
* device instance VSS r0 *1 0,0
CVSS VSS vsubs 1.94019687e-13
* device instance XD0_XDFFM_CLKB_t0 r0 *1 0,0
RXD0_XDFFM_CLKB_t0 XD0_XDFFM_CLKB__t0 XD0_XDFFM_CLKB 39.0013857145
* device instance XD0_XDFFM_CLKB_t1 r0 *1 0,0
RXD0_XDFFM_CLKB_t1 XD0_XDFFM_CLKB__t1 XD0_XDFFM_CLKB 39.7757392862
* device instance XD0_XDFFM_CLKB_t2 r0 *1 0,0
RXD0_XDFFM_CLKB_t2 XD0_XDFFM_CLKB__t2 XD0_XDFFM_CLKB 36.6783249993
* device instance XD0_XDFFM_CLKB_t3 r0 *1 0,0
RXD0_XDFFM_CLKB_t3 XD0_XDFFM_CLKB__t3 XD0_XDFFM_CLKB 39.0725906406
* device instance XD0_XDFFM_CLKB_t4 r0 *1 0,0
RXD0_XDFFM_CLKB_t4 XD0_XDFFM_CLKB__t4 XD0_XDFFM_CLKB 36.8696882383
* device instance XD0_XDFFM_CLKB_t5 r0 *1 0,0
RXD0_XDFFM_CLKB_t5 XD0_XDFFM_CLKB__t5 XD0_XDFFM_CLKB 39.5131711211
* device instance XD0_XDFFM_CLKB r0 *1 0,0
CXD0_XDFFM_CLKB XD0_XDFFM_CLKB vsubs 5.1724346e-14
* device instance XD0_XDFFM_M_t0 r0 *1 0,0
RXD0_XDFFM_M_t0 XD0_XDFFM_M__t0 XD0_XDFFM_M 30.2079062543
* device instance XD0_XDFFM_M_t1 r0 *1 0,0
RXD0_XDFFM_M_t1 XD0_XDFFM_M__t1 XD0_XDFFM_M 29.594368763
* device instance XD0_XDFFM_M_t2 r0 *1 0,0
RXD0_XDFFM_M_t2 XD0_XDFFM_M__t2 XD0_XDFFM_M 30.8214437457
* device instance XD0_XDFFM_M_t3 r0 *1 0,0
RXD0_XDFFM_M_t3 XD0_XDFFM_M__t3 XD0_XDFFM_M 31.434981237
* device instance XD0_XDFFM_M_t4 r0 *1 0,0
RXD0_XDFFM_M_t4 XD0_XDFFM_M__t4 XD0_XDFFM_M 30.6892158381
* device instance XD0_XDFFM_M_t5 r0 *1 0,0
RXD0_XDFFM_M_t5 XD0_XDFFM_M__t5 XD0_XDFFM_M 29.9910524858
* device instance XD0_XDFFM_M_t6 r0 *1 0,0
RXD0_XDFFM_M_t6 XD0_XDFFM_M__t6 XD0_XDFFM_M 31.0382975142
* device instance XD0_XDFFM_M_t7 r0 *1 0,0
RXD0_XDFFM_M_t7 XD0_XDFFM_M__t7 XD0_XDFFM_M 30.3401341619
* device instance XD0_XDFFM_M r0 *1 0,0
CXD0_XDFFM_M XD0_XDFFM_M vsubs 5.489909e-14
* device instance XD0_XDFFM_MB_t0 r0 *1 0,0
RXD0_XDFFM_MB_t0 XD0_XDFFM_MB__t0 XD0_XDFFM_MB 55.4904557228
* device instance XD0_XDFFM_MB_t1 r0 *1 0,0
RXD0_XDFFM_MB_t1 XD0_XDFFM_MB__t1 XD0_XDFFM_MB 56.6174942772
* device instance XD0_XDFFM_MB_t2 r0 *1 0,0
RXD0_XDFFM_MB_t2 XD0_XDFFM_MB__t2 XD0_XDFFM_MB 56.374598037
* device instance XD0_XDFFM_MB_t3 r0 *1 0,0
RXD0_XDFFM_MB_t3 XD0_XDFFM_MB__t3 XD0_XDFFM_MB 55.733351963
* device instance XD0_XDFFM_MB r0 *1 0,0
CXD0_XDFFM_MB XD0_XDFFM_MB vsubs 4.9839184e-14
* device instance XD0_XDFFM_S_t0 r0 *1 0,0
RXD0_XDFFM_S_t0 XD0_XDFFM_S__t0 XD0_XDFFM_S 39.5287333333
* device instance XD0_XDFFM_S_t1 r0 *1 0,0
RXD0_XDFFM_S_t1 XD0_XDFFM_S__t1 XD0_XDFFM_S 38.7424740552
* device instance XD0_XDFFM_S_t2 r0 *1 0,0
RXD0_XDFFM_S_t2 XD0_XDFFM_S__t2 XD0_XDFFM_S 40.3149926114
* device instance XD0_XDFFM_S_t3 r0 *1 0,0
RXD0_XDFFM_S_t3 XD0_XDFFM_S__t3 XD0_XDFFM_S 39.5287333333
* device instance XD0_XDFFM_S_t4 r0 *1 0,0
RXD0_XDFFM_S_t4 XD0_XDFFM_S__t4 XD0_XDFFM_S 39.9760877502
* device instance XD0_XDFFM_S_t5 r0 *1 0,0
RXD0_XDFFM_S_t5 XD0_XDFFM_S__t5 XD0_XDFFM_S 39.0813789165
* device instance XD0_XDFFM_S r0 *1 0,0
CXD0_XDFFM_S XD0_XDFFM_S vsubs 5.3159062e-14
* device instance XD0_XDFFM_SB_t0 r0 *1 0,0
RXD0_XDFFM_SB_t0 XD0_XDFFM_SB__t0 XD0_XDFFM_SB 40.4851394307
* device instance XD0_XDFFM_SB_t1 r0 *1 0,0
RXD0_XDFFM_SB_t1 XD0_XDFFM_SB__t1 XD0_XDFFM_SB 38.9125939027
* device instance XD0_XDFFM_SB_t2 r0 *1 0,0
RXD0_XDFFM_SB_t2 XD0_XDFFM_SB__t2 XD0_XDFFM_SB 39.6988666667
* device instance XD0_XDFFM_SB_t3 r0 *1 0,0
RXD0_XDFFM_SB_t3 XD0_XDFFM_SB__t3 XD0_XDFFM_SB 39.2515045768
* device instance XD0_XDFFM_SB_t4 r0 *1 0,0
RXD0_XDFFM_SB_t4 XD0_XDFFM_SB__t4 XD0_XDFFM_SB 40.1462287565
* device instance XD0_XDFFM_SB_t5 r0 *1 0,0
RXD0_XDFFM_SB_t5 XD0_XDFFM_SB__t5 XD0_XDFFM_SB 39.6988666667
* device instance XD0_XDFFM_SB r0 *1 0,0
CXD0_XDFFM_SB XD0_XDFFM_SB vsubs 5.3412247e-14
* device instance XD0_XDFFQ_CLKB_t0 r0 *1 0,0
RXD0_XDFFQ_CLKB_t0 XD0_XDFFQ_CLKB__t0 XD0_XDFFQ_CLKB 38.2835808187
* device instance XD0_XDFFQ_CLKB_t1 r0 *1 0,0
RXD0_XDFFQ_CLKB_t1 XD0_XDFFQ_CLKB__t1 XD0_XDFFQ_CLKB 39.0812270468
* device instance XD0_XDFFQ_CLKB_t2 r0 *1 0,0
RXD0_XDFFQ_CLKB_t2 XD0_XDFFQ_CLKB__t2 XD0_XDFFQ_CLKB 35.8906421344
* device instance XD0_XDFFQ_CLKB_t3 r0 *1 0,0
RXD0_XDFFQ_CLKB_t3 XD0_XDFFQ_CLKB__t3 XD0_XDFFQ_CLKB 38.3569275983
* device instance XD0_XDFFQ_CLKB_t4 r0 *1 0,0
RXD0_XDFFQ_CLKB_t4 XD0_XDFFQ_CLKB__t4 XD0_XDFFQ_CLKB 36.0877616046
* device instance XD0_XDFFQ_CLKB_t5 r0 *1 0,0
RXD0_XDFFQ_CLKB_t5 XD0_XDFFQ_CLKB__t5 XD0_XDFFQ_CLKB 38.8107607971
* device instance XD0_XDFFQ_CLKB r0 *1 0,0
CXD0_XDFFQ_CLKB XD0_XDFFQ_CLKB vsubs 5.0950424e-14
* device instance XD0_XDFFQ_M_t0 r0 *1 0,0
RXD0_XDFFQ_M_t0 XD0_XDFFQ_M__t0 XD0_XDFFQ_M 30.3659698386
* device instance XD0_XDFFQ_M_t1 r0 *1 0,0
RXD0_XDFFQ_M_t1 XD0_XDFFQ_M__t1 XD0_XDFFQ_M 29.8660355867
* device instance XD0_XDFFQ_M_t2 r0 *1 0,0
RXD0_XDFFQ_M_t2 XD0_XDFFQ_M__t2 XD0_XDFFQ_M 29.22875676
* device instance XD0_XDFFQ_M_t3 r0 *1 0,0
RXD0_XDFFQ_M_t3 XD0_XDFFQ_M__t3 XD0_XDFFQ_M 30.5033144133
* device instance XD0_XDFFQ_M_t4 r0 *1 0,0
RXD0_XDFFQ_M_t4 XD0_XDFFQ_M__t4 XD0_XDFFQ_M 31.14059324
* device instance XD0_XDFFQ_M_t5 r0 *1 0,0
RXD0_XDFFQ_M_t5 XD0_XDFFQ_M__t5 XD0_XDFFQ_M 29.6407904841
* device instance XD0_XDFFQ_M_t6 r0 *1 0,0
RXD0_XDFFQ_M_t6 XD0_XDFFQ_M__t6 XD0_XDFFQ_M 30.7285595159
* device instance XD0_XDFFQ_M_t7 r0 *1 0,0
RXD0_XDFFQ_M_t7 XD0_XDFFQ_M__t7 XD0_XDFFQ_M 30.0033801614
* device instance XD0_XDFFQ_M r0 *1 0,0
CXD0_XDFFQ_M XD0_XDFFQ_M vsubs 5.4576191e-14
* device instance XD0_XDFFQ_MB_t0 r0 *1 0,0
RXD0_XDFFQ_MB_t0 XD0_XDFFQ_MB__t0 XD0_XDFFQ_MB 53.9385074486
* device instance XD0_XDFFQ_MB_t1 r0 *1 0,0
RXD0_XDFFQ_MB_t1 XD0_XDFFQ_MB__t1 XD0_XDFFQ_MB 55.0894425514
* device instance XD0_XDFFQ_MB_t2 r0 *1 0,0
RXD0_XDFFQ_MB_t2 XD0_XDFFQ_MB__t2 XD0_XDFFQ_MB 54.841396193
* device instance XD0_XDFFQ_MB_t3 r0 *1 0,0
RXD0_XDFFQ_MB_t3 XD0_XDFFQ_MB__t3 XD0_XDFFQ_MB 54.186553807
* device instance XD0_XDFFQ_MB r0 *1 0,0
CXD0_XDFFQ_MB XD0_XDFFQ_MB vsubs 4.861424e-14
* device instance XD0_XDFFQ_S_t0 r0 *1 0,0
RXD0_XDFFQ_S_t0 XD0_XDFFQ_S__t0 XD0_XDFFQ_S 38.7954
* device instance XD0_XDFFQ_S_t1 r0 *1 0,0
RXD0_XDFFQ_S_t1 XD0_XDFFQ_S__t1 XD0_XDFFQ_S 37.9855383162
* device instance XD0_XDFFQ_S_t2 r0 *1 0,0
RXD0_XDFFQ_S_t2 XD0_XDFFQ_S__t2 XD0_XDFFQ_S 39.6052616838
* device instance XD0_XDFFQ_S_t3 r0 *1 0,0
RXD0_XDFFQ_S_t3 XD0_XDFFQ_S__t3 XD0_XDFFQ_S 38.7954
* device instance XD0_XDFFQ_S_t4 r0 *1 0,0
RXD0_XDFFQ_S_t4 XD0_XDFFQ_S__t4 XD0_XDFFQ_S 39.2561833718
* device instance XD0_XDFFQ_S_t5 r0 *1 0,0
RXD0_XDFFQ_S_t5 XD0_XDFFQ_S__t5 XD0_XDFFQ_S 38.3346166282
* device instance XD0_XDFFQ_S r0 *1 0,0
CXD0_XDFFQ_S XD0_XDFFQ_S vsubs 5.2383504e-14
* device instance XD0_XDFFQ_SB_t0 r0 *1 0,0
RXD0_XDFFQ_SB_t0 XD0_XDFFQ_SB__t0 XD0_XDFFQ_SB 39.7753034567
* device instance XD0_XDFFQ_SB_t1 r0 *1 0,0
RXD0_XDFFQ_SB_t1 XD0_XDFFQ_SB__t1 XD0_XDFFQ_SB 38.15576321
* device instance XD0_XDFFQ_SB_t2 r0 *1 0,0
RXD0_XDFFQ_SB_t2 XD0_XDFFQ_SB__t2 XD0_XDFFQ_SB 38.9655333333
* device instance XD0_XDFFQ_SB_t3 r0 *1 0,0
RXD0_XDFFQ_SB_t3 XD0_XDFFQ_SB__t3 XD0_XDFFQ_SB 38.5048020563
* device instance XD0_XDFFQ_SB_t4 r0 *1 0,0
RXD0_XDFFQ_SB_t4 XD0_XDFFQ_SB__t4 XD0_XDFFQ_SB 39.4262646104
* device instance XD0_XDFFQ_SB_t5 r0 *1 0,0
RXD0_XDFFQ_SB_t5 XD0_XDFFQ_SB__t5 XD0_XDFFQ_SB 38.9655333333
* device instance XD0_XDFFQ_SB r0 *1 0,0
CXD0_XDFFQ_SB XD0_XDFFQ_SB vsubs 5.2635054e-14
* device instance XD0_XN2_mid1_t0 r0 *1 0,0
RXD0_XN2_mid1_t0 XD0_XN2_mid1__t0 XD0_XN2_mid1 6.5779
* device instance XD0_XN2_mid1_t1 r0 *1 0,0
RXD0_XN2_mid1_t1 XD0_XN2_mid1__t1 XD0_XN2_mid1 6.5779
* device instance XD0_XN2_mid1 r0 *1 0,0
CXD0_XN2_mid1 XD0_XN2_mid1 vsubs 3.356409e-15
* device instance XD0_XN3_mid1_t0 r0 *1 0,0
RXD0_XN3_mid1_t0 XD0_XN3_mid1__t0 XD0_XN3_mid1 6.7539
* device instance XD0_XN3_mid1_t1 r0 *1 0,0
RXD0_XN3_mid1_t1 XD0_XN3_mid1__t1 XD0_XN3_mid1 6.7539
* device instance XD0_XN3_mid1 r0 *1 0,0
CXD0_XN3_mid1 XD0_XN3_mid1 vsubs 3.46952e-15
* device instance XD0_XN3_mid2_t0 r0 *1 0,0
RXD0_XN3_mid2_t0 XD0_XN3_mid2__t0 XD0_XN3_mid2 6.9299
* device instance XD0_XN3_mid2_t1 r0 *1 0,0
RXD0_XN3_mid2_t1 XD0_XN3_mid2__t1 XD0_XN3_mid2 6.9299
* device instance XD0_XN3_mid2 r0 *1 0,0
CXD0_XN3_mid2 XD0_XN3_mid2 vsubs 3.559168e-15
* device instance XD0_XNOR_midp_t0 r0 *1 0,0
RXD0_XNOR_midp_t0 XD0_XNOR_midp__t0 XD0_XNOR_midp 8.6391
* device instance XD0_XNOR_midp_t1 r0 *1 0,0
RXD0_XNOR_midp_t1 XD0_XNOR_midp__t1 XD0_XNOR_midp 8.6391
* device instance XD0_XNOR_midp r0 *1 0,0
CXD0_XNOR_midp XD0_XNOR_midp vsubs 4.239063e-15
* device instance XD0_dmodout_t0 r0 *1 0,0
RXD0_dmodout_t0 XD0_dmodout__t0 XD0_dmodout 56.8371046224
* device instance XD0_dmodout_t1 r0 *1 0,0
RXD0_dmodout_t1 XD0_dmodout__t1 XD0_dmodout 59.1956453776
* device instance XD0_dmodout_t2 r0 *1 0,0
RXD0_dmodout_t2 XD0_dmodout__t2 XD0_dmodout 57.3454108196
* device instance XD0_dmodout_t3 r0 *1 0,0
RXD0_dmodout_t3 XD0_dmodout__t3 XD0_dmodout 58.6873391804
* device instance XD0_dmodout r0 *1 0,0
CXD0_dmodout XD0_dmodout vsubs 5.1915022e-14
* device instance XD0_dq_t0 r0 *1 0,0
RXD0_dq_t0 XD0_dq__t0 XD0_dq 56.6880010604
* device instance XD0_dq_t1 r0 *1 0,0
RXD0_dq_t1 XD0_dq__t1 XD0_dq 58.7337989396
* device instance XD0_dq_t2 r0 *1 0,0
RXD0_dq_t2 XD0_dq__t2 XD0_dq 39.2499256323
* device instance XD0_dq_t3 r0 *1 0,0
RXD0_dq_t3 XD0_dq__t3 XD0_dq 38.6679314081
* device instance XD0_dq_t4 r0 *1 0,0
RXD0_dq_t4 XD0_dq__t4 XD0_dq 37.5039429596
* device instance XD0_dq r0 *1 0,0
CXD0_dq XD0_dq vsubs 5.1925491e-14
* device instance XD0_nm_t0 r0 *1 0,0
RXD0_nm_t0 XD0_nm__t0 XD0_nm 40.4700310716
* device instance XD0_nm_t1 r0 *1 0,0
RXD0_nm_t1 XD0_nm__t1 XD0_nm 39.4586
* device instance XD0_nm_t2 r0 *1 0,0
RXD0_nm_t2 XD0_nm__t2 XD0_nm 38.4471689284
* device instance XD0_nm_t3 r0 *1 0,0
RXD0_nm_t3 XD0_nm__t3 XD0_nm 58.6124305972
* device instance XD0_nm_t4 r0 *1 0,0
RXD0_nm_t4 XD0_nm__t4 XD0_nm 59.7633694028
* device instance XD0_nm r0 *1 0,0
CXD0_nm XD0_nm vsubs 5.3317856e-14
* device instance XD0_nt_t0 r0 *1 0,0
RXD0_nt_t0 XD0_nt__t0 XD0_nt 30.8906751081
* device instance XD0_nt_t1 r0 *1 0,0
RXD0_nt_t1 XD0_nt__t1 XD0_nt 28.964274964
* device instance XD0_nt_t2 r0 *1 0,0
RXD0_nt_t2 XD0_nt__t2 XD0_nt 29.927475036
* device instance XD0_nt_t3 r0 *1 0,0
RXD0_nt_t3 XD0_nt__t3 XD0_nt 28.0010748919
* device instance XD0_nt_t4 r0 *1 0,0
RXD0_nt_t4 XD0_nt__t4 XD0_nt 58.0697085592
* device instance XD0_nt_t5 r0 *1 0,0
RXD0_nt_t5 XD0_nt__t5 XD0_nt 59.7137914408
* device instance XD0_nt r0 *1 0,0
CXD0_nt XD0_nt vsubs 5.3298834e-14
* device instance XD0_t1_t0 r0 *1 0,0
RXD0_t1_t0 XD0_t1__t0 XD0_t1 56.2983002741
* device instance XD0_t1_t1 r0 *1 0,0
RXD0_t1_t1 XD0_t1__t1 XD0_t1 53.9225997259
* device instance XD0_t1_t2 r0 *1 0,0
RXD0_t1_t2 XD0_t1__t2 XD0_t1 54.4346041544
* device instance XD0_t1_t3 r0 *1 0,0
RXD0_t1_t3 XD0_t1__t3 XD0_t1 55.7862958456
* device instance XD0_t1 r0 *1 0,0
CXD0_t1 XD0_t1 vsubs 4.9546116e-14
* device instance XD1_XDFFM_CLKB_t0 r0 *1 0,0
RXD1_XDFFM_CLKB_t0 XD1_XDFFM_CLKB__t0 XD1_XDFFM_CLKB 46.0464037388
* device instance XD1_XDFFM_CLKB_t1 r0 *1 0,0
RXD1_XDFFM_CLKB_t1 XD1_XDFFM_CLKB__t1 XD1_XDFFM_CLKB 46.872284347
* device instance XD1_XDFFM_CLKB_t2 r0 *1 0,0
RXD1_XDFFM_CLKB_t2 XD1_XDFFM_CLKB__t2 XD1_XDFFM_CLKB 43.5687619141
* device instance XD1_XDFFM_CLKB_t3 r0 *1 0,0
RXD1_XDFFM_CLKB_t3 XD1_XDFFM_CLKB__t3 XD1_XDFFM_CLKB 43.7728588461
* device instance XD1_XDFFM_CLKB_t4 r0 *1 0,0
RXD1_XDFFM_CLKB_t4 XD1_XDFFM_CLKB__t4 XD1_XDFFM_CLKB 46.1223467833
* device instance XD1_XDFFM_CLKB_t5 r0 *1 0,0
RXD1_XDFFM_CLKB_t5 XD1_XDFFM_CLKB__t5 XD1_XDFFM_CLKB 46.5922443707
* device instance XD1_XDFFM_CLKB r0 *1 0,0
CXD1_XDFFM_CLKB XD1_XDFFM_CLKB vsubs 6.1808621e-14
* device instance XD1_XDFFM_M_t0 r0 *1 0,0
RXD1_XDFFM_M_t0 XD1_XDFFM_M__t0 XD1_XDFFM_M 36.2766148712
* device instance XD1_XDFFM_M_t1 r0 *1 0,0
RXD1_XDFFM_M_t1 XD1_XDFFM_M__t1 XD1_XDFFM_M 35.6124946137
* device instance XD1_XDFFM_M_t2 r0 *1 0,0
RXD1_XDFFM_M_t2 XD1_XDFFM_M__t2 XD1_XDFFM_M 36.9407351288
* device instance XD1_XDFFM_M_t3 r0 *1 0,0
RXD1_XDFFM_M_t3 XD1_XDFFM_M__t3 XD1_XDFFM_M 37.6048553863
* device instance XD1_XDFFM_M_t4 r0 *1 0,0
RXD1_XDFFM_M_t4 XD1_XDFFM_M__t4 XD1_XDFFM_M 36.7976057629
* device instance XD1_XDFFM_M_t5 r0 *1 0,0
RXD1_XDFFM_M_t5 XD1_XDFFM_M__t5 XD1_XDFFM_M 36.0418827113
* device instance XD1_XDFFM_M_t6 r0 *1 0,0
RXD1_XDFFM_M_t6 XD1_XDFFM_M__t6 XD1_XDFFM_M 37.1754672887
* device instance XD1_XDFFM_M_t7 r0 *1 0,0
RXD1_XDFFM_M_t7 XD1_XDFFM_M__t7 XD1_XDFFM_M 36.4197442371
* device instance XD1_XDFFM_M r0 *1 0,0
CXD1_XDFFM_M XD1_XDFFM_M vsubs 6.6705433e-14
* device instance XD1_XDFFM_MB_t0 r0 *1 0,0
RXD1_XDFFM_MB_t0 XD1_XDFFM_MB__t0 XD1_XDFFM_MB 64.309315893
* device instance XD1_XDFFM_MB_t1 r0 *1 0,0
RXD1_XDFFM_MB_t1 XD1_XDFFM_MB__t1 XD1_XDFFM_MB 65.486634107
* device instance XD1_XDFFM_MB_t2 r0 *1 0,0
RXD1_XDFFM_MB_t2 XD1_XDFFM_MB__t2 XD1_XDFFM_MB 65.2329017333
* device instance XD1_XDFFM_MB_t3 r0 *1 0,0
RXD1_XDFFM_MB_t3 XD1_XDFFM_MB__t3 XD1_XDFFM_MB 64.5630482667
* device instance XD1_XDFFM_MB r0 *1 0,0
CXD1_XDFFM_MB XD1_XDFFM_MB vsubs 5.8201391e-14
* device instance XD1_XDFFM_S_t0 r0 *1 0,0
RXD1_XDFFM_S_t0 XD1_XDFFM_S__t0 XD1_XDFFM_S 46.5394
* device instance XD1_XDFFM_S_t1 r0 *1 0,0
RXD1_XDFFM_S_t1 XD1_XDFFM_S__t1 XD1_XDFFM_S 45.7032981338
* device instance XD1_XDFFM_S_t2 r0 *1 0,0
RXD1_XDFFM_S_t2 XD1_XDFFM_S__t2 XD1_XDFFM_S 47.3755018662
* device instance XD1_XDFFM_S_t3 r0 *1 0,0
RXD1_XDFFM_S_t3 XD1_XDFFM_S__t3 XD1_XDFFM_S 46.5394
* device instance XD1_XDFFM_S_t4 r0 *1 0,0
RXD1_XDFFM_S_t4 XD1_XDFFM_S__t4 XD1_XDFFM_S 46.0636868692
* device instance XD1_XDFFM_S_t5 r0 *1 0,0
RXD1_XDFFM_S_t5 XD1_XDFFM_S__t5 XD1_XDFFM_S 47.0151131308
* device instance XD1_XDFFM_S r0 *1 0,0
CXD1_XDFFM_S XD1_XDFFM_S vsubs 6.324278e-14
* device instance XD1_XDFFM_SB_t0 r0 *1 0,0
RXD1_XDFFM_SB_t0 XD1_XDFFM_SB__t0 XD1_XDFFM_SB 47.5454551456
* device instance XD1_XDFFM_SB_t1 r0 *1 0,0
RXD1_XDFFM_SB_t1 XD1_XDFFM_SB__t1 XD1_XDFFM_SB 45.8736115211
* device instance XD1_XDFFM_SB_t2 r0 *1 0,0
RXD1_XDFFM_SB_t2 XD1_XDFFM_SB__t2 XD1_XDFFM_SB 46.7095333333
* device instance XD1_XDFFM_SB_t3 r0 *1 0,0
RXD1_XDFFM_SB_t3 XD1_XDFFM_SB__t3 XD1_XDFFM_SB 46.2339226471
* device instance XD1_XDFFM_SB_t4 r0 *1 0,0
RXD1_XDFFM_SB_t4 XD1_XDFFM_SB__t4 XD1_XDFFM_SB 47.1851440196
* device instance XD1_XDFFM_SB_t5 r0 *1 0,0
RXD1_XDFFM_SB_t5 XD1_XDFFM_SB__t5 XD1_XDFFM_SB 46.7095333333
* device instance XD1_XDFFM_SB r0 *1 0,0
CXD1_XDFFM_SB XD1_XDFFM_SB vsubs 6.349433e-14
* device instance XD1_XDFFQ_CLKB_t0 r0 *1 0,0
RXD1_XDFFQ_CLKB_t0 XD1_XDFFQ_CLKB__t0 XD1_XDFFQ_CLKB 45.3285565466
* device instance XD1_XDFFQ_CLKB_t1 r0 *1 0,0
RXD1_XDFFQ_CLKB_t1 XD1_XDFFQ_CLKB__t1 XD1_XDFFQ_CLKB 46.1776663664
* device instance XD1_XDFFQ_CLKB_t2 r0 *1 0,0
RXD1_XDFFQ_CLKB_t2 XD1_XDFFQ_CLKB__t2 XD1_XDFFQ_CLKB 42.781227087
* device instance XD1_XDFFQ_CLKB_t3 r0 *1 0,0
RXD1_XDFFQ_CLKB_t3 XD1_XDFFQ_CLKB__t3 XD1_XDFFQ_CLKB 45.4066356105
* device instance XD1_XDFFQ_CLKB_t4 r0 *1 0,0
RXD1_XDFFQ_CLKB_t4 XD1_XDFFQ_CLKB__t4 XD1_XDFFQ_CLKB 42.9910645712
* device instance XD1_XDFFQ_CLKB_t5 r0 *1 0,0
RXD1_XDFFQ_CLKB_t5 XD1_XDFFQ_CLKB__t5 XD1_XDFFQ_CLKB 45.8897498183
* device instance XD1_XDFFQ_CLKB r0 *1 0,0
CXD1_XDFFQ_CLKB XD1_XDFFQ_CLKB vsubs 6.10347e-14
* device instance XD1_XDFFQ_M_t0 r0 *1 0,0
RXD1_XDFFQ_M_t0 XD1_XDFFQ_M__t0 XD1_XDFFQ_M 35.9348200349
* device instance XD1_XDFFQ_M_t1 r0 *1 0,0
RXD1_XDFFQ_M_t1 XD1_XDFFQ_M__t1 XD1_XDFFQ_M 35.2471101046
* device instance XD1_XDFFQ_M_t2 r0 *1 0,0
RXD1_XDFFQ_M_t2 XD1_XDFFQ_M__t2 XD1_XDFFQ_M 36.6225299651
* device instance XD1_XDFFQ_M_t3 r0 *1 0,0
RXD1_XDFFQ_M_t3 XD1_XDFFQ_M__t3 XD1_XDFFQ_M 37.3102398954
* device instance XD1_XDFFQ_M_t4 r0 *1 0,0
RXD1_XDFFQ_M_t4 XD1_XDFFQ_M__t4 XD1_XDFFQ_M 36.4743166181
* device instance XD1_XDFFQ_M_t5 r0 *1 0,0
RXD1_XDFFQ_M_t5 XD1_XDFFQ_M__t5 XD1_XDFFQ_M 35.6917501457
* device instance XD1_XDFFQ_M_t6 r0 *1 0,0
RXD1_XDFFQ_M_t6 XD1_XDFFQ_M__t6 XD1_XDFFQ_M 36.8655998543
* device instance XD1_XDFFQ_M_t7 r0 *1 0,0
RXD1_XDFFQ_M_t7 XD1_XDFFQ_M__t7 XD1_XDFFQ_M 36.0830333819
* device instance XD1_XDFFQ_M r0 *1 0,0
CXD1_XDFFQ_M XD1_XDFFQ_M vsubs 6.6382535e-14
* device instance XD1_XDFFQ_MB_t0 r0 *1 0,0
RXD1_XDFFQ_MB_t0 XD1_XDFFQ_MB__t0 XD1_XDFFQ_MB 62.7574581872
* device instance XD1_XDFFQ_MB_t1 r0 *1 0,0
RXD1_XDFFQ_MB_t1 XD1_XDFFQ_MB__t1 XD1_XDFFQ_MB 63.9584918128
* device instance XD1_XDFFQ_MB_t2 r0 *1 0,0
RXD1_XDFFQ_MB_t2 XD1_XDFFQ_MB__t2 XD1_XDFFQ_MB 63.699648359
* device instance XD1_XDFFQ_MB_t3 r0 *1 0,0
RXD1_XDFFQ_MB_t3 XD1_XDFFQ_MB__t3 XD1_XDFFQ_MB 63.016301641
* device instance XD1_XDFFQ_MB r0 *1 0,0
CXD1_XDFFQ_MB XD1_XDFFQ_MB vsubs 5.6976447e-14
* device instance XD1_XDFFQ_S_t0 r0 *1 0,0
RXD1_XDFFQ_S_t0 XD1_XDFFQ_S__t0 XD1_XDFFQ_S 45.8060666667
* device instance XD1_XDFFQ_S_t1 r0 *1 0,0
RXD1_XDFFQ_S_t1 XD1_XDFFQ_S__t1 XD1_XDFFQ_S 44.9465314047
* device instance XD1_XDFFQ_S_t2 r0 *1 0,0
RXD1_XDFFQ_S_t2 XD1_XDFFQ_S__t2 XD1_XDFFQ_S 46.6656019286
* device instance XD1_XDFFQ_S_t3 r0 *1 0,0
RXD1_XDFFQ_S_t3 XD1_XDFFQ_S__t3 XD1_XDFFQ_S 45.8060666667
* device instance XD1_XDFFQ_S_t4 r0 *1 0,0
RXD1_XDFFQ_S_t4 XD1_XDFFQ_S__t4 XD1_XDFFQ_S 46.2951125916
* device instance XD1_XDFFQ_S_t5 r0 *1 0,0
RXD1_XDFFQ_S_t5 XD1_XDFFQ_S__t5 XD1_XDFFQ_S 45.3170207418
* device instance XD1_XDFFQ_S r0 *1 0,0
CXD1_XDFFQ_S XD1_XDFFQ_S vsubs 6.2468859e-14
* device instance XD1_XDFFQ_SB_t0 r0 *1 0,0
RXD1_XDFFQ_SB_t0 XD1_XDFFQ_SB__t0 XD1_XDFFQ_SB 46.835452845
* device instance XD1_XDFFQ_SB_t1 r0 *1 0,0
RXD1_XDFFQ_SB_t1 XD1_XDFFQ_SB__t1 XD1_XDFFQ_SB 45.116947155
* device instance XD1_XDFFQ_SB_t2 r0 *1 0,0
RXD1_XDFFQ_SB_t2 XD1_XDFFQ_SB__t2 XD1_XDFFQ_SB 45.9762
* device instance XD1_XDFFQ_SB_t3 r0 *1 0,0
RXD1_XDFFQ_SB_t3 XD1_XDFFQ_SB__t3 XD1_XDFFQ_SB 45.4873147606
* device instance XD1_XDFFQ_SB_t4 r0 *1 0,0
RXD1_XDFFQ_SB_t4 XD1_XDFFQ_SB__t4 XD1_XDFFQ_SB 45.9762
* device instance XD1_XDFFQ_SB_t5 r0 *1 0,0
RXD1_XDFFQ_SB_t5 XD1_XDFFQ_SB__t5 XD1_XDFFQ_SB 46.4650852394
* device instance XD1_XDFFQ_SB r0 *1 0,0
CXD1_XDFFQ_SB XD1_XDFFQ_SB vsubs 6.2720409e-14
* device instance XD1_XN2_mid1_t0 r0 *1 0,0
RXD1_XN2_mid1_t0 XD1_XN2_mid1__t0 XD1_XN2_mid1 9.9219
* device instance XD1_XN2_mid1_t1 r0 *1 0,0
RXD1_XN2_mid1_t1 XD1_XN2_mid1__t1 XD1_XN2_mid1 9.9219
* device instance XD1_XN2_mid1 r0 *1 0,0
CXD1_XN2_mid1 XD1_XN2_mid1 vsubs 5.049026e-15
* device instance XD1_XN3_mid1_t0 r0 *1 0,0
RXD1_XN3_mid1_t0 XD1_XN3_mid1__t0 XD1_XN3_mid1 10.0979
* device instance XD1_XN3_mid1_t1 r0 *1 0,0
RXD1_XN3_mid1_t1 XD1_XN3_mid1__t1 XD1_XN3_mid1 10.0979
* device instance XD1_XN3_mid1 r0 *1 0,0
CXD1_XN3_mid1 XD1_XN3_mid1 vsubs 5.158865e-15
* device instance XD1_XN3_mid2_t0 r0 *1 0,0
RXD1_XN3_mid2_t0 XD1_XN3_mid2__t0 XD1_XN3_mid2 10.2739
* device instance XD1_XN3_mid2_t1 r0 *1 0,0
RXD1_XN3_mid2_t1 XD1_XN3_mid2__t1 XD1_XN3_mid2 10.2739
* device instance XD1_XN3_mid2 r0 *1 0,0
CXD1_XN3_mid2 XD1_XN3_mid2 vsubs 5.248512e-15
* device instance XD1_XNOR_midp_t0 r0 *1 0,0
RXD1_XNOR_midp_t0 XD1_XNOR_midp__t0 XD1_XNOR_midp 11.9831
* device instance XD1_XNOR_midp_t1 r0 *1 0,0
RXD1_XNOR_midp_t1 XD1_XNOR_midp__t1 XD1_XNOR_midp 11.9831
* device instance XD1_XNOR_midp r0 *1 0,0
CXD1_XNOR_midp XD1_XNOR_midp vsubs 5.990583e-15
* device instance XD1_dmodout_t0 r0 *1 0,0
RXD1_dmodout_t0 XD1_dmodout__t0 XD1_dmodout 65.6354843417
* device instance XD1_dmodout_t1 r0 *1 0,0
RXD1_dmodout_t1 XD1_dmodout__t1 XD1_dmodout 68.0852656583
* device instance XD1_dmodout_t2 r0 *1 0,0
RXD1_dmodout_t2 XD1_dmodout__t2 XD1_dmodout 67.557295547
* device instance XD1_dmodout_t3 r0 *1 0,0
RXD1_dmodout_t3 XD1_dmodout__t3 XD1_dmodout 66.163454453
* device instance XD1_dmodout r0 *1 0,0
CXD1_dmodout XD1_dmodout vsubs 6.0276149e-14
* device instance XD1_dq_t0 r0 *1 0,0
RXD1_dq_t0 XD1_dq__t0 XD1_dq 66.319238168
* device instance XD1_dq_t1 r0 *1 0,0
RXD1_dq_t1 XD1_dq__t1 XD1_dq 68.462561832
* device instance XD1_dq_t2 r0 *1 0,0
RXD1_dq_t2 XD1_dq__t2 XD1_dq 45.7402515048
* device instance XD1_dq_t3 r0 *1 0,0
RXD1_dq_t3 XD1_dq__t3 XD1_dq 45.1305128762
* device instance XD1_dq_t4 r0 *1 0,0
RXD1_dq_t4 XD1_dq__t4 XD1_dq 43.911035619
* device instance XD1_dq r0 *1 0,0
CXD1_dq XD1_dq vsubs 6.1129654e-14
* device instance XD1_nm_t0 r0 *1 0,0
RXD1_nm_t0 XD1_nm__t0 XD1_nm 46.9716924801
* device instance XD1_nm_t1 r0 *1 0,0
RXD1_nm_t1 XD1_nm__t1 XD1_nm 44.8521741866
* device instance XD1_nm_t2 r0 *1 0,0
RXD1_nm_t2 XD1_nm__t2 XD1_nm 45.9119333333
* device instance XD1_nm_t3 r0 *1 0,0
RXD1_nm_t3 XD1_nm__t3 XD1_nm 68.2649335889
* device instance XD1_nm_t4 r0 *1 0,0
RXD1_nm_t4 XD1_nm__t4 XD1_nm 69.4708664111
* device instance XD1_nm r0 *1 0,0
CXD1_nm XD1_nm vsubs 6.2556902e-14
* device instance XD1_nt_t0 r0 *1 0,0
RXD1_nt_t0 XD1_nt__t0 XD1_nt 36.2276306286
* device instance XD1_nt_t1 r0 *1 0,0
RXD1_nt_t1 XD1_nt__t1 XD1_nt 33.1801193714
* device instance XD1_nt_t2 r0 *1 0,0
RXD1_nt_t2 XD1_nt__t2 XD1_nt 34.1959564571
* device instance XD1_nt_t3 r0 *1 0,0
RXD1_nt_t3 XD1_nt__t3 XD1_nt 35.2117935429
* device instance XD1_nt_t4 r0 *1 0,0
RXD1_nt_t4 XD1_nt__t4 XD1_nt 68.5407855906
* device instance XD1_nt_t5 r0 *1 0,0
RXD1_nt_t5 XD1_nt__t5 XD1_nt 70.2747144094
* device instance XD1_nt r0 *1 0,0
CXD1_nt XD1_nt vsubs 6.3410368e-14
* device instance XD1_t1_t0 r0 *1 0,0
RXD1_t1_t0 XD1_t1__t0 XD1_t1 65.1894961197
* device instance XD1_t1_t1 r0 *1 0,0
RXD1_t1_t1 XD1_t1__t1 XD1_t1 62.7194038803
* device instance XD1_t1_t2 r0 *1 0,0
RXD1_t1_t2 XD1_t1__t2 XD1_t1 63.2517513457
* device instance XD1_t1_t3 r0 *1 0,0
RXD1_t1_t3 XD1_t1__t3 XD1_t1 64.6571486543
* device instance XD1_t1 r0 *1 0,0
CXD1_t1 XD1_t1 vsubs 5.790613e-14
* device instance XD2_XDFFM_CLKB_t0 r0 *1 0,0
RXD2_XDFFM_CLKB_t0 XD2_XDFFM_CLKB__t0 XD2_XDFFM_CLKB 53.9535271353
* device instance XD2_XDFFM_CLKB_t1 r0 *1 0,0
RXD2_XDFFM_CLKB_t1 XD2_XDFFM_CLKB__t1 XD2_XDFFM_CLKB 53.0853008541
* device instance XD2_XDFFM_CLKB_t2 r0 *1 0,0
RXD2_XDFFM_CLKB_t2 XD2_XDFFM_CLKB__t2 XD2_XDFFM_CLKB 50.4806220106
* device instance XD2_XDFFM_CLKB_t3 r0 *1 0,0
RXD2_XDFFM_CLKB_t3 XD2_XDFFM_CLKB__t3 XD2_XDFFM_CLKB 50.6951836778
* device instance XD2_XDFFM_CLKB_t4 r0 *1 0,0
RXD2_XDFFM_CLKB_t4 XD2_XDFFM_CLKB__t4 XD2_XDFFM_CLKB 53.1651377535
* device instance XD2_XDFFM_CLKB_t5 r0 *1 0,0
RXD2_XDFFM_CLKB_t5 XD2_XDFFM_CLKB__t5 XD2_XDFFM_CLKB 53.6591285687
* device instance XD2_XDFFM_CLKB r0 *1 0,0
CXD2_XDFFM_CLKB XD2_XDFFM_CLKB vsubs 7.1889067e-14
* device instance XD2_XDFFM_M_t0 r0 *1 0,0
RXD2_XDFFM_M_t0 XD2_XDFFM_M__t0 XD2_XDFFM_M 42.3498273673
* device instance XD2_XDFFM_M_t1 r0 *1 0,0
RXD2_XDFFM_M_t1 XD2_XDFFM_M__t1 XD2_XDFFM_M 41.6441321018
* device instance XD2_XDFFM_M_t2 r0 *1 0,0
RXD2_XDFFM_M_t2 XD2_XDFFM_M__t2 XD2_XDFFM_M 43.0555226327
* device instance XD2_XDFFM_M_t3 r0 *1 0,0
RXD2_XDFFM_M_t3 XD2_XDFFM_M__t3 XD2_XDFFM_M 43.7612178982
* device instance XD2_XDFFM_M_t4 r0 *1 0,0
RXD2_XDFFM_M_t4 XD2_XDFFM_M__t4 XD2_XDFFM_M 42.9034331359
* device instance XD2_XDFFM_M_t5 r0 *1 0,0
RXD2_XDFFM_M_t5 XD2_XDFFM_M__t5 XD2_XDFFM_M 42.1004005924
* device instance XD2_XDFFM_M_t6 r0 *1 0,0
RXD2_XDFFM_M_t6 XD2_XDFFM_M__t6 XD2_XDFFM_M 43.3049494076
* device instance XD2_XDFFM_M_t7 r0 *1 0,0
RXD2_XDFFM_M_t7 XD2_XDFFM_M__t7 XD2_XDFFM_M 42.5019168641
* device instance XD2_XDFFM_M r0 *1 0,0
CXD2_XDFFM_M XD2_XDFFM_M vsubs 7.8506312e-14
* device instance XD2_XDFFM_MB_t0 r0 *1 0,0
RXD2_XDFFM_MB_t0 XD2_XDFFM_MB__t0 XD2_XDFFM_MB 73.1326529537
* device instance XD2_XDFFM_MB_t1 r0 *1 0,0
RXD2_XDFFM_MB_t1 XD2_XDFFM_MB__t1 XD2_XDFFM_MB 74.3512970463
* device instance XD2_XDFFM_MB_t2 r0 *1 0,0
RXD2_XDFFM_MB_t2 XD2_XDFFM_MB__t2 XD2_XDFFM_MB 74.0886582332
* device instance XD2_XDFFM_MB_t3 r0 *1 0,0
RXD2_XDFFM_MB_t3 XD2_XDFFM_MB__t3 XD2_XDFFM_MB 73.3952917668
* device instance XD2_XDFFM_MB r0 *1 0,0
CXD2_XDFFM_MB XD2_XDFFM_MB vsubs 6.6561405e-14
* device instance XD2_XDFFM_S_t0 r0 *1 0,0
RXD2_XDFFM_S_t0 XD2_XDFFM_S__t0 XD2_XDFFM_S 53.5500666667
* device instance XD2_XDFFM_S_t1 r0 *1 0,0
RXD2_XDFFM_S_t1 XD2_XDFFM_S__t1 XD2_XDFFM_S 54.4272135072
* device instance XD2_XDFFM_S_t2 r0 *1 0,0
RXD2_XDFFM_S_t2 XD2_XDFFM_S__t2 XD2_XDFFM_S 52.6729198262
* device instance XD2_XDFFM_S_t3 r0 *1 0,0
RXD2_XDFFM_S_t3 XD2_XDFFM_S__t3 XD2_XDFFM_S 53.5500666667
* device instance XD2_XDFFM_S_t4 r0 *1 0,0
RXD2_XDFFM_S_t4 XD2_XDFFM_S__t4 XD2_XDFFM_S 53.0510003609
* device instance XD2_XDFFM_S_t5 r0 *1 0,0
RXD2_XDFFM_S_t5 XD2_XDFFM_S__t5 XD2_XDFFM_S 54.0491329725
* device instance XD2_XDFFM_S r0 *1 0,0
CXD2_XDFFM_S XD2_XDFFM_S vsubs 7.3323227e-14
* device instance XD2_XDFFM_SB_t0 r0 *1 0,0
RXD2_XDFFM_SB_t0 XD2_XDFFM_SB__t0 XD2_XDFFM_SB 54.5970382355
* device instance XD2_XDFFM_SB_t1 r0 *1 0,0
RXD2_XDFFM_SB_t1 XD2_XDFFM_SB__t1 XD2_XDFFM_SB 52.8433617645
* device instance XD2_XDFFM_SB_t2 r0 *1 0,0
RXD2_XDFFM_SB_t2 XD2_XDFFM_SB__t2 XD2_XDFFM_SB 53.7202
* device instance XD2_XDFFM_SB_t3 r0 *1 0,0
RXD2_XDFFM_SB_t3 XD2_XDFFM_SB__t3 XD2_XDFFM_SB 53.2213092798
* device instance XD2_XDFFM_SB_t4 r0 *1 0,0
RXD2_XDFFM_SB_t4 XD2_XDFFM_SB__t4 XD2_XDFFM_SB 54.2190907202
* device instance XD2_XDFFM_SB_t5 r0 *1 0,0
RXD2_XDFFM_SB_t5 XD2_XDFFM_SB__t5 XD2_XDFFM_SB 53.7202
* device instance XD2_XDFFM_SB r0 *1 0,0
CXD2_XDFFM_SB XD2_XDFFM_SB vsubs 7.3574776e-14
* device instance XD2_XDFFQ_CLKB_t0 r0 *1 0,0
RXD2_XDFFQ_CLKB_t0 XD2_XDFFQ_CLKB__t0 XD2_XDFFQ_CLKB 52.3671694753
* device instance XD2_XDFFQ_CLKB_t1 r0 *1 0,0
RXD2_XDFFQ_CLKB_t1 XD2_XDFFQ_CLKB__t1 XD2_XDFFQ_CLKB 53.2581986882
* device instance XD2_XDFFQ_CLKB_t2 r0 *1 0,0
RXD2_XDFFQ_CLKB_t2 XD2_XDFFQ_CLKB__t2 XD2_XDFFQ_CLKB 49.6940818365
* device instance XD2_XDFFQ_CLKB_t3 r0 *1 0,0
RXD2_XDFFQ_CLKB_t3 XD2_XDFFQ_CLKB__t3 XD2_XDFFQ_CLKB 52.449103196
* device instance XD2_XDFFQ_CLKB_t4 r0 *1 0,0
RXD2_XDFFQ_CLKB_t4 XD2_XDFFQ_CLKB__t4 XD2_XDFFQ_CLKB 49.914278711
* device instance XD2_XDFFQ_CLKB_t5 r0 *1 0,0
RXD2_XDFFQ_CLKB_t5 XD2_XDFFQ_CLKB__t5 XD2_XDFFQ_CLKB 52.956068093
* device instance XD2_XDFFQ_CLKB r0 *1 0,0
CXD2_XDFFQ_CLKB XD2_XDFFQ_CLKB vsubs 7.1115146e-14
* device instance XD2_XDFFQ_M_t0 r0 *1 0,0
RXD2_XDFFQ_M_t0 XD2_XDFFQ_M__t0 XD2_XDFFQ_M 42.0082779531
* device instance XD2_XDFFQ_M_t1 r0 *1 0,0
RXD2_XDFFQ_M_t1 XD2_XDFFQ_M__t1 XD2_XDFFQ_M 41.2794838593
* device instance XD2_XDFFQ_M_t2 r0 *1 0,0
RXD2_XDFFQ_M_t2 XD2_XDFFQ_M__t2 XD2_XDFFQ_M 42.7370720469
* device instance XD2_XDFFQ_M_t3 r0 *1 0,0
RXD2_XDFFQ_M_t3 XD2_XDFFQ_M__t3 XD2_XDFFQ_M 43.4658661407
* device instance XD2_XDFFQ_M_t4 r0 *1 0,0
RXD2_XDFFQ_M_t4 XD2_XDFFQ_M__t4 XD2_XDFFQ_M 42.5800043543
* device instance XD2_XDFFQ_M_t5 r0 *1 0,0
RXD2_XDFFQ_M_t5 XD2_XDFFQ_M__t5 XD2_XDFFQ_M 41.7506869372
* device instance XD2_XDFFQ_M_t6 r0 *1 0,0
RXD2_XDFFQ_M_t6 XD2_XDFFQ_M__t6 XD2_XDFFQ_M 42.9946630628
* device instance XD2_XDFFQ_M_t7 r0 *1 0,0
RXD2_XDFFQ_M_t7 XD2_XDFFQ_M__t7 XD2_XDFFQ_M 42.1653456457
* device instance XD2_XDFFQ_M r0 *1 0,0
CXD2_XDFFQ_M XD2_XDFFQ_M vsubs 7.8183414e-14
* device instance XD2_XDFFQ_MB_t0 r0 *1 0,0
RXD2_XDFFQ_MB_t0 XD2_XDFFQ_MB__t0 XD2_XDFFQ_MB 71.5810515754
* device instance XD2_XDFFQ_MB_t1 r0 *1 0,0
RXD2_XDFFQ_MB_t1 XD2_XDFFQ_MB__t1 XD2_XDFFQ_MB 72.8228984246
* device instance XD2_XDFFQ_MB_t2 r0 *1 0,0
RXD2_XDFFQ_MB_t2 XD2_XDFFQ_MB__t2 XD2_XDFFQ_MB 72.5552590174
* device instance XD2_XDFFQ_MB_t3 r0 *1 0,0
RXD2_XDFFQ_MB_t3 XD2_XDFFQ_MB__t3 XD2_XDFFQ_MB 71.8486909826
* device instance XD2_XDFFQ_MB r0 *1 0,0
CXD2_XDFFQ_MB XD2_XDFFQ_MB vsubs 6.5336461e-14
* device instance XD2_XDFFQ_S_t0 r0 *1 0,0
RXD2_XDFFQ_S_t0 XD2_XDFFQ_S__t0 XD2_XDFFQ_S 52.8167333333
* device instance XD2_XDFFQ_S_t1 r0 *1 0,0
RXD2_XDFFQ_S_t1 XD2_XDFFQ_S__t1 XD2_XDFFQ_S 51.916646499
* device instance XD2_XDFFQ_S_t2 r0 *1 0,0
RXD2_XDFFQ_S_t2 XD2_XDFFQ_S__t2 XD2_XDFFQ_S 53.7168201676
* device instance XD2_XDFFQ_S_t3 r0 *1 0,0
RXD2_XDFFQ_S_t3 XD2_XDFFQ_S__t3 XD2_XDFFQ_S 52.8167333333
* device instance XD2_XDFFQ_S_t4 r0 *1 0,0
RXD2_XDFFQ_S_t4 XD2_XDFFQ_S__t4 XD2_XDFFQ_S 53.3288517046
* device instance XD2_XDFFQ_S_t5 r0 *1 0,0
RXD2_XDFFQ_S_t5 XD2_XDFFQ_S__t5 XD2_XDFFQ_S 52.3046149621
* device instance XD2_XDFFQ_S r0 *1 0,0
CXD2_XDFFQ_S XD2_XDFFQ_S vsubs 7.2549306e-14
* device instance XD2_XDFFQ_SB_t0 r0 *1 0,0
RXD2_XDFFQ_SB_t0 XD2_XDFFQ_SB__t0 XD2_XDFFQ_SB 53.8865485285
* device instance XD2_XDFFQ_SB_t1 r0 *1 0,0
RXD2_XDFFQ_SB_t1 XD2_XDFFQ_SB__t1 XD2_XDFFQ_SB 52.0871848048
* device instance XD2_XDFFQ_SB_t2 r0 *1 0,0
RXD2_XDFFQ_SB_t2 XD2_XDFFQ_SB__t2 XD2_XDFFQ_SB 52.9868666667
* device instance XD2_XDFFQ_SB_t3 r0 *1 0,0
RXD2_XDFFQ_SB_t3 XD2_XDFFQ_SB__t3 XD2_XDFFQ_SB 52.4749787108
* device instance XD2_XDFFQ_SB_t4 r0 *1 0,0
RXD2_XDFFQ_SB_t4 XD2_XDFFQ_SB__t4 XD2_XDFFQ_SB 52.9868666667
* device instance XD2_XDFFQ_SB_t5 r0 *1 0,0
RXD2_XDFFQ_SB_t5 XD2_XDFFQ_SB__t5 XD2_XDFFQ_SB 53.4987546226
* device instance XD2_XDFFQ_SB r0 *1 0,0
CXD2_XDFFQ_SB XD2_XDFFQ_SB vsubs 7.2800855e-14
* device instance XD2_XN2_mid1_t0 r0 *1 0,0
RXD2_XN2_mid1_t0 XD2_XN2_mid1__t0 XD2_XN2_mid1 13.2659
* device instance XD2_XN2_mid1_t1 r0 *1 0,0
RXD2_XN2_mid1_t1 XD2_XN2_mid1__t1 XD2_XN2_mid1 13.2659
* device instance XD2_XN2_mid1 r0 *1 0,0
CXD2_XN2_mid1 XD2_XN2_mid1 vsubs 6.741642e-15
* device instance XD2_XN3_mid1_t0 r0 *1 0,0
RXD2_XN3_mid1_t0 XD2_XN3_mid1__t0 XD2_XN3_mid1 13.4419
* device instance XD2_XN3_mid1_t1 r0 *1 0,0
RXD2_XN3_mid1_t1 XD2_XN3_mid1__t1 XD2_XN3_mid1 13.4419
* device instance XD2_XN3_mid1 r0 *1 0,0
CXD2_XN3_mid1 XD2_XN3_mid1 vsubs 6.851481e-15
* device instance XD2_XN3_mid2_t0 r0 *1 0,0
RXD2_XN3_mid2_t0 XD2_XN3_mid2__t0 XD2_XN3_mid2 13.6179
* device instance XD2_XN3_mid2_t1 r0 *1 0,0
RXD2_XN3_mid2_t1 XD2_XN3_mid2__t1 XD2_XN3_mid2 13.6179
* device instance XD2_XN3_mid2 r0 *1 0,0
CXD2_XN3_mid2 XD2_XN3_mid2 vsubs 6.941129e-15
* device instance XD2_XNOR_midp_t0 r0 *1 0,0
RXD2_XNOR_midp_t0 XD2_XNOR_midp__t0 XD2_XNOR_midp 15.3271
* device instance XD2_XNOR_midp_t1 r0 *1 0,0
RXD2_XNOR_midp_t1 XD2_XNOR_midp__t1 XD2_XNOR_midp 15.3271
* device instance XD2_XNOR_midp r0 *1 0,0
CXD2_XNOR_midp XD2_XNOR_midp vsubs 7.738831e-15
* device instance XD2_dmodout_t0 r0 *1 0,0
RXD2_dmodout_t0 XD2_dmodout__t0 XD2_dmodout 74.442061088
* device instance XD2_dmodout_t1 r0 *1 0,0
RXD2_dmodout_t1 XD2_dmodout__t1 XD2_dmodout 76.966688912
* device instance XD2_dmodout_t2 r0 *1 0,0
RXD2_dmodout_t2 XD2_dmodout__t2 XD2_dmodout 76.4225880879
* device instance XD2_dmodout_t3 r0 *1 0,0
RXD2_dmodout_t3 XD2_dmodout__t3 XD2_dmodout 74.9861619121
* device instance XD2_dmodout r0 *1 0,0
CXD2_dmodout XD2_dmodout vsubs 6.8636163e-14
* device instance XD2_dq_t0 r0 *1 0,0
RXD2_dq_t0 XD2_dq__t0 XD2_dq 75.959567628
* device instance XD2_dq_t1 r0 *1 0,0
RXD2_dq_t1 XD2_dq__t1 XD2_dq 78.182232372
* device instance XD2_dq_t2 r0 *1 0,0
RXD2_dq_t2 XD2_dq__t2 XD2_dq 52.2236797305
* device instance XD2_dq_t3 r0 *1 0,0
RXD2_dq_t3 XD2_dq__t3 XD2_dq 51.5913699326
* device instance XD2_dq_t4 r0 *1 0,0
RXD2_dq_t4 XD2_dq__t4 XD2_dq 50.3267503369
* device instance XD2_dq r0 *1 0,0
CXD2_dq XD2_dq vsubs 7.0335977e-14
* device instance XD2_nm_t0 r0 *1 0,0
RXD2_nm_t0 XD2_nm__t0 XD2_nm 53.4646074644
* device instance XD2_nm_t1 r0 *1 0,0
RXD2_nm_t1 XD2_nm__t1 XD2_nm 51.2659258689
* device instance XD2_nm_t2 r0 *1 0,0
RXD2_nm_t2 XD2_nm__t2 XD2_nm 52.3652666667
* device instance XD2_nm_t3 r0 *1 0,0
RXD2_nm_t3 XD2_nm__t3 XD2_nm 77.9224129944
* device instance XD2_nm_t4 r0 *1 0,0
RXD2_nm_t4 XD2_nm__t4 XD2_nm 79.1733870056
* device instance XD2_nm r0 *1 0,0
CXD2_nm XD2_nm vsubs 7.179104e-14
* device instance XD2_nt_t0 r0 *1 0,0
RXD2_nt_t0 XD2_nt__t0 XD2_nt 41.5495626459
* device instance XD2_nt_t1 r0 *1 0,0
RXD2_nt_t1 XD2_nt__t1 XD2_nt 40.4911042153
* device instance XD2_nt_t2 r0 *1 0,0
RXD2_nt_t2 XD2_nt__t2 XD2_nt 39.4326457847
* device instance XD2_nt_t3 r0 *1 0,0
RXD2_nt_t3 XD2_nt__t3 XD2_nt 38.3741873541
* device instance XD2_nt_t4 r0 *1 0,0
RXD2_nt_t4 XD2_nt__t4 XD2_nt 79.0204104773
* device instance XD2_nt_t5 r0 *1 0,0
RXD2_nt_t5 XD2_nt__t5 XD2_nt 80.8270895227
* device instance XD2_nt r0 *1 0,0
CXD2_nt XD2_nt vsubs 7.3518629e-14
* device instance XD2_t1_t0 r0 *1 0,0
RXD2_t1_t0 XD2_t1__t0 XD2_t1 74.0717962642
* device instance XD2_t1_t1 r0 *1 0,0
RXD2_t1_t1 XD2_t1__t1 XD2_t1 71.5251037358
* device instance XD2_t1_t2 r0 *1 0,0
RXD2_t1_t2 XD2_t1__t2 XD2_t1 72.0739598841
* device instance XD2_t1_t3 r0 *1 0,0
RXD2_t1_t3 XD2_t1__t3 XD2_t1 73.5229401159
* device instance XD2_t1 r0 *1 0,0
CXD2_t1 XD2_t1 vsubs 6.6266144e-14
* device instance XD3_XDFFM_CLKB_t0 r0 *1 0,0
RXD3_XDFFM_CLKB_t0 XD3_XDFFM_CLKB__t0 XD3_XDFFM_CLKB 60.119579214
* device instance XD3_XDFFM_CLKB_t1 r0 *1 0,0
RXD3_XDFFM_CLKB_t1 XD3_XDFFM_CLKB__t1 XD3_XDFFM_CLKB 61.0232230351
* device instance XD3_XDFFM_CLKB_t2 r0 *1 0,0
RXD3_XDFFM_CLKB_t2 XD3_XDFFM_CLKB__t2 XD3_XDFFM_CLKB 57.4086477509
* device instance XD3_XDFFM_CLKB_t3 r0 *1 0,0
RXD3_XDFFM_CLKB_t3 XD3_XDFFM_CLKB__t3 XD3_XDFFM_CLKB 60.2026728987
* device instance XD3_XDFFM_CLKB_t4 r0 *1 0,0
RXD3_XDFFM_CLKB_t4 XD3_XDFFM_CLKB__t4 XD3_XDFFM_CLKB 57.6319620285
* device instance XD3_XDFFM_CLKB_t5 r0 *1 0,0
RXD3_XDFFM_CLKB_t5 XD3_XDFFM_CLKB__t5 XD3_XDFFM_CLKB 60.7168150728
* device instance XD3_XDFFM_CLKB r0 *1 0,0
CXD3_XDFFM_CLKB XD3_XDFFM_CLKB vsubs 8.1969513e-14
* device instance XD3_XDFFM_M_t0 r0 *1 0,0
RXD3_XDFFM_M_t0 XD3_XDFFM_M__t0 XD3_XDFFM_M 48.4264390322
* device instance XD3_XDFFM_M_t1 r0 *1 0,0
RXD3_XDFFM_M_t1 XD3_XDFFM_M__t1 XD3_XDFFM_M 47.6859670965
* device instance XD3_XDFFM_M_t2 r0 *1 0,0
RXD3_XDFFM_M_t2 XD3_XDFFM_M__t2 XD3_XDFFM_M 49.1669109678
* device instance XD3_XDFFM_M_t3 r0 *1 0,0
RXD3_XDFFM_M_t3 XD3_XDFFM_M__t3 XD3_XDFFM_M 49.9073829035
* device instance XD3_XDFFM_M_t4 r0 *1 0,0
RXD3_XDFFM_M_t4 XD3_XDFFM_M__t4 XD3_XDFFM_M 49.0073264989
* device instance XD3_XDFFM_M_t5 r0 *1 0,0
RXD3_XDFFM_M_t5 XD3_XDFFM_M__t5 XD3_XDFFM_M 48.1647205032
* device instance XD3_XDFFM_M_t6 r0 *1 0,0
RXD3_XDFFM_M_t6 XD3_XDFFM_M__t6 XD3_XDFFM_M 49.4286294968
* device instance XD3_XDFFM_M_t7 r0 *1 0,0
RXD3_XDFFM_M_t7 XD3_XDFFM_M__t7 XD3_XDFFM_M 48.5860235011
* device instance XD3_XDFFM_M r0 *1 0,0
CXD3_XDFFM_M XD3_XDFFM_M vsubs 9.030719e-14
* device instance XD3_XDFFM_MB_t0 r0 *1 0,0
RXD3_XDFFM_MB_t0 XD3_XDFFM_MB__t0 XD3_XDFFM_MB 81.9593688146
* device instance XD3_XDFFM_MB_t1 r0 *1 0,0
RXD3_XDFFM_MB_t1 XD3_XDFFM_MB__t1 XD3_XDFFM_MB 83.2125811854
* device instance XD3_XDFFM_MB_t2 r0 *1 0,0
RXD3_XDFFM_MB_t2 XD3_XDFFM_MB__t2 XD3_XDFFM_MB 82.9424923124
* device instance XD3_XDFFM_MB_t3 r0 *1 0,0
RXD3_XDFFM_MB_t3 XD3_XDFFM_MB__t3 XD3_XDFFM_MB 82.2294576876
* device instance XD3_XDFFM_MB r0 *1 0,0
CXD3_XDFFM_MB XD3_XDFFM_MB vsubs 7.4921419e-14
* device instance XD3_XDFFM_S_t0 r0 *1 0,0
RXD3_XDFFM_S_t0 XD3_XDFFM_S__t0 XD3_XDFFM_S 60.5607333333
* device instance XD3_XDFFM_S_t1 r0 *1 0,0
RXD3_XDFFM_S_t1 XD3_XDFFM_S__t1 XD3_XDFFM_S 59.6491987558
* device instance XD3_XDFFM_S_t2 r0 *1 0,0
RXD3_XDFFM_S_t2 XD3_XDFFM_S__t2 XD3_XDFFM_S 61.4722679109
* device instance XD3_XDFFM_S_t3 r0 *1 0,0
RXD3_XDFFM_S_t3 XD3_XDFFM_S__t3 XD3_XDFFM_S 60.5607333333
* device instance XD3_XDFFM_S_t4 r0 *1 0,0
RXD3_XDFFM_S_t4 XD3_XDFFM_S__t4 XD3_XDFFM_S 61.0793650757
* device instance XD3_XDFFM_S_t5 r0 *1 0,0
RXD3_XDFFM_S_t5 XD3_XDFFM_S__t5 XD3_XDFFM_S 60.0421015909
* device instance XD3_XDFFM_S r0 *1 0,0
CXD3_XDFFM_S XD3_XDFFM_S vsubs 8.3403673e-14
* device instance XD3_XDFFM_SB_t0 r0 *1 0,0
RXD3_XDFFM_SB_t0 XD3_XDFFM_SB__t0 XD3_XDFFM_SB 61.6420063964
* device instance XD3_XDFFM_SB_t1 r0 *1 0,0
RXD3_XDFFM_SB_t1 XD3_XDFFM_SB__t1 XD3_XDFFM_SB 59.819726937
* device instance XD3_XDFFM_SB_t2 r0 *1 0,0
RXD3_XDFFM_SB_t2 XD3_XDFFM_SB__t2 XD3_XDFFM_SB 60.7308666667
* device instance XD3_XDFFM_SB_t3 r0 *1 0,0
RXD3_XDFFM_SB_t3 XD3_XDFFM_SB__t3 XD3_XDFFM_SB 60.2124595791
* device instance XD3_XDFFM_SB_t4 r0 *1 0,0
RXD3_XDFFM_SB_t4 XD3_XDFFM_SB__t4 XD3_XDFFM_SB 61.2492737542
* device instance XD3_XDFFM_SB_t5 r0 *1 0,0
RXD3_XDFFM_SB_t5 XD3_XDFFM_SB__t5 XD3_XDFFM_SB 60.7308666667
* device instance XD3_XDFFM_SB r0 *1 0,0
CXD3_XDFFM_SB XD3_XDFFM_SB vsubs 8.3655222e-14
* device instance XD3_XDFFQ_CLKB_t0 r0 *1 0,0
RXD3_XDFFQ_CLKB_t0 XD3_XDFFQ_CLKB__t0 XD3_XDFFQ_CLKB 59.4010394254
* device instance XD3_XDFFQ_CLKB_t1 r0 *1 0,0
RXD3_XDFFQ_CLKB_t1 XD3_XDFFQ_CLKB__t1 XD3_XDFFQ_CLKB 60.3268735636
* device instance XD3_XDFFQ_CLKB_t2 r0 *1 0,0
RXD3_XDFFQ_CLKB_t2 XD3_XDFFQ_CLKB__t2 XD3_XDFFQ_CLKB 56.6235370109
* device instance XD3_XDFFQ_CLKB_t3 r0 *1 0,0
RXD3_XDFFQ_CLKB_t3 XD3_XDFFQ_CLKB__t3 XD3_XDFFQ_CLKB 59.4861735991
* device instance XD3_XDFFQ_CLKB_t4 r0 *1 0,0
RXD3_XDFFQ_CLKB_t4 XD3_XDFFQ_CLKB__t4 XD3_XDFFQ_CLKB 56.8523351025
* device instance XD3_XDFFQ_CLKB_t5 r0 *1 0,0
RXD3_XDFFQ_CLKB_t5 XD3_XDFFQ_CLKB__t5 XD3_XDFFQ_CLKB 60.0129412984
* device instance XD3_XDFFQ_CLKB r0 *1 0,0
CXD3_XDFFQ_CLKB XD3_XDFFQ_CLKB vsubs 8.1195592e-14
* device instance XD3_XDFFQ_M_t0 r0 *1 0,0
RXD3_XDFFQ_M_t0 XD3_XDFFQ_M__t0 XD3_XDFFQ_M 48.0852202574
* device instance XD3_XDFFQ_M_t1 r0 *1 0,0
RXD3_XDFFQ_M_t1 XD3_XDFFQ_M__t1 XD3_XDFFQ_M 47.3223107721
* device instance XD3_XDFFQ_M_t2 r0 *1 0,0
RXD3_XDFFQ_M_t2 XD3_XDFFQ_M__t2 XD3_XDFFQ_M 48.8481297426
* device instance XD3_XDFFQ_M_t3 r0 *1 0,0
RXD3_XDFFQ_M_t3 XD3_XDFFQ_M__t3 XD3_XDFFQ_M 49.6110392279
* device instance XD3_XDFFQ_M_t4 r0 *1 0,0
RXD3_XDFFQ_M_t4 XD3_XDFFQ_M__t4 XD3_XDFFQ_M 48.6837095949
* device instance XD3_XDFFQ_M_t5 r0 *1 0,0
RXD3_XDFFQ_M_t5 XD3_XDFFQ_M__t5 XD3_XDFFQ_M 47.8155712152
* device instance XD3_XDFFQ_M_t6 r0 *1 0,0
RXD3_XDFFQ_M_t6 XD3_XDFFQ_M__t6 XD3_XDFFQ_M 49.1177787848
* device instance XD3_XDFFQ_M_t7 r0 *1 0,0
RXD3_XDFFQ_M_t7 XD3_XDFFQ_M__t7 XD3_XDFFQ_M 48.2496404051
* device instance XD3_XDFFQ_M r0 *1 0,0
CXD3_XDFFQ_M XD3_XDFFQ_M vsubs 8.9984292e-14
* device instance XD3_XDFFQ_MB_t0 r0 *1 0,0
RXD3_XDFFQ_MB_t0 XD3_XDFFQ_MB__t0 XD3_XDFFQ_MB 80.408106371
* device instance XD3_XDFFQ_MB_t1 r0 *1 0,0
RXD3_XDFFQ_MB_t1 XD3_XDFFQ_MB__t1 XD3_XDFFQ_MB 81.683843629
* device instance XD3_XDFFQ_MB_t2 r0 *1 0,0
RXD3_XDFFQ_MB_t2 XD3_XDFFQ_MB__t2 XD3_XDFFQ_MB 81.4089002544
* device instance XD3_XDFFQ_MB_t3 r0 *1 0,0
RXD3_XDFFQ_MB_t3 XD3_XDFFQ_MB__t3 XD3_XDFFQ_MB 80.6830497456
* device instance XD3_XDFFQ_MB r0 *1 0,0
CXD3_XDFFQ_MB XD3_XDFFQ_MB vsubs 7.3696475e-14
* device instance XD3_XDFFQ_S_t0 r0 *1 0,0
RXD3_XDFFQ_S_t0 XD3_XDFFQ_S__t0 XD3_XDFFQ_S 59.8274
* device instance XD3_XDFFQ_S_t1 r0 *1 0,0
RXD3_XDFFQ_S_t1 XD3_XDFFQ_S__t1 XD3_XDFFQ_S 58.8935821803
* device instance XD3_XDFFQ_S_t2 r0 *1 0,0
RXD3_XDFFQ_S_t2 XD3_XDFFQ_S__t2 XD3_XDFFQ_S 60.7612178197
* device instance XD3_XDFFQ_S_t3 r0 *1 0,0
RXD3_XDFFQ_S_t3 XD3_XDFFQ_S__t3 XD3_XDFFQ_S 59.8274
* device instance XD3_XDFFQ_S_t4 r0 *1 0,0
RXD3_XDFFQ_S_t4 XD3_XDFFQ_S__t4 XD3_XDFFQ_S 60.3587101388
* device instance XD3_XDFFQ_S_t5 r0 *1 0,0
RXD3_XDFFQ_S_t5 XD3_XDFFQ_S__t5 XD3_XDFFQ_S 59.2960898612
* device instance XD3_XDFFQ_S r0 *1 0,0
CXD3_XDFFQ_S XD3_XDFFQ_S vsubs 8.2629752e-14
* device instance XD3_XDFFQ_SB_t0 r0 *1 0,0
RXD3_XDFFQ_SB_t0 XD3_XDFFQ_SB__t0 XD3_XDFFQ_SB 60.9308670362
* device instance XD3_XDFFQ_SB_t1 r0 *1 0,0
RXD3_XDFFQ_SB_t1 XD3_XDFFQ_SB__t1 XD3_XDFFQ_SB 59.0641996305
* device instance XD3_XDFFQ_SB_t2 r0 *1 0,0
RXD3_XDFFQ_SB_t2 XD3_XDFFQ_SB__t2 XD3_XDFFQ_SB 59.9975333333
* device instance XD3_XDFFQ_SB_t3 r0 *1 0,0
RXD3_XDFFQ_SB_t3 XD3_XDFFQ_SB__t3 XD3_XDFFQ_SB 59.4664986403
* device instance XD3_XDFFQ_SB_t4 r0 *1 0,0
RXD3_XDFFQ_SB_t4 XD3_XDFFQ_SB__t4 XD3_XDFFQ_SB 60.5285680263
* device instance XD3_XDFFQ_SB_t5 r0 *1 0,0
RXD3_XDFFQ_SB_t5 XD3_XDFFQ_SB__t5 XD3_XDFFQ_SB 59.9975333333
* device instance XD3_XDFFQ_SB r0 *1 0,0
CXD3_XDFFQ_SB XD3_XDFFQ_SB vsubs 8.2881301e-14
* device instance XD3_XN2_mid1_t0 r0 *1 0,0
RXD3_XN2_mid1_t0 XD3_XN2_mid1__t0 XD3_XN2_mid1 16.6099
* device instance XD3_XN2_mid1_t1 r0 *1 0,0
RXD3_XN2_mid1_t1 XD3_XN2_mid1__t1 XD3_XN2_mid1 16.6099
* device instance XD3_XN2_mid1 r0 *1 0,0
CXD3_XN2_mid1 XD3_XN2_mid1 vsubs 8.434259e-15
* device instance XD3_XN3_mid1_t0 r0 *1 0,0
RXD3_XN3_mid1_t0 XD3_XN3_mid1__t0 XD3_XN3_mid1 16.7859
* device instance XD3_XN3_mid1_t1 r0 *1 0,0
RXD3_XN3_mid1_t1 XD3_XN3_mid1__t1 XD3_XN3_mid1 16.7859
* device instance XD3_XN3_mid1 r0 *1 0,0
CXD3_XN3_mid1 XD3_XN3_mid1 vsubs 8.544098e-15
* device instance XD3_XN3_mid2_t0 r0 *1 0,0
RXD3_XN3_mid2_t0 XD3_XN3_mid2__t0 XD3_XN3_mid2 16.9619
* device instance XD3_XN3_mid2_t1 r0 *1 0,0
RXD3_XN3_mid2_t1 XD3_XN3_mid2__t1 XD3_XN3_mid2 16.9619
* device instance XD3_XN3_mid2 r0 *1 0,0
CXD3_XN3_mid2 XD3_XN3_mid2 vsubs 8.633746e-15
* device instance XD3_XNOR_midp_t0 r0 *1 0,0
RXD3_XNOR_midp_t0 XD3_XNOR_midp__t0 XD3_XNOR_midp 18.6711
* device instance XD3_XNOR_midp_t1 r0 *1 0,0
RXD3_XNOR_midp_t1 XD3_XNOR_midp__t1 XD3_XNOR_midp 18.6711
* device instance XD3_XNOR_midp r0 *1 0,0
CXD3_XNOR_midp XD3_XNOR_midp vsubs 9.487078e-15
* device instance XD3_dmodout_t0 r0 *1 0,0
RXD3_dmodout_t0 XD3_dmodout__t0 XD3_dmodout 83.254807723
* device instance XD3_dmodout_t1 r0 *1 0,0
RXD3_dmodout_t1 XD3_dmodout__t1 XD3_dmodout 85.841942277
* device instance XD3_dmodout_t2 r0 *1 0,0
RXD3_dmodout_t2 XD3_dmodout__t2 XD3_dmodout 83.8123798251
* device instance XD3_dmodout_t3 r0 *1 0,0
RXD3_dmodout_t3 XD3_dmodout__t3 XD3_dmodout 85.2843701749
* device instance XD3_dmodout r0 *1 0,0
CXD3_dmodout XD3_dmodout vsubs 7.6996177e-14
* device instance XD3_dq_t0 r0 *1 0,0
RXD3_dq_t0 XD3_dq__t0 XD3_dq 85.6066632638
* device instance XD3_dq_t1 r0 *1 0,0
RXD3_dq_t1 XD3_dq__t1 XD3_dq 87.8951367362
* device instance XD3_dq_t2 r0 *1 0,0
RXD3_dq_t2 XD3_dq__t2 XD3_dq 58.7019749953
* device instance XD3_dq_t3 r0 *1 0,0
RXD3_dq_t3 XD3_dq__t3 XD3_dq 58.0509437488
* device instance XD3_dq_t4 r0 *1 0,0
RXD3_dq_t4 XD3_dq__t4 XD3_dq 56.7488812559
* device instance XD3_dq r0 *1 0,0
CXD3_dq XD3_dq vsubs 7.9542299e-14
* device instance XD3_nm_t0 r0 *1 0,0
RXD3_nm_t0 XD3_nm__t0 XD3_nm 59.9509533889
* device instance XD3_nm_t1 r0 *1 0,0
RXD3_nm_t1 XD3_nm__t1 XD3_nm 57.6862466111
* device instance XD3_nm_t2 r0 *1 0,0
RXD3_nm_t2 XD3_nm__t2 XD3_nm 58.8186
* device instance XD3_nm_t3 r0 *1 0,0
RXD3_nm_t3 XD3_nm__t3 XD3_nm 87.5836299684
* device instance XD3_nm_t4 r0 *1 0,0
RXD3_nm_t4 XD3_nm__t4 XD3_nm 88.8721700316
* device instance XD3_nm r0 *1 0,0
CXD3_nm XD3_nm vsubs 8.1025178e-14
* device instance XD3_nt_t0 r0 *1 0,0
RXD3_nt_t0 XD3_nt__t0 XD3_nt 46.8603866121
* device instance XD3_nt_t1 r0 *1 0,0
RXD3_nt_t1 XD3_nt__t1 XD3_nt 43.5793633879
* device instance XD3_nt_t2 r0 *1 0,0
RXD3_nt_t2 XD3_nt__t2 XD3_nt 44.673037796
* device instance XD3_nt_t3 r0 *1 0,0
RXD3_nt_t3 XD3_nt__t3 XD3_nt 45.766712204
* device instance XD3_nt_t4 r0 *1 0,0
RXD3_nt_t4 XD3_nt__t4 XD3_nt 89.5063554621
* device instance XD3_nt_t5 r0 *1 0,0
RXD3_nt_t5 XD3_nt__t5 XD3_nt 91.3731445379
* device instance XD3_nt r0 *1 0,0
CXD3_nt XD3_nt vsubs 8.3626891e-14
* device instance XD3_t1_t0 r0 *1 0,0
RXD3_t1_t0 XD3_t1__t0 XD3_t1 82.9474991537
* device instance XD3_t1_t1 r0 *1 0,0
RXD3_t1_t1 XD3_t1__t1 XD3_t1 80.3374008463
* device instance XD3_t1_t2 r0 *1 0,0
RXD3_t1_t2 XD3_t1__t2 XD3_t1 80.8999220333
* device instance XD3_t1_t3 r0 *1 0,0
RXD3_t1_t3 XD3_t1__t3 XD3_t1 82.3849779667
* device instance XD3_t1 r0 *1 0,0
CXD3_t1 XD3_t1 vsubs 7.4626158e-14
* device instance XD4_XDFFM_CLKB_t0 r0 *1 0,0
RXD4_XDFFM_CLKB_t0 XD4_XDFFM_CLKB__t0 XD4_XDFFM_CLKB 67.1502866095
* device instance XD4_XDFFM_CLKB_t1 r0 *1 0,0
RXD4_XDFFM_CLKB_t1 XD4_XDFFM_CLKB__t1 XD4_XDFFM_CLKB 68.0839915237
* device instance XD4_XDFFM_CLKB_t2 r0 *1 0,0
RXD4_XDFFM_CLKB_t2 XD4_XDFFM_CLKB__t2 XD4_XDFFM_CLKB 64.3491718669
* device instance XD4_XDFFM_CLKB_t3 r0 *1 0,0
RXD4_XDFFM_CLKB_t3 XD4_XDFFM_CLKB__t3 XD4_XDFFM_CLKB 67.2361445326
* device instance XD4_XDFFM_CLKB_t4 r0 *1 0,0
RXD4_XDFFM_CLKB_t4 XD4_XDFFM_CLKB__t4 XD4_XDFFM_CLKB 64.5799150353
* device instance XD4_XDFFM_CLKB_t5 r0 *1 0,0
RXD4_XDFFM_CLKB_t5 XD4_XDFFM_CLKB__t5 XD4_XDFFM_CLKB 67.7673904321
* device instance XD4_XDFFM_CLKB r0 *1 0,0
CXD4_XDFFM_CLKB XD4_XDFFM_CLKB vsubs 9.204996e-14
* device instance XD4_XDFFM_M_t0 r0 *1 0,0
RXD4_XDFFM_M_t0 XD4_XDFFM_M__t0 XD4_XDFFM_M 54.5056791337
* device instance XD4_XDFFM_M_t1 r0 *1 0,0
RXD4_XDFFM_M_t1 XD4_XDFFM_M__t1 XD4_XDFFM_M 53.7356874012
* device instance XD4_XDFFM_M_t2 r0 *1 0,0
RXD4_XDFFM_M_t2 XD4_XDFFM_M__t2 XD4_XDFFM_M 55.2756708663
* device instance XD4_XDFFM_M_t3 r0 *1 0,0
RXD4_XDFFM_M_t3 XD4_XDFFM_M__t3 XD4_XDFFM_M 56.0456625988
* device instance XD4_XDFFM_M_t4 r0 *1 0,0
RXD4_XDFFM_M_t4 XD4_XDFFM_M__t4 XD4_XDFFM_M 55.1097243722
* device instance XD4_XDFFM_M_t5 r0 *1 0,0
RXD4_XDFFM_M_t5 XD4_XDFFM_M__t5 XD4_XDFFM_M 54.2335268835
* device instance XD4_XDFFM_M_t6 r0 *1 0,0
RXD4_XDFFM_M_t6 XD4_XDFFM_M__t6 XD4_XDFFM_M 55.5478231165
* device instance XD4_XDFFM_M_t7 r0 *1 0,0
RXD4_XDFFM_M_t7 XD4_XDFFM_M__t7 XD4_XDFFM_M 54.6716256278
* device instance XD4_XDFFM_M r0 *1 0,0
CXD4_XDFFM_M XD4_XDFFM_M vsubs 1.02108069e-13
* device instance XD4_XDFFM_MB_t0 r0 *1 0,0
RXD4_XDFFM_MB_t0 XD4_XDFFM_MB__t0 XD4_XDFFM_MB 90.7886973617
* device instance XD4_XDFFM_MB_t1 r0 *1 0,0
RXD4_XDFFM_MB_t1 XD4_XDFFM_MB__t1 XD4_XDFFM_MB 92.0712526383
* device instance XD4_XDFFM_MB_t2 r0 *1 0,0
RXD4_XDFFM_MB_t2 XD4_XDFFM_MB__t2 XD4_XDFFM_MB 91.0651101369
* device instance XD4_XDFFM_MB_t3 r0 *1 0,0
RXD4_XDFFM_MB_t3 XD4_XDFFM_MB__t3 XD4_XDFFM_MB 91.7948398631
* device instance XD4_XDFFM_MB r0 *1 0,0
CXD4_XDFFM_MB XD4_XDFFM_MB vsubs 8.3281433e-14
* device instance XD4_XDFFM_S_t0 r0 *1 0,0
RXD4_XDFFM_S_t0 XD4_XDFFM_S__t0 XD4_XDFFM_S 67.5714
* device instance XD4_XDFFM_S_t1 r0 *1 0,0
RXD4_XDFFM_S_t1 XD4_XDFFM_S__t1 XD4_XDFFM_S 66.6306367746
* device instance XD4_XDFFM_S_t2 r0 *1 0,0
RXD4_XDFFM_S_t2 XD4_XDFFM_S__t2 XD4_XDFFM_S 68.5121632254
* device instance XD4_XDFFM_S_t3 r0 *1 0,0
RXD4_XDFFM_S_t3 XD4_XDFFM_S__t3 XD4_XDFFM_S 67.5714
* device instance XD4_XDFFM_S_t4 r0 *1 0,0
RXD4_XDFFM_S_t4 XD4_XDFFM_S__t4 XD4_XDFFM_S 68.1066618351
* device instance XD4_XDFFM_S_t5 r0 *1 0,0
RXD4_XDFFM_S_t5 XD4_XDFFM_S__t5 XD4_XDFFM_S 67.0361381649
* device instance XD4_XDFFM_S r0 *1 0,0
CXD4_XDFFM_S XD4_XDFFM_S vsubs 9.3484119e-14
* device instance XD4_XDFFM_SB_t0 r0 *1 0,0
RXD4_XDFFM_SB_t0 XD4_XDFFM_SB__t0 XD4_XDFFM_SB 68.6818438018
* device instance XD4_XDFFM_SB_t1 r0 *1 0,0
RXD4_XDFFM_SB_t1 XD4_XDFFM_SB__t1 XD4_XDFFM_SB 66.8012228649
* device instance XD4_XDFFM_SB_t2 r0 *1 0,0
RXD4_XDFFM_SB_t2 XD4_XDFFM_SB__t2 XD4_XDFFM_SB 67.7415333333
* device instance XD4_XDFFM_SB_t3 r0 *1 0,0
RXD4_XDFFM_SB_t3 XD4_XDFFM_SB__t3 XD4_XDFFM_SB 67.2065291013
* device instance XD4_XDFFM_SB_t4 r0 *1 0,0
RXD4_XDFFM_SB_t4 XD4_XDFFM_SB__t4 XD4_XDFFM_SB 68.2765375654
* device instance XD4_XDFFM_SB_t5 r0 *1 0,0
RXD4_XDFFM_SB_t5 XD4_XDFFM_SB__t5 XD4_XDFFM_SB 67.7415333333
* device instance XD4_XDFFM_SB r0 *1 0,0
CXD4_XDFFM_SB XD4_XDFFM_SB vsubs 9.3735669e-14
* device instance XD4_XDFFQ_CLKB_t0 r0 *1 0,0
RXD4_XDFFQ_CLKB_t0 XD4_XDFFQ_CLKB__t0 XD4_XDFFQ_CLKB 66.4312794007
* device instance XD4_XDFFQ_CLKB_t1 r0 *1 0,0
RXD4_XDFFQ_CLKB_t1 XD4_XDFFQ_CLKB__t1 XD4_XDFFQ_CLKB 67.3864735018
* device instance XD4_XDFFQ_CLKB_t2 r0 *1 0,0
RXD4_XDFFQ_CLKB_t2 XD4_XDFFQ_CLKB__t2 XD4_XDFFQ_CLKB 63.5656970975
* device instance XD4_XDFFQ_CLKB_t3 r0 *1 0,0
RXD4_XDFFQ_CLKB_t3 XD4_XDFFQ_CLKB__t3 XD4_XDFFQ_CLKB 63.8017508121
* device instance XD4_XDFFQ_CLKB_t4 r0 *1 0,0
RXD4_XDFFQ_CLKB_t4 XD4_XDFFQ_CLKB__t4 XD4_XDFFQ_CLKB 66.5191133411
* device instance XD4_XDFFQ_CLKB_t5 r0 *1 0,0
RXD4_XDFFQ_CLKB_t5 XD4_XDFFQ_CLKB__t5 XD4_XDFFQ_CLKB 67.0625858468
* device instance XD4_XDFFQ_CLKB r0 *1 0,0
CXD4_XDFFQ_CLKB XD4_XDFFQ_CLKB vsubs 9.1276038e-14
* device instance XD4_XDFFQ_M_t0 r0 *1 0,0
RXD4_XDFFQ_M_t0 XD4_XDFFQ_M__t0 XD4_XDFFQ_M 54.1648297158
* device instance XD4_XDFFQ_M_t1 r0 *1 0,0
RXD4_XDFFQ_M_t1 XD4_XDFFQ_M__t1 XD4_XDFFQ_M 53.3731391475
* device instance XD4_XDFFQ_M_t2 r0 *1 0,0
RXD4_XDFFQ_M_t2 XD4_XDFFQ_M__t2 XD4_XDFFQ_M 54.9565202842
* device instance XD4_XDFFQ_M_t3 r0 *1 0,0
RXD4_XDFFQ_M_t3 XD4_XDFFQ_M__t3 XD4_XDFFQ_M 55.7482108525
* device instance XD4_XDFFQ_M_t4 r0 *1 0,0
RXD4_XDFFQ_M_t4 XD4_XDFFQ_M__t4 XD4_XDFFQ_M 54.7858973168
* device instance XD4_XDFFQ_M_t5 r0 *1 0,0
RXD4_XDFFQ_M_t5 XD4_XDFFQ_M__t5 XD4_XDFFQ_M 53.8850080495
* device instance XD4_XDFFQ_M_t6 r0 *1 0,0
RXD4_XDFFQ_M_t6 XD4_XDFFQ_M__t6 XD4_XDFFQ_M 54.3354526832
* device instance XD4_XDFFQ_M_t7 r0 *1 0,0
RXD4_XDFFQ_M_t7 XD4_XDFFQ_M__t7 XD4_XDFFQ_M 55.2363419505
* device instance XD4_XDFFQ_M r0 *1 0,0
CXD4_XDFFQ_M XD4_XDFFQ_M vsubs 1.0178517e-13
* device instance XD4_XDFFQ_MB_t0 r0 *1 0,0
RXD4_XDFFQ_MB_t0 XD4_XDFFQ_MB__t0 XD4_XDFFQ_MB 89.2378107316
* device instance XD4_XDFFQ_MB_t1 r0 *1 0,0
RXD4_XDFFQ_MB_t1 XD4_XDFFQ_MB__t1 XD4_XDFFQ_MB 90.5421392684
* device instance XD4_XDFFQ_MB_t2 r0 *1 0,0
RXD4_XDFFQ_MB_t2 XD4_XDFFQ_MB__t2 XD4_XDFFQ_MB 89.5189160197
* device instance XD4_XDFFQ_MB_t3 r0 *1 0,0
RXD4_XDFFQ_MB_t3 XD4_XDFFQ_MB__t3 XD4_XDFFQ_MB 90.2610339803
* device instance XD4_XDFFQ_MB r0 *1 0,0
CXD4_XDFFQ_MB XD4_XDFFQ_MB vsubs 8.2056489e-14
* device instance XD4_XDFFQ_S_t0 r0 *1 0,0
RXD4_XDFFQ_S_t0 XD4_XDFFQ_S__t0 XD4_XDFFQ_S 66.8380666667
* device instance XD4_XDFFQ_S_t1 r0 *1 0,0
RXD4_XDFFQ_S_t1 XD4_XDFFQ_S__t1 XD4_XDFFQ_S 65.8757511498
* device instance XD4_XDFFQ_S_t2 r0 *1 0,0
RXD4_XDFFQ_S_t2 XD4_XDFFQ_S__t2 XD4_XDFFQ_S 67.8003821835
* device instance XD4_XDFFQ_S_t3 r0 *1 0,0
RXD4_XDFFQ_S_t3 XD4_XDFFQ_S__t3 XD4_XDFFQ_S 66.8380666667
* device instance XD4_XDFFQ_S_t4 r0 *1 0,0
RXD4_XDFFQ_S_t4 XD4_XDFFQ_S__t4 XD4_XDFFQ_S 67.3855910125
* device instance XD4_XDFFQ_S_t5 r0 *1 0,0
RXD4_XDFFQ_S_t5 XD4_XDFFQ_S__t5 XD4_XDFFQ_S 66.2905423209
* device instance XD4_XDFFQ_S r0 *1 0,0
CXD4_XDFFQ_S XD4_XDFFQ_S vsubs 9.2710198e-14
* device instance XD4_XDFFQ_SB_t0 r0 *1 0,0
RXD4_XDFFQ_SB_t0 XD4_XDFFQ_SB__t0 XD4_XDFFQ_SB 67.9699806851
* device instance XD4_XDFFQ_SB_t1 r0 *1 0,0
RXD4_XDFFQ_SB_t1 XD4_XDFFQ_SB__t1 XD4_XDFFQ_SB 66.0464193149
* device instance XD4_XDFFQ_SB_t2 r0 *1 0,0
RXD4_XDFFQ_SB_t2 XD4_XDFFQ_SB__t2 XD4_XDFFQ_SB 67.0082
* device instance XD4_XDFFQ_SB_t3 r0 *1 0,0
RXD4_XDFFQ_SB_t3 XD4_XDFFQ_SB__t3 XD4_XDFFQ_SB 66.460979955
* device instance XD4_XDFFQ_SB_t4 r0 *1 0,0
RXD4_XDFFQ_SB_t4 XD4_XDFFQ_SB__t4 XD4_XDFFQ_SB 67.555420045
* device instance XD4_XDFFQ_SB_t5 r0 *1 0,0
RXD4_XDFFQ_SB_t5 XD4_XDFFQ_SB__t5 XD4_XDFFQ_SB 67.0082
* device instance XD4_XDFFQ_SB r0 *1 0,0
CXD4_XDFFQ_SB XD4_XDFFQ_SB vsubs 9.2961747e-14
* device instance XD4_XN2_mid1_t0 r0 *1 0,0
RXD4_XN2_mid1_t0 XD4_XN2_mid1__t0 XD4_XN2_mid1 19.9539
* device instance XD4_XN2_mid1_t1 r0 *1 0,0
RXD4_XN2_mid1_t1 XD4_XN2_mid1__t1 XD4_XN2_mid1 19.9539
* device instance XD4_XN2_mid1 r0 *1 0,0
CXD4_XN2_mid1 XD4_XN2_mid1 vsubs 1.0126876e-14
* device instance XD4_XN3_mid1_t0 r0 *1 0,0
RXD4_XN3_mid1_t0 XD4_XN3_mid1__t0 XD4_XN3_mid1 20.1299
* device instance XD4_XN3_mid1_t1 r0 *1 0,0
RXD4_XN3_mid1_t1 XD4_XN3_mid1__t1 XD4_XN3_mid1 20.1299
* device instance XD4_XN3_mid1 r0 *1 0,0
CXD4_XN3_mid1 XD4_XN3_mid1 vsubs 1.0236715e-14
* device instance XD4_XN3_mid2_t0 r0 *1 0,0
RXD4_XN3_mid2_t0 XD4_XN3_mid2__t0 XD4_XN3_mid2 20.3059
* device instance XD4_XN3_mid2_t1 r0 *1 0,0
RXD4_XN3_mid2_t1 XD4_XN3_mid2__t1 XD4_XN3_mid2 20.3059
* device instance XD4_XN3_mid2 r0 *1 0,0
CXD4_XN3_mid2 XD4_XN3_mid2 vsubs 1.0326363e-14
* device instance XD4_XNOR_midp_t0 r0 *1 0,0
RXD4_XNOR_midp_t0 XD4_XNOR_midp__t0 XD4_XNOR_midp 22.0151
* device instance XD4_XNOR_midp_t1 r0 *1 0,0
RXD4_XNOR_midp_t1 XD4_XNOR_midp__t1 XD4_XNOR_midp 22.0151
* device instance XD4_XNOR_midp r0 *1 0,0
CXD4_XNOR_midp XD4_XNOR_midp vsubs 1.1235326e-14
* device instance XD4_dmodout_t0 r0 *1 0,0
RXD4_dmodout_t0 XD4_dmodout__t0 XD4_dmodout 92.0723146235
* device instance XD4_dmodout_t1 r0 *1 0,0
RXD4_dmodout_t1 XD4_dmodout__t1 XD4_dmodout 94.7124353765
* device instance XD4_dmodout_t2 r0 *1 0,0
RXD4_dmodout_t2 XD4_dmodout__t2 XD4_dmodout 94.1434438349
* device instance XD4_dmodout_t3 r0 *1 0,0
RXD4_dmodout_t3 XD4_dmodout__t3 XD4_dmodout 92.6413061651
* device instance XD4_dmodout r0 *1 0,0
CXD4_dmodout XD4_dmodout vsubs 8.5356191e-14
* device instance XD4_dq_t0 r0 *1 0,0
RXD4_dq_t0 XD4_dq__t0 XD4_dq 95.2589300484
* device instance XD4_dq_t1 r0 *1 0,0
RXD4_dq_t1 XD4_dq__t1 XD4_dq 97.6028699516
* device instance XD4_dq_t2 r0 *1 0,0
RXD4_dq_t2 XD4_dq__t2 XD4_dq 63.1759158505
* device instance XD4_dq_t3 r0 *1 0,0
RXD4_dq_t3 XD4_dq__t3 XD4_dq 64.5095368299
* device instance XD4_dq_t4 r0 *1 0,0
RXD4_dq_t4 XD4_dq__t4 XD4_dq 65.1763473196
* device instance XD4_dq r0 *1 0,0
CXD4_dq XD4_dq vsubs 8.8748622e-14
* device instance XD4_nm_t0 r0 *1 0,0
RXD4_nm_t0 XD4_nm__t0 XD4_nm 66.4322402743
* device instance XD4_nm_t1 r0 *1 0,0
RXD4_nm_t1 XD4_nm__t1 XD4_nm 65.2719333333
* device instance XD4_nm_t2 r0 *1 0,0
RXD4_nm_t2 XD4_nm__t2 XD4_nm 64.1116263923
* device instance XD4_nm_t3 r0 *1 0,0
RXD4_nm_t3 XD4_nm__t3 XD4_nm 97.2477253611
* device instance XD4_nm_t4 r0 *1 0,0
RXD4_nm_t4 XD4_nm__t4 XD4_nm 98.5680746389
* device instance XD4_nm r0 *1 0,0
CXD4_nm XD4_nm vsubs 9.0259315e-14
* device instance XD4_nt_t0 r0 *1 0,0
RXD4_nt_t0 XD4_nt__t0 XD4_nt 52.1627661299
* device instance XD4_nt_t1 r0 *1 0,0
RXD4_nt_t1 XD4_nt__t1 XD4_nt 48.7929838701
* device instance XD4_nt_t2 r0 *1 0,0
RXD4_nt_t2 XD4_nt__t2 XD4_nt 49.9162446234
* device instance XD4_nt_t3 r0 *1 0,0
RXD4_nt_t3 XD4_nt__t3 XD4_nt 51.0395053766
* device instance XD4_nt_t4 r0 *1 0,0
RXD4_nt_t4 XD4_nt__t4 XD4_nt 99.9971050468
* device instance XD4_nt_t5 r0 *1 0,0
RXD4_nt_t5 XD4_nt__t5 XD4_nt 101.914394953
* device instance XD4_nt r0 *1 0,0
CXD4_nt XD4_nt vsubs 9.3735153e-14
* device instance XD4_t1_t0 r0 *1 0,0
RXD4_t1_t0 XD4_t1__t0 XD4_t1 91.8181742012
* device instance XD4_t1_t1 r0 *1 0,0
RXD4_t1_t1 XD4_t1__t1 XD4_t1 89.1547257988
* device instance XD4_t1_t2 r0 *1 0,0
RXD4_t1_t2 XD4_t1__t2 XD4_t1 89.728744851
* device instance XD4_t1_t3 r0 *1 0,0
RXD4_t1_t3 XD4_t1__t3 XD4_t1 91.244155149
* device instance XD4_t1 r0 *1 0,0
CXD4_t1 XD4_t1 vsubs 8.2986172e-14
* device instance XD5_XDFFM_CLKB_t0 r0 *1 0,0
RXD5_XDFFM_CLKB_t0 XD5_XDFFM_CLKB__t0 XD5_XDFFM_CLKB 74.1781761825
* device instance XD5_XDFFM_CLKB_t1 r0 *1 0,0
RXD5_XDFFM_CLKB_t1 XD5_XDFFM_CLKB__t1 XD5_XDFFM_CLKB 75.1377154562
* device instance XD5_XDFFM_CLKB_t2 r0 *1 0,0
RXD5_XDFFM_CLKB_t2 XD5_XDFFM_CLKB__t2 XD5_XDFFM_CLKB 71.2995583613
* device instance XD5_XDFFM_CLKB_t3 r0 *1 0,0
RXD5_XDFFM_CLKB_t3 XD5_XDFFM_CLKB__t3 XD5_XDFFM_CLKB 74.2664096789
* device instance XD5_XDFFM_CLKB_t4 r0 *1 0,0
RXD5_XDFFM_CLKB_t4 XD5_XDFFM_CLKB__t4 XD5_XDFFM_CLKB 71.536685883
* device instance XD5_XDFFM_CLKB_t5 r0 *1 0,0
RXD5_XDFFM_CLKB_t5 XD5_XDFFM_CLKB__t5 XD5_XDFFM_CLKB 74.8123544381
* device instance XD5_XDFFM_CLKB r0 *1 0,0
CXD5_XDFFM_CLKB XD5_XDFFM_CLKB vsubs 1.02120589e-13
* device instance XD5_XDFFM_M_t0 r0 *1 0,0
RXD5_XDFFM_M_t0 XD5_XDFFM_M__t0 XD5_XDFFM_M 60.5869935755
* device instance XD5_XDFFM_M_t1 r0 *1 0,0
RXD5_XDFFM_M_t1 XD5_XDFFM_M__t1 XD5_XDFFM_M 61.3823564245
* device instance XD5_XDFFM_M_t2 r0 *1 0,0
RXD5_XDFFM_M_t2 XD5_XDFFM_M__t2 XD5_XDFFM_M 59.7916307265
* device instance XD5_XDFFM_M_t3 r0 *1 0,0
RXD5_XDFFM_M_t3 XD5_XDFFM_M__t3 XD5_XDFFM_M 62.1777192735
* device instance XD5_XDFFM_M_t4 r0 *1 0,0
RXD5_XDFFM_M_t4 XD5_XDFFM_M__t4 XD5_XDFFM_M 61.2109420174
* device instance XD5_XDFFM_M_t5 r0 *1 0,0
RXD5_XDFFM_M_t5 XD5_XDFFM_M__t5 XD5_XDFFM_M 60.3058739478
* device instance XD5_XDFFM_M_t6 r0 *1 0,0
RXD5_XDFFM_M_t6 XD5_XDFFM_M__t6 XD5_XDFFM_M 61.6634760522
* device instance XD5_XDFFM_M_t7 r0 *1 0,0
RXD5_XDFFM_M_t7 XD5_XDFFM_M__t7 XD5_XDFFM_M 60.7584079826
* device instance XD5_XDFFM_M r0 *1 0,0
CXD5_XDFFM_M XD5_XDFFM_M vsubs 1.13895857e-13
* device instance XD5_XDFFM_MB_t0 r0 *1 0,0
RXD5_XDFFM_MB_t0 XD5_XDFFM_MB__t0 XD5_XDFFM_MB 99.620087819
* device instance XD5_XDFFM_MB_t1 r0 *1 0,0
RXD5_XDFFM_MB_t1 XD5_XDFFM_MB__t1 XD5_XDFFM_MB 100.927862181
* device instance XD5_XDFFM_MB_t2 r0 *1 0,0
RXD5_XDFFM_MB_t2 XD5_XDFFM_MB__t2 XD5_XDFFM_MB 100.646014258
* device instance XD5_XDFFM_MB_t3 r0 *1 0,0
RXD5_XDFFM_MB_t3 XD5_XDFFM_MB__t3 XD5_XDFFM_MB 99.9019357419
* device instance XD5_XDFFM_MB r0 *1 0,0
CXD5_XDFFM_MB XD5_XDFFM_MB vsubs 9.1634902e-14
* device instance XD5_XDFFM_S_t0 r0 *1 0,0
RXD5_XDFFM_S_t0 XD5_XDFFM_S__t0 XD5_XDFFM_S 74.5820666667
* device instance XD5_XDFFM_S_t1 r0 *1 0,0
RXD5_XDFFM_S_t1 XD5_XDFFM_S__t1 XD5_XDFFM_S 73.6161538924
* device instance XD5_XDFFM_S_t2 r0 *1 0,0
RXD5_XDFFM_S_t2 XD5_XDFFM_S__t2 XD5_XDFFM_S 75.5479794409
* device instance XD5_XDFFM_S_t3 r0 *1 0,0
RXD5_XDFFM_S_t3 XD5_XDFFM_S__t3 XD5_XDFFM_S 74.5820666667
* device instance XD5_XDFFM_S_t4 r0 *1 0,0
RXD5_XDFFM_S_t4 XD5_XDFFM_S__t4 XD5_XDFFM_S 75.1316377279
* device instance XD5_XDFFM_S_t5 r0 *1 0,0
RXD5_XDFFM_S_t5 XD5_XDFFM_S__t5 XD5_XDFFM_S 74.0324956055
* device instance XD5_XDFFM_S r0 *1 0,0
CXD5_XDFFM_S XD5_XDFFM_S vsubs 1.03554748e-13
* device instance XD5_XDFFM_SB_t0 r0 *1 0,0
RXD5_XDFFM_SB_t0 XD5_XDFFM_SB__t0 XD5_XDFFM_SB 75.7176215212
* device instance XD5_XDFFM_SB_t1 r0 *1 0,0
RXD5_XDFFM_SB_t1 XD5_XDFFM_SB__t1 XD5_XDFFM_SB 73.7867784788
* device instance XD5_XDFFM_SB_t2 r0 *1 0,0
RXD5_XDFFM_SB_t2 XD5_XDFFM_SB__t2 XD5_XDFFM_SB 74.7522
* device instance XD5_XDFFM_SB_t3 r0 *1 0,0
RXD5_XDFFM_SB_t3 XD5_XDFFM_SB__t3 XD5_XDFFM_SB 74.2029084448
* device instance XD5_XDFFM_SB_t4 r0 *1 0,0
RXD5_XDFFM_SB_t4 XD5_XDFFM_SB__t4 XD5_XDFFM_SB 75.3014915552
* device instance XD5_XDFFM_SB_t5 r0 *1 0,0
RXD5_XDFFM_SB_t5 XD5_XDFFM_SB__t5 XD5_XDFFM_SB 74.7522
* device instance XD5_XDFFM_SB r0 *1 0,0
CXD5_XDFFM_SB XD5_XDFFM_SB vsubs 1.03806298e-13
* device instance XD5_XDFFQ_CLKB_t0 r0 *1 0,0
RXD5_XDFFQ_CLKB_t0 XD5_XDFFQ_CLKB__t0 XD5_XDFFQ_CLKB 73.4586794268
* device instance XD5_XDFFQ_CLKB_t1 r0 *1 0,0
RXD5_XDFFQ_CLKB_t1 XD5_XDFFQ_CLKB__t1 XD5_XDFFQ_CLKB 74.438973567
* device instance XD5_XDFFQ_CLKB_t2 r0 *1 0,0
RXD5_XDFFQ_CLKB_t2 XD5_XDFFQ_CLKB__t2 XD5_XDFFQ_CLKB 70.5177970062
* device instance XD5_XDFFQ_CLKB_t3 r0 *1 0,0
RXD5_XDFFQ_CLKB_t3 XD5_XDFFQ_CLKB__t3 XD5_XDFFQ_CLKB 73.5488214167
* device instance XD5_XDFFQ_CLKB_t4 r0 *1 0,0
RXD5_XDFFQ_CLKB_t4 XD5_XDFFQ_CLKB__t4 XD5_XDFFQ_CLKB 70.7600536041
* device instance XD5_XDFFQ_CLKB_t5 r0 *1 0,0
RXD5_XDFFQ_CLKB_t5 XD5_XDFFQ_CLKB__t5 XD5_XDFFQ_CLKB 74.1065749792
* device instance XD5_XDFFQ_CLKB r0 *1 0,0
CXD5_XDFFQ_CLKB XD5_XDFFQ_CLKB vsubs 1.01346667e-13
* device instance XD5_XDFFQ_M_t0 r0 *1 0,0
RXD5_XDFFQ_M_t0 XD5_XDFFQ_M__t0 XD5_XDFFQ_M 60.2465261312
* device instance XD5_XDFFQ_M_t1 r0 *1 0,0
RXD5_XDFFQ_M_t1 XD5_XDFFQ_M__t1 XD5_XDFFQ_M 59.4302283935
* device instance XD5_XDFFQ_M_t2 r0 *1 0,0
RXD5_XDFFQ_M_t2 XD5_XDFFQ_M__t2 XD5_XDFFQ_M 61.0628238688
* device instance XD5_XDFFQ_M_t3 r0 *1 0,0
RXD5_XDFFQ_M_t3 XD5_XDFFQ_M__t3 XD5_XDFFQ_M 61.8791216065
* device instance XD5_XDFFQ_M_t4 r0 *1 0,0
RXD5_XDFFQ_M_t4 XD5_XDFFQ_M__t4 XD5_XDFFQ_M 60.8868976323
* device instance XD5_XDFFQ_M_t5 r0 *1 0,0
RXD5_XDFFQ_M_t5 XD5_XDFFQ_M__t5 XD5_XDFFQ_M 59.9580071032
* device instance XD5_XDFFQ_M_t6 r0 *1 0,0
RXD5_XDFFQ_M_t6 XD5_XDFFQ_M__t6 XD5_XDFFQ_M 61.3513428968
* device instance XD5_XDFFQ_M_t7 r0 *1 0,0
RXD5_XDFFQ_M_t7 XD5_XDFFQ_M__t7 XD5_XDFFQ_M 60.4224523677
* device instance XD5_XDFFQ_M r0 *1 0,0
CXD5_XDFFQ_M XD5_XDFFQ_M vsubs 1.13572959e-13
* device instance XD5_XDFFQ_MB_t0 r0 *1 0,0
RXD5_XDFFQ_MB_t0 XD5_XDFFQ_MB__t0 XD5_XDFFQ_MB 98.069588286
* device instance XD5_XDFFQ_MB_t1 r0 *1 0,0
RXD5_XDFFQ_MB_t1 XD5_XDFFQ_MB__t1 XD5_XDFFQ_MB 99.398361714
* device instance XD5_XDFFQ_MB_t2 r0 *1 0,0
RXD5_XDFFQ_MB_t2 XD5_XDFFQ_MB__t2 XD5_XDFFQ_MB 99.1119881304
* device instance XD5_XDFFQ_MB_t3 r0 *1 0,0
RXD5_XDFFQ_MB_t3 XD5_XDFFQ_MB__t3 XD5_XDFFQ_MB 98.3559618696
* device instance XD5_XDFFQ_MB r0 *1 0,0
CXD5_XDFFQ_MB XD5_XDFFQ_MB vsubs 9.0409958e-14
* device instance XD5_XDFFQ_S_t0 r0 *1 0,0
RXD5_XDFFQ_S_t0 XD5_XDFFQ_S__t0 XD5_XDFFQ_S 73.8487333333
* device instance XD5_XDFFQ_S_t1 r0 *1 0,0
RXD5_XDFFQ_S_t1 XD5_XDFFQ_S__t1 XD5_XDFFQ_S 72.8620231838
* device instance XD5_XDFFQ_S_t2 r0 *1 0,0
RXD5_XDFFQ_S_t2 XD5_XDFFQ_S__t2 XD5_XDFFQ_S 74.8354434829
* device instance XD5_XDFFQ_S_t3 r0 *1 0,0
RXD5_XDFFQ_S_t3 XD5_XDFFQ_S__t3 XD5_XDFFQ_S 73.8487333333
* device instance XD5_XDFFQ_S_t4 r0 *1 0,0
RXD5_XDFFQ_S_t4 XD5_XDFFQ_S__t4 XD5_XDFFQ_S 74.4101373839
* device instance XD5_XDFFQ_S_t5 r0 *1 0,0
RXD5_XDFFQ_S_t5 XD5_XDFFQ_S__t5 XD5_XDFFQ_S 73.2873292827
* device instance XD5_XDFFQ_S r0 *1 0,0
CXD5_XDFFQ_S XD5_XDFFQ_S vsubs 1.02780827e-13
* device instance XD5_XDFFQ_SB_t0 r0 *1 0,0
RXD5_XDFFQ_SB_t0 XD5_XDFFQ_SB__t0 XD5_XDFFQ_SB 75.0050103316
* device instance XD5_XDFFQ_SB_t1 r0 *1 0,0
RXD5_XDFFQ_SB_t1 XD5_XDFFQ_SB__t1 XD5_XDFFQ_SB 73.0327230017
* device instance XD5_XDFFQ_SB_t2 r0 *1 0,0
RXD5_XDFFQ_SB_t2 XD5_XDFFQ_SB__t2 XD5_XDFFQ_SB 74.0188666667
* device instance XD5_XDFFQ_SB_t3 r0 *1 0,0
RXD5_XDFFQ_SB_t3 XD5_XDFFQ_SB__t3 XD5_XDFFQ_SB 73.4577849263
* device instance XD5_XDFFQ_SB_t4 r0 *1 0,0
RXD5_XDFFQ_SB_t4 XD5_XDFFQ_SB__t4 XD5_XDFFQ_SB 74.5799484071
* device instance XD5_XDFFQ_SB_t5 r0 *1 0,0
RXD5_XDFFQ_SB_t5 XD5_XDFFQ_SB__t5 XD5_XDFFQ_SB 74.0188666667
* device instance XD5_XDFFQ_SB r0 *1 0,0
CXD5_XDFFQ_SB XD5_XDFFQ_SB vsubs 1.03032376e-13
* device instance XD5_XN2_mid1_t0 r0 *1 0,0
RXD5_XN2_mid1_t0 XD5_XN2_mid1__t0 XD5_XN2_mid1 23.2979
* device instance XD5_XN2_mid1_t1 r0 *1 0,0
RXD5_XN2_mid1_t1 XD5_XN2_mid1__t1 XD5_XN2_mid1 23.2979
* device instance XD5_XN2_mid1 r0 *1 0,0
CXD5_XN2_mid1 XD5_XN2_mid1 vsubs 1.1814027e-14
* device instance XD5_XN3_mid1_t0 r0 *1 0,0
RXD5_XN3_mid1_t0 XD5_XN3_mid1__t0 XD5_XN3_mid1 23.4739
* device instance XD5_XN3_mid1_t1 r0 *1 0,0
RXD5_XN3_mid1_t1 XD5_XN3_mid1__t1 XD5_XN3_mid1 23.4739
* device instance XD5_XN3_mid1 r0 *1 0,0
CXD5_XN3_mid1 XD5_XN3_mid1 vsubs 1.1926059e-14
* device instance XD5_XN3_mid2_t0 r0 *1 0,0
RXD5_XN3_mid2_t0 XD5_XN3_mid2__t0 XD5_XN3_mid2 23.6499
* device instance XD5_XN3_mid2_t1 r0 *1 0,0
RXD5_XN3_mid2_t1 XD5_XN3_mid2__t1 XD5_XN3_mid2 23.6499
* device instance XD5_XN3_mid2 r0 *1 0,0
CXD5_XN3_mid2 XD5_XN3_mid2 vsubs 1.2015707e-14
* device instance XD5_XNOR_midp_t0 r0 *1 0,0
RXD5_XNOR_midp_t0 XD5_XNOR_midp__t0 XD5_XNOR_midp 25.3591
* device instance XD5_XNOR_midp_t1 r0 *1 0,0
RXD5_XNOR_midp_t1 XD5_XNOR_midp__t1 XD5_XNOR_midp 25.3591
* device instance XD5_XNOR_midp r0 *1 0,0
CXD5_XNOR_midp XD5_XNOR_midp vsubs 1.2983574e-14
* device instance XD5_dmodout_t0 r0 *1 0,0
RXD5_dmodout_t0 XD5_dmodout__t0 XD5_dmodout 100.893571184
* device instance XD5_dmodout_t1 r0 *1 0,0
RXD5_dmodout_t1 XD5_dmodout__t1 XD5_dmodout 103.579178816
* device instance XD5_dmodout_t2 r0 *1 0,0
RXD5_dmodout_t2 XD5_dmodout__t2 XD5_dmodout 103.000384068
* device instance XD5_dmodout_t3 r0 *1 0,0
RXD5_dmodout_t3 XD5_dmodout__t3 XD5_dmodout 101.472365932
* device instance XD5_dmodout r0 *1 0,0
CXD5_dmodout XD5_dmodout vsubs 9.3709661e-14
* device instance XD5_dq_t0 r0 *1 0,0
RXD5_dq_t0 XD5_dq__t0 XD5_dq 104.915237769
* device instance XD5_dq_t1 r0 *1 0,0
RXD5_dq_t1 XD5_dq__t1 XD5_dq 107.306562231
* device instance XD5_dq_t2 r0 *1 0,0
RXD5_dq_t2 XD5_dq__t2 XD5_dq 70.9673635265
* device instance XD5_dq_t3 r0 *1 0,0
RXD5_dq_t3 XD5_dq__t3 XD5_dq 69.6067823675
* device instance XD5_dq_t4 r0 *1 0,0
RXD5_dq_t4 XD5_dq__t4 XD5_dq 71.647654106
* device instance XD5_dq r0 *1 0,0
CXD5_dq XD5_dq vsubs 9.7945127e-14
* device instance XD5_nm_t0 r0 *1 0,0
RXD5_nm_t0 XD5_nm__t0 XD5_nm 72.9095482707
* device instance XD5_nm_t1 r0 *1 0,0
RXD5_nm_t1 XD5_nm__t1 XD5_nm 70.5409850626
* device instance XD5_nm_t2 r0 *1 0,0
RXD5_nm_t2 XD5_nm__t2 XD5_nm 71.7252666667
* device instance XD5_nm_t3 r0 *1 0,0
RXD5_nm_t3 XD5_nm__t3 XD5_nm 106.914084605
* device instance XD5_nm_t4 r0 *1 0,0
RXD5_nm_t4 XD5_nm__t4 XD5_nm 108.261715395
* device instance XD5_nm r0 *1 0,0
CXD5_nm XD5_nm vsubs 9.9487988e-14
* device instance XD5_nt_t0 r0 *1 0,0
RXD5_nt_t0 XD5_nt__t0 XD5_nt 57.4585762247
* device instance XD5_nt_t1 r0 *1 0,0
RXD5_nt_t1 XD5_nt__t1 XD5_nt 54.0131737753
* device instance XD5_nt_t2 r0 *1 0,0
RXD5_nt_t2 XD5_nt__t2 XD5_nt 55.1616412584
* device instance XD5_nt_t3 r0 *1 0,0
RXD5_nt_t3 XD5_nt__t3 XD5_nt 56.3101087416
* device instance XD5_nt_t4 r0 *1 0,0
RXD5_nt_t4 XD5_nt__t4 XD5_nt 110.491592407
* device instance XD5_nt_t5 r0 *1 0,0
RXD5_nt_t5 XD5_nt__t5 XD5_nt 112.451907593
* device instance XD5_nt r0 *1 0,0
CXD5_nt XD5_nt vsubs 1.03840142e-13
* device instance XD5_t1_t0 r0 *1 0,0
RXD5_t1_t0 XD5_t1__t0 XD5_t1 100.684929599
* device instance XD5_t1_t1 r0 *1 0,0
RXD5_t1_t1 XD5_t1__t1 XD5_t1 97.9759704012
* device instance XD5_t1_t2 r0 *1 0,0
RXD5_t1_t2 XD5_t1__t2 XD5_t1 98.5597978145
* device instance XD5_t1_t3 r0 *1 0,0
RXD5_t1_t3 XD5_t1__t3 XD5_t1 100.101102185
* device instance XD5_t1 r0 *1 0,0
CXD5_t1 XD5_t1 vsubs 9.1342357e-14
* device instance XFRT_CLKB_t0 r0 *1 0,0
RXFRT_CLKB_t0 XFRT_CLKB__t0 XFRT_CLKB 79.7159392778
* device instance XFRT_CLKB_t1 r0 *1 0,0
RXFRT_CLKB_t1 XFRT_CLKB__t1 XFRT_CLKB 78.7198657111
* device instance XFRT_CLKB_t2 r0 *1 0,0
RXFRT_CLKB_t2 XFRT_CLKB__t2 XFRT_CLKB 75.7316450111
* device instance XFRT_CLKB_t3 r0 *1 0,0
RXFRT_CLKB_t3 XFRT_CLKB__t3 XFRT_CLKB 78.8114586828
* device instance XFRT_CLKB_t4 r0 *1 0,0
RXFRT_CLKB_t4 XFRT_CLKB__t4 XFRT_CLKB 75.9778011224
* device instance XFRT_CLKB_t5 r0 *1 0,0
RXFRT_CLKB_t5 XFRT_CLKB__t5 XFRT_CLKB 79.3781901948
* device instance XFRT_CLKB r0 *1 0,0
CXFRT_CLKB XFRT_CLKB vsubs 1.08888876e-13
* device instance XFRT_M_t0 r0 *1 0,0
RXFRT_M_t0 XFRT_M__t0 XFRT_M 64.7928002996
* device instance XFRT_M_t1 r0 *1 0,0
RXFRT_M_t1 XFRT_M__t1 XFRT_M 65.6245497004
* device instance XFRT_M_t2 r0 *1 0,0
RXFRT_M_t2 XFRT_M__t2 XFRT_M 63.9610508989
* device instance XFRT_M_t3 r0 *1 0,0
RXFRT_M_t3 XFRT_M__t3 XFRT_M 66.4562991011
* device instance XFRT_M_t4 r0 *1 0,0
RXFRT_M_t4 XFRT_M__t4 XFRT_M 65.445293364
* device instance XFRT_M_t5 r0 *1 0,0
RXFRT_M_t5 XFRT_M__t5 XFRT_M 64.498819908
* device instance XFRT_M_t6 r0 *1 0,0
RXFRT_M_t6 XFRT_M__t6 XFRT_M 65.918530092
* device instance XFRT_M_t7 r0 *1 0,0
RXFRT_M_t7 XFRT_M__t7 XFRT_M 64.972056636
* device instance XFRT_M r0 *1 0,0
CXFRT_M XFRT_M vsubs 1.22386214e-13
* device instance XFRT_MB_t0 r0 *1 0,0
RXFRT_MB_t0 XFRT_MB__t0 XFRT_MB 104.705916661
* device instance XFRT_MB_t1 r0 *1 0,0
RXFRT_MB_t1 XFRT_MB__t1 XFRT_MB 106.050033339
* device instance XFRT_MB_t2 r0 *1 0,0
RXFRT_MB_t2 XFRT_MB__t2 XFRT_MB 105.76035302
* device instance XFRT_MB_t3 r0 *1 0,0
RXFRT_MB_t3 XFRT_MB__t3 XFRT_MB 104.99559698
* device instance XFRT_MB r0 *1 0,0
CXFRT_MB XFRT_MB vsubs 9.6683314e-14
* device instance XFRT_S_t0 r0 *1 0,0
RXFRT_S_t0 XFRT_S__t0 XFRT_S 79.0994
* device instance XFRT_S_t1 r0 *1 0,0
RXFRT_S_t1 XFRT_S__t1 XFRT_S 78.0973581296
* device instance XFRT_S_t2 r0 *1 0,0
RXFRT_S_t2 XFRT_S__t2 XFRT_S 80.1014418704
* device instance XFRT_S_t3 r0 *1 0,0
RXFRT_S_t3 XFRT_S__t3 XFRT_S 79.0994
* device instance XFRT_S_t4 r0 *1 0,0
RXFRT_S_t4 XFRT_S__t4 XFRT_S 79.6695272711
* device instance XFRT_S_t5 r0 *1 0,0
RXFRT_S_t5 XFRT_S__t5 XFRT_S 78.5292727289
* device instance XFRT_S r0 *1 0,0
CXFRT_S XFRT_S vsubs 1.10324149e-13
* device instance XFRT_SB_t0 r0 *1 0,0
RXFRT_SB_t0 XFRT_SB__t0 XFRT_SB 80.2709962801
* device instance XFRT_SB_t1 r0 *1 0,0
RXFRT_SB_t1 XFRT_SB__t1 XFRT_SB 78.2680703866
* device instance XFRT_SB_t2 r0 *1 0,0
RXFRT_SB_t2 XFRT_SB__t2 XFRT_SB 79.2695333333
* device instance XFRT_SB_t3 r0 *1 0,0
RXFRT_SB_t3 XFRT_SB__t3 XFRT_SB 78.6997354498
* device instance XFRT_SB_t4 r0 *1 0,0
RXFRT_SB_t4 XFRT_SB__t4 XFRT_SB 79.8393312168
* device instance XFRT_SB_t5 r0 *1 0,0
RXFRT_SB_t5 XFRT_SB__t5 XFRT_SB 79.2695333333
* device instance XFRT_SB r0 *1 0,0
CXFRT_SB XFRT_SB vsubs 1.10577335e-13
* device instance ck1_t0 r0 *1 0,0
Rck1_t0 ck1__t0 ck1 28.8223772507
* device instance ck1_t1 r0 *1 0,0
Rck1_t1 ck1__t1 ck1 41.141479373
* device instance ck1_t2 r0 *1 0,0
Rck1_t2 ck1__t2 ck1 41.9114232557
* device instance ck1_t3 r0 *1 0,0
Rck1_t3 ck1__t3 ck1 20.3529945415
* device instance ck1_t4 r0 *1 0,0
Rck1_t4 ck1__t4 ck1 45.7611426689
* device instance ck1_t5 r0 *1 0,0
Rck1_t5 ck1__t5 ck1 49.6108620821
* device instance ck1_t6 r0 *1 0,0
Rck1_t6 ck1__t6 ck1 50.3808059648
* device instance ck1_t7 r0 *1 0,0
Rck1_t7 ck1__t7 ck1 54.230525378
* device instance ck1_t8 r0 *1 0,0
Rck1_t8 ck1__t8 ck1 27.2824894854
* device instance ck1_t9 r0 *1 0,0
Rck1_t9 ck1__t9 ck1 51.0902753279
* device instance ck1_t10 r0 *1 0,0
Rck1_t10 ck1__t10 ck1 32.6912715115
* device instance ck1_t11 r0 *1 0,0
Rck1_t11 ck1__t11 ck1 39.2623443031
* device instance ck1_t12 r0 *1 0,0
Rck1_t12 ck1__t12 ck1 37.9481297448
* device instance ck1_t13 r0 *1 0,0
Rck1_t13 ck1__t13 ck1 37.5100582253
* device instance ck1_t14 r0 *1 0,0
Rck1_t14 ck1__t14 ck1 34.4435575893
* device instance ck1_t15 r0 *1 0,0
Rck1_t15 ck1__t15 ck1 33.129343031
* device instance ck1_t16 r0 *1 0,0
Rck1_t16 ck1__t16 ck1 46.2714886141
* device instance ck1_t17 r0 *1 0,0
Rck1_t17 ck1__t17 ck1 47.147631653
* device instance ck1 r0 *1 0,0
Cck1 ck1 vsubs 1.75793059e-13
* device instance ck2_t0 r0 *1 0,0
Rck2_t0 ck2__t0 ck2 54.7376345252
* device instance ck2_t1 r0 *1 0,0
Rck2_t1 ck2__t1 ck2 42.4649975051
* device instance ck2_t2 r0 *1 0,0
Rck2_t2 ck2__t2 ck2 43.1869173298
* device instance ck2_t3 r0 *1 0,0
Rck2_t3 ck2__t3 ck2 46.7965164534
* device instance ck2_t4 r0 *1 0,0
Rck2_t4 ck2__t4 ck2 50.4061155769
* device instance ck2_t5 r0 *1 0,0
Rck2_t5 ck2__t5 ck2 51.1280354016
* device instance ck2_t6 r0 *1 0,0
Rck2_t6 ck2__t6 ck2 22.9731622379
* device instance ck2_t7 r0 *1 0,0
Rck2_t7 ck2__t7 ck2 30.9142803098
* device instance ck2_t8 r0 *1 0,0
Rck2_t8 ck2__t8 ck2 29.4704406603
* device instance ck2_t9 r0 *1 0,0
Rck2_t9 ck2__t9 ck2 51.7932527114
* device instance ck2_t10 r0 *1 0,0
Rck2_t10 ck2__t10 ck2 47.2750303602
* device instance ck2_t11 r0 *1 0,0
Rck2_t11 ck2__t11 ck2 34.5418582795
* device instance ck2_t12 r0 *1 0,0
Rck2_t12 ck2__t12 ck2 40.7030705766
* device instance ck2_t13 r0 *1 0,0
Rck2_t13 ck2__t13 ck2 39.4708281172
* device instance ck2_t14 r0 *1 0,0
Rck2_t14 ck2__t14 ck2 39.0600806307
* device instance ck2_t15 r0 *1 0,0
Rck2_t15 ck2__t15 ck2 36.1848482254
* device instance ck2_t16 r0 *1 0,0
Rck2_t16 ck2__t16 ck2 34.952605766
* device instance ck2_t17 r0 *1 0,0
Rck2_t17 ck2__t17 ck2 48.0965253331
* device instance ck2 r0 *1 0,0
Cck2 ck2 vsubs 1.81481395e-13
* device instance ck3_t0 r0 *1 0,0
Rck3_t0 ck3__t0 ck3 43.8013638522
* device instance ck3_t1 r0 *1 0,0
Rck3_t1 ck3__t1 ck3 44.4835191857
* device instance ck3_t2 r0 *1 0,0
Rck3_t2 ck3__t2 ck3 47.8942958534
* device instance ck3_t3 r0 *1 0,0
Rck3_t3 ck3__t3 ck3 25.3831698465
* device instance ck3_t4 r0 *1 0,0
Rck3_t4 ck3__t4 ck3 32.8868785155
* device instance ck3_t5 r0 *1 0,0
Rck3_t5 ck3__t5 ck3 51.3050725211
* device instance ck3_t6 r0 *1 0,0
Rck3_t6 ck3__t6 ck3 51.9872278547
* device instance ck3_t7 r0 *1 0,0
Rck3_t7 ck3__t7 ck3 55.3980045224
* device instance ck3_t8 r0 *1 0,0
Rck3_t8 ck3__t8 ck3 31.5225678484
* device instance ck3_t9 r0 *1 0,0
Rck3_t9 ck3__t9 ck3 37.8671351748
* device instance ck3_t10 r0 *1 0,0
Rck3_t10 ck3__t10 ck3 52.6158039379
* device instance ck3_t11 r0 *1 0,0
Rck3_t11 ck3__t11 ck3 40.9721180723
* device instance ck3_t12 r0 *1 0,0
Rck3_t12 ck3__t12 ck3 40.5839952101
* device instance ck3_t13 r0 *1 0,0
Rck3_t13 ck3__t13 ck3 42.1364866588
* device instance ck3_t14 r0 *1 0,0
Rck3_t14 ck3__t14 ck3 48.3464524538
* device instance ck3_t15 r0 *1 0,0
Rck3_t15 ck3__t15 ck3 36.314643726
* device instance ck3_t16 r0 *1 0,0
Rck3_t16 ck3__t16 ck3 36.7027665882
* device instance ck3_t17 r0 *1 0,0
Rck3_t17 ck3__t17 ck3 49.1226981782
* device instance ck3 r0 *1 0,0
Cck3 ck3 vsubs 1.87171366e-13
* device instance ck4_t0 r0 *1 0,0
Rck4_t0 ck4__t0 ck4 27.6329417228
* device instance ck4_t1 r0 *1 0,0
Rck4_t1 ck4__t1 ck4 34.7685132051
* device instance ck4_t2 r0 *1 0,0
Rck4_t2 ck4__t2 ck4 52.2830977525
* device instance ck4_t3 r0 *1 0,0
Rck4_t3 ck4__t3 ck4 52.9317860691
* device instance ck4_t4 r0 *1 0,0
Rck4_t4 ck4__t4 ck4 56.1752276519
* device instance ck4_t5 r0 *1 0,0
Rck4_t5 ck4__t5 ck4 45.1475262702
* device instance ck4_t6 r0 *1 0,0
Rck4_t6 ck4__t6 ck4 45.7962145868
* device instance ck4_t7 r0 *1 0,0
Rck4_t7 ck4__t7 ck4 49.0396561696
* device instance ck4_t8 r0 *1 0,0
Rck4_t8 ck4__t8 ck4 33.471136572
* device instance ck4_t9 r0 *1 0,0
Rck4_t9 ck4__t9 ck4 53.5295237707
* device instance ck4_t10 r0 *1 0,0
Rck4_t10 ck4__t10 ck4 49.4696296515
* device instance ck4_t11 r0 *1 0,0
Rck4_t11 ck4__t11 ck4 42.4570852638
* device instance ck4_t12 r0 *1 0,0
Rck4_t12 ck4__t12 ck4 42.0880039802
* device instance ck4_t13 r0 *1 0,0
Rck4_t13 ck4__t13 ck4 39.5044349952
* device instance ck4_t14 r0 *1 0,0
Rck4_t14 ck4__t14 ck4 38.3971911445
* device instance ck4_t15 r0 *1 0,0
Rck4_t15 ck4__t15 ck4 38.028109861
* device instance ck4_t16 r0 *1 0,0
Rck4_t16 ck4__t16 ck4 43.5643291145
* device instance ck4_t17 r0 *1 0,0
Rck4_t17 ck4__t17 ck4 50.2077922186
* device instance ck4 r0 *1 0,0
Cck4 ck4 vsubs 1.92861338e-13
* device instance ck5_t0 r0 *1 0,0
Rck5_t0 ck5__t0 ck5 36.5792075888
* device instance ck5_t1 r0 *1 0,0
Rck5_t1 ck5__t1 ck5 46.5013284135
* device instance ck5_t2 r0 *1 0,0
Rck5_t2 ck5__t2 ck5 47.1214609651
* device instance ck5_t3 r0 *1 0,0
Rck5_t3 ck5__t3 ck5 29.7577495219
* device instance ck5_t4 r0 *1 0,0
Rck5_t4 ck5__t4 ck5 50.2221237228
* device instance ck5_t5 r0 *1 0,0
Rck5_t5 ck5__t5 ck5 53.3227864805
* device instance ck5_t6 r0 *1 0,0
Rck5_t6 ck5__t6 ck5 57.0435817897
* device instance ck5_t7 r0 *1 0,0
Rck5_t7 ck5__t7 ck5 53.942919032
* device instance ck5_t8 r0 *1 0,0
Rck5_t8 ck5__t8 ck5 35.3389424858
* device instance ck5_t9 r0 *1 0,0
Rck5_t9 ck5__t9 ck5 44.9878248299
* device instance ck5_t10 r0 *1 0,0
Rck5_t10 ck5__t10 ck5 43.929322716
* device instance ck5_t11 r0 *1 0,0
Rck5_t11 ck5__t11 ck5 43.5764886781
* device instance ck5_t12 r0 *1 0,0
Rck5_t12 ck5__t12 ck5 41.1066504125
* device instance ck5_t13 r0 *1 0,0
Rck5_t13 ck5__t13 ck5 40.0481482986
* device instance ck5_t14 r0 *1 0,0
Rck5_t14 ck5__t14 ck5 39.6953142607
* device instance ck5_t15 r0 *1 0,0
Rck5_t15 ck5__t15 ck5 50.633169437
* device instance ck5_t16 r0 *1 0,0
Rck5_t16 ck5__t16 ck5 54.5143438544
* device instance ck5_t17 r0 *1 0,0
Rck5_t17 ck5__t17 ck5 51.3388375129
* device instance ck5 r0 *1 0,0
Cck5 ck5 vsubs 1.98537072e-13
* device instance mod0_t0 r0 *1 0,0
Rmod0_t0 mod0__t0 mod0 66.7235433112
* device instance mod0_t1 r0 *1 0,0
Rmod0_t1 mod0__t1 mod0 50.91866819
* device instance mod0_t2 r0 *1 0,0
Rmod0_t2 mod0__t2 mod0 33.8980334441
* device instance mod0_t3 r0 *1 0,0
Rmod0_t3 mod0__t3 mod0 93.4702550548
* device instance mod0_t4 r0 *1 0,0
Rmod0_t4 mod0__t4 mod0 76.8164443335
* device instance mod0_t5 r0 *1 0,0
Rmod0_t5 mod0__t5 mod0 58.1398611333
* device instance mod0_t6 r0 *1 0,0
Rmod0_t6 mod0__t6 mod0 67.1322900816
* device instance mod0_t7 r0 *1 0,0
Rmod0_t7 mod0__t7 mod0 42.9219044516
* device instance mod0 r0 *1 0,0
Cmod0 mod0 vsubs 1.16061533e-13
* device instance mod1_t0 r0 *1 0,0
Rmod1_t0 mod1__t0 mod1 69.3570940205
* device instance mod1_t1 r0 *1 0,0
Rmod1_t1 mod1__t1 mod1 38.2862798975
* device instance mod1_t2 r0 *1 0,0
Rmod1_t2 mod1__t2 mod1 54.3970724057
* device instance mod1_t3 r0 *1 0,0
Rmod1_t3 mod1__t3 mod1 94.6740536763
* device instance mod1_t4 r0 *1 0,0
Rmod1_t4 mod1__t4 mod1 61.2322546952
* device instance mod1_t5 r0 *1 0,0
Rmod1_t5 mod1__t5 mod1 69.7439911312
* device instance mod1_t6 r0 *1 0,0
Rmod1_t6 mod1__t6 mod1 78.9104765239
* device instance mod1_t7 r0 *1 0,0
Rmod1_t7 mod1__t7 mod1 46.8277776497
* device instance mod1 r0 *1 0,0
Cmod1 mod1 vsubs 1.21292335e-13
* device instance mod2_t0 r0 *1 0,0
Rmod2_t0 mod2__t0 mod2 72.0421734072
* device instance mod2_t1 r0 *1 0,0
Rmod2_t1 mod2__t1 mod2 57.7781446753
* device instance mod2_t2 r0 *1 0,0
Rmod2_t2 mod2__t2 mod2 42.4168829641
* device instance mod2_t3 r0 *1 0,0
Rmod2_t3 mod2__t3 mod2 96.1812989534
* device instance mod2_t4 r0 *1 0,0
Rmod2_t4 mod2__t4 mod2 81.151098917
* device instance mod2_t5 r0 *1 0,0
Rmod2_t5 mod2__t5 mod2 64.2953302166
* device instance mod2_t6 r0 *1 0,0
Rmod2_t6 mod2__t6 mod2 72.411070702
* device instance mod2_t7 r0 *1 0,0
Rmod2_t7 mod2__t7 mod2 50.5610001645
* device instance mod2 r0 *1 0,0
Cmod2 mod2 vsubs 1.26525886e-13
* device instance mod3_t0 r0 *1 0,0
Rmod3_t0 mod3__t0 mod3 46.3524233526
* device instance mod3_t1 r0 *1 0,0
Rmod3_t1 mod3__t1 mod3 61.0855265999
* device instance mod3_t2 r0 *1 0,0
Rmod3_t2 mod3__t2 mod3 74.7662653295
* device instance mod3_t3 r0 *1 0,0
Rmod3_t3 mod3__t3 mod3 97.918284718
* device instance mod3_t4 r0 *1 0,0
Rmod3_t4 mod3__t4 mod3 83.5027052476
* device instance mod3_t5 r0 *1 0,0
Rmod3_t5 mod3__t5 mod3 75.120077538
* device instance mod3_t6 r0 *1 0,0
Rmod3_t6 mod3__t6 mod3 67.3362089505
* device instance mod3_t7 r0 *1 0,0
Rmod3_t7 mod3__t7 mod3 54.1635082639
* device instance mod3 r0 *1 0,0
Cmod3 mod3 vsubs 1.31759437e-13
* device instance mod4_t0 r0 *1 0,0
Rmod4_t0 mod4__t0 mod4 77.5206035383
* device instance mod4_t1 r0 *1 0,0
Rmod4_t1 mod4__t1 mod4 50.1367323084
* device instance mod4_t2 r0 *1 0,0
Rmod4_t2 mod4__t2 mod4 64.3357766498
* device instance mod4_t3 r0 *1 0,0
Rmod4_t3 mod4__t3 mod4 99.8333875035
* device instance mod4_t4 r0 *1 0,0
Rmod4_t4 mod4__t4 mod4 77.8615904406
* device instance mod4_t5 r0 *1 0,0
Rmod4_t5 mod4__t5 mod4 70.3598785903
* device instance mod4_t6 r0 *1 0,0
Rmod4_t6 mod4__t6 mod4 85.9403570487
* device instance mod4_t7 r0 *1 0,0
Rmod4_t7 mod4__t7 mod4 57.6646739204
* device instance mod4 r0 *1 0,0
Cmod4 mod4 vsubs 1.36991875e-13
* device instance net1_t0 r0 *1 0,0
Rnet1_t0 net1__t0 net1 65.5410623086
* device instance net1_t1 r0 *1 0,0
Rnet1_t1 net1__t1 net1 104.161987691
* device instance net1_t2 r0 *1 0,0
Rnet1_t2 net1__t2 net1 95.8385123934
* device instance net1_t3 r0 *1 0,0
Rnet1_t3 net1__t3 net1 73.8645376066
* device instance net1 r0 *1 0,0
Cnet1 net1 vsubs 7.9008527e-14
* device instance cc_CKIN_CKIN_VCO r0 *1 0,0
Ccc_CKIN_CKIN_VCO CKIN CKIN_VCO 1.8151e-17
* device instance cc_CKIN_DIVOUT r0 *1 0,0
Ccc_CKIN_DIVOUT CKIN DIVOUT 2.4201e-17
* device instance cc_CKIN_FB r0 *1 0,0
Ccc_CKIN_FB CKIN FB 6.05e-18
* device instance cc_CKIN_P0 r0 *1 0,0
Ccc_CKIN_P0 CKIN P0 6.05e-18
* device instance cc_CKIN_P1 r0 *1 0,0
Ccc_CKIN_P1 CKIN P1 6.05e-18
* device instance cc_CKIN_P2 r0 *1 0,0
Ccc_CKIN_P2 CKIN P2 6.05e-18
* device instance cc_CKIN_P3 r0 *1 0,0
Ccc_CKIN_P3 CKIN P3 6.05e-18
* device instance cc_CKIN_P4 r0 *1 0,0
Ccc_CKIN_P4 CKIN P4 6.05e-18
* device instance cc_CKIN_P5 r0 *1 0,0
Ccc_CKIN_P5 CKIN P5 6.05e-18
* device instance cc_CKIN_VDD_DIV r0 *1 0,0
Ccc_CKIN_VDD_DIV CKIN VDD_DIV 1.08905e-16
* device instance cc_CKIN_VSS r0 *1 0,0
Ccc_CKIN_VSS CKIN VSS 5.08221e-16
* device instance cc_CKIN_XD0_XDFFM_CLKB r0 *1 0,0
Ccc_CKIN_XD0_XDFFM_CLKB CKIN XD0_XDFFM_CLKB 3.6302e-17
* device instance cc_CKIN_XD0_XDFFM_M r0 *1 0,0
Ccc_CKIN_XD0_XDFFM_M CKIN XD0_XDFFM_M 4.8402e-17
* device instance cc_CKIN_XD0_XDFFM_MB r0 *1 0,0
Ccc_CKIN_XD0_XDFFM_MB CKIN XD0_XDFFM_MB 2.4201e-17
* device instance cc_CKIN_XD0_XDFFM_S r0 *1 0,0
Ccc_CKIN_XD0_XDFFM_S CKIN XD0_XDFFM_S 3.0251e-17
* device instance cc_CKIN_XD0_XDFFM_SB r0 *1 0,0
Ccc_CKIN_XD0_XDFFM_SB CKIN XD0_XDFFM_SB 2.4201e-17
* device instance cc_CKIN_XD0_XDFFQ_CLKB r0 *1 0,0
Ccc_CKIN_XD0_XDFFQ_CLKB CKIN XD0_XDFFQ_CLKB 3.6302e-17
* device instance cc_CKIN_XD0_XDFFQ_M r0 *1 0,0
Ccc_CKIN_XD0_XDFFQ_M CKIN XD0_XDFFQ_M 4.8402e-17
* device instance cc_CKIN_XD0_XDFFQ_MB r0 *1 0,0
Ccc_CKIN_XD0_XDFFQ_MB CKIN XD0_XDFFQ_MB 2.4201e-17
* device instance cc_CKIN_XD0_XDFFQ_S r0 *1 0,0
Ccc_CKIN_XD0_XDFFQ_S CKIN XD0_XDFFQ_S 3.6302e-17
* device instance cc_CKIN_XD0_XDFFQ_SB r0 *1 0,0
Ccc_CKIN_XD0_XDFFQ_SB CKIN XD0_XDFFQ_SB 3.6302e-17
* device instance cc_CKIN_XD0_XN2_mid1 r0 *1 0,0
Ccc_CKIN_XD0_XN2_mid1 CKIN XD0_XN2_mid1 1.21e-17
* device instance cc_CKIN_XD0_XNOR_midp r0 *1 0,0
Ccc_CKIN_XD0_XNOR_midp CKIN XD0_XNOR_midp 1.21e-17
* device instance cc_CKIN_XD0_dmodout r0 *1 0,0
Ccc_CKIN_XD0_dmodout CKIN XD0_dmodout 2.4201e-17
* device instance cc_CKIN_XD0_dq r0 *1 0,0
Ccc_CKIN_XD0_dq CKIN XD0_dq 1.8151e-17
* device instance cc_CKIN_XD0_nm r0 *1 0,0
Ccc_CKIN_XD0_nm CKIN XD0_nm 3.0251e-17
* device instance cc_CKIN_XD0_nt r0 *1 0,0
Ccc_CKIN_XD0_nt CKIN XD0_nt 2.4201e-17
* device instance cc_CKIN_XD0_t1 r0 *1 0,0
Ccc_CKIN_XD0_t1 CKIN XD0_t1 1.21e-17
* device instance cc_CKIN_XD1_XDFFM_CLKB r0 *1 0,0
Ccc_CKIN_XD1_XDFFM_CLKB CKIN XD1_XDFFM_CLKB 1.8151e-17
* device instance cc_CKIN_XD1_XDFFM_M r0 *1 0,0
Ccc_CKIN_XD1_XDFFM_M CKIN XD1_XDFFM_M 2.4201e-17
* device instance cc_CKIN_XD1_XDFFM_MB r0 *1 0,0
Ccc_CKIN_XD1_XDFFM_MB CKIN XD1_XDFFM_MB 1.21e-17
* device instance cc_CKIN_XD1_XDFFM_S r0 *1 0,0
Ccc_CKIN_XD1_XDFFM_S CKIN XD1_XDFFM_S 1.8151e-17
* device instance cc_CKIN_XD1_XDFFM_SB r0 *1 0,0
Ccc_CKIN_XD1_XDFFM_SB CKIN XD1_XDFFM_SB 1.8151e-17
* device instance cc_CKIN_XD1_XDFFQ_CLKB r0 *1 0,0
Ccc_CKIN_XD1_XDFFQ_CLKB CKIN XD1_XDFFQ_CLKB 1.8151e-17
* device instance cc_CKIN_XD1_XDFFQ_M r0 *1 0,0
Ccc_CKIN_XD1_XDFFQ_M CKIN XD1_XDFFQ_M 2.4201e-17
* device instance cc_CKIN_XD1_XDFFQ_MB r0 *1 0,0
Ccc_CKIN_XD1_XDFFQ_MB CKIN XD1_XDFFQ_MB 1.21e-17
* device instance cc_CKIN_XD1_XDFFQ_S r0 *1 0,0
Ccc_CKIN_XD1_XDFFQ_S CKIN XD1_XDFFQ_S 1.8151e-17
* device instance cc_CKIN_XD1_XDFFQ_SB r0 *1 0,0
Ccc_CKIN_XD1_XDFFQ_SB CKIN XD1_XDFFQ_SB 1.8151e-17
* device instance cc_CKIN_XD1_XN2_mid1 r0 *1 0,0
Ccc_CKIN_XD1_XN2_mid1 CKIN XD1_XN2_mid1 1.21e-17
* device instance cc_CKIN_XD1_XN3_mid1 r0 *1 0,0
Ccc_CKIN_XD1_XN3_mid1 CKIN XD1_XN3_mid1 1.21e-17
* device instance cc_CKIN_XD1_XN3_mid2 r0 *1 0,0
Ccc_CKIN_XD1_XN3_mid2 CKIN XD1_XN3_mid2 1.21e-17
* device instance cc_CKIN_XD1_dmodout r0 *1 0,0
Ccc_CKIN_XD1_dmodout CKIN XD1_dmodout 1.21e-17
* device instance cc_CKIN_XD1_dq r0 *1 0,0
Ccc_CKIN_XD1_dq CKIN XD1_dq 1.8151e-17
* device instance cc_CKIN_XD1_nm r0 *1 0,0
Ccc_CKIN_XD1_nm CKIN XD1_nm 1.21e-17
* device instance cc_CKIN_XD1_nt r0 *1 0,0
Ccc_CKIN_XD1_nt CKIN XD1_nt 1.21e-17
* device instance cc_CKIN_XD1_t1 r0 *1 0,0
Ccc_CKIN_XD1_t1 CKIN XD1_t1 1.21e-17
* device instance cc_CKIN_XD2_XDFFM_CLKB r0 *1 0,0
Ccc_CKIN_XD2_XDFFM_CLKB CKIN XD2_XDFFM_CLKB 1.8151e-17
* device instance cc_CKIN_XD2_XDFFM_M r0 *1 0,0
Ccc_CKIN_XD2_XDFFM_M CKIN XD2_XDFFM_M 2.4201e-17
* device instance cc_CKIN_XD2_XDFFM_MB r0 *1 0,0
Ccc_CKIN_XD2_XDFFM_MB CKIN XD2_XDFFM_MB 1.21e-17
* device instance cc_CKIN_XD2_XDFFM_S r0 *1 0,0
Ccc_CKIN_XD2_XDFFM_S CKIN XD2_XDFFM_S 1.8151e-17
* device instance cc_CKIN_XD2_XDFFM_SB r0 *1 0,0
Ccc_CKIN_XD2_XDFFM_SB CKIN XD2_XDFFM_SB 1.8151e-17
* device instance cc_CKIN_XD2_XDFFQ_CLKB r0 *1 0,0
Ccc_CKIN_XD2_XDFFQ_CLKB CKIN XD2_XDFFQ_CLKB 1.8151e-17
* device instance cc_CKIN_XD2_XDFFQ_M r0 *1 0,0
Ccc_CKIN_XD2_XDFFQ_M CKIN XD2_XDFFQ_M 2.4201e-17
* device instance cc_CKIN_XD2_XDFFQ_MB r0 *1 0,0
Ccc_CKIN_XD2_XDFFQ_MB CKIN XD2_XDFFQ_MB 1.21e-17
* device instance cc_CKIN_XD2_XDFFQ_S r0 *1 0,0
Ccc_CKIN_XD2_XDFFQ_S CKIN XD2_XDFFQ_S 1.8151e-17
* device instance cc_CKIN_XD2_XDFFQ_SB r0 *1 0,0
Ccc_CKIN_XD2_XDFFQ_SB CKIN XD2_XDFFQ_SB 1.8151e-17
* device instance cc_CKIN_XD2_XN2_mid1 r0 *1 0,0
Ccc_CKIN_XD2_XN2_mid1 CKIN XD2_XN2_mid1 1.21e-17
* device instance cc_CKIN_XD2_XN3_mid1 r0 *1 0,0
Ccc_CKIN_XD2_XN3_mid1 CKIN XD2_XN3_mid1 1.21e-17
* device instance cc_CKIN_XD2_XN3_mid2 r0 *1 0,0
Ccc_CKIN_XD2_XN3_mid2 CKIN XD2_XN3_mid2 1.21e-17
* device instance cc_CKIN_XD2_dmodout r0 *1 0,0
Ccc_CKIN_XD2_dmodout CKIN XD2_dmodout 1.21e-17
* device instance cc_CKIN_XD2_dq r0 *1 0,0
Ccc_CKIN_XD2_dq CKIN XD2_dq 1.8151e-17
* device instance cc_CKIN_XD2_nm r0 *1 0,0
Ccc_CKIN_XD2_nm CKIN XD2_nm 1.21e-17
* device instance cc_CKIN_XD2_nt r0 *1 0,0
Ccc_CKIN_XD2_nt CKIN XD2_nt 1.21e-17
* device instance cc_CKIN_XD2_t1 r0 *1 0,0
Ccc_CKIN_XD2_t1 CKIN XD2_t1 1.21e-17
* device instance cc_CKIN_XD3_XDFFM_CLKB r0 *1 0,0
Ccc_CKIN_XD3_XDFFM_CLKB CKIN XD3_XDFFM_CLKB 1.8151e-17
* device instance cc_CKIN_XD3_XDFFM_M r0 *1 0,0
Ccc_CKIN_XD3_XDFFM_M CKIN XD3_XDFFM_M 2.4201e-17
* device instance cc_CKIN_XD3_XDFFM_MB r0 *1 0,0
Ccc_CKIN_XD3_XDFFM_MB CKIN XD3_XDFFM_MB 1.21e-17
* device instance cc_CKIN_XD3_XDFFM_S r0 *1 0,0
Ccc_CKIN_XD3_XDFFM_S CKIN XD3_XDFFM_S 1.8151e-17
* device instance cc_CKIN_XD3_XDFFM_SB r0 *1 0,0
Ccc_CKIN_XD3_XDFFM_SB CKIN XD3_XDFFM_SB 1.8151e-17
* device instance cc_CKIN_XD3_XDFFQ_CLKB r0 *1 0,0
Ccc_CKIN_XD3_XDFFQ_CLKB CKIN XD3_XDFFQ_CLKB 1.8151e-17
* device instance cc_CKIN_XD3_XDFFQ_M r0 *1 0,0
Ccc_CKIN_XD3_XDFFQ_M CKIN XD3_XDFFQ_M 2.4201e-17
* device instance cc_CKIN_XD3_XDFFQ_MB r0 *1 0,0
Ccc_CKIN_XD3_XDFFQ_MB CKIN XD3_XDFFQ_MB 1.21e-17
* device instance cc_CKIN_XD3_XDFFQ_S r0 *1 0,0
Ccc_CKIN_XD3_XDFFQ_S CKIN XD3_XDFFQ_S 1.8151e-17
* device instance cc_CKIN_XD3_XDFFQ_SB r0 *1 0,0
Ccc_CKIN_XD3_XDFFQ_SB CKIN XD3_XDFFQ_SB 1.8151e-17
* device instance cc_CKIN_XD3_XN2_mid1 r0 *1 0,0
Ccc_CKIN_XD3_XN2_mid1 CKIN XD3_XN2_mid1 1.21e-17
* device instance cc_CKIN_XD3_XN3_mid1 r0 *1 0,0
Ccc_CKIN_XD3_XN3_mid1 CKIN XD3_XN3_mid1 1.21e-17
* device instance cc_CKIN_XD3_XN3_mid2 r0 *1 0,0
Ccc_CKIN_XD3_XN3_mid2 CKIN XD3_XN3_mid2 1.21e-17
* device instance cc_CKIN_XD3_dmodout r0 *1 0,0
Ccc_CKIN_XD3_dmodout CKIN XD3_dmodout 1.21e-17
* device instance cc_CKIN_XD3_dq r0 *1 0,0
Ccc_CKIN_XD3_dq CKIN XD3_dq 1.8151e-17
* device instance cc_CKIN_XD3_nm r0 *1 0,0
Ccc_CKIN_XD3_nm CKIN XD3_nm 1.21e-17
* device instance cc_CKIN_XD3_nt r0 *1 0,0
Ccc_CKIN_XD3_nt CKIN XD3_nt 1.21e-17
* device instance cc_CKIN_XD3_t1 r0 *1 0,0
Ccc_CKIN_XD3_t1 CKIN XD3_t1 1.21e-17
* device instance cc_CKIN_XD4_XDFFM_CLKB r0 *1 0,0
Ccc_CKIN_XD4_XDFFM_CLKB CKIN XD4_XDFFM_CLKB 1.8151e-17
* device instance cc_CKIN_XD4_XDFFM_M r0 *1 0,0
Ccc_CKIN_XD4_XDFFM_M CKIN XD4_XDFFM_M 2.4201e-17
* device instance cc_CKIN_XD4_XDFFM_MB r0 *1 0,0
Ccc_CKIN_XD4_XDFFM_MB CKIN XD4_XDFFM_MB 1.21e-17
* device instance cc_CKIN_XD4_XDFFM_S r0 *1 0,0
Ccc_CKIN_XD4_XDFFM_S CKIN XD4_XDFFM_S 1.8151e-17
* device instance cc_CKIN_XD4_XDFFM_SB r0 *1 0,0
Ccc_CKIN_XD4_XDFFM_SB CKIN XD4_XDFFM_SB 1.8151e-17
* device instance cc_CKIN_XD4_XDFFQ_CLKB r0 *1 0,0
Ccc_CKIN_XD4_XDFFQ_CLKB CKIN XD4_XDFFQ_CLKB 1.8151e-17
* device instance cc_CKIN_XD4_XDFFQ_M r0 *1 0,0
Ccc_CKIN_XD4_XDFFQ_M CKIN XD4_XDFFQ_M 2.4201e-17
* device instance cc_CKIN_XD4_XDFFQ_MB r0 *1 0,0
Ccc_CKIN_XD4_XDFFQ_MB CKIN XD4_XDFFQ_MB 1.21e-17
* device instance cc_CKIN_XD4_XDFFQ_S r0 *1 0,0
Ccc_CKIN_XD4_XDFFQ_S CKIN XD4_XDFFQ_S 1.8151e-17
* device instance cc_CKIN_XD4_XDFFQ_SB r0 *1 0,0
Ccc_CKIN_XD4_XDFFQ_SB CKIN XD4_XDFFQ_SB 1.8151e-17
* device instance cc_CKIN_XD4_XN2_mid1 r0 *1 0,0
Ccc_CKIN_XD4_XN2_mid1 CKIN XD4_XN2_mid1 1.21e-17
* device instance cc_CKIN_XD4_XN3_mid1 r0 *1 0,0
Ccc_CKIN_XD4_XN3_mid1 CKIN XD4_XN3_mid1 1.21e-17
* device instance cc_CKIN_XD4_XN3_mid2 r0 *1 0,0
Ccc_CKIN_XD4_XN3_mid2 CKIN XD4_XN3_mid2 1.21e-17
* device instance cc_CKIN_XD4_dmodout r0 *1 0,0
Ccc_CKIN_XD4_dmodout CKIN XD4_dmodout 1.21e-17
* device instance cc_CKIN_XD4_dq r0 *1 0,0
Ccc_CKIN_XD4_dq CKIN XD4_dq 1.8151e-17
* device instance cc_CKIN_XD4_nm r0 *1 0,0
Ccc_CKIN_XD4_nm CKIN XD4_nm 1.21e-17
* device instance cc_CKIN_XD4_nt r0 *1 0,0
Ccc_CKIN_XD4_nt CKIN XD4_nt 1.21e-17
* device instance cc_CKIN_XD4_t1 r0 *1 0,0
Ccc_CKIN_XD4_t1 CKIN XD4_t1 1.21e-17
* device instance cc_CKIN_XD5_XDFFM_CLKB r0 *1 0,0
Ccc_CKIN_XD5_XDFFM_CLKB CKIN XD5_XDFFM_CLKB 1.8151e-17
* device instance cc_CKIN_XD5_XDFFM_M r0 *1 0,0
Ccc_CKIN_XD5_XDFFM_M CKIN XD5_XDFFM_M 2.4201e-17
* device instance cc_CKIN_XD5_XDFFM_MB r0 *1 0,0
Ccc_CKIN_XD5_XDFFM_MB CKIN XD5_XDFFM_MB 1.21e-17
* device instance cc_CKIN_XD5_XDFFM_S r0 *1 0,0
Ccc_CKIN_XD5_XDFFM_S CKIN XD5_XDFFM_S 1.8151e-17
* device instance cc_CKIN_XD5_XDFFM_SB r0 *1 0,0
Ccc_CKIN_XD5_XDFFM_SB CKIN XD5_XDFFM_SB 1.8151e-17
* device instance cc_CKIN_XD5_XDFFQ_CLKB r0 *1 0,0
Ccc_CKIN_XD5_XDFFQ_CLKB CKIN XD5_XDFFQ_CLKB 1.8151e-17
* device instance cc_CKIN_XD5_XDFFQ_M r0 *1 0,0
Ccc_CKIN_XD5_XDFFQ_M CKIN XD5_XDFFQ_M 2.4201e-17
* device instance cc_CKIN_XD5_XDFFQ_MB r0 *1 0,0
Ccc_CKIN_XD5_XDFFQ_MB CKIN XD5_XDFFQ_MB 1.21e-17
* device instance cc_CKIN_XD5_XDFFQ_S r0 *1 0,0
Ccc_CKIN_XD5_XDFFQ_S CKIN XD5_XDFFQ_S 1.8151e-17
* device instance cc_CKIN_XD5_XDFFQ_SB r0 *1 0,0
Ccc_CKIN_XD5_XDFFQ_SB CKIN XD5_XDFFQ_SB 1.8151e-17
* device instance cc_CKIN_XD5_XN2_mid1 r0 *1 0,0
Ccc_CKIN_XD5_XN2_mid1 CKIN XD5_XN2_mid1 1.21e-17
* device instance cc_CKIN_XD5_XN3_mid1 r0 *1 0,0
Ccc_CKIN_XD5_XN3_mid1 CKIN XD5_XN3_mid1 1.21e-17
* device instance cc_CKIN_XD5_XN3_mid2 r0 *1 0,0
Ccc_CKIN_XD5_XN3_mid2 CKIN XD5_XN3_mid2 1.21e-17
* device instance cc_CKIN_XD5_dmodout r0 *1 0,0
Ccc_CKIN_XD5_dmodout CKIN XD5_dmodout 1.21e-17
* device instance cc_CKIN_XD5_dq r0 *1 0,0
Ccc_CKIN_XD5_dq CKIN XD5_dq 1.8151e-17
* device instance cc_CKIN_XD5_nm r0 *1 0,0
Ccc_CKIN_XD5_nm CKIN XD5_nm 1.21e-17
* device instance cc_CKIN_XD5_nt r0 *1 0,0
Ccc_CKIN_XD5_nt CKIN XD5_nt 1.21e-17
* device instance cc_CKIN_XD5_t1 r0 *1 0,0
Ccc_CKIN_XD5_t1 CKIN XD5_t1 1.21e-17
* device instance cc_CKIN_XFRT_CLKB r0 *1 0,0
Ccc_CKIN_XFRT_CLKB CKIN XFRT_CLKB 1.8151e-17
* device instance cc_CKIN_XFRT_M r0 *1 0,0
Ccc_CKIN_XFRT_M CKIN XFRT_M 2.4201e-17
* device instance cc_CKIN_XFRT_MB r0 *1 0,0
Ccc_CKIN_XFRT_MB CKIN XFRT_MB 1.21e-17
* device instance cc_CKIN_XFRT_S r0 *1 0,0
Ccc_CKIN_XFRT_S CKIN XFRT_S 1.8151e-17
* device instance cc_CKIN_XFRT_SB r0 *1 0,0
Ccc_CKIN_XFRT_SB CKIN XFRT_SB 1.8151e-17
* device instance cc_CKIN_ck1 r0 *1 0,0
Ccc_CKIN_ck1 CKIN ck1 6.6553e-17
* device instance cc_CKIN_ck2 r0 *1 0,0
Ccc_CKIN_ck2 CKIN ck2 5.4452e-17
* device instance cc_CKIN_ck3 r0 *1 0,0
Ccc_CKIN_ck3 CKIN ck3 5.4452e-17
* device instance cc_CKIN_ck4 r0 *1 0,0
Ccc_CKIN_ck4 CKIN ck4 5.4452e-17
* device instance cc_CKIN_ck5 r0 *1 0,0
Ccc_CKIN_ck5 CKIN ck5 5.4452e-17
* device instance cc_CKIN_mod0 r0 *1 0,0
Ccc_CKIN_mod0 CKIN mod0 3.0251e-17
* device instance cc_CKIN_mod1 r0 *1 0,0
Ccc_CKIN_mod1 CKIN mod1 2.4201e-17
* device instance cc_CKIN_mod2 r0 *1 0,0
Ccc_CKIN_mod2 CKIN mod2 2.4201e-17
* device instance cc_CKIN_mod3 r0 *1 0,0
Ccc_CKIN_mod3 CKIN mod3 2.4201e-17
* device instance cc_CKIN_mod4 r0 *1 0,0
Ccc_CKIN_mod4 CKIN mod4 2.4201e-17
* device instance cc_CKIN_net1 r0 *1 0,0
Ccc_CKIN_net1 CKIN net1 1.21e-17
* device instance cc_CKIN_VCO_DIVOUT r0 *1 0,0
Ccc_CKIN_VCO_DIVOUT CKIN_VCO DIVOUT 3.0251e-17
* device instance cc_CKIN_VCO_FB r0 *1 0,0
Ccc_CKIN_VCO_FB CKIN_VCO FB 6.05e-18
* device instance cc_CKIN_VCO_P0 r0 *1 0,0
Ccc_CKIN_VCO_P0 CKIN_VCO P0 6.05e-18
* device instance cc_CKIN_VCO_P1 r0 *1 0,0
Ccc_CKIN_VCO_P1 CKIN_VCO P1 6.05e-18
* device instance cc_CKIN_VCO_P2 r0 *1 0,0
Ccc_CKIN_VCO_P2 CKIN_VCO P2 6.05e-18
* device instance cc_CKIN_VCO_P3 r0 *1 0,0
Ccc_CKIN_VCO_P3 CKIN_VCO P3 6.05e-18
* device instance cc_CKIN_VCO_P4 r0 *1 0,0
Ccc_CKIN_VCO_P4 CKIN_VCO P4 6.05e-18
* device instance cc_CKIN_VCO_P5 r0 *1 0,0
Ccc_CKIN_VCO_P5 CKIN_VCO P5 6.05e-18
* device instance cc_CKIN_VCO_VDD_DIV r0 *1 0,0
Ccc_CKIN_VCO_VDD_DIV CKIN_VCO VDD_DIV 6.17125e-16
* device instance cc_CKIN_VCO_VSS r0 *1 0,0
Ccc_CKIN_VCO_VSS CKIN_VCO VSS 2.4201e-17
* device instance cc_CKIN_VCO_XD0_XDFFM_CLKB r0 *1 0,0
Ccc_CKIN_VCO_XD0_XDFFM_CLKB CKIN_VCO XD0_XDFFM_CLKB 1.8151e-17
* device instance cc_CKIN_VCO_XD0_XDFFM_M r0 *1 0,0
Ccc_CKIN_VCO_XD0_XDFFM_M CKIN_VCO XD0_XDFFM_M 2.4201e-17
* device instance cc_CKIN_VCO_XD0_XDFFM_MB r0 *1 0,0
Ccc_CKIN_VCO_XD0_XDFFM_MB CKIN_VCO XD0_XDFFM_MB 1.21e-17
* device instance cc_CKIN_VCO_XD0_XDFFM_S r0 *1 0,0
Ccc_CKIN_VCO_XD0_XDFFM_S CKIN_VCO XD0_XDFFM_S 1.8151e-17
* device instance cc_CKIN_VCO_XD0_XDFFM_SB r0 *1 0,0
Ccc_CKIN_VCO_XD0_XDFFM_SB CKIN_VCO XD0_XDFFM_SB 1.8151e-17
* device instance cc_CKIN_VCO_XD0_XDFFQ_CLKB r0 *1 0,0
Ccc_CKIN_VCO_XD0_XDFFQ_CLKB CKIN_VCO XD0_XDFFQ_CLKB 1.8151e-17
* device instance cc_CKIN_VCO_XD0_XDFFQ_M r0 *1 0,0
Ccc_CKIN_VCO_XD0_XDFFQ_M CKIN_VCO XD0_XDFFQ_M 2.4201e-17
* device instance cc_CKIN_VCO_XD0_XDFFQ_MB r0 *1 0,0
Ccc_CKIN_VCO_XD0_XDFFQ_MB CKIN_VCO XD0_XDFFQ_MB 1.21e-17
* device instance cc_CKIN_VCO_XD0_XDFFQ_S r0 *1 0,0
Ccc_CKIN_VCO_XD0_XDFFQ_S CKIN_VCO XD0_XDFFQ_S 1.8151e-17
* device instance cc_CKIN_VCO_XD0_XDFFQ_SB r0 *1 0,0
Ccc_CKIN_VCO_XD0_XDFFQ_SB CKIN_VCO XD0_XDFFQ_SB 1.8151e-17
* device instance cc_CKIN_VCO_XD0_XNOR_midp r0 *1 0,0
Ccc_CKIN_VCO_XD0_XNOR_midp CKIN_VCO XD0_XNOR_midp 1.21e-17
* device instance cc_CKIN_VCO_XD0_dmodout r0 *1 0,0
Ccc_CKIN_VCO_XD0_dmodout CKIN_VCO XD0_dmodout 1.21e-17
* device instance cc_CKIN_VCO_XD0_dq r0 *1 0,0
Ccc_CKIN_VCO_XD0_dq CKIN_VCO XD0_dq 1.21e-17
* device instance cc_CKIN_VCO_XD0_nm r0 *1 0,0
Ccc_CKIN_VCO_XD0_nm CKIN_VCO XD0_nm 1.8151e-17
* device instance cc_CKIN_VCO_XD0_nt r0 *1 0,0
Ccc_CKIN_VCO_XD0_nt CKIN_VCO XD0_nt 2.4201e-17
* device instance cc_CKIN_VCO_XD0_t1 r0 *1 0,0
Ccc_CKIN_VCO_XD0_t1 CKIN_VCO XD0_t1 1.21e-17
* device instance cc_CKIN_VCO_XD1_XDFFM_CLKB r0 *1 0,0
Ccc_CKIN_VCO_XD1_XDFFM_CLKB CKIN_VCO XD1_XDFFM_CLKB 1.8151e-17
* device instance cc_CKIN_VCO_XD1_XDFFM_M r0 *1 0,0
Ccc_CKIN_VCO_XD1_XDFFM_M CKIN_VCO XD1_XDFFM_M 2.4201e-17
* device instance cc_CKIN_VCO_XD1_XDFFM_MB r0 *1 0,0
Ccc_CKIN_VCO_XD1_XDFFM_MB CKIN_VCO XD1_XDFFM_MB 1.21e-17
* device instance cc_CKIN_VCO_XD1_XDFFM_S r0 *1 0,0
Ccc_CKIN_VCO_XD1_XDFFM_S CKIN_VCO XD1_XDFFM_S 1.8151e-17
* device instance cc_CKIN_VCO_XD1_XDFFM_SB r0 *1 0,0
Ccc_CKIN_VCO_XD1_XDFFM_SB CKIN_VCO XD1_XDFFM_SB 1.8151e-17
* device instance cc_CKIN_VCO_XD1_XDFFQ_CLKB r0 *1 0,0
Ccc_CKIN_VCO_XD1_XDFFQ_CLKB CKIN_VCO XD1_XDFFQ_CLKB 1.8151e-17
* device instance cc_CKIN_VCO_XD1_XDFFQ_M r0 *1 0,0
Ccc_CKIN_VCO_XD1_XDFFQ_M CKIN_VCO XD1_XDFFQ_M 2.4201e-17
* device instance cc_CKIN_VCO_XD1_XDFFQ_MB r0 *1 0,0
Ccc_CKIN_VCO_XD1_XDFFQ_MB CKIN_VCO XD1_XDFFQ_MB 1.21e-17
* device instance cc_CKIN_VCO_XD1_XDFFQ_S r0 *1 0,0
Ccc_CKIN_VCO_XD1_XDFFQ_S CKIN_VCO XD1_XDFFQ_S 1.8151e-17
* device instance cc_CKIN_VCO_XD1_XDFFQ_SB r0 *1 0,0
Ccc_CKIN_VCO_XD1_XDFFQ_SB CKIN_VCO XD1_XDFFQ_SB 1.8151e-17
* device instance cc_CKIN_VCO_XD1_XNOR_midp r0 *1 0,0
Ccc_CKIN_VCO_XD1_XNOR_midp CKIN_VCO XD1_XNOR_midp 1.21e-17
* device instance cc_CKIN_VCO_XD1_dmodout r0 *1 0,0
Ccc_CKIN_VCO_XD1_dmodout CKIN_VCO XD1_dmodout 1.21e-17
* device instance cc_CKIN_VCO_XD1_dq r0 *1 0,0
Ccc_CKIN_VCO_XD1_dq CKIN_VCO XD1_dq 1.21e-17
* device instance cc_CKIN_VCO_XD1_nm r0 *1 0,0
Ccc_CKIN_VCO_XD1_nm CKIN_VCO XD1_nm 1.8151e-17
* device instance cc_CKIN_VCO_XD1_nt r0 *1 0,0
Ccc_CKIN_VCO_XD1_nt CKIN_VCO XD1_nt 2.4201e-17
* device instance cc_CKIN_VCO_XD1_t1 r0 *1 0,0
Ccc_CKIN_VCO_XD1_t1 CKIN_VCO XD1_t1 1.21e-17
* device instance cc_CKIN_VCO_XD2_XDFFM_CLKB r0 *1 0,0
Ccc_CKIN_VCO_XD2_XDFFM_CLKB CKIN_VCO XD2_XDFFM_CLKB 1.8151e-17
* device instance cc_CKIN_VCO_XD2_XDFFM_M r0 *1 0,0
Ccc_CKIN_VCO_XD2_XDFFM_M CKIN_VCO XD2_XDFFM_M 2.4201e-17
* device instance cc_CKIN_VCO_XD2_XDFFM_MB r0 *1 0,0
Ccc_CKIN_VCO_XD2_XDFFM_MB CKIN_VCO XD2_XDFFM_MB 1.21e-17
* device instance cc_CKIN_VCO_XD2_XDFFM_S r0 *1 0,0
Ccc_CKIN_VCO_XD2_XDFFM_S CKIN_VCO XD2_XDFFM_S 1.8151e-17
* device instance cc_CKIN_VCO_XD2_XDFFM_SB r0 *1 0,0
Ccc_CKIN_VCO_XD2_XDFFM_SB CKIN_VCO XD2_XDFFM_SB 1.8151e-17
* device instance cc_CKIN_VCO_XD2_XDFFQ_CLKB r0 *1 0,0
Ccc_CKIN_VCO_XD2_XDFFQ_CLKB CKIN_VCO XD2_XDFFQ_CLKB 1.8151e-17
* device instance cc_CKIN_VCO_XD2_XDFFQ_M r0 *1 0,0
Ccc_CKIN_VCO_XD2_XDFFQ_M CKIN_VCO XD2_XDFFQ_M 2.4201e-17
* device instance cc_CKIN_VCO_XD2_XDFFQ_MB r0 *1 0,0
Ccc_CKIN_VCO_XD2_XDFFQ_MB CKIN_VCO XD2_XDFFQ_MB 1.21e-17
* device instance cc_CKIN_VCO_XD2_XDFFQ_S r0 *1 0,0
Ccc_CKIN_VCO_XD2_XDFFQ_S CKIN_VCO XD2_XDFFQ_S 1.8151e-17
* device instance cc_CKIN_VCO_XD2_XDFFQ_SB r0 *1 0,0
Ccc_CKIN_VCO_XD2_XDFFQ_SB CKIN_VCO XD2_XDFFQ_SB 1.8151e-17
* device instance cc_CKIN_VCO_XD2_XNOR_midp r0 *1 0,0
Ccc_CKIN_VCO_XD2_XNOR_midp CKIN_VCO XD2_XNOR_midp 1.21e-17
* device instance cc_CKIN_VCO_XD2_dmodout r0 *1 0,0
Ccc_CKIN_VCO_XD2_dmodout CKIN_VCO XD2_dmodout 1.21e-17
* device instance cc_CKIN_VCO_XD2_dq r0 *1 0,0
Ccc_CKIN_VCO_XD2_dq CKIN_VCO XD2_dq 1.21e-17
* device instance cc_CKIN_VCO_XD2_nm r0 *1 0,0
Ccc_CKIN_VCO_XD2_nm CKIN_VCO XD2_nm 1.8151e-17
* device instance cc_CKIN_VCO_XD2_nt r0 *1 0,0
Ccc_CKIN_VCO_XD2_nt CKIN_VCO XD2_nt 2.4201e-17
* device instance cc_CKIN_VCO_XD2_t1 r0 *1 0,0
Ccc_CKIN_VCO_XD2_t1 CKIN_VCO XD2_t1 1.21e-17
* device instance cc_CKIN_VCO_XD3_XDFFM_CLKB r0 *1 0,0
Ccc_CKIN_VCO_XD3_XDFFM_CLKB CKIN_VCO XD3_XDFFM_CLKB 1.8151e-17
* device instance cc_CKIN_VCO_XD3_XDFFM_M r0 *1 0,0
Ccc_CKIN_VCO_XD3_XDFFM_M CKIN_VCO XD3_XDFFM_M 2.4201e-17
* device instance cc_CKIN_VCO_XD3_XDFFM_MB r0 *1 0,0
Ccc_CKIN_VCO_XD3_XDFFM_MB CKIN_VCO XD3_XDFFM_MB 1.21e-17
* device instance cc_CKIN_VCO_XD3_XDFFM_S r0 *1 0,0
Ccc_CKIN_VCO_XD3_XDFFM_S CKIN_VCO XD3_XDFFM_S 1.8151e-17
* device instance cc_CKIN_VCO_XD3_XDFFM_SB r0 *1 0,0
Ccc_CKIN_VCO_XD3_XDFFM_SB CKIN_VCO XD3_XDFFM_SB 1.8151e-17
* device instance cc_CKIN_VCO_XD3_XDFFQ_CLKB r0 *1 0,0
Ccc_CKIN_VCO_XD3_XDFFQ_CLKB CKIN_VCO XD3_XDFFQ_CLKB 1.8151e-17
* device instance cc_CKIN_VCO_XD3_XDFFQ_M r0 *1 0,0
Ccc_CKIN_VCO_XD3_XDFFQ_M CKIN_VCO XD3_XDFFQ_M 2.4201e-17
* device instance cc_CKIN_VCO_XD3_XDFFQ_MB r0 *1 0,0
Ccc_CKIN_VCO_XD3_XDFFQ_MB CKIN_VCO XD3_XDFFQ_MB 1.21e-17
* device instance cc_CKIN_VCO_XD3_XDFFQ_S r0 *1 0,0
Ccc_CKIN_VCO_XD3_XDFFQ_S CKIN_VCO XD3_XDFFQ_S 1.8151e-17
* device instance cc_CKIN_VCO_XD3_XDFFQ_SB r0 *1 0,0
Ccc_CKIN_VCO_XD3_XDFFQ_SB CKIN_VCO XD3_XDFFQ_SB 1.8151e-17
* device instance cc_CKIN_VCO_XD3_XNOR_midp r0 *1 0,0
Ccc_CKIN_VCO_XD3_XNOR_midp CKIN_VCO XD3_XNOR_midp 1.21e-17
* device instance cc_CKIN_VCO_XD3_dmodout r0 *1 0,0
Ccc_CKIN_VCO_XD3_dmodout CKIN_VCO XD3_dmodout 1.21e-17
* device instance cc_CKIN_VCO_XD3_dq r0 *1 0,0
Ccc_CKIN_VCO_XD3_dq CKIN_VCO XD3_dq 1.21e-17
* device instance cc_CKIN_VCO_XD3_nm r0 *1 0,0
Ccc_CKIN_VCO_XD3_nm CKIN_VCO XD3_nm 1.8151e-17
* device instance cc_CKIN_VCO_XD3_nt r0 *1 0,0
Ccc_CKIN_VCO_XD3_nt CKIN_VCO XD3_nt 2.4201e-17
* device instance cc_CKIN_VCO_XD3_t1 r0 *1 0,0
Ccc_CKIN_VCO_XD3_t1 CKIN_VCO XD3_t1 1.21e-17
* device instance cc_CKIN_VCO_XD4_XDFFM_CLKB r0 *1 0,0
Ccc_CKIN_VCO_XD4_XDFFM_CLKB CKIN_VCO XD4_XDFFM_CLKB 1.8151e-17
* device instance cc_CKIN_VCO_XD4_XDFFM_M r0 *1 0,0
Ccc_CKIN_VCO_XD4_XDFFM_M CKIN_VCO XD4_XDFFM_M 2.4201e-17
* device instance cc_CKIN_VCO_XD4_XDFFM_MB r0 *1 0,0
Ccc_CKIN_VCO_XD4_XDFFM_MB CKIN_VCO XD4_XDFFM_MB 1.21e-17
* device instance cc_CKIN_VCO_XD4_XDFFM_S r0 *1 0,0
Ccc_CKIN_VCO_XD4_XDFFM_S CKIN_VCO XD4_XDFFM_S 1.8151e-17
* device instance cc_CKIN_VCO_XD4_XDFFM_SB r0 *1 0,0
Ccc_CKIN_VCO_XD4_XDFFM_SB CKIN_VCO XD4_XDFFM_SB 1.8151e-17
* device instance cc_CKIN_VCO_XD4_XDFFQ_CLKB r0 *1 0,0
Ccc_CKIN_VCO_XD4_XDFFQ_CLKB CKIN_VCO XD4_XDFFQ_CLKB 1.8151e-17
* device instance cc_CKIN_VCO_XD4_XDFFQ_M r0 *1 0,0
Ccc_CKIN_VCO_XD4_XDFFQ_M CKIN_VCO XD4_XDFFQ_M 2.4201e-17
* device instance cc_CKIN_VCO_XD4_XDFFQ_MB r0 *1 0,0
Ccc_CKIN_VCO_XD4_XDFFQ_MB CKIN_VCO XD4_XDFFQ_MB 1.21e-17
* device instance cc_CKIN_VCO_XD4_XDFFQ_S r0 *1 0,0
Ccc_CKIN_VCO_XD4_XDFFQ_S CKIN_VCO XD4_XDFFQ_S 1.8151e-17
* device instance cc_CKIN_VCO_XD4_XDFFQ_SB r0 *1 0,0
Ccc_CKIN_VCO_XD4_XDFFQ_SB CKIN_VCO XD4_XDFFQ_SB 1.8151e-17
* device instance cc_CKIN_VCO_XD4_XNOR_midp r0 *1 0,0
Ccc_CKIN_VCO_XD4_XNOR_midp CKIN_VCO XD4_XNOR_midp 1.21e-17
* device instance cc_CKIN_VCO_XD4_dmodout r0 *1 0,0
Ccc_CKIN_VCO_XD4_dmodout CKIN_VCO XD4_dmodout 1.21e-17
* device instance cc_CKIN_VCO_XD4_dq r0 *1 0,0
Ccc_CKIN_VCO_XD4_dq CKIN_VCO XD4_dq 1.21e-17
* device instance cc_CKIN_VCO_XD4_nm r0 *1 0,0
Ccc_CKIN_VCO_XD4_nm CKIN_VCO XD4_nm 1.8151e-17
* device instance cc_CKIN_VCO_XD4_nt r0 *1 0,0
Ccc_CKIN_VCO_XD4_nt CKIN_VCO XD4_nt 2.4201e-17
* device instance cc_CKIN_VCO_XD4_t1 r0 *1 0,0
Ccc_CKIN_VCO_XD4_t1 CKIN_VCO XD4_t1 1.21e-17
* device instance cc_CKIN_VCO_XD5_XDFFM_CLKB r0 *1 0,0
Ccc_CKIN_VCO_XD5_XDFFM_CLKB CKIN_VCO XD5_XDFFM_CLKB 1.8151e-17
* device instance cc_CKIN_VCO_XD5_XDFFM_M r0 *1 0,0
Ccc_CKIN_VCO_XD5_XDFFM_M CKIN_VCO XD5_XDFFM_M 2.4201e-17
* device instance cc_CKIN_VCO_XD5_XDFFM_MB r0 *1 0,0
Ccc_CKIN_VCO_XD5_XDFFM_MB CKIN_VCO XD5_XDFFM_MB 1.21e-17
* device instance cc_CKIN_VCO_XD5_XDFFM_S r0 *1 0,0
Ccc_CKIN_VCO_XD5_XDFFM_S CKIN_VCO XD5_XDFFM_S 1.8151e-17
* device instance cc_CKIN_VCO_XD5_XDFFM_SB r0 *1 0,0
Ccc_CKIN_VCO_XD5_XDFFM_SB CKIN_VCO XD5_XDFFM_SB 1.8151e-17
* device instance cc_CKIN_VCO_XD5_XDFFQ_CLKB r0 *1 0,0
Ccc_CKIN_VCO_XD5_XDFFQ_CLKB CKIN_VCO XD5_XDFFQ_CLKB 1.8151e-17
* device instance cc_CKIN_VCO_XD5_XDFFQ_M r0 *1 0,0
Ccc_CKIN_VCO_XD5_XDFFQ_M CKIN_VCO XD5_XDFFQ_M 2.4201e-17
* device instance cc_CKIN_VCO_XD5_XDFFQ_MB r0 *1 0,0
Ccc_CKIN_VCO_XD5_XDFFQ_MB CKIN_VCO XD5_XDFFQ_MB 1.21e-17
* device instance cc_CKIN_VCO_XD5_XDFFQ_S r0 *1 0,0
Ccc_CKIN_VCO_XD5_XDFFQ_S CKIN_VCO XD5_XDFFQ_S 1.8151e-17
* device instance cc_CKIN_VCO_XD5_XDFFQ_SB r0 *1 0,0
Ccc_CKIN_VCO_XD5_XDFFQ_SB CKIN_VCO XD5_XDFFQ_SB 1.8151e-17
* device instance cc_CKIN_VCO_XD5_XNOR_midp r0 *1 0,0
Ccc_CKIN_VCO_XD5_XNOR_midp CKIN_VCO XD5_XNOR_midp 1.21e-17
* device instance cc_CKIN_VCO_XD5_dmodout r0 *1 0,0
Ccc_CKIN_VCO_XD5_dmodout CKIN_VCO XD5_dmodout 1.21e-17
* device instance cc_CKIN_VCO_XD5_dq r0 *1 0,0
Ccc_CKIN_VCO_XD5_dq CKIN_VCO XD5_dq 1.21e-17
* device instance cc_CKIN_VCO_XD5_nm r0 *1 0,0
Ccc_CKIN_VCO_XD5_nm CKIN_VCO XD5_nm 1.8151e-17
* device instance cc_CKIN_VCO_XD5_nt r0 *1 0,0
Ccc_CKIN_VCO_XD5_nt CKIN_VCO XD5_nt 2.4201e-17
* device instance cc_CKIN_VCO_XD5_t1 r0 *1 0,0
Ccc_CKIN_VCO_XD5_t1 CKIN_VCO XD5_t1 1.21e-17
* device instance cc_CKIN_VCO_XFRT_CLKB r0 *1 0,0
Ccc_CKIN_VCO_XFRT_CLKB CKIN_VCO XFRT_CLKB 3.6302e-17
* device instance cc_CKIN_VCO_XFRT_M r0 *1 0,0
Ccc_CKIN_VCO_XFRT_M CKIN_VCO XFRT_M 4.8402e-17
* device instance cc_CKIN_VCO_XFRT_MB r0 *1 0,0
Ccc_CKIN_VCO_XFRT_MB CKIN_VCO XFRT_MB 2.4201e-17
* device instance cc_CKIN_VCO_XFRT_S r0 *1 0,0
Ccc_CKIN_VCO_XFRT_S CKIN_VCO XFRT_S 3.0251e-17
* device instance cc_CKIN_VCO_XFRT_SB r0 *1 0,0
Ccc_CKIN_VCO_XFRT_SB CKIN_VCO XFRT_SB 2.4201e-17
* device instance cc_CKIN_VCO_ck1 r0 *1 0,0
Ccc_CKIN_VCO_ck1 CKIN_VCO ck1 5.4452e-17
* device instance cc_CKIN_VCO_ck2 r0 *1 0,0
Ccc_CKIN_VCO_ck2 CKIN_VCO ck2 5.4452e-17
* device instance cc_CKIN_VCO_ck3 r0 *1 0,0
Ccc_CKIN_VCO_ck3 CKIN_VCO ck3 5.4452e-17
* device instance cc_CKIN_VCO_ck4 r0 *1 0,0
Ccc_CKIN_VCO_ck4 CKIN_VCO ck4 5.4452e-17
* device instance cc_CKIN_VCO_ck5 r0 *1 0,0
Ccc_CKIN_VCO_ck5 CKIN_VCO ck5 5.4452e-17
* device instance cc_CKIN_VCO_mod0 r0 *1 0,0
Ccc_CKIN_VCO_mod0 CKIN_VCO mod0 2.4201e-17
* device instance cc_CKIN_VCO_mod1 r0 *1 0,0
Ccc_CKIN_VCO_mod1 CKIN_VCO mod1 2.4201e-17
* device instance cc_CKIN_VCO_mod2 r0 *1 0,0
Ccc_CKIN_VCO_mod2 CKIN_VCO mod2 2.4201e-17
* device instance cc_CKIN_VCO_mod3 r0 *1 0,0
Ccc_CKIN_VCO_mod3 CKIN_VCO mod3 2.4201e-17
* device instance cc_CKIN_VCO_mod4 r0 *1 0,0
Ccc_CKIN_VCO_mod4 CKIN_VCO mod4 2.4201e-17
* device instance cc_CKIN_VCO_net1 r0 *1 0,0
Ccc_CKIN_VCO_net1 CKIN_VCO net1 1.21e-17
* device instance cc_DIVOUT_FB r0 *1 0,0
Ccc_DIVOUT_FB DIVOUT FB 6.05e-18
* device instance cc_DIVOUT_P0 r0 *1 0,0
Ccc_DIVOUT_P0 DIVOUT P0 6.05e-18
* device instance cc_DIVOUT_P1 r0 *1 0,0
Ccc_DIVOUT_P1 DIVOUT P1 6.05e-18
* device instance cc_DIVOUT_P2 r0 *1 0,0
Ccc_DIVOUT_P2 DIVOUT P2 6.05e-18
* device instance cc_DIVOUT_P3 r0 *1 0,0
Ccc_DIVOUT_P3 DIVOUT P3 6.05e-18
* device instance cc_DIVOUT_P4 r0 *1 0,0
Ccc_DIVOUT_P4 DIVOUT P4 6.05e-18
* device instance cc_DIVOUT_P5 r0 *1 0,0
Ccc_DIVOUT_P5 DIVOUT P5 6.05e-18
* device instance cc_DIVOUT_VDD_DIV r0 *1 0,0
Ccc_DIVOUT_VDD_DIV DIVOUT VDD_DIV 6.16319e-16
* device instance cc_DIVOUT_VSS r0 *1 0,0
Ccc_DIVOUT_VSS DIVOUT VSS 1.02048e-16
* device instance cc_DIVOUT_XD0_XDFFM_CLKB r0 *1 0,0
Ccc_DIVOUT_XD0_XDFFM_CLKB DIVOUT XD0_XDFFM_CLKB 1.8151e-17
* device instance cc_DIVOUT_XD0_XDFFM_M r0 *1 0,0
Ccc_DIVOUT_XD0_XDFFM_M DIVOUT XD0_XDFFM_M 2.4201e-17
* device instance cc_DIVOUT_XD0_XDFFM_MB r0 *1 0,0
Ccc_DIVOUT_XD0_XDFFM_MB DIVOUT XD0_XDFFM_MB 1.21e-17
* device instance cc_DIVOUT_XD0_XDFFM_S r0 *1 0,0
Ccc_DIVOUT_XD0_XDFFM_S DIVOUT XD0_XDFFM_S 1.8151e-17
* device instance cc_DIVOUT_XD0_XDFFM_SB r0 *1 0,0
Ccc_DIVOUT_XD0_XDFFM_SB DIVOUT XD0_XDFFM_SB 1.8151e-17
* device instance cc_DIVOUT_XD0_XDFFQ_CLKB r0 *1 0,0
Ccc_DIVOUT_XD0_XDFFQ_CLKB DIVOUT XD0_XDFFQ_CLKB 1.8151e-17
* device instance cc_DIVOUT_XD0_XDFFQ_M r0 *1 0,0
Ccc_DIVOUT_XD0_XDFFQ_M DIVOUT XD0_XDFFQ_M 2.4201e-17
* device instance cc_DIVOUT_XD0_XDFFQ_MB r0 *1 0,0
Ccc_DIVOUT_XD0_XDFFQ_MB DIVOUT XD0_XDFFQ_MB 1.21e-17
* device instance cc_DIVOUT_XD0_XDFFQ_S r0 *1 0,0
Ccc_DIVOUT_XD0_XDFFQ_S DIVOUT XD0_XDFFQ_S 1.8151e-17
* device instance cc_DIVOUT_XD0_XDFFQ_SB r0 *1 0,0
Ccc_DIVOUT_XD0_XDFFQ_SB DIVOUT XD0_XDFFQ_SB 1.8151e-17
* device instance cc_DIVOUT_XD0_XNOR_midp r0 *1 0,0
Ccc_DIVOUT_XD0_XNOR_midp DIVOUT XD0_XNOR_midp 1.21e-17
* device instance cc_DIVOUT_XD0_dmodout r0 *1 0,0
Ccc_DIVOUT_XD0_dmodout DIVOUT XD0_dmodout 1.21e-17
* device instance cc_DIVOUT_XD0_dq r0 *1 0,0
Ccc_DIVOUT_XD0_dq DIVOUT XD0_dq 1.21e-17
* device instance cc_DIVOUT_XD0_nm r0 *1 0,0
Ccc_DIVOUT_XD0_nm DIVOUT XD0_nm 1.8151e-17
* device instance cc_DIVOUT_XD0_nt r0 *1 0,0
Ccc_DIVOUT_XD0_nt DIVOUT XD0_nt 2.4201e-17
* device instance cc_DIVOUT_XD0_t1 r0 *1 0,0
Ccc_DIVOUT_XD0_t1 DIVOUT XD0_t1 1.21e-17
* device instance cc_DIVOUT_XD1_XDFFM_CLKB r0 *1 0,0
Ccc_DIVOUT_XD1_XDFFM_CLKB DIVOUT XD1_XDFFM_CLKB 1.8151e-17
* device instance cc_DIVOUT_XD1_XDFFM_M r0 *1 0,0
Ccc_DIVOUT_XD1_XDFFM_M DIVOUT XD1_XDFFM_M 2.4201e-17
* device instance cc_DIVOUT_XD1_XDFFM_MB r0 *1 0,0
Ccc_DIVOUT_XD1_XDFFM_MB DIVOUT XD1_XDFFM_MB 1.21e-17
* device instance cc_DIVOUT_XD1_XDFFM_S r0 *1 0,0
Ccc_DIVOUT_XD1_XDFFM_S DIVOUT XD1_XDFFM_S 1.8151e-17
* device instance cc_DIVOUT_XD1_XDFFM_SB r0 *1 0,0
Ccc_DIVOUT_XD1_XDFFM_SB DIVOUT XD1_XDFFM_SB 1.8151e-17
* device instance cc_DIVOUT_XD1_XDFFQ_CLKB r0 *1 0,0
Ccc_DIVOUT_XD1_XDFFQ_CLKB DIVOUT XD1_XDFFQ_CLKB 1.8151e-17
* device instance cc_DIVOUT_XD1_XDFFQ_M r0 *1 0,0
Ccc_DIVOUT_XD1_XDFFQ_M DIVOUT XD1_XDFFQ_M 2.4201e-17
* device instance cc_DIVOUT_XD1_XDFFQ_MB r0 *1 0,0
Ccc_DIVOUT_XD1_XDFFQ_MB DIVOUT XD1_XDFFQ_MB 1.21e-17
* device instance cc_DIVOUT_XD1_XDFFQ_S r0 *1 0,0
Ccc_DIVOUT_XD1_XDFFQ_S DIVOUT XD1_XDFFQ_S 1.8151e-17
* device instance cc_DIVOUT_XD1_XDFFQ_SB r0 *1 0,0
Ccc_DIVOUT_XD1_XDFFQ_SB DIVOUT XD1_XDFFQ_SB 1.8151e-17
* device instance cc_DIVOUT_XD1_XNOR_midp r0 *1 0,0
Ccc_DIVOUT_XD1_XNOR_midp DIVOUT XD1_XNOR_midp 1.21e-17
* device instance cc_DIVOUT_XD1_dmodout r0 *1 0,0
Ccc_DIVOUT_XD1_dmodout DIVOUT XD1_dmodout 1.21e-17
* device instance cc_DIVOUT_XD1_dq r0 *1 0,0
Ccc_DIVOUT_XD1_dq DIVOUT XD1_dq 1.21e-17
* device instance cc_DIVOUT_XD1_nm r0 *1 0,0
Ccc_DIVOUT_XD1_nm DIVOUT XD1_nm 1.8151e-17
* device instance cc_DIVOUT_XD1_nt r0 *1 0,0
Ccc_DIVOUT_XD1_nt DIVOUT XD1_nt 2.4201e-17
* device instance cc_DIVOUT_XD1_t1 r0 *1 0,0
Ccc_DIVOUT_XD1_t1 DIVOUT XD1_t1 1.21e-17
* device instance cc_DIVOUT_XD2_XDFFM_CLKB r0 *1 0,0
Ccc_DIVOUT_XD2_XDFFM_CLKB DIVOUT XD2_XDFFM_CLKB 1.8151e-17
* device instance cc_DIVOUT_XD2_XDFFM_M r0 *1 0,0
Ccc_DIVOUT_XD2_XDFFM_M DIVOUT XD2_XDFFM_M 2.4201e-17
* device instance cc_DIVOUT_XD2_XDFFM_MB r0 *1 0,0
Ccc_DIVOUT_XD2_XDFFM_MB DIVOUT XD2_XDFFM_MB 1.21e-17
* device instance cc_DIVOUT_XD2_XDFFM_S r0 *1 0,0
Ccc_DIVOUT_XD2_XDFFM_S DIVOUT XD2_XDFFM_S 1.8151e-17
* device instance cc_DIVOUT_XD2_XDFFM_SB r0 *1 0,0
Ccc_DIVOUT_XD2_XDFFM_SB DIVOUT XD2_XDFFM_SB 1.8151e-17
* device instance cc_DIVOUT_XD2_XDFFQ_CLKB r0 *1 0,0
Ccc_DIVOUT_XD2_XDFFQ_CLKB DIVOUT XD2_XDFFQ_CLKB 1.8151e-17
* device instance cc_DIVOUT_XD2_XDFFQ_M r0 *1 0,0
Ccc_DIVOUT_XD2_XDFFQ_M DIVOUT XD2_XDFFQ_M 2.4201e-17
* device instance cc_DIVOUT_XD2_XDFFQ_MB r0 *1 0,0
Ccc_DIVOUT_XD2_XDFFQ_MB DIVOUT XD2_XDFFQ_MB 1.21e-17
* device instance cc_DIVOUT_XD2_XDFFQ_S r0 *1 0,0
Ccc_DIVOUT_XD2_XDFFQ_S DIVOUT XD2_XDFFQ_S 1.8151e-17
* device instance cc_DIVOUT_XD2_XDFFQ_SB r0 *1 0,0
Ccc_DIVOUT_XD2_XDFFQ_SB DIVOUT XD2_XDFFQ_SB 1.8151e-17
* device instance cc_DIVOUT_XD2_XNOR_midp r0 *1 0,0
Ccc_DIVOUT_XD2_XNOR_midp DIVOUT XD2_XNOR_midp 1.21e-17
* device instance cc_DIVOUT_XD2_dmodout r0 *1 0,0
Ccc_DIVOUT_XD2_dmodout DIVOUT XD2_dmodout 1.21e-17
* device instance cc_DIVOUT_XD2_dq r0 *1 0,0
Ccc_DIVOUT_XD2_dq DIVOUT XD2_dq 1.21e-17
* device instance cc_DIVOUT_XD2_nm r0 *1 0,0
Ccc_DIVOUT_XD2_nm DIVOUT XD2_nm 1.8151e-17
* device instance cc_DIVOUT_XD2_nt r0 *1 0,0
Ccc_DIVOUT_XD2_nt DIVOUT XD2_nt 2.4201e-17
* device instance cc_DIVOUT_XD2_t1 r0 *1 0,0
Ccc_DIVOUT_XD2_t1 DIVOUT XD2_t1 1.21e-17
* device instance cc_DIVOUT_XD3_XDFFM_CLKB r0 *1 0,0
Ccc_DIVOUT_XD3_XDFFM_CLKB DIVOUT XD3_XDFFM_CLKB 1.8151e-17
* device instance cc_DIVOUT_XD3_XDFFM_M r0 *1 0,0
Ccc_DIVOUT_XD3_XDFFM_M DIVOUT XD3_XDFFM_M 2.4201e-17
* device instance cc_DIVOUT_XD3_XDFFM_MB r0 *1 0,0
Ccc_DIVOUT_XD3_XDFFM_MB DIVOUT XD3_XDFFM_MB 1.21e-17
* device instance cc_DIVOUT_XD3_XDFFM_S r0 *1 0,0
Ccc_DIVOUT_XD3_XDFFM_S DIVOUT XD3_XDFFM_S 1.8151e-17
* device instance cc_DIVOUT_XD3_XDFFM_SB r0 *1 0,0
Ccc_DIVOUT_XD3_XDFFM_SB DIVOUT XD3_XDFFM_SB 1.8151e-17
* device instance cc_DIVOUT_XD3_XDFFQ_CLKB r0 *1 0,0
Ccc_DIVOUT_XD3_XDFFQ_CLKB DIVOUT XD3_XDFFQ_CLKB 1.8151e-17
* device instance cc_DIVOUT_XD3_XDFFQ_M r0 *1 0,0
Ccc_DIVOUT_XD3_XDFFQ_M DIVOUT XD3_XDFFQ_M 2.4201e-17
* device instance cc_DIVOUT_XD3_XDFFQ_MB r0 *1 0,0
Ccc_DIVOUT_XD3_XDFFQ_MB DIVOUT XD3_XDFFQ_MB 1.21e-17
* device instance cc_DIVOUT_XD3_XDFFQ_S r0 *1 0,0
Ccc_DIVOUT_XD3_XDFFQ_S DIVOUT XD3_XDFFQ_S 1.8151e-17
* device instance cc_DIVOUT_XD3_XDFFQ_SB r0 *1 0,0
Ccc_DIVOUT_XD3_XDFFQ_SB DIVOUT XD3_XDFFQ_SB 1.8151e-17
* device instance cc_DIVOUT_XD3_XNOR_midp r0 *1 0,0
Ccc_DIVOUT_XD3_XNOR_midp DIVOUT XD3_XNOR_midp 1.21e-17
* device instance cc_DIVOUT_XD3_dmodout r0 *1 0,0
Ccc_DIVOUT_XD3_dmodout DIVOUT XD3_dmodout 1.21e-17
* device instance cc_DIVOUT_XD3_dq r0 *1 0,0
Ccc_DIVOUT_XD3_dq DIVOUT XD3_dq 1.21e-17
* device instance cc_DIVOUT_XD3_nm r0 *1 0,0
Ccc_DIVOUT_XD3_nm DIVOUT XD3_nm 1.8151e-17
* device instance cc_DIVOUT_XD3_nt r0 *1 0,0
Ccc_DIVOUT_XD3_nt DIVOUT XD3_nt 2.4201e-17
* device instance cc_DIVOUT_XD3_t1 r0 *1 0,0
Ccc_DIVOUT_XD3_t1 DIVOUT XD3_t1 1.21e-17
* device instance cc_DIVOUT_XD4_XDFFM_CLKB r0 *1 0,0
Ccc_DIVOUT_XD4_XDFFM_CLKB DIVOUT XD4_XDFFM_CLKB 1.8151e-17
* device instance cc_DIVOUT_XD4_XDFFM_M r0 *1 0,0
Ccc_DIVOUT_XD4_XDFFM_M DIVOUT XD4_XDFFM_M 2.4201e-17
* device instance cc_DIVOUT_XD4_XDFFM_MB r0 *1 0,0
Ccc_DIVOUT_XD4_XDFFM_MB DIVOUT XD4_XDFFM_MB 1.21e-17
* device instance cc_DIVOUT_XD4_XDFFM_S r0 *1 0,0
Ccc_DIVOUT_XD4_XDFFM_S DIVOUT XD4_XDFFM_S 1.8151e-17
* device instance cc_DIVOUT_XD4_XDFFM_SB r0 *1 0,0
Ccc_DIVOUT_XD4_XDFFM_SB DIVOUT XD4_XDFFM_SB 1.8151e-17
* device instance cc_DIVOUT_XD4_XDFFQ_CLKB r0 *1 0,0
Ccc_DIVOUT_XD4_XDFFQ_CLKB DIVOUT XD4_XDFFQ_CLKB 1.8151e-17
* device instance cc_DIVOUT_XD4_XDFFQ_M r0 *1 0,0
Ccc_DIVOUT_XD4_XDFFQ_M DIVOUT XD4_XDFFQ_M 2.4201e-17
* device instance cc_DIVOUT_XD4_XDFFQ_MB r0 *1 0,0
Ccc_DIVOUT_XD4_XDFFQ_MB DIVOUT XD4_XDFFQ_MB 1.21e-17
* device instance cc_DIVOUT_XD4_XDFFQ_S r0 *1 0,0
Ccc_DIVOUT_XD4_XDFFQ_S DIVOUT XD4_XDFFQ_S 1.8151e-17
* device instance cc_DIVOUT_XD4_XDFFQ_SB r0 *1 0,0
Ccc_DIVOUT_XD4_XDFFQ_SB DIVOUT XD4_XDFFQ_SB 1.8151e-17
* device instance cc_DIVOUT_XD4_XNOR_midp r0 *1 0,0
Ccc_DIVOUT_XD4_XNOR_midp DIVOUT XD4_XNOR_midp 1.21e-17
* device instance cc_DIVOUT_XD4_dmodout r0 *1 0,0
Ccc_DIVOUT_XD4_dmodout DIVOUT XD4_dmodout 1.21e-17
* device instance cc_DIVOUT_XD4_dq r0 *1 0,0
Ccc_DIVOUT_XD4_dq DIVOUT XD4_dq 1.21e-17
* device instance cc_DIVOUT_XD4_nm r0 *1 0,0
Ccc_DIVOUT_XD4_nm DIVOUT XD4_nm 1.8151e-17
* device instance cc_DIVOUT_XD4_nt r0 *1 0,0
Ccc_DIVOUT_XD4_nt DIVOUT XD4_nt 2.4201e-17
* device instance cc_DIVOUT_XD4_t1 r0 *1 0,0
Ccc_DIVOUT_XD4_t1 DIVOUT XD4_t1 1.21e-17
* device instance cc_DIVOUT_XD5_XDFFM_CLKB r0 *1 0,0
Ccc_DIVOUT_XD5_XDFFM_CLKB DIVOUT XD5_XDFFM_CLKB 3.6302e-17
* device instance cc_DIVOUT_XD5_XDFFM_M r0 *1 0,0
Ccc_DIVOUT_XD5_XDFFM_M DIVOUT XD5_XDFFM_M 4.8402e-17
* device instance cc_DIVOUT_XD5_XDFFM_MB r0 *1 0,0
Ccc_DIVOUT_XD5_XDFFM_MB DIVOUT XD5_XDFFM_MB 2.4201e-17
* device instance cc_DIVOUT_XD5_XDFFM_S r0 *1 0,0
Ccc_DIVOUT_XD5_XDFFM_S DIVOUT XD5_XDFFM_S 3.6302e-17
* device instance cc_DIVOUT_XD5_XDFFM_SB r0 *1 0,0
Ccc_DIVOUT_XD5_XDFFM_SB DIVOUT XD5_XDFFM_SB 3.6302e-17
* device instance cc_DIVOUT_XD5_XDFFQ_CLKB r0 *1 0,0
Ccc_DIVOUT_XD5_XDFFQ_CLKB DIVOUT XD5_XDFFQ_CLKB 3.6302e-17
* device instance cc_DIVOUT_XD5_XDFFQ_M r0 *1 0,0
Ccc_DIVOUT_XD5_XDFFQ_M DIVOUT XD5_XDFFQ_M 4.8402e-17
* device instance cc_DIVOUT_XD5_XDFFQ_MB r0 *1 0,0
Ccc_DIVOUT_XD5_XDFFQ_MB DIVOUT XD5_XDFFQ_MB 2.4201e-17
* device instance cc_DIVOUT_XD5_XDFFQ_S r0 *1 0,0
Ccc_DIVOUT_XD5_XDFFQ_S DIVOUT XD5_XDFFQ_S 3.6302e-17
* device instance cc_DIVOUT_XD5_XDFFQ_SB r0 *1 0,0
Ccc_DIVOUT_XD5_XDFFQ_SB DIVOUT XD5_XDFFQ_SB 3.6302e-17
* device instance cc_DIVOUT_XD5_XN2_mid1 r0 *1 0,0
Ccc_DIVOUT_XD5_XN2_mid1 DIVOUT XD5_XN2_mid1 1.21e-17
* device instance cc_DIVOUT_XD5_XNOR_midp r0 *1 0,0
Ccc_DIVOUT_XD5_XNOR_midp DIVOUT XD5_XNOR_midp 1.21e-17
* device instance cc_DIVOUT_XD5_dmodout r0 *1 0,0
Ccc_DIVOUT_XD5_dmodout DIVOUT XD5_dmodout 2.4201e-17
* device instance cc_DIVOUT_XD5_dq r0 *1 0,0
Ccc_DIVOUT_XD5_dq DIVOUT XD5_dq 3.0251e-17
* device instance cc_DIVOUT_XD5_nm r0 *1 0,0
Ccc_DIVOUT_XD5_nm DIVOUT XD5_nm 3.0251e-17
* device instance cc_DIVOUT_XD5_nt r0 *1 0,0
Ccc_DIVOUT_XD5_nt DIVOUT XD5_nt 2.4201e-17
* device instance cc_DIVOUT_XD5_t1 r0 *1 0,0
Ccc_DIVOUT_XD5_t1 DIVOUT XD5_t1 1.8151e-17
* device instance cc_DIVOUT_XFRT_CLKB r0 *1 0,0
Ccc_DIVOUT_XFRT_CLKB DIVOUT XFRT_CLKB 2.4201e-17
* device instance cc_DIVOUT_XFRT_M r0 *1 0,0
Ccc_DIVOUT_XFRT_M DIVOUT XFRT_M 3.4688e-17
* device instance cc_DIVOUT_XFRT_MB r0 *1 0,0
Ccc_DIVOUT_XFRT_MB DIVOUT XFRT_MB 1.21e-17
* device instance cc_DIVOUT_XFRT_S r0 *1 0,0
Ccc_DIVOUT_XFRT_S DIVOUT XFRT_S 1.8151e-17
* device instance cc_DIVOUT_XFRT_SB r0 *1 0,0
Ccc_DIVOUT_XFRT_SB DIVOUT XFRT_SB 1.8151e-17
* device instance cc_DIVOUT_ck1 r0 *1 0,0
Ccc_DIVOUT_ck1 DIVOUT ck1 5.4452e-17
* device instance cc_DIVOUT_ck2 r0 *1 0,0
Ccc_DIVOUT_ck2 DIVOUT ck2 5.4452e-17
* device instance cc_DIVOUT_ck3 r0 *1 0,0
Ccc_DIVOUT_ck3 DIVOUT ck3 5.4452e-17
* device instance cc_DIVOUT_ck4 r0 *1 0,0
Ccc_DIVOUT_ck4 DIVOUT ck4 5.4452e-17
* device instance cc_DIVOUT_ck5 r0 *1 0,0
Ccc_DIVOUT_ck5 DIVOUT ck5 9.0754e-17
* device instance cc_DIVOUT_mod0 r0 *1 0,0
Ccc_DIVOUT_mod0 DIVOUT mod0 2.4201e-17
* device instance cc_DIVOUT_mod1 r0 *1 0,0
Ccc_DIVOUT_mod1 DIVOUT mod1 2.4201e-17
* device instance cc_DIVOUT_mod2 r0 *1 0,0
Ccc_DIVOUT_mod2 DIVOUT mod2 2.4201e-17
* device instance cc_DIVOUT_mod3 r0 *1 0,0
Ccc_DIVOUT_mod3 DIVOUT mod3 2.4201e-17
* device instance cc_DIVOUT_mod4 r0 *1 0,0
Ccc_DIVOUT_mod4 DIVOUT mod4 3.0251e-17
* device instance cc_DIVOUT_net1 r0 *1 0,0
Ccc_DIVOUT_net1 DIVOUT net1 1.21e-17
* device instance cc_FB_P0 r0 *1 0,0
Ccc_FB_P0 FB P0 6.05e-18
* device instance cc_FB_P1 r0 *1 0,0
Ccc_FB_P1 FB P1 6.05e-18
* device instance cc_FB_P2 r0 *1 0,0
Ccc_FB_P2 FB P2 6.05e-18
* device instance cc_FB_P3 r0 *1 0,0
Ccc_FB_P3 FB P3 6.05e-18
* device instance cc_FB_P4 r0 *1 0,0
Ccc_FB_P4 FB P4 6.05e-18
* device instance cc_FB_P5 r0 *1 0,0
Ccc_FB_P5 FB P5 6.05e-18
* device instance cc_FB_VDD_DIV r0 *1 0,0
Ccc_FB_VDD_DIV FB VDD_DIV 6.28419e-16
* device instance cc_FB_VSS r0 *1 0,0
Ccc_FB_VSS FB VSS 5.244e-18
* device instance cc_FB_XD0_XDFFM_CLKB r0 *1 0,0
Ccc_FB_XD0_XDFFM_CLKB FB XD0_XDFFM_CLKB 1.8151e-17
* device instance cc_FB_XD0_XDFFM_M r0 *1 0,0
Ccc_FB_XD0_XDFFM_M FB XD0_XDFFM_M 2.4201e-17
* device instance cc_FB_XD0_XDFFM_MB r0 *1 0,0
Ccc_FB_XD0_XDFFM_MB FB XD0_XDFFM_MB 1.21e-17
* device instance cc_FB_XD0_XDFFM_S r0 *1 0,0
Ccc_FB_XD0_XDFFM_S FB XD0_XDFFM_S 1.8151e-17
* device instance cc_FB_XD0_XDFFM_SB r0 *1 0,0
Ccc_FB_XD0_XDFFM_SB FB XD0_XDFFM_SB 1.8151e-17
* device instance cc_FB_XD0_XDFFQ_CLKB r0 *1 0,0
Ccc_FB_XD0_XDFFQ_CLKB FB XD0_XDFFQ_CLKB 1.8151e-17
* device instance cc_FB_XD0_XDFFQ_M r0 *1 0,0
Ccc_FB_XD0_XDFFQ_M FB XD0_XDFFQ_M 2.4201e-17
* device instance cc_FB_XD0_XDFFQ_MB r0 *1 0,0
Ccc_FB_XD0_XDFFQ_MB FB XD0_XDFFQ_MB 1.21e-17
* device instance cc_FB_XD0_XDFFQ_S r0 *1 0,0
Ccc_FB_XD0_XDFFQ_S FB XD0_XDFFQ_S 1.8151e-17
* device instance cc_FB_XD0_XDFFQ_SB r0 *1 0,0
Ccc_FB_XD0_XDFFQ_SB FB XD0_XDFFQ_SB 1.8151e-17
* device instance cc_FB_XD0_XNOR_midp r0 *1 0,0
Ccc_FB_XD0_XNOR_midp FB XD0_XNOR_midp 1.21e-17
* device instance cc_FB_XD0_dmodout r0 *1 0,0
Ccc_FB_XD0_dmodout FB XD0_dmodout 1.21e-17
* device instance cc_FB_XD0_dq r0 *1 0,0
Ccc_FB_XD0_dq FB XD0_dq 1.21e-17
* device instance cc_FB_XD0_nm r0 *1 0,0
Ccc_FB_XD0_nm FB XD0_nm 1.8151e-17
* device instance cc_FB_XD0_nt r0 *1 0,0
Ccc_FB_XD0_nt FB XD0_nt 2.4201e-17
* device instance cc_FB_XD0_t1 r0 *1 0,0
Ccc_FB_XD0_t1 FB XD0_t1 1.21e-17
* device instance cc_FB_XD1_XDFFM_CLKB r0 *1 0,0
Ccc_FB_XD1_XDFFM_CLKB FB XD1_XDFFM_CLKB 1.8151e-17
* device instance cc_FB_XD1_XDFFM_M r0 *1 0,0
Ccc_FB_XD1_XDFFM_M FB XD1_XDFFM_M 2.4201e-17
* device instance cc_FB_XD1_XDFFM_MB r0 *1 0,0
Ccc_FB_XD1_XDFFM_MB FB XD1_XDFFM_MB 1.21e-17
* device instance cc_FB_XD1_XDFFM_S r0 *1 0,0
Ccc_FB_XD1_XDFFM_S FB XD1_XDFFM_S 1.8151e-17
* device instance cc_FB_XD1_XDFFM_SB r0 *1 0,0
Ccc_FB_XD1_XDFFM_SB FB XD1_XDFFM_SB 1.8151e-17
* device instance cc_FB_XD1_XDFFQ_CLKB r0 *1 0,0
Ccc_FB_XD1_XDFFQ_CLKB FB XD1_XDFFQ_CLKB 1.8151e-17
* device instance cc_FB_XD1_XDFFQ_M r0 *1 0,0
Ccc_FB_XD1_XDFFQ_M FB XD1_XDFFQ_M 2.4201e-17
* device instance cc_FB_XD1_XDFFQ_MB r0 *1 0,0
Ccc_FB_XD1_XDFFQ_MB FB XD1_XDFFQ_MB 1.21e-17
* device instance cc_FB_XD1_XDFFQ_S r0 *1 0,0
Ccc_FB_XD1_XDFFQ_S FB XD1_XDFFQ_S 1.8151e-17
* device instance cc_FB_XD1_XDFFQ_SB r0 *1 0,0
Ccc_FB_XD1_XDFFQ_SB FB XD1_XDFFQ_SB 1.8151e-17
* device instance cc_FB_XD1_XNOR_midp r0 *1 0,0
Ccc_FB_XD1_XNOR_midp FB XD1_XNOR_midp 1.21e-17
* device instance cc_FB_XD1_dmodout r0 *1 0,0
Ccc_FB_XD1_dmodout FB XD1_dmodout 1.21e-17
* device instance cc_FB_XD1_dq r0 *1 0,0
Ccc_FB_XD1_dq FB XD1_dq 1.21e-17
* device instance cc_FB_XD1_nm r0 *1 0,0
Ccc_FB_XD1_nm FB XD1_nm 1.8151e-17
* device instance cc_FB_XD1_nt r0 *1 0,0
Ccc_FB_XD1_nt FB XD1_nt 2.4201e-17
* device instance cc_FB_XD1_t1 r0 *1 0,0
Ccc_FB_XD1_t1 FB XD1_t1 1.21e-17
* device instance cc_FB_XD2_XDFFM_CLKB r0 *1 0,0
Ccc_FB_XD2_XDFFM_CLKB FB XD2_XDFFM_CLKB 1.8151e-17
* device instance cc_FB_XD2_XDFFM_M r0 *1 0,0
Ccc_FB_XD2_XDFFM_M FB XD2_XDFFM_M 2.4201e-17
* device instance cc_FB_XD2_XDFFM_MB r0 *1 0,0
Ccc_FB_XD2_XDFFM_MB FB XD2_XDFFM_MB 1.21e-17
* device instance cc_FB_XD2_XDFFM_S r0 *1 0,0
Ccc_FB_XD2_XDFFM_S FB XD2_XDFFM_S 1.8151e-17
* device instance cc_FB_XD2_XDFFM_SB r0 *1 0,0
Ccc_FB_XD2_XDFFM_SB FB XD2_XDFFM_SB 1.8151e-17
* device instance cc_FB_XD2_XDFFQ_CLKB r0 *1 0,0
Ccc_FB_XD2_XDFFQ_CLKB FB XD2_XDFFQ_CLKB 1.8151e-17
* device instance cc_FB_XD2_XDFFQ_M r0 *1 0,0
Ccc_FB_XD2_XDFFQ_M FB XD2_XDFFQ_M 2.4201e-17
* device instance cc_FB_XD2_XDFFQ_MB r0 *1 0,0
Ccc_FB_XD2_XDFFQ_MB FB XD2_XDFFQ_MB 1.21e-17
* device instance cc_FB_XD2_XDFFQ_S r0 *1 0,0
Ccc_FB_XD2_XDFFQ_S FB XD2_XDFFQ_S 1.8151e-17
* device instance cc_FB_XD2_XDFFQ_SB r0 *1 0,0
Ccc_FB_XD2_XDFFQ_SB FB XD2_XDFFQ_SB 1.8151e-17
* device instance cc_FB_XD2_XNOR_midp r0 *1 0,0
Ccc_FB_XD2_XNOR_midp FB XD2_XNOR_midp 1.21e-17
* device instance cc_FB_XD2_dmodout r0 *1 0,0
Ccc_FB_XD2_dmodout FB XD2_dmodout 1.21e-17
* device instance cc_FB_XD2_dq r0 *1 0,0
Ccc_FB_XD2_dq FB XD2_dq 1.21e-17
* device instance cc_FB_XD2_nm r0 *1 0,0
Ccc_FB_XD2_nm FB XD2_nm 1.8151e-17
* device instance cc_FB_XD2_nt r0 *1 0,0
Ccc_FB_XD2_nt FB XD2_nt 2.4201e-17
* device instance cc_FB_XD2_t1 r0 *1 0,0
Ccc_FB_XD2_t1 FB XD2_t1 1.21e-17
* device instance cc_FB_XD3_XDFFM_CLKB r0 *1 0,0
Ccc_FB_XD3_XDFFM_CLKB FB XD3_XDFFM_CLKB 1.8151e-17
* device instance cc_FB_XD3_XDFFM_M r0 *1 0,0
Ccc_FB_XD3_XDFFM_M FB XD3_XDFFM_M 2.4201e-17
* device instance cc_FB_XD3_XDFFM_MB r0 *1 0,0
Ccc_FB_XD3_XDFFM_MB FB XD3_XDFFM_MB 1.21e-17
* device instance cc_FB_XD3_XDFFM_S r0 *1 0,0
Ccc_FB_XD3_XDFFM_S FB XD3_XDFFM_S 1.8151e-17
* device instance cc_FB_XD3_XDFFM_SB r0 *1 0,0
Ccc_FB_XD3_XDFFM_SB FB XD3_XDFFM_SB 1.8151e-17
* device instance cc_FB_XD3_XDFFQ_CLKB r0 *1 0,0
Ccc_FB_XD3_XDFFQ_CLKB FB XD3_XDFFQ_CLKB 1.8151e-17
* device instance cc_FB_XD3_XDFFQ_M r0 *1 0,0
Ccc_FB_XD3_XDFFQ_M FB XD3_XDFFQ_M 2.4201e-17
* device instance cc_FB_XD3_XDFFQ_MB r0 *1 0,0
Ccc_FB_XD3_XDFFQ_MB FB XD3_XDFFQ_MB 1.21e-17
* device instance cc_FB_XD3_XDFFQ_S r0 *1 0,0
Ccc_FB_XD3_XDFFQ_S FB XD3_XDFFQ_S 1.8151e-17
* device instance cc_FB_XD3_XDFFQ_SB r0 *1 0,0
Ccc_FB_XD3_XDFFQ_SB FB XD3_XDFFQ_SB 1.8151e-17
* device instance cc_FB_XD3_XNOR_midp r0 *1 0,0
Ccc_FB_XD3_XNOR_midp FB XD3_XNOR_midp 1.21e-17
* device instance cc_FB_XD3_dmodout r0 *1 0,0
Ccc_FB_XD3_dmodout FB XD3_dmodout 1.21e-17
* device instance cc_FB_XD3_dq r0 *1 0,0
Ccc_FB_XD3_dq FB XD3_dq 1.21e-17
* device instance cc_FB_XD3_nm r0 *1 0,0
Ccc_FB_XD3_nm FB XD3_nm 1.8151e-17
* device instance cc_FB_XD3_nt r0 *1 0,0
Ccc_FB_XD3_nt FB XD3_nt 2.4201e-17
* device instance cc_FB_XD3_t1 r0 *1 0,0
Ccc_FB_XD3_t1 FB XD3_t1 1.21e-17
* device instance cc_FB_XD4_XDFFM_CLKB r0 *1 0,0
Ccc_FB_XD4_XDFFM_CLKB FB XD4_XDFFM_CLKB 1.8151e-17
* device instance cc_FB_XD4_XDFFM_M r0 *1 0,0
Ccc_FB_XD4_XDFFM_M FB XD4_XDFFM_M 2.4201e-17
* device instance cc_FB_XD4_XDFFM_MB r0 *1 0,0
Ccc_FB_XD4_XDFFM_MB FB XD4_XDFFM_MB 1.21e-17
* device instance cc_FB_XD4_XDFFM_S r0 *1 0,0
Ccc_FB_XD4_XDFFM_S FB XD4_XDFFM_S 1.8151e-17
* device instance cc_FB_XD4_XDFFM_SB r0 *1 0,0
Ccc_FB_XD4_XDFFM_SB FB XD4_XDFFM_SB 1.8151e-17
* device instance cc_FB_XD4_XDFFQ_CLKB r0 *1 0,0
Ccc_FB_XD4_XDFFQ_CLKB FB XD4_XDFFQ_CLKB 1.8151e-17
* device instance cc_FB_XD4_XDFFQ_M r0 *1 0,0
Ccc_FB_XD4_XDFFQ_M FB XD4_XDFFQ_M 2.4201e-17
* device instance cc_FB_XD4_XDFFQ_MB r0 *1 0,0
Ccc_FB_XD4_XDFFQ_MB FB XD4_XDFFQ_MB 1.21e-17
* device instance cc_FB_XD4_XDFFQ_S r0 *1 0,0
Ccc_FB_XD4_XDFFQ_S FB XD4_XDFFQ_S 1.8151e-17
* device instance cc_FB_XD4_XDFFQ_SB r0 *1 0,0
Ccc_FB_XD4_XDFFQ_SB FB XD4_XDFFQ_SB 1.8151e-17
* device instance cc_FB_XD4_XNOR_midp r0 *1 0,0
Ccc_FB_XD4_XNOR_midp FB XD4_XNOR_midp 1.21e-17
* device instance cc_FB_XD4_dmodout r0 *1 0,0
Ccc_FB_XD4_dmodout FB XD4_dmodout 1.21e-17
* device instance cc_FB_XD4_dq r0 *1 0,0
Ccc_FB_XD4_dq FB XD4_dq 1.21e-17
* device instance cc_FB_XD4_nm r0 *1 0,0
Ccc_FB_XD4_nm FB XD4_nm 1.8151e-17
* device instance cc_FB_XD4_nt r0 *1 0,0
Ccc_FB_XD4_nt FB XD4_nt 2.4201e-17
* device instance cc_FB_XD4_t1 r0 *1 0,0
Ccc_FB_XD4_t1 FB XD4_t1 1.21e-17
* device instance cc_FB_XD5_XDFFM_CLKB r0 *1 0,0
Ccc_FB_XD5_XDFFM_CLKB FB XD5_XDFFM_CLKB 1.8151e-17
* device instance cc_FB_XD5_XDFFM_M r0 *1 0,0
Ccc_FB_XD5_XDFFM_M FB XD5_XDFFM_M 2.4201e-17
* device instance cc_FB_XD5_XDFFM_MB r0 *1 0,0
Ccc_FB_XD5_XDFFM_MB FB XD5_XDFFM_MB 1.21e-17
* device instance cc_FB_XD5_XDFFM_S r0 *1 0,0
Ccc_FB_XD5_XDFFM_S FB XD5_XDFFM_S 1.8151e-17
* device instance cc_FB_XD5_XDFFM_SB r0 *1 0,0
Ccc_FB_XD5_XDFFM_SB FB XD5_XDFFM_SB 1.8151e-17
* device instance cc_FB_XD5_XDFFQ_CLKB r0 *1 0,0
Ccc_FB_XD5_XDFFQ_CLKB FB XD5_XDFFQ_CLKB 1.8151e-17
* device instance cc_FB_XD5_XDFFQ_M r0 *1 0,0
Ccc_FB_XD5_XDFFQ_M FB XD5_XDFFQ_M 2.4201e-17
* device instance cc_FB_XD5_XDFFQ_MB r0 *1 0,0
Ccc_FB_XD5_XDFFQ_MB FB XD5_XDFFQ_MB 1.21e-17
* device instance cc_FB_XD5_XDFFQ_S r0 *1 0,0
Ccc_FB_XD5_XDFFQ_S FB XD5_XDFFQ_S 1.8151e-17
* device instance cc_FB_XD5_XDFFQ_SB r0 *1 0,0
Ccc_FB_XD5_XDFFQ_SB FB XD5_XDFFQ_SB 1.8151e-17
* device instance cc_FB_XD5_XNOR_midp r0 *1 0,0
Ccc_FB_XD5_XNOR_midp FB XD5_XNOR_midp 1.21e-17
* device instance cc_FB_XD5_dmodout r0 *1 0,0
Ccc_FB_XD5_dmodout FB XD5_dmodout 1.21e-17
* device instance cc_FB_XD5_dq r0 *1 0,0
Ccc_FB_XD5_dq FB XD5_dq 1.21e-17
* device instance cc_FB_XD5_nm r0 *1 0,0
Ccc_FB_XD5_nm FB XD5_nm 1.8151e-17
* device instance cc_FB_XD5_nt r0 *1 0,0
Ccc_FB_XD5_nt FB XD5_nt 2.4201e-17
* device instance cc_FB_XD5_t1 r0 *1 0,0
Ccc_FB_XD5_t1 FB XD5_t1 1.21e-17
* device instance cc_FB_XFRT_CLKB r0 *1 0,0
Ccc_FB_XFRT_CLKB FB XFRT_CLKB 1.8151e-17
* device instance cc_FB_XFRT_M r0 *1 0,0
Ccc_FB_XFRT_M FB XFRT_M 2.4201e-17
* device instance cc_FB_XFRT_MB r0 *1 0,0
Ccc_FB_XFRT_MB FB XFRT_MB 1.21e-17
* device instance cc_FB_XFRT_S r0 *1 0,0
Ccc_FB_XFRT_S FB XFRT_S 1.8151e-17
* device instance cc_FB_XFRT_SB r0 *1 0,0
Ccc_FB_XFRT_SB FB XFRT_SB 1.8151e-17
* device instance cc_FB_ck1 r0 *1 0,0
Ccc_FB_ck1 FB ck1 5.4452e-17
* device instance cc_FB_ck2 r0 *1 0,0
Ccc_FB_ck2 FB ck2 5.4452e-17
* device instance cc_FB_ck3 r0 *1 0,0
Ccc_FB_ck3 FB ck3 5.4452e-17
* device instance cc_FB_ck4 r0 *1 0,0
Ccc_FB_ck4 FB ck4 5.4452e-17
* device instance cc_FB_ck5 r0 *1 0,0
Ccc_FB_ck5 FB ck5 5.4452e-17
* device instance cc_FB_mod0 r0 *1 0,0
Ccc_FB_mod0 FB mod0 2.4201e-17
* device instance cc_FB_mod1 r0 *1 0,0
Ccc_FB_mod1 FB mod1 2.4201e-17
* device instance cc_FB_mod2 r0 *1 0,0
Ccc_FB_mod2 FB mod2 2.4201e-17
* device instance cc_FB_mod3 r0 *1 0,0
Ccc_FB_mod3 FB mod3 2.4201e-17
* device instance cc_FB_mod4 r0 *1 0,0
Ccc_FB_mod4 FB mod4 2.4201e-17
* device instance cc_FB_net1 r0 *1 0,0
Ccc_FB_net1 FB net1 1.21e-17
* device instance cc_P0_P1 r0 *1 0,0
Ccc_P0_P1 P0 P1 6.05e-18
* device instance cc_P0_P2 r0 *1 0,0
Ccc_P0_P2 P0 P2 6.05e-18
* device instance cc_P0_P3 r0 *1 0,0
Ccc_P0_P3 P0 P3 6.05e-18
* device instance cc_P0_P4 r0 *1 0,0
Ccc_P0_P4 P0 P4 6.05e-18
* device instance cc_P0_P5 r0 *1 0,0
Ccc_P0_P5 P0 P5 6.05e-18
* device instance cc_P0_VDD_DIV r0 *1 0,0
Ccc_P0_VDD_DIV P0 VDD_DIV 2.4201e-17
* device instance cc_P0_VSS r0 *1 0,0
Ccc_P0_VSS P0 VSS 5.32422e-16
* device instance cc_P0_XD0_XDFFM_CLKB r0 *1 0,0
Ccc_P0_XD0_XDFFM_CLKB P0 XD0_XDFFM_CLKB 1.8151e-17
* device instance cc_P0_XD0_XDFFM_M r0 *1 0,0
Ccc_P0_XD0_XDFFM_M P0 XD0_XDFFM_M 2.4201e-17
* device instance cc_P0_XD0_XDFFM_MB r0 *1 0,0
Ccc_P0_XD0_XDFFM_MB P0 XD0_XDFFM_MB 1.21e-17
* device instance cc_P0_XD0_XDFFM_S r0 *1 0,0
Ccc_P0_XD0_XDFFM_S P0 XD0_XDFFM_S 1.8151e-17
* device instance cc_P0_XD0_XDFFM_SB r0 *1 0,0
Ccc_P0_XD0_XDFFM_SB P0 XD0_XDFFM_SB 1.8151e-17
* device instance cc_P0_XD0_XDFFQ_CLKB r0 *1 0,0
Ccc_P0_XD0_XDFFQ_CLKB P0 XD0_XDFFQ_CLKB 1.8151e-17
* device instance cc_P0_XD0_XDFFQ_M r0 *1 0,0
Ccc_P0_XD0_XDFFQ_M P0 XD0_XDFFQ_M 2.4201e-17
* device instance cc_P0_XD0_XDFFQ_MB r0 *1 0,0
Ccc_P0_XD0_XDFFQ_MB P0 XD0_XDFFQ_MB 1.21e-17
* device instance cc_P0_XD0_XDFFQ_S r0 *1 0,0
Ccc_P0_XD0_XDFFQ_S P0 XD0_XDFFQ_S 1.8151e-17
* device instance cc_P0_XD0_XDFFQ_SB r0 *1 0,0
Ccc_P0_XD0_XDFFQ_SB P0 XD0_XDFFQ_SB 1.8151e-17
* device instance cc_P0_XD0_XN2_mid1 r0 *1 0,0
Ccc_P0_XD0_XN2_mid1 P0 XD0_XN2_mid1 1.21e-17
* device instance cc_P0_XD0_XN3_mid1 r0 *1 0,0
Ccc_P0_XD0_XN3_mid1 P0 XD0_XN3_mid1 6.05e-18
* device instance cc_P0_XD0_XN3_mid2 r0 *1 0,0
Ccc_P0_XD0_XN3_mid2 P0 XD0_XN3_mid2 1.21e-17
* device instance cc_P0_XD0_dmodout r0 *1 0,0
Ccc_P0_XD0_dmodout P0 XD0_dmodout 1.21e-17
* device instance cc_P0_XD0_dq r0 *1 0,0
Ccc_P0_XD0_dq P0 XD0_dq 1.8151e-17
* device instance cc_P0_XD0_nm r0 *1 0,0
Ccc_P0_XD0_nm P0 XD0_nm 1.21e-17
* device instance cc_P0_XD0_nt r0 *1 0,0
Ccc_P0_XD0_nt P0 XD0_nt 1.21e-17
* device instance cc_P0_XD0_t1 r0 *1 0,0
Ccc_P0_XD0_t1 P0 XD0_t1 1.21e-17
* device instance cc_P0_XD1_XDFFM_CLKB r0 *1 0,0
Ccc_P0_XD1_XDFFM_CLKB P0 XD1_XDFFM_CLKB 1.8151e-17
* device instance cc_P0_XD1_XDFFM_M r0 *1 0,0
Ccc_P0_XD1_XDFFM_M P0 XD1_XDFFM_M 2.4201e-17
* device instance cc_P0_XD1_XDFFM_MB r0 *1 0,0
Ccc_P0_XD1_XDFFM_MB P0 XD1_XDFFM_MB 1.21e-17
* device instance cc_P0_XD1_XDFFM_S r0 *1 0,0
Ccc_P0_XD1_XDFFM_S P0 XD1_XDFFM_S 1.8151e-17
* device instance cc_P0_XD1_XDFFM_SB r0 *1 0,0
Ccc_P0_XD1_XDFFM_SB P0 XD1_XDFFM_SB 1.8151e-17
* device instance cc_P0_XD1_XDFFQ_CLKB r0 *1 0,0
Ccc_P0_XD1_XDFFQ_CLKB P0 XD1_XDFFQ_CLKB 1.8151e-17
* device instance cc_P0_XD1_XDFFQ_M r0 *1 0,0
Ccc_P0_XD1_XDFFQ_M P0 XD1_XDFFQ_M 2.4201e-17
* device instance cc_P0_XD1_XDFFQ_MB r0 *1 0,0
Ccc_P0_XD1_XDFFQ_MB P0 XD1_XDFFQ_MB 1.21e-17
* device instance cc_P0_XD1_XDFFQ_S r0 *1 0,0
Ccc_P0_XD1_XDFFQ_S P0 XD1_XDFFQ_S 1.8151e-17
* device instance cc_P0_XD1_XDFFQ_SB r0 *1 0,0
Ccc_P0_XD1_XDFFQ_SB P0 XD1_XDFFQ_SB 1.8151e-17
* device instance cc_P0_XD1_XN2_mid1 r0 *1 0,0
Ccc_P0_XD1_XN2_mid1 P0 XD1_XN2_mid1 1.21e-17
* device instance cc_P0_XD1_XN3_mid1 r0 *1 0,0
Ccc_P0_XD1_XN3_mid1 P0 XD1_XN3_mid1 1.21e-17
* device instance cc_P0_XD1_XN3_mid2 r0 *1 0,0
Ccc_P0_XD1_XN3_mid2 P0 XD1_XN3_mid2 1.21e-17
* device instance cc_P0_XD1_dmodout r0 *1 0,0
Ccc_P0_XD1_dmodout P0 XD1_dmodout 1.21e-17
* device instance cc_P0_XD1_dq r0 *1 0,0
Ccc_P0_XD1_dq P0 XD1_dq 1.8151e-17
* device instance cc_P0_XD1_nm r0 *1 0,0
Ccc_P0_XD1_nm P0 XD1_nm 1.21e-17
* device instance cc_P0_XD1_nt r0 *1 0,0
Ccc_P0_XD1_nt P0 XD1_nt 1.21e-17
* device instance cc_P0_XD1_t1 r0 *1 0,0
Ccc_P0_XD1_t1 P0 XD1_t1 1.21e-17
* device instance cc_P0_XD2_XDFFM_CLKB r0 *1 0,0
Ccc_P0_XD2_XDFFM_CLKB P0 XD2_XDFFM_CLKB 1.8151e-17
* device instance cc_P0_XD2_XDFFM_M r0 *1 0,0
Ccc_P0_XD2_XDFFM_M P0 XD2_XDFFM_M 2.4201e-17
* device instance cc_P0_XD2_XDFFM_MB r0 *1 0,0
Ccc_P0_XD2_XDFFM_MB P0 XD2_XDFFM_MB 1.21e-17
* device instance cc_P0_XD2_XDFFM_S r0 *1 0,0
Ccc_P0_XD2_XDFFM_S P0 XD2_XDFFM_S 1.8151e-17
* device instance cc_P0_XD2_XDFFM_SB r0 *1 0,0
Ccc_P0_XD2_XDFFM_SB P0 XD2_XDFFM_SB 1.8151e-17
* device instance cc_P0_XD2_XDFFQ_CLKB r0 *1 0,0
Ccc_P0_XD2_XDFFQ_CLKB P0 XD2_XDFFQ_CLKB 1.8151e-17
* device instance cc_P0_XD2_XDFFQ_M r0 *1 0,0
Ccc_P0_XD2_XDFFQ_M P0 XD2_XDFFQ_M 2.4201e-17
* device instance cc_P0_XD2_XDFFQ_MB r0 *1 0,0
Ccc_P0_XD2_XDFFQ_MB P0 XD2_XDFFQ_MB 1.21e-17
* device instance cc_P0_XD2_XDFFQ_S r0 *1 0,0
Ccc_P0_XD2_XDFFQ_S P0 XD2_XDFFQ_S 1.8151e-17
* device instance cc_P0_XD2_XDFFQ_SB r0 *1 0,0
Ccc_P0_XD2_XDFFQ_SB P0 XD2_XDFFQ_SB 1.8151e-17
* device instance cc_P0_XD2_XN2_mid1 r0 *1 0,0
Ccc_P0_XD2_XN2_mid1 P0 XD2_XN2_mid1 1.21e-17
* device instance cc_P0_XD2_XN3_mid1 r0 *1 0,0
Ccc_P0_XD2_XN3_mid1 P0 XD2_XN3_mid1 1.21e-17
* device instance cc_P0_XD2_XN3_mid2 r0 *1 0,0
Ccc_P0_XD2_XN3_mid2 P0 XD2_XN3_mid2 1.21e-17
* device instance cc_P0_XD2_dmodout r0 *1 0,0
Ccc_P0_XD2_dmodout P0 XD2_dmodout 1.21e-17
* device instance cc_P0_XD2_dq r0 *1 0,0
Ccc_P0_XD2_dq P0 XD2_dq 1.8151e-17
* device instance cc_P0_XD2_nm r0 *1 0,0
Ccc_P0_XD2_nm P0 XD2_nm 1.21e-17
* device instance cc_P0_XD2_nt r0 *1 0,0
Ccc_P0_XD2_nt P0 XD2_nt 1.21e-17
* device instance cc_P0_XD2_t1 r0 *1 0,0
Ccc_P0_XD2_t1 P0 XD2_t1 1.21e-17
* device instance cc_P0_XD3_XDFFM_CLKB r0 *1 0,0
Ccc_P0_XD3_XDFFM_CLKB P0 XD3_XDFFM_CLKB 1.8151e-17
* device instance cc_P0_XD3_XDFFM_M r0 *1 0,0
Ccc_P0_XD3_XDFFM_M P0 XD3_XDFFM_M 2.4201e-17
* device instance cc_P0_XD3_XDFFM_MB r0 *1 0,0
Ccc_P0_XD3_XDFFM_MB P0 XD3_XDFFM_MB 1.21e-17
* device instance cc_P0_XD3_XDFFM_S r0 *1 0,0
Ccc_P0_XD3_XDFFM_S P0 XD3_XDFFM_S 1.8151e-17
* device instance cc_P0_XD3_XDFFM_SB r0 *1 0,0
Ccc_P0_XD3_XDFFM_SB P0 XD3_XDFFM_SB 1.8151e-17
* device instance cc_P0_XD3_XDFFQ_CLKB r0 *1 0,0
Ccc_P0_XD3_XDFFQ_CLKB P0 XD3_XDFFQ_CLKB 1.8151e-17
* device instance cc_P0_XD3_XDFFQ_M r0 *1 0,0
Ccc_P0_XD3_XDFFQ_M P0 XD3_XDFFQ_M 2.4201e-17
* device instance cc_P0_XD3_XDFFQ_MB r0 *1 0,0
Ccc_P0_XD3_XDFFQ_MB P0 XD3_XDFFQ_MB 1.21e-17
* device instance cc_P0_XD3_XDFFQ_S r0 *1 0,0
Ccc_P0_XD3_XDFFQ_S P0 XD3_XDFFQ_S 1.8151e-17
* device instance cc_P0_XD3_XDFFQ_SB r0 *1 0,0
Ccc_P0_XD3_XDFFQ_SB P0 XD3_XDFFQ_SB 1.8151e-17
* device instance cc_P0_XD3_XN2_mid1 r0 *1 0,0
Ccc_P0_XD3_XN2_mid1 P0 XD3_XN2_mid1 1.21e-17
* device instance cc_P0_XD3_XN3_mid1 r0 *1 0,0
Ccc_P0_XD3_XN3_mid1 P0 XD3_XN3_mid1 1.21e-17
* device instance cc_P0_XD3_XN3_mid2 r0 *1 0,0
Ccc_P0_XD3_XN3_mid2 P0 XD3_XN3_mid2 1.21e-17
* device instance cc_P0_XD3_dmodout r0 *1 0,0
Ccc_P0_XD3_dmodout P0 XD3_dmodout 1.21e-17
* device instance cc_P0_XD3_dq r0 *1 0,0
Ccc_P0_XD3_dq P0 XD3_dq 1.8151e-17
* device instance cc_P0_XD3_nm r0 *1 0,0
Ccc_P0_XD3_nm P0 XD3_nm 1.21e-17
* device instance cc_P0_XD3_nt r0 *1 0,0
Ccc_P0_XD3_nt P0 XD3_nt 1.21e-17
* device instance cc_P0_XD3_t1 r0 *1 0,0
Ccc_P0_XD3_t1 P0 XD3_t1 1.21e-17
* device instance cc_P0_XD4_XDFFM_CLKB r0 *1 0,0
Ccc_P0_XD4_XDFFM_CLKB P0 XD4_XDFFM_CLKB 1.8151e-17
* device instance cc_P0_XD4_XDFFM_M r0 *1 0,0
Ccc_P0_XD4_XDFFM_M P0 XD4_XDFFM_M 2.4201e-17
* device instance cc_P0_XD4_XDFFM_MB r0 *1 0,0
Ccc_P0_XD4_XDFFM_MB P0 XD4_XDFFM_MB 1.21e-17
* device instance cc_P0_XD4_XDFFM_S r0 *1 0,0
Ccc_P0_XD4_XDFFM_S P0 XD4_XDFFM_S 1.8151e-17
* device instance cc_P0_XD4_XDFFM_SB r0 *1 0,0
Ccc_P0_XD4_XDFFM_SB P0 XD4_XDFFM_SB 1.8151e-17
* device instance cc_P0_XD4_XDFFQ_CLKB r0 *1 0,0
Ccc_P0_XD4_XDFFQ_CLKB P0 XD4_XDFFQ_CLKB 1.8151e-17
* device instance cc_P0_XD4_XDFFQ_M r0 *1 0,0
Ccc_P0_XD4_XDFFQ_M P0 XD4_XDFFQ_M 2.4201e-17
* device instance cc_P0_XD4_XDFFQ_MB r0 *1 0,0
Ccc_P0_XD4_XDFFQ_MB P0 XD4_XDFFQ_MB 1.21e-17
* device instance cc_P0_XD4_XDFFQ_S r0 *1 0,0
Ccc_P0_XD4_XDFFQ_S P0 XD4_XDFFQ_S 1.8151e-17
* device instance cc_P0_XD4_XDFFQ_SB r0 *1 0,0
Ccc_P0_XD4_XDFFQ_SB P0 XD4_XDFFQ_SB 1.8151e-17
* device instance cc_P0_XD4_XN2_mid1 r0 *1 0,0
Ccc_P0_XD4_XN2_mid1 P0 XD4_XN2_mid1 1.21e-17
* device instance cc_P0_XD4_XN3_mid1 r0 *1 0,0
Ccc_P0_XD4_XN3_mid1 P0 XD4_XN3_mid1 1.21e-17
* device instance cc_P0_XD4_XN3_mid2 r0 *1 0,0
Ccc_P0_XD4_XN3_mid2 P0 XD4_XN3_mid2 1.21e-17
* device instance cc_P0_XD4_dmodout r0 *1 0,0
Ccc_P0_XD4_dmodout P0 XD4_dmodout 1.21e-17
* device instance cc_P0_XD4_dq r0 *1 0,0
Ccc_P0_XD4_dq P0 XD4_dq 1.8151e-17
* device instance cc_P0_XD4_nm r0 *1 0,0
Ccc_P0_XD4_nm P0 XD4_nm 1.21e-17
* device instance cc_P0_XD4_nt r0 *1 0,0
Ccc_P0_XD4_nt P0 XD4_nt 1.21e-17
* device instance cc_P0_XD4_t1 r0 *1 0,0
Ccc_P0_XD4_t1 P0 XD4_t1 1.21e-17
* device instance cc_P0_XD5_XDFFM_CLKB r0 *1 0,0
Ccc_P0_XD5_XDFFM_CLKB P0 XD5_XDFFM_CLKB 1.8151e-17
* device instance cc_P0_XD5_XDFFM_M r0 *1 0,0
Ccc_P0_XD5_XDFFM_M P0 XD5_XDFFM_M 2.4201e-17
* device instance cc_P0_XD5_XDFFM_MB r0 *1 0,0
Ccc_P0_XD5_XDFFM_MB P0 XD5_XDFFM_MB 1.21e-17
* device instance cc_P0_XD5_XDFFM_S r0 *1 0,0
Ccc_P0_XD5_XDFFM_S P0 XD5_XDFFM_S 1.8151e-17
* device instance cc_P0_XD5_XDFFM_SB r0 *1 0,0
Ccc_P0_XD5_XDFFM_SB P0 XD5_XDFFM_SB 1.8151e-17
* device instance cc_P0_XD5_XDFFQ_CLKB r0 *1 0,0
Ccc_P0_XD5_XDFFQ_CLKB P0 XD5_XDFFQ_CLKB 1.8151e-17
* device instance cc_P0_XD5_XDFFQ_M r0 *1 0,0
Ccc_P0_XD5_XDFFQ_M P0 XD5_XDFFQ_M 2.4201e-17
* device instance cc_P0_XD5_XDFFQ_MB r0 *1 0,0
Ccc_P0_XD5_XDFFQ_MB P0 XD5_XDFFQ_MB 1.21e-17
* device instance cc_P0_XD5_XDFFQ_S r0 *1 0,0
Ccc_P0_XD5_XDFFQ_S P0 XD5_XDFFQ_S 1.8151e-17
* device instance cc_P0_XD5_XDFFQ_SB r0 *1 0,0
Ccc_P0_XD5_XDFFQ_SB P0 XD5_XDFFQ_SB 1.8151e-17
* device instance cc_P0_XD5_XN2_mid1 r0 *1 0,0
Ccc_P0_XD5_XN2_mid1 P0 XD5_XN2_mid1 1.21e-17
* device instance cc_P0_XD5_XN3_mid1 r0 *1 0,0
Ccc_P0_XD5_XN3_mid1 P0 XD5_XN3_mid1 1.21e-17
* device instance cc_P0_XD5_XN3_mid2 r0 *1 0,0
Ccc_P0_XD5_XN3_mid2 P0 XD5_XN3_mid2 1.21e-17
* device instance cc_P0_XD5_dmodout r0 *1 0,0
Ccc_P0_XD5_dmodout P0 XD5_dmodout 1.21e-17
* device instance cc_P0_XD5_dq r0 *1 0,0
Ccc_P0_XD5_dq P0 XD5_dq 1.8151e-17
* device instance cc_P0_XD5_nm r0 *1 0,0
Ccc_P0_XD5_nm P0 XD5_nm 1.21e-17
* device instance cc_P0_XD5_nt r0 *1 0,0
Ccc_P0_XD5_nt P0 XD5_nt 1.21e-17
* device instance cc_P0_XD5_t1 r0 *1 0,0
Ccc_P0_XD5_t1 P0 XD5_t1 1.21e-17
* device instance cc_P0_XFRT_CLKB r0 *1 0,0
Ccc_P0_XFRT_CLKB P0 XFRT_CLKB 1.8151e-17
* device instance cc_P0_XFRT_M r0 *1 0,0
Ccc_P0_XFRT_M P0 XFRT_M 2.4201e-17
* device instance cc_P0_XFRT_MB r0 *1 0,0
Ccc_P0_XFRT_MB P0 XFRT_MB 1.21e-17
* device instance cc_P0_XFRT_S r0 *1 0,0
Ccc_P0_XFRT_S P0 XFRT_S 1.8151e-17
* device instance cc_P0_XFRT_SB r0 *1 0,0
Ccc_P0_XFRT_SB P0 XFRT_SB 1.8151e-17
* device instance cc_P0_ck1 r0 *1 0,0
Ccc_P0_ck1 P0 ck1 5.4452e-17
* device instance cc_P0_ck2 r0 *1 0,0
Ccc_P0_ck2 P0 ck2 5.4452e-17
* device instance cc_P0_ck3 r0 *1 0,0
Ccc_P0_ck3 P0 ck3 5.4452e-17
* device instance cc_P0_ck4 r0 *1 0,0
Ccc_P0_ck4 P0 ck4 5.4452e-17
* device instance cc_P0_ck5 r0 *1 0,0
Ccc_P0_ck5 P0 ck5 5.4452e-17
* device instance cc_P0_mod0 r0 *1 0,0
Ccc_P0_mod0 P0 mod0 2.4201e-17
* device instance cc_P0_mod1 r0 *1 0,0
Ccc_P0_mod1 P0 mod1 2.4201e-17
* device instance cc_P0_mod2 r0 *1 0,0
Ccc_P0_mod2 P0 mod2 2.4201e-17
* device instance cc_P0_mod3 r0 *1 0,0
Ccc_P0_mod3 P0 mod3 2.4201e-17
* device instance cc_P0_mod4 r0 *1 0,0
Ccc_P0_mod4 P0 mod4 2.4201e-17
* device instance cc_P0_net1 r0 *1 0,0
Ccc_P0_net1 P0 net1 1.21e-17
* device instance cc_P1_P2 r0 *1 0,0
Ccc_P1_P2 P1 P2 6.05e-18
* device instance cc_P1_P3 r0 *1 0,0
Ccc_P1_P3 P1 P3 6.05e-18
* device instance cc_P1_P4 r0 *1 0,0
Ccc_P1_P4 P1 P4 6.05e-18
* device instance cc_P1_P5 r0 *1 0,0
Ccc_P1_P5 P1 P5 6.05e-18
* device instance cc_P1_VDD_DIV r0 *1 0,0
Ccc_P1_VDD_DIV P1 VDD_DIV 1.21005e-16
* device instance cc_P1_VSS r0 *1 0,0
Ccc_P1_VSS P1 VSS 4.47718e-16
* device instance cc_P1_XD0_XDFFM_CLKB r0 *1 0,0
Ccc_P1_XD0_XDFFM_CLKB P1 XD0_XDFFM_CLKB 1.8151e-17
* device instance cc_P1_XD0_XDFFM_M r0 *1 0,0
Ccc_P1_XD0_XDFFM_M P1 XD0_XDFFM_M 2.4201e-17
* device instance cc_P1_XD0_XDFFM_MB r0 *1 0,0
Ccc_P1_XD0_XDFFM_MB P1 XD0_XDFFM_MB 1.21e-17
* device instance cc_P1_XD0_XDFFM_S r0 *1 0,0
Ccc_P1_XD0_XDFFM_S P1 XD0_XDFFM_S 1.8151e-17
* device instance cc_P1_XD0_XDFFM_SB r0 *1 0,0
Ccc_P1_XD0_XDFFM_SB P1 XD0_XDFFM_SB 1.8151e-17
* device instance cc_P1_XD0_XDFFQ_CLKB r0 *1 0,0
Ccc_P1_XD0_XDFFQ_CLKB P1 XD0_XDFFQ_CLKB 1.8151e-17
* device instance cc_P1_XD0_XDFFQ_M r0 *1 0,0
Ccc_P1_XD0_XDFFQ_M P1 XD0_XDFFQ_M 2.4201e-17
* device instance cc_P1_XD0_XDFFQ_MB r0 *1 0,0
Ccc_P1_XD0_XDFFQ_MB P1 XD0_XDFFQ_MB 1.21e-17
* device instance cc_P1_XD0_XDFFQ_S r0 *1 0,0
Ccc_P1_XD0_XDFFQ_S P1 XD0_XDFFQ_S 1.8151e-17
* device instance cc_P1_XD0_XDFFQ_SB r0 *1 0,0
Ccc_P1_XD0_XDFFQ_SB P1 XD0_XDFFQ_SB 1.8151e-17
* device instance cc_P1_XD0_XNOR_midp r0 *1 0,0
Ccc_P1_XD0_XNOR_midp P1 XD0_XNOR_midp 1.21e-17
* device instance cc_P1_XD0_dmodout r0 *1 0,0
Ccc_P1_XD0_dmodout P1 XD0_dmodout 1.21e-17
* device instance cc_P1_XD0_dq r0 *1 0,0
Ccc_P1_XD0_dq P1 XD0_dq 1.21e-17
* device instance cc_P1_XD0_nm r0 *1 0,0
Ccc_P1_XD0_nm P1 XD0_nm 1.8151e-17
* device instance cc_P1_XD0_nt r0 *1 0,0
Ccc_P1_XD0_nt P1 XD0_nt 2.4201e-17
* device instance cc_P1_XD0_t1 r0 *1 0,0
Ccc_P1_XD0_t1 P1 XD0_t1 1.21e-17
* device instance cc_P1_XD1_XDFFM_CLKB r0 *1 0,0
Ccc_P1_XD1_XDFFM_CLKB P1 XD1_XDFFM_CLKB 1.8151e-17
* device instance cc_P1_XD1_XDFFM_M r0 *1 0,0
Ccc_P1_XD1_XDFFM_M P1 XD1_XDFFM_M 2.4201e-17
* device instance cc_P1_XD1_XDFFM_MB r0 *1 0,0
Ccc_P1_XD1_XDFFM_MB P1 XD1_XDFFM_MB 1.21e-17
* device instance cc_P1_XD1_XDFFM_S r0 *1 0,0
Ccc_P1_XD1_XDFFM_S P1 XD1_XDFFM_S 1.8151e-17
* device instance cc_P1_XD1_XDFFM_SB r0 *1 0,0
Ccc_P1_XD1_XDFFM_SB P1 XD1_XDFFM_SB 1.8151e-17
* device instance cc_P1_XD1_XDFFQ_CLKB r0 *1 0,0
Ccc_P1_XD1_XDFFQ_CLKB P1 XD1_XDFFQ_CLKB 1.8151e-17
* device instance cc_P1_XD1_XDFFQ_M r0 *1 0,0
Ccc_P1_XD1_XDFFQ_M P1 XD1_XDFFQ_M 2.4201e-17
* device instance cc_P1_XD1_XDFFQ_MB r0 *1 0,0
Ccc_P1_XD1_XDFFQ_MB P1 XD1_XDFFQ_MB 1.21e-17
* device instance cc_P1_XD1_XDFFQ_S r0 *1 0,0
Ccc_P1_XD1_XDFFQ_S P1 XD1_XDFFQ_S 1.8151e-17
* device instance cc_P1_XD1_XDFFQ_SB r0 *1 0,0
Ccc_P1_XD1_XDFFQ_SB P1 XD1_XDFFQ_SB 1.8151e-17
* device instance cc_P1_XD1_XN2_mid1 r0 *1 0,0
Ccc_P1_XD1_XN2_mid1 P1 XD1_XN2_mid1 1.21e-17
* device instance cc_P1_XD1_XN3_mid1 r0 *1 0,0
Ccc_P1_XD1_XN3_mid1 P1 XD1_XN3_mid1 6.05e-18
* device instance cc_P1_XD1_XN3_mid2 r0 *1 0,0
Ccc_P1_XD1_XN3_mid2 P1 XD1_XN3_mid2 1.21e-17
* device instance cc_P1_XD1_dmodout r0 *1 0,0
Ccc_P1_XD1_dmodout P1 XD1_dmodout 1.21e-17
* device instance cc_P1_XD1_dq r0 *1 0,0
Ccc_P1_XD1_dq P1 XD1_dq 1.8151e-17
* device instance cc_P1_XD1_nm r0 *1 0,0
Ccc_P1_XD1_nm P1 XD1_nm 1.21e-17
* device instance cc_P1_XD1_nt r0 *1 0,0
Ccc_P1_XD1_nt P1 XD1_nt 1.21e-17
* device instance cc_P1_XD1_t1 r0 *1 0,0
Ccc_P1_XD1_t1 P1 XD1_t1 1.21e-17
* device instance cc_P1_XD2_XDFFM_CLKB r0 *1 0,0
Ccc_P1_XD2_XDFFM_CLKB P1 XD2_XDFFM_CLKB 1.8151e-17
* device instance cc_P1_XD2_XDFFM_M r0 *1 0,0
Ccc_P1_XD2_XDFFM_M P1 XD2_XDFFM_M 2.4201e-17
* device instance cc_P1_XD2_XDFFM_MB r0 *1 0,0
Ccc_P1_XD2_XDFFM_MB P1 XD2_XDFFM_MB 1.21e-17
* device instance cc_P1_XD2_XDFFM_S r0 *1 0,0
Ccc_P1_XD2_XDFFM_S P1 XD2_XDFFM_S 1.8151e-17
* device instance cc_P1_XD2_XDFFM_SB r0 *1 0,0
Ccc_P1_XD2_XDFFM_SB P1 XD2_XDFFM_SB 1.8151e-17
* device instance cc_P1_XD2_XDFFQ_CLKB r0 *1 0,0
Ccc_P1_XD2_XDFFQ_CLKB P1 XD2_XDFFQ_CLKB 1.8151e-17
* device instance cc_P1_XD2_XDFFQ_M r0 *1 0,0
Ccc_P1_XD2_XDFFQ_M P1 XD2_XDFFQ_M 2.4201e-17
* device instance cc_P1_XD2_XDFFQ_MB r0 *1 0,0
Ccc_P1_XD2_XDFFQ_MB P1 XD2_XDFFQ_MB 1.21e-17
* device instance cc_P1_XD2_XDFFQ_S r0 *1 0,0
Ccc_P1_XD2_XDFFQ_S P1 XD2_XDFFQ_S 1.8151e-17
* device instance cc_P1_XD2_XDFFQ_SB r0 *1 0,0
Ccc_P1_XD2_XDFFQ_SB P1 XD2_XDFFQ_SB 1.8151e-17
* device instance cc_P1_XD2_XN2_mid1 r0 *1 0,0
Ccc_P1_XD2_XN2_mid1 P1 XD2_XN2_mid1 1.21e-17
* device instance cc_P1_XD2_XN3_mid1 r0 *1 0,0
Ccc_P1_XD2_XN3_mid1 P1 XD2_XN3_mid1 1.21e-17
* device instance cc_P1_XD2_XN3_mid2 r0 *1 0,0
Ccc_P1_XD2_XN3_mid2 P1 XD2_XN3_mid2 1.21e-17
* device instance cc_P1_XD2_dmodout r0 *1 0,0
Ccc_P1_XD2_dmodout P1 XD2_dmodout 1.21e-17
* device instance cc_P1_XD2_dq r0 *1 0,0
Ccc_P1_XD2_dq P1 XD2_dq 1.8151e-17
* device instance cc_P1_XD2_nm r0 *1 0,0
Ccc_P1_XD2_nm P1 XD2_nm 1.21e-17
* device instance cc_P1_XD2_nt r0 *1 0,0
Ccc_P1_XD2_nt P1 XD2_nt 1.21e-17
* device instance cc_P1_XD2_t1 r0 *1 0,0
Ccc_P1_XD2_t1 P1 XD2_t1 1.21e-17
* device instance cc_P1_XD3_XDFFM_CLKB r0 *1 0,0
Ccc_P1_XD3_XDFFM_CLKB P1 XD3_XDFFM_CLKB 1.8151e-17
* device instance cc_P1_XD3_XDFFM_M r0 *1 0,0
Ccc_P1_XD3_XDFFM_M P1 XD3_XDFFM_M 2.4201e-17
* device instance cc_P1_XD3_XDFFM_MB r0 *1 0,0
Ccc_P1_XD3_XDFFM_MB P1 XD3_XDFFM_MB 1.21e-17
* device instance cc_P1_XD3_XDFFM_S r0 *1 0,0
Ccc_P1_XD3_XDFFM_S P1 XD3_XDFFM_S 1.8151e-17
* device instance cc_P1_XD3_XDFFM_SB r0 *1 0,0
Ccc_P1_XD3_XDFFM_SB P1 XD3_XDFFM_SB 1.8151e-17
* device instance cc_P1_XD3_XDFFQ_CLKB r0 *1 0,0
Ccc_P1_XD3_XDFFQ_CLKB P1 XD3_XDFFQ_CLKB 1.8151e-17
* device instance cc_P1_XD3_XDFFQ_M r0 *1 0,0
Ccc_P1_XD3_XDFFQ_M P1 XD3_XDFFQ_M 2.4201e-17
* device instance cc_P1_XD3_XDFFQ_MB r0 *1 0,0
Ccc_P1_XD3_XDFFQ_MB P1 XD3_XDFFQ_MB 1.21e-17
* device instance cc_P1_XD3_XDFFQ_S r0 *1 0,0
Ccc_P1_XD3_XDFFQ_S P1 XD3_XDFFQ_S 1.8151e-17
* device instance cc_P1_XD3_XDFFQ_SB r0 *1 0,0
Ccc_P1_XD3_XDFFQ_SB P1 XD3_XDFFQ_SB 1.8151e-17
* device instance cc_P1_XD3_XN2_mid1 r0 *1 0,0
Ccc_P1_XD3_XN2_mid1 P1 XD3_XN2_mid1 1.21e-17
* device instance cc_P1_XD3_XN3_mid1 r0 *1 0,0
Ccc_P1_XD3_XN3_mid1 P1 XD3_XN3_mid1 1.21e-17
* device instance cc_P1_XD3_XN3_mid2 r0 *1 0,0
Ccc_P1_XD3_XN3_mid2 P1 XD3_XN3_mid2 1.21e-17
* device instance cc_P1_XD3_dmodout r0 *1 0,0
Ccc_P1_XD3_dmodout P1 XD3_dmodout 1.21e-17
* device instance cc_P1_XD3_dq r0 *1 0,0
Ccc_P1_XD3_dq P1 XD3_dq 1.8151e-17
* device instance cc_P1_XD3_nm r0 *1 0,0
Ccc_P1_XD3_nm P1 XD3_nm 1.21e-17
* device instance cc_P1_XD3_nt r0 *1 0,0
Ccc_P1_XD3_nt P1 XD3_nt 1.21e-17
* device instance cc_P1_XD3_t1 r0 *1 0,0
Ccc_P1_XD3_t1 P1 XD3_t1 1.21e-17
* device instance cc_P1_XD4_XDFFM_CLKB r0 *1 0,0
Ccc_P1_XD4_XDFFM_CLKB P1 XD4_XDFFM_CLKB 1.8151e-17
* device instance cc_P1_XD4_XDFFM_M r0 *1 0,0
Ccc_P1_XD4_XDFFM_M P1 XD4_XDFFM_M 2.4201e-17
* device instance cc_P1_XD4_XDFFM_MB r0 *1 0,0
Ccc_P1_XD4_XDFFM_MB P1 XD4_XDFFM_MB 1.21e-17
* device instance cc_P1_XD4_XDFFM_S r0 *1 0,0
Ccc_P1_XD4_XDFFM_S P1 XD4_XDFFM_S 1.8151e-17
* device instance cc_P1_XD4_XDFFM_SB r0 *1 0,0
Ccc_P1_XD4_XDFFM_SB P1 XD4_XDFFM_SB 1.8151e-17
* device instance cc_P1_XD4_XDFFQ_CLKB r0 *1 0,0
Ccc_P1_XD4_XDFFQ_CLKB P1 XD4_XDFFQ_CLKB 1.8151e-17
* device instance cc_P1_XD4_XDFFQ_M r0 *1 0,0
Ccc_P1_XD4_XDFFQ_M P1 XD4_XDFFQ_M 2.4201e-17
* device instance cc_P1_XD4_XDFFQ_MB r0 *1 0,0
Ccc_P1_XD4_XDFFQ_MB P1 XD4_XDFFQ_MB 1.21e-17
* device instance cc_P1_XD4_XDFFQ_S r0 *1 0,0
Ccc_P1_XD4_XDFFQ_S P1 XD4_XDFFQ_S 1.8151e-17
* device instance cc_P1_XD4_XDFFQ_SB r0 *1 0,0
Ccc_P1_XD4_XDFFQ_SB P1 XD4_XDFFQ_SB 1.8151e-17
* device instance cc_P1_XD4_XN2_mid1 r0 *1 0,0
Ccc_P1_XD4_XN2_mid1 P1 XD4_XN2_mid1 1.21e-17
* device instance cc_P1_XD4_XN3_mid1 r0 *1 0,0
Ccc_P1_XD4_XN3_mid1 P1 XD4_XN3_mid1 1.21e-17
* device instance cc_P1_XD4_XN3_mid2 r0 *1 0,0
Ccc_P1_XD4_XN3_mid2 P1 XD4_XN3_mid2 1.21e-17
* device instance cc_P1_XD4_dmodout r0 *1 0,0
Ccc_P1_XD4_dmodout P1 XD4_dmodout 1.21e-17
* device instance cc_P1_XD4_dq r0 *1 0,0
Ccc_P1_XD4_dq P1 XD4_dq 1.8151e-17
* device instance cc_P1_XD4_nm r0 *1 0,0
Ccc_P1_XD4_nm P1 XD4_nm 1.21e-17
* device instance cc_P1_XD4_nt r0 *1 0,0
Ccc_P1_XD4_nt P1 XD4_nt 1.21e-17
* device instance cc_P1_XD4_t1 r0 *1 0,0
Ccc_P1_XD4_t1 P1 XD4_t1 1.21e-17
* device instance cc_P1_XD5_XDFFM_CLKB r0 *1 0,0
Ccc_P1_XD5_XDFFM_CLKB P1 XD5_XDFFM_CLKB 1.8151e-17
* device instance cc_P1_XD5_XDFFM_M r0 *1 0,0
Ccc_P1_XD5_XDFFM_M P1 XD5_XDFFM_M 2.4201e-17
* device instance cc_P1_XD5_XDFFM_MB r0 *1 0,0
Ccc_P1_XD5_XDFFM_MB P1 XD5_XDFFM_MB 1.21e-17
* device instance cc_P1_XD5_XDFFM_S r0 *1 0,0
Ccc_P1_XD5_XDFFM_S P1 XD5_XDFFM_S 1.8151e-17
* device instance cc_P1_XD5_XDFFM_SB r0 *1 0,0
Ccc_P1_XD5_XDFFM_SB P1 XD5_XDFFM_SB 1.8151e-17
* device instance cc_P1_XD5_XDFFQ_CLKB r0 *1 0,0
Ccc_P1_XD5_XDFFQ_CLKB P1 XD5_XDFFQ_CLKB 1.8151e-17
* device instance cc_P1_XD5_XDFFQ_M r0 *1 0,0
Ccc_P1_XD5_XDFFQ_M P1 XD5_XDFFQ_M 2.4201e-17
* device instance cc_P1_XD5_XDFFQ_MB r0 *1 0,0
Ccc_P1_XD5_XDFFQ_MB P1 XD5_XDFFQ_MB 1.21e-17
* device instance cc_P1_XD5_XDFFQ_S r0 *1 0,0
Ccc_P1_XD5_XDFFQ_S P1 XD5_XDFFQ_S 1.8151e-17
* device instance cc_P1_XD5_XDFFQ_SB r0 *1 0,0
Ccc_P1_XD5_XDFFQ_SB P1 XD5_XDFFQ_SB 1.8151e-17
* device instance cc_P1_XD5_XN2_mid1 r0 *1 0,0
Ccc_P1_XD5_XN2_mid1 P1 XD5_XN2_mid1 1.21e-17
* device instance cc_P1_XD5_XN3_mid1 r0 *1 0,0
Ccc_P1_XD5_XN3_mid1 P1 XD5_XN3_mid1 1.21e-17
* device instance cc_P1_XD5_XN3_mid2 r0 *1 0,0
Ccc_P1_XD5_XN3_mid2 P1 XD5_XN3_mid2 1.21e-17
* device instance cc_P1_XD5_dmodout r0 *1 0,0
Ccc_P1_XD5_dmodout P1 XD5_dmodout 1.21e-17
* device instance cc_P1_XD5_dq r0 *1 0,0
Ccc_P1_XD5_dq P1 XD5_dq 1.8151e-17
* device instance cc_P1_XD5_nm r0 *1 0,0
Ccc_P1_XD5_nm P1 XD5_nm 1.21e-17
* device instance cc_P1_XD5_nt r0 *1 0,0
Ccc_P1_XD5_nt P1 XD5_nt 1.21e-17
* device instance cc_P1_XD5_t1 r0 *1 0,0
Ccc_P1_XD5_t1 P1 XD5_t1 1.21e-17
* device instance cc_P1_XFRT_CLKB r0 *1 0,0
Ccc_P1_XFRT_CLKB P1 XFRT_CLKB 1.8151e-17
* device instance cc_P1_XFRT_M r0 *1 0,0
Ccc_P1_XFRT_M P1 XFRT_M 2.4201e-17
* device instance cc_P1_XFRT_MB r0 *1 0,0
Ccc_P1_XFRT_MB P1 XFRT_MB 1.21e-17
* device instance cc_P1_XFRT_S r0 *1 0,0
Ccc_P1_XFRT_S P1 XFRT_S 1.8151e-17
* device instance cc_P1_XFRT_SB r0 *1 0,0
Ccc_P1_XFRT_SB P1 XFRT_SB 1.8151e-17
* device instance cc_P1_ck1 r0 *1 0,0
Ccc_P1_ck1 P1 ck1 5.4452e-17
* device instance cc_P1_ck2 r0 *1 0,0
Ccc_P1_ck2 P1 ck2 5.4452e-17
* device instance cc_P1_ck3 r0 *1 0,0
Ccc_P1_ck3 P1 ck3 5.4452e-17
* device instance cc_P1_ck4 r0 *1 0,0
Ccc_P1_ck4 P1 ck4 5.4452e-17
* device instance cc_P1_ck5 r0 *1 0,0
Ccc_P1_ck5 P1 ck5 5.4452e-17
* device instance cc_P1_mod0 r0 *1 0,0
Ccc_P1_mod0 P1 mod0 2.4201e-17
* device instance cc_P1_mod1 r0 *1 0,0
Ccc_P1_mod1 P1 mod1 2.4201e-17
* device instance cc_P1_mod2 r0 *1 0,0
Ccc_P1_mod2 P1 mod2 2.4201e-17
* device instance cc_P1_mod3 r0 *1 0,0
Ccc_P1_mod3 P1 mod3 2.4201e-17
* device instance cc_P1_mod4 r0 *1 0,0
Ccc_P1_mod4 P1 mod4 2.4201e-17
* device instance cc_P1_net1 r0 *1 0,0
Ccc_P1_net1 P1 net1 1.21e-17
* device instance cc_P2_P3 r0 *1 0,0
Ccc_P2_P3 P2 P3 6.05e-18
* device instance cc_P2_P4 r0 *1 0,0
Ccc_P2_P4 P2 P4 6.05e-18
* device instance cc_P2_P5 r0 *1 0,0
Ccc_P2_P5 P2 P5 6.05e-18
* device instance cc_P2_VDD_DIV r0 *1 0,0
Ccc_P2_VDD_DIV P2 VDD_DIV 2.17809e-16
* device instance cc_P2_VSS r0 *1 0,0
Ccc_P2_VSS P2 VSS 3.63015e-16
* device instance cc_P2_XD0_XDFFM_CLKB r0 *1 0,0
Ccc_P2_XD0_XDFFM_CLKB P2 XD0_XDFFM_CLKB 1.8151e-17
* device instance cc_P2_XD0_XDFFM_M r0 *1 0,0
Ccc_P2_XD0_XDFFM_M P2 XD0_XDFFM_M 2.4201e-17
* device instance cc_P2_XD0_XDFFM_MB r0 *1 0,0
Ccc_P2_XD0_XDFFM_MB P2 XD0_XDFFM_MB 1.21e-17
* device instance cc_P2_XD0_XDFFM_S r0 *1 0,0
Ccc_P2_XD0_XDFFM_S P2 XD0_XDFFM_S 1.8151e-17
* device instance cc_P2_XD0_XDFFM_SB r0 *1 0,0
Ccc_P2_XD0_XDFFM_SB P2 XD0_XDFFM_SB 1.8151e-17
* device instance cc_P2_XD0_XDFFQ_CLKB r0 *1 0,0
Ccc_P2_XD0_XDFFQ_CLKB P2 XD0_XDFFQ_CLKB 1.8151e-17
* device instance cc_P2_XD0_XDFFQ_M r0 *1 0,0
Ccc_P2_XD0_XDFFQ_M P2 XD0_XDFFQ_M 2.4201e-17
* device instance cc_P2_XD0_XDFFQ_MB r0 *1 0,0
Ccc_P2_XD0_XDFFQ_MB P2 XD0_XDFFQ_MB 1.21e-17
* device instance cc_P2_XD0_XDFFQ_S r0 *1 0,0
Ccc_P2_XD0_XDFFQ_S P2 XD0_XDFFQ_S 1.8151e-17
* device instance cc_P2_XD0_XDFFQ_SB r0 *1 0,0
Ccc_P2_XD0_XDFFQ_SB P2 XD0_XDFFQ_SB 1.8151e-17
* device instance cc_P2_XD0_XNOR_midp r0 *1 0,0
Ccc_P2_XD0_XNOR_midp P2 XD0_XNOR_midp 1.21e-17
* device instance cc_P2_XD0_dmodout r0 *1 0,0
Ccc_P2_XD0_dmodout P2 XD0_dmodout 1.21e-17
* device instance cc_P2_XD0_dq r0 *1 0,0
Ccc_P2_XD0_dq P2 XD0_dq 1.21e-17
* device instance cc_P2_XD0_nm r0 *1 0,0
Ccc_P2_XD0_nm P2 XD0_nm 1.8151e-17
* device instance cc_P2_XD0_nt r0 *1 0,0
Ccc_P2_XD0_nt P2 XD0_nt 2.4201e-17
* device instance cc_P2_XD0_t1 r0 *1 0,0
Ccc_P2_XD0_t1 P2 XD0_t1 1.21e-17
* device instance cc_P2_XD1_XDFFM_CLKB r0 *1 0,0
Ccc_P2_XD1_XDFFM_CLKB P2 XD1_XDFFM_CLKB 1.8151e-17
* device instance cc_P2_XD1_XDFFM_M r0 *1 0,0
Ccc_P2_XD1_XDFFM_M P2 XD1_XDFFM_M 2.4201e-17
* device instance cc_P2_XD1_XDFFM_MB r0 *1 0,0
Ccc_P2_XD1_XDFFM_MB P2 XD1_XDFFM_MB 1.21e-17
* device instance cc_P2_XD1_XDFFM_S r0 *1 0,0
Ccc_P2_XD1_XDFFM_S P2 XD1_XDFFM_S 1.8151e-17
* device instance cc_P2_XD1_XDFFM_SB r0 *1 0,0
Ccc_P2_XD1_XDFFM_SB P2 XD1_XDFFM_SB 1.8151e-17
* device instance cc_P2_XD1_XDFFQ_CLKB r0 *1 0,0
Ccc_P2_XD1_XDFFQ_CLKB P2 XD1_XDFFQ_CLKB 1.8151e-17
* device instance cc_P2_XD1_XDFFQ_M r0 *1 0,0
Ccc_P2_XD1_XDFFQ_M P2 XD1_XDFFQ_M 2.4201e-17
* device instance cc_P2_XD1_XDFFQ_MB r0 *1 0,0
Ccc_P2_XD1_XDFFQ_MB P2 XD1_XDFFQ_MB 1.21e-17
* device instance cc_P2_XD1_XDFFQ_S r0 *1 0,0
Ccc_P2_XD1_XDFFQ_S P2 XD1_XDFFQ_S 1.8151e-17
* device instance cc_P2_XD1_XDFFQ_SB r0 *1 0,0
Ccc_P2_XD1_XDFFQ_SB P2 XD1_XDFFQ_SB 1.8151e-17
* device instance cc_P2_XD1_XNOR_midp r0 *1 0,0
Ccc_P2_XD1_XNOR_midp P2 XD1_XNOR_midp 1.21e-17
* device instance cc_P2_XD1_dmodout r0 *1 0,0
Ccc_P2_XD1_dmodout P2 XD1_dmodout 1.21e-17
* device instance cc_P2_XD1_dq r0 *1 0,0
Ccc_P2_XD1_dq P2 XD1_dq 1.21e-17
* device instance cc_P2_XD1_nm r0 *1 0,0
Ccc_P2_XD1_nm P2 XD1_nm 1.8151e-17
* device instance cc_P2_XD1_nt r0 *1 0,0
Ccc_P2_XD1_nt P2 XD1_nt 2.4201e-17
* device instance cc_P2_XD1_t1 r0 *1 0,0
Ccc_P2_XD1_t1 P2 XD1_t1 1.21e-17
* device instance cc_P2_XD2_XDFFM_CLKB r0 *1 0,0
Ccc_P2_XD2_XDFFM_CLKB P2 XD2_XDFFM_CLKB 1.8151e-17
* device instance cc_P2_XD2_XDFFM_M r0 *1 0,0
Ccc_P2_XD2_XDFFM_M P2 XD2_XDFFM_M 2.4201e-17
* device instance cc_P2_XD2_XDFFM_MB r0 *1 0,0
Ccc_P2_XD2_XDFFM_MB P2 XD2_XDFFM_MB 1.21e-17
* device instance cc_P2_XD2_XDFFM_S r0 *1 0,0
Ccc_P2_XD2_XDFFM_S P2 XD2_XDFFM_S 1.8151e-17
* device instance cc_P2_XD2_XDFFM_SB r0 *1 0,0
Ccc_P2_XD2_XDFFM_SB P2 XD2_XDFFM_SB 1.8151e-17
* device instance cc_P2_XD2_XDFFQ_CLKB r0 *1 0,0
Ccc_P2_XD2_XDFFQ_CLKB P2 XD2_XDFFQ_CLKB 1.8151e-17
* device instance cc_P2_XD2_XDFFQ_M r0 *1 0,0
Ccc_P2_XD2_XDFFQ_M P2 XD2_XDFFQ_M 2.4201e-17
* device instance cc_P2_XD2_XDFFQ_MB r0 *1 0,0
Ccc_P2_XD2_XDFFQ_MB P2 XD2_XDFFQ_MB 1.21e-17
* device instance cc_P2_XD2_XDFFQ_S r0 *1 0,0
Ccc_P2_XD2_XDFFQ_S P2 XD2_XDFFQ_S 1.8151e-17
* device instance cc_P2_XD2_XDFFQ_SB r0 *1 0,0
Ccc_P2_XD2_XDFFQ_SB P2 XD2_XDFFQ_SB 1.8151e-17
* device instance cc_P2_XD2_XN2_mid1 r0 *1 0,0
Ccc_P2_XD2_XN2_mid1 P2 XD2_XN2_mid1 1.21e-17
* device instance cc_P2_XD2_XN3_mid1 r0 *1 0,0
Ccc_P2_XD2_XN3_mid1 P2 XD2_XN3_mid1 6.05e-18
* device instance cc_P2_XD2_XN3_mid2 r0 *1 0,0
Ccc_P2_XD2_XN3_mid2 P2 XD2_XN3_mid2 1.21e-17
* device instance cc_P2_XD2_dmodout r0 *1 0,0
Ccc_P2_XD2_dmodout P2 XD2_dmodout 1.21e-17
* device instance cc_P2_XD2_dq r0 *1 0,0
Ccc_P2_XD2_dq P2 XD2_dq 1.8151e-17
* device instance cc_P2_XD2_nm r0 *1 0,0
Ccc_P2_XD2_nm P2 XD2_nm 1.21e-17
* device instance cc_P2_XD2_nt r0 *1 0,0
Ccc_P2_XD2_nt P2 XD2_nt 1.21e-17
* device instance cc_P2_XD2_t1 r0 *1 0,0
Ccc_P2_XD2_t1 P2 XD2_t1 1.21e-17
* device instance cc_P2_XD3_XDFFM_CLKB r0 *1 0,0
Ccc_P2_XD3_XDFFM_CLKB P2 XD3_XDFFM_CLKB 1.8151e-17
* device instance cc_P2_XD3_XDFFM_M r0 *1 0,0
Ccc_P2_XD3_XDFFM_M P2 XD3_XDFFM_M 2.4201e-17
* device instance cc_P2_XD3_XDFFM_MB r0 *1 0,0
Ccc_P2_XD3_XDFFM_MB P2 XD3_XDFFM_MB 1.21e-17
* device instance cc_P2_XD3_XDFFM_S r0 *1 0,0
Ccc_P2_XD3_XDFFM_S P2 XD3_XDFFM_S 1.8151e-17
* device instance cc_P2_XD3_XDFFM_SB r0 *1 0,0
Ccc_P2_XD3_XDFFM_SB P2 XD3_XDFFM_SB 1.8151e-17
* device instance cc_P2_XD3_XDFFQ_CLKB r0 *1 0,0
Ccc_P2_XD3_XDFFQ_CLKB P2 XD3_XDFFQ_CLKB 1.8151e-17
* device instance cc_P2_XD3_XDFFQ_M r0 *1 0,0
Ccc_P2_XD3_XDFFQ_M P2 XD3_XDFFQ_M 2.4201e-17
* device instance cc_P2_XD3_XDFFQ_MB r0 *1 0,0
Ccc_P2_XD3_XDFFQ_MB P2 XD3_XDFFQ_MB 1.21e-17
* device instance cc_P2_XD3_XDFFQ_S r0 *1 0,0
Ccc_P2_XD3_XDFFQ_S P2 XD3_XDFFQ_S 1.8151e-17
* device instance cc_P2_XD3_XDFFQ_SB r0 *1 0,0
Ccc_P2_XD3_XDFFQ_SB P2 XD3_XDFFQ_SB 1.8151e-17
* device instance cc_P2_XD3_XN2_mid1 r0 *1 0,0
Ccc_P2_XD3_XN2_mid1 P2 XD3_XN2_mid1 1.21e-17
* device instance cc_P2_XD3_XN3_mid1 r0 *1 0,0
Ccc_P2_XD3_XN3_mid1 P2 XD3_XN3_mid1 1.21e-17
* device instance cc_P2_XD3_XN3_mid2 r0 *1 0,0
Ccc_P2_XD3_XN3_mid2 P2 XD3_XN3_mid2 1.21e-17
* device instance cc_P2_XD3_dmodout r0 *1 0,0
Ccc_P2_XD3_dmodout P2 XD3_dmodout 1.21e-17
* device instance cc_P2_XD3_dq r0 *1 0,0
Ccc_P2_XD3_dq P2 XD3_dq 1.8151e-17
* device instance cc_P2_XD3_nm r0 *1 0,0
Ccc_P2_XD3_nm P2 XD3_nm 1.21e-17
* device instance cc_P2_XD3_nt r0 *1 0,0
Ccc_P2_XD3_nt P2 XD3_nt 1.21e-17
* device instance cc_P2_XD3_t1 r0 *1 0,0
Ccc_P2_XD3_t1 P2 XD3_t1 1.21e-17
* device instance cc_P2_XD4_XDFFM_CLKB r0 *1 0,0
Ccc_P2_XD4_XDFFM_CLKB P2 XD4_XDFFM_CLKB 1.8151e-17
* device instance cc_P2_XD4_XDFFM_M r0 *1 0,0
Ccc_P2_XD4_XDFFM_M P2 XD4_XDFFM_M 2.4201e-17
* device instance cc_P2_XD4_XDFFM_MB r0 *1 0,0
Ccc_P2_XD4_XDFFM_MB P2 XD4_XDFFM_MB 1.21e-17
* device instance cc_P2_XD4_XDFFM_S r0 *1 0,0
Ccc_P2_XD4_XDFFM_S P2 XD4_XDFFM_S 1.8151e-17
* device instance cc_P2_XD4_XDFFM_SB r0 *1 0,0
Ccc_P2_XD4_XDFFM_SB P2 XD4_XDFFM_SB 1.8151e-17
* device instance cc_P2_XD4_XDFFQ_CLKB r0 *1 0,0
Ccc_P2_XD4_XDFFQ_CLKB P2 XD4_XDFFQ_CLKB 1.8151e-17
* device instance cc_P2_XD4_XDFFQ_M r0 *1 0,0
Ccc_P2_XD4_XDFFQ_M P2 XD4_XDFFQ_M 2.4201e-17
* device instance cc_P2_XD4_XDFFQ_MB r0 *1 0,0
Ccc_P2_XD4_XDFFQ_MB P2 XD4_XDFFQ_MB 1.21e-17
* device instance cc_P2_XD4_XDFFQ_S r0 *1 0,0
Ccc_P2_XD4_XDFFQ_S P2 XD4_XDFFQ_S 1.8151e-17
* device instance cc_P2_XD4_XDFFQ_SB r0 *1 0,0
Ccc_P2_XD4_XDFFQ_SB P2 XD4_XDFFQ_SB 1.8151e-17
* device instance cc_P2_XD4_XN2_mid1 r0 *1 0,0
Ccc_P2_XD4_XN2_mid1 P2 XD4_XN2_mid1 1.21e-17
* device instance cc_P2_XD4_XN3_mid1 r0 *1 0,0
Ccc_P2_XD4_XN3_mid1 P2 XD4_XN3_mid1 1.21e-17
* device instance cc_P2_XD4_XN3_mid2 r0 *1 0,0
Ccc_P2_XD4_XN3_mid2 P2 XD4_XN3_mid2 1.21e-17
* device instance cc_P2_XD4_dmodout r0 *1 0,0
Ccc_P2_XD4_dmodout P2 XD4_dmodout 1.21e-17
* device instance cc_P2_XD4_dq r0 *1 0,0
Ccc_P2_XD4_dq P2 XD4_dq 1.8151e-17
* device instance cc_P2_XD4_nm r0 *1 0,0
Ccc_P2_XD4_nm P2 XD4_nm 1.21e-17
* device instance cc_P2_XD4_nt r0 *1 0,0
Ccc_P2_XD4_nt P2 XD4_nt 1.21e-17
* device instance cc_P2_XD4_t1 r0 *1 0,0
Ccc_P2_XD4_t1 P2 XD4_t1 1.21e-17
* device instance cc_P2_XD5_XDFFM_CLKB r0 *1 0,0
Ccc_P2_XD5_XDFFM_CLKB P2 XD5_XDFFM_CLKB 1.8151e-17
* device instance cc_P2_XD5_XDFFM_M r0 *1 0,0
Ccc_P2_XD5_XDFFM_M P2 XD5_XDFFM_M 2.4201e-17
* device instance cc_P2_XD5_XDFFM_MB r0 *1 0,0
Ccc_P2_XD5_XDFFM_MB P2 XD5_XDFFM_MB 1.21e-17
* device instance cc_P2_XD5_XDFFM_S r0 *1 0,0
Ccc_P2_XD5_XDFFM_S P2 XD5_XDFFM_S 1.8151e-17
* device instance cc_P2_XD5_XDFFM_SB r0 *1 0,0
Ccc_P2_XD5_XDFFM_SB P2 XD5_XDFFM_SB 1.8151e-17
* device instance cc_P2_XD5_XDFFQ_CLKB r0 *1 0,0
Ccc_P2_XD5_XDFFQ_CLKB P2 XD5_XDFFQ_CLKB 1.8151e-17
* device instance cc_P2_XD5_XDFFQ_M r0 *1 0,0
Ccc_P2_XD5_XDFFQ_M P2 XD5_XDFFQ_M 2.4201e-17
* device instance cc_P2_XD5_XDFFQ_MB r0 *1 0,0
Ccc_P2_XD5_XDFFQ_MB P2 XD5_XDFFQ_MB 1.21e-17
* device instance cc_P2_XD5_XDFFQ_S r0 *1 0,0
Ccc_P2_XD5_XDFFQ_S P2 XD5_XDFFQ_S 1.8151e-17
* device instance cc_P2_XD5_XDFFQ_SB r0 *1 0,0
Ccc_P2_XD5_XDFFQ_SB P2 XD5_XDFFQ_SB 1.8151e-17
* device instance cc_P2_XD5_XN2_mid1 r0 *1 0,0
Ccc_P2_XD5_XN2_mid1 P2 XD5_XN2_mid1 1.21e-17
* device instance cc_P2_XD5_XN3_mid1 r0 *1 0,0
Ccc_P2_XD5_XN3_mid1 P2 XD5_XN3_mid1 1.21e-17
* device instance cc_P2_XD5_XN3_mid2 r0 *1 0,0
Ccc_P2_XD5_XN3_mid2 P2 XD5_XN3_mid2 1.21e-17
* device instance cc_P2_XD5_dmodout r0 *1 0,0
Ccc_P2_XD5_dmodout P2 XD5_dmodout 1.21e-17
* device instance cc_P2_XD5_dq r0 *1 0,0
Ccc_P2_XD5_dq P2 XD5_dq 1.8151e-17
* device instance cc_P2_XD5_nm r0 *1 0,0
Ccc_P2_XD5_nm P2 XD5_nm 1.21e-17
* device instance cc_P2_XD5_nt r0 *1 0,0
Ccc_P2_XD5_nt P2 XD5_nt 1.21e-17
* device instance cc_P2_XD5_t1 r0 *1 0,0
Ccc_P2_XD5_t1 P2 XD5_t1 1.21e-17
* device instance cc_P2_XFRT_CLKB r0 *1 0,0
Ccc_P2_XFRT_CLKB P2 XFRT_CLKB 1.8151e-17
* device instance cc_P2_XFRT_M r0 *1 0,0
Ccc_P2_XFRT_M P2 XFRT_M 2.4201e-17
* device instance cc_P2_XFRT_MB r0 *1 0,0
Ccc_P2_XFRT_MB P2 XFRT_MB 1.21e-17
* device instance cc_P2_XFRT_S r0 *1 0,0
Ccc_P2_XFRT_S P2 XFRT_S 1.8151e-17
* device instance cc_P2_XFRT_SB r0 *1 0,0
Ccc_P2_XFRT_SB P2 XFRT_SB 1.8151e-17
* device instance cc_P2_ck1 r0 *1 0,0
Ccc_P2_ck1 P2 ck1 5.4452e-17
* device instance cc_P2_ck2 r0 *1 0,0
Ccc_P2_ck2 P2 ck2 5.4452e-17
* device instance cc_P2_ck3 r0 *1 0,0
Ccc_P2_ck3 P2 ck3 5.4452e-17
* device instance cc_P2_ck4 r0 *1 0,0
Ccc_P2_ck4 P2 ck4 5.4452e-17
* device instance cc_P2_ck5 r0 *1 0,0
Ccc_P2_ck5 P2 ck5 5.4452e-17
* device instance cc_P2_mod0 r0 *1 0,0
Ccc_P2_mod0 P2 mod0 2.4201e-17
* device instance cc_P2_mod1 r0 *1 0,0
Ccc_P2_mod1 P2 mod1 2.4201e-17
* device instance cc_P2_mod2 r0 *1 0,0
Ccc_P2_mod2 P2 mod2 2.4201e-17
* device instance cc_P2_mod3 r0 *1 0,0
Ccc_P2_mod3 P2 mod3 2.4201e-17
* device instance cc_P2_mod4 r0 *1 0,0
Ccc_P2_mod4 P2 mod4 2.4201e-17
* device instance cc_P2_net1 r0 *1 0,0
Ccc_P2_net1 P2 net1 1.21e-17
* device instance cc_P3_P4 r0 *1 0,0
Ccc_P3_P4 P3 P4 6.05e-18
* device instance cc_P3_P5 r0 *1 0,0
Ccc_P3_P5 P3 P5 6.05e-18
* device instance cc_P3_VDD_DIV r0 *1 0,0
Ccc_P3_VDD_DIV P3 VDD_DIV 3.14613e-16
* device instance cc_P3_VSS r0 *1 0,0
Ccc_P3_VSS P3 VSS 2.78311e-16
* device instance cc_P3_XD0_XDFFM_CLKB r0 *1 0,0
Ccc_P3_XD0_XDFFM_CLKB P3 XD0_XDFFM_CLKB 1.8151e-17
* device instance cc_P3_XD0_XDFFM_M r0 *1 0,0
Ccc_P3_XD0_XDFFM_M P3 XD0_XDFFM_M 2.4201e-17
* device instance cc_P3_XD0_XDFFM_MB r0 *1 0,0
Ccc_P3_XD0_XDFFM_MB P3 XD0_XDFFM_MB 1.21e-17
* device instance cc_P3_XD0_XDFFM_S r0 *1 0,0
Ccc_P3_XD0_XDFFM_S P3 XD0_XDFFM_S 1.8151e-17
* device instance cc_P3_XD0_XDFFM_SB r0 *1 0,0
Ccc_P3_XD0_XDFFM_SB P3 XD0_XDFFM_SB 1.8151e-17
* device instance cc_P3_XD0_XDFFQ_CLKB r0 *1 0,0
Ccc_P3_XD0_XDFFQ_CLKB P3 XD0_XDFFQ_CLKB 1.8151e-17
* device instance cc_P3_XD0_XDFFQ_M r0 *1 0,0
Ccc_P3_XD0_XDFFQ_M P3 XD0_XDFFQ_M 2.4201e-17
* device instance cc_P3_XD0_XDFFQ_MB r0 *1 0,0
Ccc_P3_XD0_XDFFQ_MB P3 XD0_XDFFQ_MB 1.21e-17
* device instance cc_P3_XD0_XDFFQ_S r0 *1 0,0
Ccc_P3_XD0_XDFFQ_S P3 XD0_XDFFQ_S 1.8151e-17
* device instance cc_P3_XD0_XDFFQ_SB r0 *1 0,0
Ccc_P3_XD0_XDFFQ_SB P3 XD0_XDFFQ_SB 1.8151e-17
* device instance cc_P3_XD0_XNOR_midp r0 *1 0,0
Ccc_P3_XD0_XNOR_midp P3 XD0_XNOR_midp 1.21e-17
* device instance cc_P3_XD0_dmodout r0 *1 0,0
Ccc_P3_XD0_dmodout P3 XD0_dmodout 1.21e-17
* device instance cc_P3_XD0_dq r0 *1 0,0
Ccc_P3_XD0_dq P3 XD0_dq 1.21e-17
* device instance cc_P3_XD0_nm r0 *1 0,0
Ccc_P3_XD0_nm P3 XD0_nm 1.8151e-17
* device instance cc_P3_XD0_nt r0 *1 0,0
Ccc_P3_XD0_nt P3 XD0_nt 2.4201e-17
* device instance cc_P3_XD0_t1 r0 *1 0,0
Ccc_P3_XD0_t1 P3 XD0_t1 1.21e-17
* device instance cc_P3_XD1_XDFFM_CLKB r0 *1 0,0
Ccc_P3_XD1_XDFFM_CLKB P3 XD1_XDFFM_CLKB 1.8151e-17
* device instance cc_P3_XD1_XDFFM_M r0 *1 0,0
Ccc_P3_XD1_XDFFM_M P3 XD1_XDFFM_M 2.4201e-17
* device instance cc_P3_XD1_XDFFM_MB r0 *1 0,0
Ccc_P3_XD1_XDFFM_MB P3 XD1_XDFFM_MB 1.21e-17
* device instance cc_P3_XD1_XDFFM_S r0 *1 0,0
Ccc_P3_XD1_XDFFM_S P3 XD1_XDFFM_S 1.8151e-17
* device instance cc_P3_XD1_XDFFM_SB r0 *1 0,0
Ccc_P3_XD1_XDFFM_SB P3 XD1_XDFFM_SB 1.8151e-17
* device instance cc_P3_XD1_XDFFQ_CLKB r0 *1 0,0
Ccc_P3_XD1_XDFFQ_CLKB P3 XD1_XDFFQ_CLKB 1.8151e-17
* device instance cc_P3_XD1_XDFFQ_M r0 *1 0,0
Ccc_P3_XD1_XDFFQ_M P3 XD1_XDFFQ_M 2.4201e-17
* device instance cc_P3_XD1_XDFFQ_MB r0 *1 0,0
Ccc_P3_XD1_XDFFQ_MB P3 XD1_XDFFQ_MB 1.21e-17
* device instance cc_P3_XD1_XDFFQ_S r0 *1 0,0
Ccc_P3_XD1_XDFFQ_S P3 XD1_XDFFQ_S 1.8151e-17
* device instance cc_P3_XD1_XDFFQ_SB r0 *1 0,0
Ccc_P3_XD1_XDFFQ_SB P3 XD1_XDFFQ_SB 1.8151e-17
* device instance cc_P3_XD1_XNOR_midp r0 *1 0,0
Ccc_P3_XD1_XNOR_midp P3 XD1_XNOR_midp 1.21e-17
* device instance cc_P3_XD1_dmodout r0 *1 0,0
Ccc_P3_XD1_dmodout P3 XD1_dmodout 1.21e-17
* device instance cc_P3_XD1_dq r0 *1 0,0
Ccc_P3_XD1_dq P3 XD1_dq 1.21e-17
* device instance cc_P3_XD1_nm r0 *1 0,0
Ccc_P3_XD1_nm P3 XD1_nm 1.8151e-17
* device instance cc_P3_XD1_nt r0 *1 0,0
Ccc_P3_XD1_nt P3 XD1_nt 2.4201e-17
* device instance cc_P3_XD1_t1 r0 *1 0,0
Ccc_P3_XD1_t1 P3 XD1_t1 1.21e-17
* device instance cc_P3_XD2_XDFFM_CLKB r0 *1 0,0
Ccc_P3_XD2_XDFFM_CLKB P3 XD2_XDFFM_CLKB 1.8151e-17
* device instance cc_P3_XD2_XDFFM_M r0 *1 0,0
Ccc_P3_XD2_XDFFM_M P3 XD2_XDFFM_M 2.4201e-17
* device instance cc_P3_XD2_XDFFM_MB r0 *1 0,0
Ccc_P3_XD2_XDFFM_MB P3 XD2_XDFFM_MB 1.21e-17
* device instance cc_P3_XD2_XDFFM_S r0 *1 0,0
Ccc_P3_XD2_XDFFM_S P3 XD2_XDFFM_S 1.8151e-17
* device instance cc_P3_XD2_XDFFM_SB r0 *1 0,0
Ccc_P3_XD2_XDFFM_SB P3 XD2_XDFFM_SB 1.8151e-17
* device instance cc_P3_XD2_XDFFQ_CLKB r0 *1 0,0
Ccc_P3_XD2_XDFFQ_CLKB P3 XD2_XDFFQ_CLKB 1.8151e-17
* device instance cc_P3_XD2_XDFFQ_M r0 *1 0,0
Ccc_P3_XD2_XDFFQ_M P3 XD2_XDFFQ_M 2.4201e-17
* device instance cc_P3_XD2_XDFFQ_MB r0 *1 0,0
Ccc_P3_XD2_XDFFQ_MB P3 XD2_XDFFQ_MB 1.21e-17
* device instance cc_P3_XD2_XDFFQ_S r0 *1 0,0
Ccc_P3_XD2_XDFFQ_S P3 XD2_XDFFQ_S 1.8151e-17
* device instance cc_P3_XD2_XDFFQ_SB r0 *1 0,0
Ccc_P3_XD2_XDFFQ_SB P3 XD2_XDFFQ_SB 1.8151e-17
* device instance cc_P3_XD2_XNOR_midp r0 *1 0,0
Ccc_P3_XD2_XNOR_midp P3 XD2_XNOR_midp 1.21e-17
* device instance cc_P3_XD2_dmodout r0 *1 0,0
Ccc_P3_XD2_dmodout P3 XD2_dmodout 1.21e-17
* device instance cc_P3_XD2_dq r0 *1 0,0
Ccc_P3_XD2_dq P3 XD2_dq 1.21e-17
* device instance cc_P3_XD2_nm r0 *1 0,0
Ccc_P3_XD2_nm P3 XD2_nm 1.8151e-17
* device instance cc_P3_XD2_nt r0 *1 0,0
Ccc_P3_XD2_nt P3 XD2_nt 2.4201e-17
* device instance cc_P3_XD2_t1 r0 *1 0,0
Ccc_P3_XD2_t1 P3 XD2_t1 1.21e-17
* device instance cc_P3_XD3_XDFFM_CLKB r0 *1 0,0
Ccc_P3_XD3_XDFFM_CLKB P3 XD3_XDFFM_CLKB 1.8151e-17
* device instance cc_P3_XD3_XDFFM_M r0 *1 0,0
Ccc_P3_XD3_XDFFM_M P3 XD3_XDFFM_M 2.4201e-17
* device instance cc_P3_XD3_XDFFM_MB r0 *1 0,0
Ccc_P3_XD3_XDFFM_MB P3 XD3_XDFFM_MB 1.21e-17
* device instance cc_P3_XD3_XDFFM_S r0 *1 0,0
Ccc_P3_XD3_XDFFM_S P3 XD3_XDFFM_S 1.8151e-17
* device instance cc_P3_XD3_XDFFM_SB r0 *1 0,0
Ccc_P3_XD3_XDFFM_SB P3 XD3_XDFFM_SB 1.8151e-17
* device instance cc_P3_XD3_XDFFQ_CLKB r0 *1 0,0
Ccc_P3_XD3_XDFFQ_CLKB P3 XD3_XDFFQ_CLKB 1.8151e-17
* device instance cc_P3_XD3_XDFFQ_M r0 *1 0,0
Ccc_P3_XD3_XDFFQ_M P3 XD3_XDFFQ_M 2.4201e-17
* device instance cc_P3_XD3_XDFFQ_MB r0 *1 0,0
Ccc_P3_XD3_XDFFQ_MB P3 XD3_XDFFQ_MB 1.21e-17
* device instance cc_P3_XD3_XDFFQ_S r0 *1 0,0
Ccc_P3_XD3_XDFFQ_S P3 XD3_XDFFQ_S 1.8151e-17
* device instance cc_P3_XD3_XDFFQ_SB r0 *1 0,0
Ccc_P3_XD3_XDFFQ_SB P3 XD3_XDFFQ_SB 1.8151e-17
* device instance cc_P3_XD3_XN2_mid1 r0 *1 0,0
Ccc_P3_XD3_XN2_mid1 P3 XD3_XN2_mid1 1.21e-17
* device instance cc_P3_XD3_XN3_mid1 r0 *1 0,0
Ccc_P3_XD3_XN3_mid1 P3 XD3_XN3_mid1 6.05e-18
* device instance cc_P3_XD3_XN3_mid2 r0 *1 0,0
Ccc_P3_XD3_XN3_mid2 P3 XD3_XN3_mid2 1.21e-17
* device instance cc_P3_XD3_dmodout r0 *1 0,0
Ccc_P3_XD3_dmodout P3 XD3_dmodout 1.21e-17
* device instance cc_P3_XD3_dq r0 *1 0,0
Ccc_P3_XD3_dq P3 XD3_dq 1.8151e-17
* device instance cc_P3_XD3_nm r0 *1 0,0
Ccc_P3_XD3_nm P3 XD3_nm 1.21e-17
* device instance cc_P3_XD3_nt r0 *1 0,0
Ccc_P3_XD3_nt P3 XD3_nt 1.21e-17
* device instance cc_P3_XD3_t1 r0 *1 0,0
Ccc_P3_XD3_t1 P3 XD3_t1 1.21e-17
* device instance cc_P3_XD4_XDFFM_CLKB r0 *1 0,0
Ccc_P3_XD4_XDFFM_CLKB P3 XD4_XDFFM_CLKB 1.8151e-17
* device instance cc_P3_XD4_XDFFM_M r0 *1 0,0
Ccc_P3_XD4_XDFFM_M P3 XD4_XDFFM_M 2.4201e-17
* device instance cc_P3_XD4_XDFFM_MB r0 *1 0,0
Ccc_P3_XD4_XDFFM_MB P3 XD4_XDFFM_MB 1.21e-17
* device instance cc_P3_XD4_XDFFM_S r0 *1 0,0
Ccc_P3_XD4_XDFFM_S P3 XD4_XDFFM_S 1.8151e-17
* device instance cc_P3_XD4_XDFFM_SB r0 *1 0,0
Ccc_P3_XD4_XDFFM_SB P3 XD4_XDFFM_SB 1.8151e-17
* device instance cc_P3_XD4_XDFFQ_CLKB r0 *1 0,0
Ccc_P3_XD4_XDFFQ_CLKB P3 XD4_XDFFQ_CLKB 1.8151e-17
* device instance cc_P3_XD4_XDFFQ_M r0 *1 0,0
Ccc_P3_XD4_XDFFQ_M P3 XD4_XDFFQ_M 2.4201e-17
* device instance cc_P3_XD4_XDFFQ_MB r0 *1 0,0
Ccc_P3_XD4_XDFFQ_MB P3 XD4_XDFFQ_MB 1.21e-17
* device instance cc_P3_XD4_XDFFQ_S r0 *1 0,0
Ccc_P3_XD4_XDFFQ_S P3 XD4_XDFFQ_S 1.8151e-17
* device instance cc_P3_XD4_XDFFQ_SB r0 *1 0,0
Ccc_P3_XD4_XDFFQ_SB P3 XD4_XDFFQ_SB 1.8151e-17
* device instance cc_P3_XD4_XN2_mid1 r0 *1 0,0
Ccc_P3_XD4_XN2_mid1 P3 XD4_XN2_mid1 1.21e-17
* device instance cc_P3_XD4_XN3_mid1 r0 *1 0,0
Ccc_P3_XD4_XN3_mid1 P3 XD4_XN3_mid1 1.21e-17
* device instance cc_P3_XD4_XN3_mid2 r0 *1 0,0
Ccc_P3_XD4_XN3_mid2 P3 XD4_XN3_mid2 1.21e-17
* device instance cc_P3_XD4_dmodout r0 *1 0,0
Ccc_P3_XD4_dmodout P3 XD4_dmodout 1.21e-17
* device instance cc_P3_XD4_dq r0 *1 0,0
Ccc_P3_XD4_dq P3 XD4_dq 1.8151e-17
* device instance cc_P3_XD4_nm r0 *1 0,0
Ccc_P3_XD4_nm P3 XD4_nm 1.21e-17
* device instance cc_P3_XD4_nt r0 *1 0,0
Ccc_P3_XD4_nt P3 XD4_nt 1.21e-17
* device instance cc_P3_XD4_t1 r0 *1 0,0
Ccc_P3_XD4_t1 P3 XD4_t1 1.21e-17
* device instance cc_P3_XD5_XDFFM_CLKB r0 *1 0,0
Ccc_P3_XD5_XDFFM_CLKB P3 XD5_XDFFM_CLKB 1.8151e-17
* device instance cc_P3_XD5_XDFFM_M r0 *1 0,0
Ccc_P3_XD5_XDFFM_M P3 XD5_XDFFM_M 2.4201e-17
* device instance cc_P3_XD5_XDFFM_MB r0 *1 0,0
Ccc_P3_XD5_XDFFM_MB P3 XD5_XDFFM_MB 1.21e-17
* device instance cc_P3_XD5_XDFFM_S r0 *1 0,0
Ccc_P3_XD5_XDFFM_S P3 XD5_XDFFM_S 1.8151e-17
* device instance cc_P3_XD5_XDFFM_SB r0 *1 0,0
Ccc_P3_XD5_XDFFM_SB P3 XD5_XDFFM_SB 1.8151e-17
* device instance cc_P3_XD5_XDFFQ_CLKB r0 *1 0,0
Ccc_P3_XD5_XDFFQ_CLKB P3 XD5_XDFFQ_CLKB 1.8151e-17
* device instance cc_P3_XD5_XDFFQ_M r0 *1 0,0
Ccc_P3_XD5_XDFFQ_M P3 XD5_XDFFQ_M 2.4201e-17
* device instance cc_P3_XD5_XDFFQ_MB r0 *1 0,0
Ccc_P3_XD5_XDFFQ_MB P3 XD5_XDFFQ_MB 1.21e-17
* device instance cc_P3_XD5_XDFFQ_S r0 *1 0,0
Ccc_P3_XD5_XDFFQ_S P3 XD5_XDFFQ_S 1.8151e-17
* device instance cc_P3_XD5_XDFFQ_SB r0 *1 0,0
Ccc_P3_XD5_XDFFQ_SB P3 XD5_XDFFQ_SB 1.8151e-17
* device instance cc_P3_XD5_XN2_mid1 r0 *1 0,0
Ccc_P3_XD5_XN2_mid1 P3 XD5_XN2_mid1 1.21e-17
* device instance cc_P3_XD5_XN3_mid1 r0 *1 0,0
Ccc_P3_XD5_XN3_mid1 P3 XD5_XN3_mid1 1.21e-17
* device instance cc_P3_XD5_XN3_mid2 r0 *1 0,0
Ccc_P3_XD5_XN3_mid2 P3 XD5_XN3_mid2 1.21e-17
* device instance cc_P3_XD5_dmodout r0 *1 0,0
Ccc_P3_XD5_dmodout P3 XD5_dmodout 1.21e-17
* device instance cc_P3_XD5_dq r0 *1 0,0
Ccc_P3_XD5_dq P3 XD5_dq 1.8151e-17
* device instance cc_P3_XD5_nm r0 *1 0,0
Ccc_P3_XD5_nm P3 XD5_nm 1.21e-17
* device instance cc_P3_XD5_nt r0 *1 0,0
Ccc_P3_XD5_nt P3 XD5_nt 1.21e-17
* device instance cc_P3_XD5_t1 r0 *1 0,0
Ccc_P3_XD5_t1 P3 XD5_t1 1.21e-17
* device instance cc_P3_XFRT_CLKB r0 *1 0,0
Ccc_P3_XFRT_CLKB P3 XFRT_CLKB 1.8151e-17
* device instance cc_P3_XFRT_M r0 *1 0,0
Ccc_P3_XFRT_M P3 XFRT_M 2.4201e-17
* device instance cc_P3_XFRT_MB r0 *1 0,0
Ccc_P3_XFRT_MB P3 XFRT_MB 1.21e-17
* device instance cc_P3_XFRT_S r0 *1 0,0
Ccc_P3_XFRT_S P3 XFRT_S 1.8151e-17
* device instance cc_P3_XFRT_SB r0 *1 0,0
Ccc_P3_XFRT_SB P3 XFRT_SB 1.8151e-17
* device instance cc_P3_ck1 r0 *1 0,0
Ccc_P3_ck1 P3 ck1 5.4452e-17
* device instance cc_P3_ck2 r0 *1 0,0
Ccc_P3_ck2 P3 ck2 5.4452e-17
* device instance cc_P3_ck3 r0 *1 0,0
Ccc_P3_ck3 P3 ck3 5.4452e-17
* device instance cc_P3_ck4 r0 *1 0,0
Ccc_P3_ck4 P3 ck4 5.4452e-17
* device instance cc_P3_ck5 r0 *1 0,0
Ccc_P3_ck5 P3 ck5 5.4452e-17
* device instance cc_P3_mod0 r0 *1 0,0
Ccc_P3_mod0 P3 mod0 2.4201e-17
* device instance cc_P3_mod1 r0 *1 0,0
Ccc_P3_mod1 P3 mod1 2.4201e-17
* device instance cc_P3_mod2 r0 *1 0,0
Ccc_P3_mod2 P3 mod2 2.4201e-17
* device instance cc_P3_mod3 r0 *1 0,0
Ccc_P3_mod3 P3 mod3 2.4201e-17
* device instance cc_P3_mod4 r0 *1 0,0
Ccc_P3_mod4 P3 mod4 2.4201e-17
* device instance cc_P3_net1 r0 *1 0,0
Ccc_P3_net1 P3 net1 1.21e-17
* device instance cc_P4_P5 r0 *1 0,0
Ccc_P4_P5 P4 P5 6.05e-18
* device instance cc_P4_VDD_DIV r0 *1 0,0
Ccc_P4_VDD_DIV P4 VDD_DIV 4.11417e-16
* device instance cc_P4_VSS r0 *1 0,0
Ccc_P4_VSS P4 VSS 1.93608e-16
* device instance cc_P4_XD0_XDFFM_CLKB r0 *1 0,0
Ccc_P4_XD0_XDFFM_CLKB P4 XD0_XDFFM_CLKB 1.8151e-17
* device instance cc_P4_XD0_XDFFM_M r0 *1 0,0
Ccc_P4_XD0_XDFFM_M P4 XD0_XDFFM_M 2.4201e-17
* device instance cc_P4_XD0_XDFFM_MB r0 *1 0,0
Ccc_P4_XD0_XDFFM_MB P4 XD0_XDFFM_MB 1.21e-17
* device instance cc_P4_XD0_XDFFM_S r0 *1 0,0
Ccc_P4_XD0_XDFFM_S P4 XD0_XDFFM_S 1.8151e-17
* device instance cc_P4_XD0_XDFFM_SB r0 *1 0,0
Ccc_P4_XD0_XDFFM_SB P4 XD0_XDFFM_SB 1.8151e-17
* device instance cc_P4_XD0_XDFFQ_CLKB r0 *1 0,0
Ccc_P4_XD0_XDFFQ_CLKB P4 XD0_XDFFQ_CLKB 1.8151e-17
* device instance cc_P4_XD0_XDFFQ_M r0 *1 0,0
Ccc_P4_XD0_XDFFQ_M P4 XD0_XDFFQ_M 2.4201e-17
* device instance cc_P4_XD0_XDFFQ_MB r0 *1 0,0
Ccc_P4_XD0_XDFFQ_MB P4 XD0_XDFFQ_MB 1.21e-17
* device instance cc_P4_XD0_XDFFQ_S r0 *1 0,0
Ccc_P4_XD0_XDFFQ_S P4 XD0_XDFFQ_S 1.8151e-17
* device instance cc_P4_XD0_XDFFQ_SB r0 *1 0,0
Ccc_P4_XD0_XDFFQ_SB P4 XD0_XDFFQ_SB 1.8151e-17
* device instance cc_P4_XD0_XNOR_midp r0 *1 0,0
Ccc_P4_XD0_XNOR_midp P4 XD0_XNOR_midp 1.21e-17
* device instance cc_P4_XD0_dmodout r0 *1 0,0
Ccc_P4_XD0_dmodout P4 XD0_dmodout 1.21e-17
* device instance cc_P4_XD0_dq r0 *1 0,0
Ccc_P4_XD0_dq P4 XD0_dq 1.21e-17
* device instance cc_P4_XD0_nm r0 *1 0,0
Ccc_P4_XD0_nm P4 XD0_nm 1.8151e-17
* device instance cc_P4_XD0_nt r0 *1 0,0
Ccc_P4_XD0_nt P4 XD0_nt 2.4201e-17
* device instance cc_P4_XD0_t1 r0 *1 0,0
Ccc_P4_XD0_t1 P4 XD0_t1 1.21e-17
* device instance cc_P4_XD1_XDFFM_CLKB r0 *1 0,0
Ccc_P4_XD1_XDFFM_CLKB P4 XD1_XDFFM_CLKB 1.8151e-17
* device instance cc_P4_XD1_XDFFM_M r0 *1 0,0
Ccc_P4_XD1_XDFFM_M P4 XD1_XDFFM_M 2.4201e-17
* device instance cc_P4_XD1_XDFFM_MB r0 *1 0,0
Ccc_P4_XD1_XDFFM_MB P4 XD1_XDFFM_MB 1.21e-17
* device instance cc_P4_XD1_XDFFM_S r0 *1 0,0
Ccc_P4_XD1_XDFFM_S P4 XD1_XDFFM_S 1.8151e-17
* device instance cc_P4_XD1_XDFFM_SB r0 *1 0,0
Ccc_P4_XD1_XDFFM_SB P4 XD1_XDFFM_SB 1.8151e-17
* device instance cc_P4_XD1_XDFFQ_CLKB r0 *1 0,0
Ccc_P4_XD1_XDFFQ_CLKB P4 XD1_XDFFQ_CLKB 1.8151e-17
* device instance cc_P4_XD1_XDFFQ_M r0 *1 0,0
Ccc_P4_XD1_XDFFQ_M P4 XD1_XDFFQ_M 2.4201e-17
* device instance cc_P4_XD1_XDFFQ_MB r0 *1 0,0
Ccc_P4_XD1_XDFFQ_MB P4 XD1_XDFFQ_MB 1.21e-17
* device instance cc_P4_XD1_XDFFQ_S r0 *1 0,0
Ccc_P4_XD1_XDFFQ_S P4 XD1_XDFFQ_S 1.8151e-17
* device instance cc_P4_XD1_XDFFQ_SB r0 *1 0,0
Ccc_P4_XD1_XDFFQ_SB P4 XD1_XDFFQ_SB 1.8151e-17
* device instance cc_P4_XD1_XNOR_midp r0 *1 0,0
Ccc_P4_XD1_XNOR_midp P4 XD1_XNOR_midp 1.21e-17
* device instance cc_P4_XD1_dmodout r0 *1 0,0
Ccc_P4_XD1_dmodout P4 XD1_dmodout 1.21e-17
* device instance cc_P4_XD1_dq r0 *1 0,0
Ccc_P4_XD1_dq P4 XD1_dq 1.21e-17
* device instance cc_P4_XD1_nm r0 *1 0,0
Ccc_P4_XD1_nm P4 XD1_nm 1.8151e-17
* device instance cc_P4_XD1_nt r0 *1 0,0
Ccc_P4_XD1_nt P4 XD1_nt 2.4201e-17
* device instance cc_P4_XD1_t1 r0 *1 0,0
Ccc_P4_XD1_t1 P4 XD1_t1 1.21e-17
* device instance cc_P4_XD2_XDFFM_CLKB r0 *1 0,0
Ccc_P4_XD2_XDFFM_CLKB P4 XD2_XDFFM_CLKB 1.8151e-17
* device instance cc_P4_XD2_XDFFM_M r0 *1 0,0
Ccc_P4_XD2_XDFFM_M P4 XD2_XDFFM_M 2.4201e-17
* device instance cc_P4_XD2_XDFFM_MB r0 *1 0,0
Ccc_P4_XD2_XDFFM_MB P4 XD2_XDFFM_MB 1.21e-17
* device instance cc_P4_XD2_XDFFM_S r0 *1 0,0
Ccc_P4_XD2_XDFFM_S P4 XD2_XDFFM_S 1.8151e-17
* device instance cc_P4_XD2_XDFFM_SB r0 *1 0,0
Ccc_P4_XD2_XDFFM_SB P4 XD2_XDFFM_SB 1.8151e-17
* device instance cc_P4_XD2_XDFFQ_CLKB r0 *1 0,0
Ccc_P4_XD2_XDFFQ_CLKB P4 XD2_XDFFQ_CLKB 1.8151e-17
* device instance cc_P4_XD2_XDFFQ_M r0 *1 0,0
Ccc_P4_XD2_XDFFQ_M P4 XD2_XDFFQ_M 2.4201e-17
* device instance cc_P4_XD2_XDFFQ_MB r0 *1 0,0
Ccc_P4_XD2_XDFFQ_MB P4 XD2_XDFFQ_MB 1.21e-17
* device instance cc_P4_XD2_XDFFQ_S r0 *1 0,0
Ccc_P4_XD2_XDFFQ_S P4 XD2_XDFFQ_S 1.8151e-17
* device instance cc_P4_XD2_XDFFQ_SB r0 *1 0,0
Ccc_P4_XD2_XDFFQ_SB P4 XD2_XDFFQ_SB 1.8151e-17
* device instance cc_P4_XD2_XNOR_midp r0 *1 0,0
Ccc_P4_XD2_XNOR_midp P4 XD2_XNOR_midp 1.21e-17
* device instance cc_P4_XD2_dmodout r0 *1 0,0
Ccc_P4_XD2_dmodout P4 XD2_dmodout 1.21e-17
* device instance cc_P4_XD2_dq r0 *1 0,0
Ccc_P4_XD2_dq P4 XD2_dq 1.21e-17
* device instance cc_P4_XD2_nm r0 *1 0,0
Ccc_P4_XD2_nm P4 XD2_nm 1.8151e-17
* device instance cc_P4_XD2_nt r0 *1 0,0
Ccc_P4_XD2_nt P4 XD2_nt 2.4201e-17
* device instance cc_P4_XD2_t1 r0 *1 0,0
Ccc_P4_XD2_t1 P4 XD2_t1 1.21e-17
* device instance cc_P4_XD3_XDFFM_CLKB r0 *1 0,0
Ccc_P4_XD3_XDFFM_CLKB P4 XD3_XDFFM_CLKB 1.8151e-17
* device instance cc_P4_XD3_XDFFM_M r0 *1 0,0
Ccc_P4_XD3_XDFFM_M P4 XD3_XDFFM_M 2.4201e-17
* device instance cc_P4_XD3_XDFFM_MB r0 *1 0,0
Ccc_P4_XD3_XDFFM_MB P4 XD3_XDFFM_MB 1.21e-17
* device instance cc_P4_XD3_XDFFM_S r0 *1 0,0
Ccc_P4_XD3_XDFFM_S P4 XD3_XDFFM_S 1.8151e-17
* device instance cc_P4_XD3_XDFFM_SB r0 *1 0,0
Ccc_P4_XD3_XDFFM_SB P4 XD3_XDFFM_SB 1.8151e-17
* device instance cc_P4_XD3_XDFFQ_CLKB r0 *1 0,0
Ccc_P4_XD3_XDFFQ_CLKB P4 XD3_XDFFQ_CLKB 1.8151e-17
* device instance cc_P4_XD3_XDFFQ_M r0 *1 0,0
Ccc_P4_XD3_XDFFQ_M P4 XD3_XDFFQ_M 2.4201e-17
* device instance cc_P4_XD3_XDFFQ_MB r0 *1 0,0
Ccc_P4_XD3_XDFFQ_MB P4 XD3_XDFFQ_MB 1.21e-17
* device instance cc_P4_XD3_XDFFQ_S r0 *1 0,0
Ccc_P4_XD3_XDFFQ_S P4 XD3_XDFFQ_S 1.8151e-17
* device instance cc_P4_XD3_XDFFQ_SB r0 *1 0,0
Ccc_P4_XD3_XDFFQ_SB P4 XD3_XDFFQ_SB 1.8151e-17
* device instance cc_P4_XD3_XNOR_midp r0 *1 0,0
Ccc_P4_XD3_XNOR_midp P4 XD3_XNOR_midp 1.21e-17
* device instance cc_P4_XD3_dmodout r0 *1 0,0
Ccc_P4_XD3_dmodout P4 XD3_dmodout 1.21e-17
* device instance cc_P4_XD3_dq r0 *1 0,0
Ccc_P4_XD3_dq P4 XD3_dq 1.21e-17
* device instance cc_P4_XD3_nm r0 *1 0,0
Ccc_P4_XD3_nm P4 XD3_nm 1.8151e-17
* device instance cc_P4_XD3_nt r0 *1 0,0
Ccc_P4_XD3_nt P4 XD3_nt 2.4201e-17
* device instance cc_P4_XD3_t1 r0 *1 0,0
Ccc_P4_XD3_t1 P4 XD3_t1 1.21e-17
* device instance cc_P4_XD4_XDFFM_CLKB r0 *1 0,0
Ccc_P4_XD4_XDFFM_CLKB P4 XD4_XDFFM_CLKB 1.8151e-17
* device instance cc_P4_XD4_XDFFM_M r0 *1 0,0
Ccc_P4_XD4_XDFFM_M P4 XD4_XDFFM_M 2.4201e-17
* device instance cc_P4_XD4_XDFFM_MB r0 *1 0,0
Ccc_P4_XD4_XDFFM_MB P4 XD4_XDFFM_MB 1.21e-17
* device instance cc_P4_XD4_XDFFM_S r0 *1 0,0
Ccc_P4_XD4_XDFFM_S P4 XD4_XDFFM_S 1.8151e-17
* device instance cc_P4_XD4_XDFFM_SB r0 *1 0,0
Ccc_P4_XD4_XDFFM_SB P4 XD4_XDFFM_SB 1.8151e-17
* device instance cc_P4_XD4_XDFFQ_CLKB r0 *1 0,0
Ccc_P4_XD4_XDFFQ_CLKB P4 XD4_XDFFQ_CLKB 1.8151e-17
* device instance cc_P4_XD4_XDFFQ_M r0 *1 0,0
Ccc_P4_XD4_XDFFQ_M P4 XD4_XDFFQ_M 2.4201e-17
* device instance cc_P4_XD4_XDFFQ_MB r0 *1 0,0
Ccc_P4_XD4_XDFFQ_MB P4 XD4_XDFFQ_MB 1.21e-17
* device instance cc_P4_XD4_XDFFQ_S r0 *1 0,0
Ccc_P4_XD4_XDFFQ_S P4 XD4_XDFFQ_S 1.8151e-17
* device instance cc_P4_XD4_XDFFQ_SB r0 *1 0,0
Ccc_P4_XD4_XDFFQ_SB P4 XD4_XDFFQ_SB 1.8151e-17
* device instance cc_P4_XD4_XN2_mid1 r0 *1 0,0
Ccc_P4_XD4_XN2_mid1 P4 XD4_XN2_mid1 1.21e-17
* device instance cc_P4_XD4_XN3_mid1 r0 *1 0,0
Ccc_P4_XD4_XN3_mid1 P4 XD4_XN3_mid1 6.05e-18
* device instance cc_P4_XD4_XN3_mid2 r0 *1 0,0
Ccc_P4_XD4_XN3_mid2 P4 XD4_XN3_mid2 1.21e-17
* device instance cc_P4_XD4_dmodout r0 *1 0,0
Ccc_P4_XD4_dmodout P4 XD4_dmodout 1.21e-17
* device instance cc_P4_XD4_dq r0 *1 0,0
Ccc_P4_XD4_dq P4 XD4_dq 1.8151e-17
* device instance cc_P4_XD4_nm r0 *1 0,0
Ccc_P4_XD4_nm P4 XD4_nm 1.21e-17
* device instance cc_P4_XD4_nt r0 *1 0,0
Ccc_P4_XD4_nt P4 XD4_nt 1.21e-17
* device instance cc_P4_XD4_t1 r0 *1 0,0
Ccc_P4_XD4_t1 P4 XD4_t1 1.21e-17
* device instance cc_P4_XD5_XDFFM_CLKB r0 *1 0,0
Ccc_P4_XD5_XDFFM_CLKB P4 XD5_XDFFM_CLKB 1.8151e-17
* device instance cc_P4_XD5_XDFFM_M r0 *1 0,0
Ccc_P4_XD5_XDFFM_M P4 XD5_XDFFM_M 2.4201e-17
* device instance cc_P4_XD5_XDFFM_MB r0 *1 0,0
Ccc_P4_XD5_XDFFM_MB P4 XD5_XDFFM_MB 1.21e-17
* device instance cc_P4_XD5_XDFFM_S r0 *1 0,0
Ccc_P4_XD5_XDFFM_S P4 XD5_XDFFM_S 1.8151e-17
* device instance cc_P4_XD5_XDFFM_SB r0 *1 0,0
Ccc_P4_XD5_XDFFM_SB P4 XD5_XDFFM_SB 1.8151e-17
* device instance cc_P4_XD5_XDFFQ_CLKB r0 *1 0,0
Ccc_P4_XD5_XDFFQ_CLKB P4 XD5_XDFFQ_CLKB 1.8151e-17
* device instance cc_P4_XD5_XDFFQ_M r0 *1 0,0
Ccc_P4_XD5_XDFFQ_M P4 XD5_XDFFQ_M 2.4201e-17
* device instance cc_P4_XD5_XDFFQ_MB r0 *1 0,0
Ccc_P4_XD5_XDFFQ_MB P4 XD5_XDFFQ_MB 1.21e-17
* device instance cc_P4_XD5_XDFFQ_S r0 *1 0,0
Ccc_P4_XD5_XDFFQ_S P4 XD5_XDFFQ_S 1.8151e-17
* device instance cc_P4_XD5_XDFFQ_SB r0 *1 0,0
Ccc_P4_XD5_XDFFQ_SB P4 XD5_XDFFQ_SB 1.8151e-17
* device instance cc_P4_XD5_XN2_mid1 r0 *1 0,0
Ccc_P4_XD5_XN2_mid1 P4 XD5_XN2_mid1 1.21e-17
* device instance cc_P4_XD5_XN3_mid1 r0 *1 0,0
Ccc_P4_XD5_XN3_mid1 P4 XD5_XN3_mid1 1.21e-17
* device instance cc_P4_XD5_XN3_mid2 r0 *1 0,0
Ccc_P4_XD5_XN3_mid2 P4 XD5_XN3_mid2 1.21e-17
* device instance cc_P4_XD5_dmodout r0 *1 0,0
Ccc_P4_XD5_dmodout P4 XD5_dmodout 1.21e-17
* device instance cc_P4_XD5_dq r0 *1 0,0
Ccc_P4_XD5_dq P4 XD5_dq 1.8151e-17
* device instance cc_P4_XD5_nm r0 *1 0,0
Ccc_P4_XD5_nm P4 XD5_nm 1.21e-17
* device instance cc_P4_XD5_nt r0 *1 0,0
Ccc_P4_XD5_nt P4 XD5_nt 1.21e-17
* device instance cc_P4_XD5_t1 r0 *1 0,0
Ccc_P4_XD5_t1 P4 XD5_t1 1.21e-17
* device instance cc_P4_XFRT_CLKB r0 *1 0,0
Ccc_P4_XFRT_CLKB P4 XFRT_CLKB 1.8151e-17
* device instance cc_P4_XFRT_M r0 *1 0,0
Ccc_P4_XFRT_M P4 XFRT_M 2.4201e-17
* device instance cc_P4_XFRT_MB r0 *1 0,0
Ccc_P4_XFRT_MB P4 XFRT_MB 1.21e-17
* device instance cc_P4_XFRT_S r0 *1 0,0
Ccc_P4_XFRT_S P4 XFRT_S 1.8151e-17
* device instance cc_P4_XFRT_SB r0 *1 0,0
Ccc_P4_XFRT_SB P4 XFRT_SB 1.8151e-17
* device instance cc_P4_ck1 r0 *1 0,0
Ccc_P4_ck1 P4 ck1 5.4452e-17
* device instance cc_P4_ck2 r0 *1 0,0
Ccc_P4_ck2 P4 ck2 5.4452e-17
* device instance cc_P4_ck3 r0 *1 0,0
Ccc_P4_ck3 P4 ck3 5.4452e-17
* device instance cc_P4_ck4 r0 *1 0,0
Ccc_P4_ck4 P4 ck4 5.4452e-17
* device instance cc_P4_ck5 r0 *1 0,0
Ccc_P4_ck5 P4 ck5 5.4452e-17
* device instance cc_P4_mod0 r0 *1 0,0
Ccc_P4_mod0 P4 mod0 2.4201e-17
* device instance cc_P4_mod1 r0 *1 0,0
Ccc_P4_mod1 P4 mod1 2.4201e-17
* device instance cc_P4_mod2 r0 *1 0,0
Ccc_P4_mod2 P4 mod2 2.4201e-17
* device instance cc_P4_mod3 r0 *1 0,0
Ccc_P4_mod3 P4 mod3 2.4201e-17
* device instance cc_P4_mod4 r0 *1 0,0
Ccc_P4_mod4 P4 mod4 2.4201e-17
* device instance cc_P4_net1 r0 *1 0,0
Ccc_P4_net1 P4 net1 1.21e-17
* device instance cc_P5_VDD_DIV r0 *1 0,0
Ccc_P5_VDD_DIV P5 VDD_DIV 5.08221e-16
* device instance cc_P5_VSS r0 *1 0,0
Ccc_P5_VSS P5 VSS 1.08905e-16
* device instance cc_P5_XD0_XDFFM_CLKB r0 *1 0,0
Ccc_P5_XD0_XDFFM_CLKB P5 XD0_XDFFM_CLKB 1.8151e-17
* device instance cc_P5_XD0_XDFFM_M r0 *1 0,0
Ccc_P5_XD0_XDFFM_M P5 XD0_XDFFM_M 2.4201e-17
* device instance cc_P5_XD0_XDFFM_MB r0 *1 0,0
Ccc_P5_XD0_XDFFM_MB P5 XD0_XDFFM_MB 1.21e-17
* device instance cc_P5_XD0_XDFFM_S r0 *1 0,0
Ccc_P5_XD0_XDFFM_S P5 XD0_XDFFM_S 1.8151e-17
* device instance cc_P5_XD0_XDFFM_SB r0 *1 0,0
Ccc_P5_XD0_XDFFM_SB P5 XD0_XDFFM_SB 1.8151e-17
* device instance cc_P5_XD0_XDFFQ_CLKB r0 *1 0,0
Ccc_P5_XD0_XDFFQ_CLKB P5 XD0_XDFFQ_CLKB 1.8151e-17
* device instance cc_P5_XD0_XDFFQ_M r0 *1 0,0
Ccc_P5_XD0_XDFFQ_M P5 XD0_XDFFQ_M 2.4201e-17
* device instance cc_P5_XD0_XDFFQ_MB r0 *1 0,0
Ccc_P5_XD0_XDFFQ_MB P5 XD0_XDFFQ_MB 1.21e-17
* device instance cc_P5_XD0_XDFFQ_S r0 *1 0,0
Ccc_P5_XD0_XDFFQ_S P5 XD0_XDFFQ_S 1.8151e-17
* device instance cc_P5_XD0_XDFFQ_SB r0 *1 0,0
Ccc_P5_XD0_XDFFQ_SB P5 XD0_XDFFQ_SB 1.8151e-17
* device instance cc_P5_XD0_XNOR_midp r0 *1 0,0
Ccc_P5_XD0_XNOR_midp P5 XD0_XNOR_midp 1.21e-17
* device instance cc_P5_XD0_dmodout r0 *1 0,0
Ccc_P5_XD0_dmodout P5 XD0_dmodout 1.21e-17
* device instance cc_P5_XD0_dq r0 *1 0,0
Ccc_P5_XD0_dq P5 XD0_dq 1.21e-17
* device instance cc_P5_XD0_nm r0 *1 0,0
Ccc_P5_XD0_nm P5 XD0_nm 1.8151e-17
* device instance cc_P5_XD0_nt r0 *1 0,0
Ccc_P5_XD0_nt P5 XD0_nt 2.4201e-17
* device instance cc_P5_XD0_t1 r0 *1 0,0
Ccc_P5_XD0_t1 P5 XD0_t1 1.21e-17
* device instance cc_P5_XD1_XDFFM_CLKB r0 *1 0,0
Ccc_P5_XD1_XDFFM_CLKB P5 XD1_XDFFM_CLKB 1.8151e-17
* device instance cc_P5_XD1_XDFFM_M r0 *1 0,0
Ccc_P5_XD1_XDFFM_M P5 XD1_XDFFM_M 2.4201e-17
* device instance cc_P5_XD1_XDFFM_MB r0 *1 0,0
Ccc_P5_XD1_XDFFM_MB P5 XD1_XDFFM_MB 1.21e-17
* device instance cc_P5_XD1_XDFFM_S r0 *1 0,0
Ccc_P5_XD1_XDFFM_S P5 XD1_XDFFM_S 1.8151e-17
* device instance cc_P5_XD1_XDFFM_SB r0 *1 0,0
Ccc_P5_XD1_XDFFM_SB P5 XD1_XDFFM_SB 1.8151e-17
* device instance cc_P5_XD1_XDFFQ_CLKB r0 *1 0,0
Ccc_P5_XD1_XDFFQ_CLKB P5 XD1_XDFFQ_CLKB 1.8151e-17
* device instance cc_P5_XD1_XDFFQ_M r0 *1 0,0
Ccc_P5_XD1_XDFFQ_M P5 XD1_XDFFQ_M 2.4201e-17
* device instance cc_P5_XD1_XDFFQ_MB r0 *1 0,0
Ccc_P5_XD1_XDFFQ_MB P5 XD1_XDFFQ_MB 1.21e-17
* device instance cc_P5_XD1_XDFFQ_S r0 *1 0,0
Ccc_P5_XD1_XDFFQ_S P5 XD1_XDFFQ_S 1.8151e-17
* device instance cc_P5_XD1_XDFFQ_SB r0 *1 0,0
Ccc_P5_XD1_XDFFQ_SB P5 XD1_XDFFQ_SB 1.8151e-17
* device instance cc_P5_XD1_XNOR_midp r0 *1 0,0
Ccc_P5_XD1_XNOR_midp P5 XD1_XNOR_midp 1.21e-17
* device instance cc_P5_XD1_dmodout r0 *1 0,0
Ccc_P5_XD1_dmodout P5 XD1_dmodout 1.21e-17
* device instance cc_P5_XD1_dq r0 *1 0,0
Ccc_P5_XD1_dq P5 XD1_dq 1.21e-17
* device instance cc_P5_XD1_nm r0 *1 0,0
Ccc_P5_XD1_nm P5 XD1_nm 1.8151e-17
* device instance cc_P5_XD1_nt r0 *1 0,0
Ccc_P5_XD1_nt P5 XD1_nt 2.4201e-17
* device instance cc_P5_XD1_t1 r0 *1 0,0
Ccc_P5_XD1_t1 P5 XD1_t1 1.21e-17
* device instance cc_P5_XD2_XDFFM_CLKB r0 *1 0,0
Ccc_P5_XD2_XDFFM_CLKB P5 XD2_XDFFM_CLKB 1.8151e-17
* device instance cc_P5_XD2_XDFFM_M r0 *1 0,0
Ccc_P5_XD2_XDFFM_M P5 XD2_XDFFM_M 2.4201e-17
* device instance cc_P5_XD2_XDFFM_MB r0 *1 0,0
Ccc_P5_XD2_XDFFM_MB P5 XD2_XDFFM_MB 1.21e-17
* device instance cc_P5_XD2_XDFFM_S r0 *1 0,0
Ccc_P5_XD2_XDFFM_S P5 XD2_XDFFM_S 1.8151e-17
* device instance cc_P5_XD2_XDFFM_SB r0 *1 0,0
Ccc_P5_XD2_XDFFM_SB P5 XD2_XDFFM_SB 1.8151e-17
* device instance cc_P5_XD2_XDFFQ_CLKB r0 *1 0,0
Ccc_P5_XD2_XDFFQ_CLKB P5 XD2_XDFFQ_CLKB 1.8151e-17
* device instance cc_P5_XD2_XDFFQ_M r0 *1 0,0
Ccc_P5_XD2_XDFFQ_M P5 XD2_XDFFQ_M 2.4201e-17
* device instance cc_P5_XD2_XDFFQ_MB r0 *1 0,0
Ccc_P5_XD2_XDFFQ_MB P5 XD2_XDFFQ_MB 1.21e-17
* device instance cc_P5_XD2_XDFFQ_S r0 *1 0,0
Ccc_P5_XD2_XDFFQ_S P5 XD2_XDFFQ_S 1.8151e-17
* device instance cc_P5_XD2_XDFFQ_SB r0 *1 0,0
Ccc_P5_XD2_XDFFQ_SB P5 XD2_XDFFQ_SB 1.8151e-17
* device instance cc_P5_XD2_XNOR_midp r0 *1 0,0
Ccc_P5_XD2_XNOR_midp P5 XD2_XNOR_midp 1.21e-17
* device instance cc_P5_XD2_dmodout r0 *1 0,0
Ccc_P5_XD2_dmodout P5 XD2_dmodout 1.21e-17
* device instance cc_P5_XD2_dq r0 *1 0,0
Ccc_P5_XD2_dq P5 XD2_dq 1.21e-17
* device instance cc_P5_XD2_nm r0 *1 0,0
Ccc_P5_XD2_nm P5 XD2_nm 1.8151e-17
* device instance cc_P5_XD2_nt r0 *1 0,0
Ccc_P5_XD2_nt P5 XD2_nt 2.4201e-17
* device instance cc_P5_XD2_t1 r0 *1 0,0
Ccc_P5_XD2_t1 P5 XD2_t1 1.21e-17
* device instance cc_P5_XD3_XDFFM_CLKB r0 *1 0,0
Ccc_P5_XD3_XDFFM_CLKB P5 XD3_XDFFM_CLKB 1.8151e-17
* device instance cc_P5_XD3_XDFFM_M r0 *1 0,0
Ccc_P5_XD3_XDFFM_M P5 XD3_XDFFM_M 2.4201e-17
* device instance cc_P5_XD3_XDFFM_MB r0 *1 0,0
Ccc_P5_XD3_XDFFM_MB P5 XD3_XDFFM_MB 1.21e-17
* device instance cc_P5_XD3_XDFFM_S r0 *1 0,0
Ccc_P5_XD3_XDFFM_S P5 XD3_XDFFM_S 1.8151e-17
* device instance cc_P5_XD3_XDFFM_SB r0 *1 0,0
Ccc_P5_XD3_XDFFM_SB P5 XD3_XDFFM_SB 1.8151e-17
* device instance cc_P5_XD3_XDFFQ_CLKB r0 *1 0,0
Ccc_P5_XD3_XDFFQ_CLKB P5 XD3_XDFFQ_CLKB 1.8151e-17
* device instance cc_P5_XD3_XDFFQ_M r0 *1 0,0
Ccc_P5_XD3_XDFFQ_M P5 XD3_XDFFQ_M 2.4201e-17
* device instance cc_P5_XD3_XDFFQ_MB r0 *1 0,0
Ccc_P5_XD3_XDFFQ_MB P5 XD3_XDFFQ_MB 1.21e-17
* device instance cc_P5_XD3_XDFFQ_S r0 *1 0,0
Ccc_P5_XD3_XDFFQ_S P5 XD3_XDFFQ_S 1.8151e-17
* device instance cc_P5_XD3_XDFFQ_SB r0 *1 0,0
Ccc_P5_XD3_XDFFQ_SB P5 XD3_XDFFQ_SB 1.8151e-17
* device instance cc_P5_XD3_XNOR_midp r0 *1 0,0
Ccc_P5_XD3_XNOR_midp P5 XD3_XNOR_midp 1.21e-17
* device instance cc_P5_XD3_dmodout r0 *1 0,0
Ccc_P5_XD3_dmodout P5 XD3_dmodout 1.21e-17
* device instance cc_P5_XD3_dq r0 *1 0,0
Ccc_P5_XD3_dq P5 XD3_dq 1.21e-17
* device instance cc_P5_XD3_nm r0 *1 0,0
Ccc_P5_XD3_nm P5 XD3_nm 1.8151e-17
* device instance cc_P5_XD3_nt r0 *1 0,0
Ccc_P5_XD3_nt P5 XD3_nt 2.4201e-17
* device instance cc_P5_XD3_t1 r0 *1 0,0
Ccc_P5_XD3_t1 P5 XD3_t1 1.21e-17
* device instance cc_P5_XD4_XDFFM_CLKB r0 *1 0,0
Ccc_P5_XD4_XDFFM_CLKB P5 XD4_XDFFM_CLKB 1.8151e-17
* device instance cc_P5_XD4_XDFFM_M r0 *1 0,0
Ccc_P5_XD4_XDFFM_M P5 XD4_XDFFM_M 2.4201e-17
* device instance cc_P5_XD4_XDFFM_MB r0 *1 0,0
Ccc_P5_XD4_XDFFM_MB P5 XD4_XDFFM_MB 1.21e-17
* device instance cc_P5_XD4_XDFFM_S r0 *1 0,0
Ccc_P5_XD4_XDFFM_S P5 XD4_XDFFM_S 1.8151e-17
* device instance cc_P5_XD4_XDFFM_SB r0 *1 0,0
Ccc_P5_XD4_XDFFM_SB P5 XD4_XDFFM_SB 1.8151e-17
* device instance cc_P5_XD4_XDFFQ_CLKB r0 *1 0,0
Ccc_P5_XD4_XDFFQ_CLKB P5 XD4_XDFFQ_CLKB 1.8151e-17
* device instance cc_P5_XD4_XDFFQ_M r0 *1 0,0
Ccc_P5_XD4_XDFFQ_M P5 XD4_XDFFQ_M 2.4201e-17
* device instance cc_P5_XD4_XDFFQ_MB r0 *1 0,0
Ccc_P5_XD4_XDFFQ_MB P5 XD4_XDFFQ_MB 1.21e-17
* device instance cc_P5_XD4_XDFFQ_S r0 *1 0,0
Ccc_P5_XD4_XDFFQ_S P5 XD4_XDFFQ_S 1.8151e-17
* device instance cc_P5_XD4_XDFFQ_SB r0 *1 0,0
Ccc_P5_XD4_XDFFQ_SB P5 XD4_XDFFQ_SB 1.8151e-17
* device instance cc_P5_XD4_XNOR_midp r0 *1 0,0
Ccc_P5_XD4_XNOR_midp P5 XD4_XNOR_midp 1.21e-17
* device instance cc_P5_XD4_dmodout r0 *1 0,0
Ccc_P5_XD4_dmodout P5 XD4_dmodout 1.21e-17
* device instance cc_P5_XD4_dq r0 *1 0,0
Ccc_P5_XD4_dq P5 XD4_dq 1.21e-17
* device instance cc_P5_XD4_nm r0 *1 0,0
Ccc_P5_XD4_nm P5 XD4_nm 1.8151e-17
* device instance cc_P5_XD4_nt r0 *1 0,0
Ccc_P5_XD4_nt P5 XD4_nt 2.4201e-17
* device instance cc_P5_XD4_t1 r0 *1 0,0
Ccc_P5_XD4_t1 P5 XD4_t1 1.21e-17
* device instance cc_P5_XD5_XDFFM_CLKB r0 *1 0,0
Ccc_P5_XD5_XDFFM_CLKB P5 XD5_XDFFM_CLKB 1.8151e-17
* device instance cc_P5_XD5_XDFFM_M r0 *1 0,0
Ccc_P5_XD5_XDFFM_M P5 XD5_XDFFM_M 2.4201e-17
* device instance cc_P5_XD5_XDFFM_MB r0 *1 0,0
Ccc_P5_XD5_XDFFM_MB P5 XD5_XDFFM_MB 1.21e-17
* device instance cc_P5_XD5_XDFFM_S r0 *1 0,0
Ccc_P5_XD5_XDFFM_S P5 XD5_XDFFM_S 1.8151e-17
* device instance cc_P5_XD5_XDFFM_SB r0 *1 0,0
Ccc_P5_XD5_XDFFM_SB P5 XD5_XDFFM_SB 1.8151e-17
* device instance cc_P5_XD5_XDFFQ_CLKB r0 *1 0,0
Ccc_P5_XD5_XDFFQ_CLKB P5 XD5_XDFFQ_CLKB 1.8151e-17
* device instance cc_P5_XD5_XDFFQ_M r0 *1 0,0
Ccc_P5_XD5_XDFFQ_M P5 XD5_XDFFQ_M 2.4201e-17
* device instance cc_P5_XD5_XDFFQ_MB r0 *1 0,0
Ccc_P5_XD5_XDFFQ_MB P5 XD5_XDFFQ_MB 1.21e-17
* device instance cc_P5_XD5_XDFFQ_S r0 *1 0,0
Ccc_P5_XD5_XDFFQ_S P5 XD5_XDFFQ_S 1.8151e-17
* device instance cc_P5_XD5_XDFFQ_SB r0 *1 0,0
Ccc_P5_XD5_XDFFQ_SB P5 XD5_XDFFQ_SB 1.8151e-17
* device instance cc_P5_XD5_XN2_mid1 r0 *1 0,0
Ccc_P5_XD5_XN2_mid1 P5 XD5_XN2_mid1 1.21e-17
* device instance cc_P5_XD5_XN3_mid1 r0 *1 0,0
Ccc_P5_XD5_XN3_mid1 P5 XD5_XN3_mid1 6.05e-18
* device instance cc_P5_XD5_XN3_mid2 r0 *1 0,0
Ccc_P5_XD5_XN3_mid2 P5 XD5_XN3_mid2 1.21e-17
* device instance cc_P5_XD5_dmodout r0 *1 0,0
Ccc_P5_XD5_dmodout P5 XD5_dmodout 1.21e-17
* device instance cc_P5_XD5_dq r0 *1 0,0
Ccc_P5_XD5_dq P5 XD5_dq 1.8151e-17
* device instance cc_P5_XD5_nm r0 *1 0,0
Ccc_P5_XD5_nm P5 XD5_nm 1.21e-17
* device instance cc_P5_XD5_nt r0 *1 0,0
Ccc_P5_XD5_nt P5 XD5_nt 1.21e-17
* device instance cc_P5_XD5_t1 r0 *1 0,0
Ccc_P5_XD5_t1 P5 XD5_t1 1.21e-17
* device instance cc_P5_XFRT_CLKB r0 *1 0,0
Ccc_P5_XFRT_CLKB P5 XFRT_CLKB 1.8151e-17
* device instance cc_P5_XFRT_M r0 *1 0,0
Ccc_P5_XFRT_M P5 XFRT_M 2.4201e-17
* device instance cc_P5_XFRT_MB r0 *1 0,0
Ccc_P5_XFRT_MB P5 XFRT_MB 1.21e-17
* device instance cc_P5_XFRT_S r0 *1 0,0
Ccc_P5_XFRT_S P5 XFRT_S 1.8151e-17
* device instance cc_P5_XFRT_SB r0 *1 0,0
Ccc_P5_XFRT_SB P5 XFRT_SB 1.8151e-17
* device instance cc_P5_ck1 r0 *1 0,0
Ccc_P5_ck1 P5 ck1 5.4452e-17
* device instance cc_P5_ck2 r0 *1 0,0
Ccc_P5_ck2 P5 ck2 5.4452e-17
* device instance cc_P5_ck3 r0 *1 0,0
Ccc_P5_ck3 P5 ck3 5.4452e-17
* device instance cc_P5_ck4 r0 *1 0,0
Ccc_P5_ck4 P5 ck4 5.4452e-17
* device instance cc_P5_ck5 r0 *1 0,0
Ccc_P5_ck5 P5 ck5 5.4452e-17
* device instance cc_P5_mod0 r0 *1 0,0
Ccc_P5_mod0 P5 mod0 2.4201e-17
* device instance cc_P5_mod1 r0 *1 0,0
Ccc_P5_mod1 P5 mod1 2.4201e-17
* device instance cc_P5_mod2 r0 *1 0,0
Ccc_P5_mod2 P5 mod2 2.4201e-17
* device instance cc_P5_mod3 r0 *1 0,0
Ccc_P5_mod3 P5 mod3 2.4201e-17
* device instance cc_P5_mod4 r0 *1 0,0
Ccc_P5_mod4 P5 mod4 2.4201e-17
* device instance cc_P5_net1 r0 *1 0,0
Ccc_P5_net1 P5 net1 1.21e-17
* device instance cc_VDD_DIV_VSS r0 *1 0,0
Ccc_VDD_DIV_VSS VDD_DIV VSS 1.08905e-16
* device instance cc_VDD_DIV_XD0_XDFFM_CLKB r0 *1 0,0
Ccc_VDD_DIV_XD0_XDFFM_CLKB VDD_DIV XD0_XDFFM_CLKB 2.3394e-17
* device instance cc_VDD_DIV_XD0_XDFFM_M r0 *1 0,0
Ccc_VDD_DIV_XD0_XDFFM_M VDD_DIV XD0_XDFFM_M 2.4201e-17
* device instance cc_VDD_DIV_XD0_XDFFM_MB r0 *1 0,0
Ccc_VDD_DIV_XD0_XDFFM_MB VDD_DIV XD0_XDFFM_MB 1.7344e-17
* device instance cc_VDD_DIV_XD0_XDFFM_S r0 *1 0,0
Ccc_VDD_DIV_XD0_XDFFM_S VDD_DIV XD0_XDFFM_S 1.8151e-17
* device instance cc_VDD_DIV_XD0_XDFFM_SB r0 *1 0,0
Ccc_VDD_DIV_XD0_XDFFM_SB VDD_DIV XD0_XDFFM_SB 2.3394e-17
* device instance cc_VDD_DIV_XD0_XDFFQ_CLKB r0 *1 0,0
Ccc_VDD_DIV_XD0_XDFFQ_CLKB VDD_DIV XD0_XDFFQ_CLKB 2.3394e-17
* device instance cc_VDD_DIV_XD0_XDFFQ_M r0 *1 0,0
Ccc_VDD_DIV_XD0_XDFFQ_M VDD_DIV XD0_XDFFQ_M 2.4201e-17
* device instance cc_VDD_DIV_XD0_XDFFQ_MB r0 *1 0,0
Ccc_VDD_DIV_XD0_XDFFQ_MB VDD_DIV XD0_XDFFQ_MB 1.7344e-17
* device instance cc_VDD_DIV_XD0_XDFFQ_S r0 *1 0,0
Ccc_VDD_DIV_XD0_XDFFQ_S VDD_DIV XD0_XDFFQ_S 1.8151e-17
* device instance cc_VDD_DIV_XD0_XDFFQ_SB r0 *1 0,0
Ccc_VDD_DIV_XD0_XDFFQ_SB VDD_DIV XD0_XDFFQ_SB 2.3394e-17
* device instance cc_VDD_DIV_XD0_XNOR_midp r0 *1 0,0
Ccc_VDD_DIV_XD0_XNOR_midp VDD_DIV XD0_XNOR_midp 1.7344e-17
* device instance cc_VDD_DIV_XD0_dmodout r0 *1 0,0
Ccc_VDD_DIV_XD0_dmodout VDD_DIV XD0_dmodout 1.7344e-17
* device instance cc_VDD_DIV_XD0_dq r0 *1 0,0
Ccc_VDD_DIV_XD0_dq VDD_DIV XD0_dq 1.21e-17
* device instance cc_VDD_DIV_XD0_nm r0 *1 0,0
Ccc_VDD_DIV_XD0_nm VDD_DIV XD0_nm 2.8638e-17
* device instance cc_VDD_DIV_XD0_nt r0 *1 0,0
Ccc_VDD_DIV_XD0_nt VDD_DIV XD0_nt 3.9932e-17
* device instance cc_VDD_DIV_XD0_t1 r0 *1 0,0
Ccc_VDD_DIV_XD0_t1 VDD_DIV XD0_t1 1.7344e-17
* device instance cc_VDD_DIV_XD1_XDFFM_CLKB r0 *1 0,0
Ccc_VDD_DIV_XD1_XDFFM_CLKB VDD_DIV XD1_XDFFM_CLKB 2.3394e-17
* device instance cc_VDD_DIV_XD1_XDFFM_M r0 *1 0,0
Ccc_VDD_DIV_XD1_XDFFM_M VDD_DIV XD1_XDFFM_M 2.4201e-17
* device instance cc_VDD_DIV_XD1_XDFFM_MB r0 *1 0,0
Ccc_VDD_DIV_XD1_XDFFM_MB VDD_DIV XD1_XDFFM_MB 1.7344e-17
* device instance cc_VDD_DIV_XD1_XDFFM_S r0 *1 0,0
Ccc_VDD_DIV_XD1_XDFFM_S VDD_DIV XD1_XDFFM_S 1.8151e-17
* device instance cc_VDD_DIV_XD1_XDFFM_SB r0 *1 0,0
Ccc_VDD_DIV_XD1_XDFFM_SB VDD_DIV XD1_XDFFM_SB 2.3394e-17
* device instance cc_VDD_DIV_XD1_XDFFQ_CLKB r0 *1 0,0
Ccc_VDD_DIV_XD1_XDFFQ_CLKB VDD_DIV XD1_XDFFQ_CLKB 2.3394e-17
* device instance cc_VDD_DIV_XD1_XDFFQ_M r0 *1 0,0
Ccc_VDD_DIV_XD1_XDFFQ_M VDD_DIV XD1_XDFFQ_M 2.4201e-17
* device instance cc_VDD_DIV_XD1_XDFFQ_MB r0 *1 0,0
Ccc_VDD_DIV_XD1_XDFFQ_MB VDD_DIV XD1_XDFFQ_MB 1.7344e-17
* device instance cc_VDD_DIV_XD1_XDFFQ_S r0 *1 0,0
Ccc_VDD_DIV_XD1_XDFFQ_S VDD_DIV XD1_XDFFQ_S 1.8151e-17
* device instance cc_VDD_DIV_XD1_XDFFQ_SB r0 *1 0,0
Ccc_VDD_DIV_XD1_XDFFQ_SB VDD_DIV XD1_XDFFQ_SB 2.3394e-17
* device instance cc_VDD_DIV_XD1_XNOR_midp r0 *1 0,0
Ccc_VDD_DIV_XD1_XNOR_midp VDD_DIV XD1_XNOR_midp 1.7344e-17
* device instance cc_VDD_DIV_XD1_dmodout r0 *1 0,0
Ccc_VDD_DIV_XD1_dmodout VDD_DIV XD1_dmodout 1.7344e-17
* device instance cc_VDD_DIV_XD1_dq r0 *1 0,0
Ccc_VDD_DIV_XD1_dq VDD_DIV XD1_dq 1.21e-17
* device instance cc_VDD_DIV_XD1_nm r0 *1 0,0
Ccc_VDD_DIV_XD1_nm VDD_DIV XD1_nm 2.8638e-17
* device instance cc_VDD_DIV_XD1_nt r0 *1 0,0
Ccc_VDD_DIV_XD1_nt VDD_DIV XD1_nt 3.9932e-17
* device instance cc_VDD_DIV_XD1_t1 r0 *1 0,0
Ccc_VDD_DIV_XD1_t1 VDD_DIV XD1_t1 1.7344e-17
* device instance cc_VDD_DIV_XD2_XDFFM_CLKB r0 *1 0,0
Ccc_VDD_DIV_XD2_XDFFM_CLKB VDD_DIV XD2_XDFFM_CLKB 2.3394e-17
* device instance cc_VDD_DIV_XD2_XDFFM_M r0 *1 0,0
Ccc_VDD_DIV_XD2_XDFFM_M VDD_DIV XD2_XDFFM_M 2.4201e-17
* device instance cc_VDD_DIV_XD2_XDFFM_MB r0 *1 0,0
Ccc_VDD_DIV_XD2_XDFFM_MB VDD_DIV XD2_XDFFM_MB 1.7344e-17
* device instance cc_VDD_DIV_XD2_XDFFM_S r0 *1 0,0
Ccc_VDD_DIV_XD2_XDFFM_S VDD_DIV XD2_XDFFM_S 1.8151e-17
* device instance cc_VDD_DIV_XD2_XDFFM_SB r0 *1 0,0
Ccc_VDD_DIV_XD2_XDFFM_SB VDD_DIV XD2_XDFFM_SB 2.3394e-17
* device instance cc_VDD_DIV_XD2_XDFFQ_CLKB r0 *1 0,0
Ccc_VDD_DIV_XD2_XDFFQ_CLKB VDD_DIV XD2_XDFFQ_CLKB 2.3394e-17
* device instance cc_VDD_DIV_XD2_XDFFQ_M r0 *1 0,0
Ccc_VDD_DIV_XD2_XDFFQ_M VDD_DIV XD2_XDFFQ_M 2.4201e-17
* device instance cc_VDD_DIV_XD2_XDFFQ_MB r0 *1 0,0
Ccc_VDD_DIV_XD2_XDFFQ_MB VDD_DIV XD2_XDFFQ_MB 1.7344e-17
* device instance cc_VDD_DIV_XD2_XDFFQ_S r0 *1 0,0
Ccc_VDD_DIV_XD2_XDFFQ_S VDD_DIV XD2_XDFFQ_S 1.8151e-17
* device instance cc_VDD_DIV_XD2_XDFFQ_SB r0 *1 0,0
Ccc_VDD_DIV_XD2_XDFFQ_SB VDD_DIV XD2_XDFFQ_SB 2.3394e-17
* device instance cc_VDD_DIV_XD2_XNOR_midp r0 *1 0,0
Ccc_VDD_DIV_XD2_XNOR_midp VDD_DIV XD2_XNOR_midp 1.7344e-17
* device instance cc_VDD_DIV_XD2_dmodout r0 *1 0,0
Ccc_VDD_DIV_XD2_dmodout VDD_DIV XD2_dmodout 1.7344e-17
* device instance cc_VDD_DIV_XD2_dq r0 *1 0,0
Ccc_VDD_DIV_XD2_dq VDD_DIV XD2_dq 1.21e-17
* device instance cc_VDD_DIV_XD2_nm r0 *1 0,0
Ccc_VDD_DIV_XD2_nm VDD_DIV XD2_nm 2.8638e-17
* device instance cc_VDD_DIV_XD2_nt r0 *1 0,0
Ccc_VDD_DIV_XD2_nt VDD_DIV XD2_nt 3.9932e-17
* device instance cc_VDD_DIV_XD2_t1 r0 *1 0,0
Ccc_VDD_DIV_XD2_t1 VDD_DIV XD2_t1 1.7344e-17
* device instance cc_VDD_DIV_XD3_XDFFM_CLKB r0 *1 0,0
Ccc_VDD_DIV_XD3_XDFFM_CLKB VDD_DIV XD3_XDFFM_CLKB 2.3394e-17
* device instance cc_VDD_DIV_XD3_XDFFM_M r0 *1 0,0
Ccc_VDD_DIV_XD3_XDFFM_M VDD_DIV XD3_XDFFM_M 2.4201e-17
* device instance cc_VDD_DIV_XD3_XDFFM_MB r0 *1 0,0
Ccc_VDD_DIV_XD3_XDFFM_MB VDD_DIV XD3_XDFFM_MB 1.7344e-17
* device instance cc_VDD_DIV_XD3_XDFFM_S r0 *1 0,0
Ccc_VDD_DIV_XD3_XDFFM_S VDD_DIV XD3_XDFFM_S 1.8151e-17
* device instance cc_VDD_DIV_XD3_XDFFM_SB r0 *1 0,0
Ccc_VDD_DIV_XD3_XDFFM_SB VDD_DIV XD3_XDFFM_SB 2.3394e-17
* device instance cc_VDD_DIV_XD3_XDFFQ_CLKB r0 *1 0,0
Ccc_VDD_DIV_XD3_XDFFQ_CLKB VDD_DIV XD3_XDFFQ_CLKB 2.3394e-17
* device instance cc_VDD_DIV_XD3_XDFFQ_M r0 *1 0,0
Ccc_VDD_DIV_XD3_XDFFQ_M VDD_DIV XD3_XDFFQ_M 2.4201e-17
* device instance cc_VDD_DIV_XD3_XDFFQ_MB r0 *1 0,0
Ccc_VDD_DIV_XD3_XDFFQ_MB VDD_DIV XD3_XDFFQ_MB 1.7344e-17
* device instance cc_VDD_DIV_XD3_XDFFQ_S r0 *1 0,0
Ccc_VDD_DIV_XD3_XDFFQ_S VDD_DIV XD3_XDFFQ_S 1.8151e-17
* device instance cc_VDD_DIV_XD3_XDFFQ_SB r0 *1 0,0
Ccc_VDD_DIV_XD3_XDFFQ_SB VDD_DIV XD3_XDFFQ_SB 2.3394e-17
* device instance cc_VDD_DIV_XD3_XNOR_midp r0 *1 0,0
Ccc_VDD_DIV_XD3_XNOR_midp VDD_DIV XD3_XNOR_midp 1.7344e-17
* device instance cc_VDD_DIV_XD3_dmodout r0 *1 0,0
Ccc_VDD_DIV_XD3_dmodout VDD_DIV XD3_dmodout 1.7344e-17
* device instance cc_VDD_DIV_XD3_dq r0 *1 0,0
Ccc_VDD_DIV_XD3_dq VDD_DIV XD3_dq 1.21e-17
* device instance cc_VDD_DIV_XD3_nm r0 *1 0,0
Ccc_VDD_DIV_XD3_nm VDD_DIV XD3_nm 2.8638e-17
* device instance cc_VDD_DIV_XD3_nt r0 *1 0,0
Ccc_VDD_DIV_XD3_nt VDD_DIV XD3_nt 3.9932e-17
* device instance cc_VDD_DIV_XD3_t1 r0 *1 0,0
Ccc_VDD_DIV_XD3_t1 VDD_DIV XD3_t1 1.7344e-17
* device instance cc_VDD_DIV_XD4_XDFFM_CLKB r0 *1 0,0
Ccc_VDD_DIV_XD4_XDFFM_CLKB VDD_DIV XD4_XDFFM_CLKB 2.3394e-17
* device instance cc_VDD_DIV_XD4_XDFFM_M r0 *1 0,0
Ccc_VDD_DIV_XD4_XDFFM_M VDD_DIV XD4_XDFFM_M 2.4201e-17
* device instance cc_VDD_DIV_XD4_XDFFM_MB r0 *1 0,0
Ccc_VDD_DIV_XD4_XDFFM_MB VDD_DIV XD4_XDFFM_MB 1.7344e-17
* device instance cc_VDD_DIV_XD4_XDFFM_S r0 *1 0,0
Ccc_VDD_DIV_XD4_XDFFM_S VDD_DIV XD4_XDFFM_S 1.8151e-17
* device instance cc_VDD_DIV_XD4_XDFFM_SB r0 *1 0,0
Ccc_VDD_DIV_XD4_XDFFM_SB VDD_DIV XD4_XDFFM_SB 2.3394e-17
* device instance cc_VDD_DIV_XD4_XDFFQ_CLKB r0 *1 0,0
Ccc_VDD_DIV_XD4_XDFFQ_CLKB VDD_DIV XD4_XDFFQ_CLKB 2.3394e-17
* device instance cc_VDD_DIV_XD4_XDFFQ_M r0 *1 0,0
Ccc_VDD_DIV_XD4_XDFFQ_M VDD_DIV XD4_XDFFQ_M 2.4201e-17
* device instance cc_VDD_DIV_XD4_XDFFQ_MB r0 *1 0,0
Ccc_VDD_DIV_XD4_XDFFQ_MB VDD_DIV XD4_XDFFQ_MB 1.7344e-17
* device instance cc_VDD_DIV_XD4_XDFFQ_S r0 *1 0,0
Ccc_VDD_DIV_XD4_XDFFQ_S VDD_DIV XD4_XDFFQ_S 1.8151e-17
* device instance cc_VDD_DIV_XD4_XDFFQ_SB r0 *1 0,0
Ccc_VDD_DIV_XD4_XDFFQ_SB VDD_DIV XD4_XDFFQ_SB 2.3394e-17
* device instance cc_VDD_DIV_XD4_XNOR_midp r0 *1 0,0
Ccc_VDD_DIV_XD4_XNOR_midp VDD_DIV XD4_XNOR_midp 1.7344e-17
* device instance cc_VDD_DIV_XD4_dmodout r0 *1 0,0
Ccc_VDD_DIV_XD4_dmodout VDD_DIV XD4_dmodout 1.7344e-17
* device instance cc_VDD_DIV_XD4_dq r0 *1 0,0
Ccc_VDD_DIV_XD4_dq VDD_DIV XD4_dq 1.21e-17
* device instance cc_VDD_DIV_XD4_nm r0 *1 0,0
Ccc_VDD_DIV_XD4_nm VDD_DIV XD4_nm 2.8638e-17
* device instance cc_VDD_DIV_XD4_nt r0 *1 0,0
Ccc_VDD_DIV_XD4_nt VDD_DIV XD4_nt 3.9932e-17
* device instance cc_VDD_DIV_XD4_t1 r0 *1 0,0
Ccc_VDD_DIV_XD4_t1 VDD_DIV XD4_t1 1.7344e-17
* device instance cc_VDD_DIV_XD5_XDFFM_CLKB r0 *1 0,0
Ccc_VDD_DIV_XD5_XDFFM_CLKB VDD_DIV XD5_XDFFM_CLKB 4.1545e-17
* device instance cc_VDD_DIV_XD5_XDFFM_M r0 *1 0,0
Ccc_VDD_DIV_XD5_XDFFM_M VDD_DIV XD5_XDFFM_M 4.8402e-17
* device instance cc_VDD_DIV_XD5_XDFFM_MB r0 *1 0,0
Ccc_VDD_DIV_XD5_XDFFM_MB VDD_DIV XD5_XDFFM_MB 2.9445e-17
* device instance cc_VDD_DIV_XD5_XDFFM_S r0 *1 0,0
Ccc_VDD_DIV_XD5_XDFFM_S VDD_DIV XD5_XDFFM_S 3.6302e-17
* device instance cc_VDD_DIV_XD5_XDFFM_SB r0 *1 0,0
Ccc_VDD_DIV_XD5_XDFFM_SB VDD_DIV XD5_XDFFM_SB 4.1545e-17
* device instance cc_VDD_DIV_XD5_XDFFQ_CLKB r0 *1 0,0
Ccc_VDD_DIV_XD5_XDFFQ_CLKB VDD_DIV XD5_XDFFQ_CLKB 4.1545e-17
* device instance cc_VDD_DIV_XD5_XDFFQ_M r0 *1 0,0
Ccc_VDD_DIV_XD5_XDFFQ_M VDD_DIV XD5_XDFFQ_M 4.8402e-17
* device instance cc_VDD_DIV_XD5_XDFFQ_MB r0 *1 0,0
Ccc_VDD_DIV_XD5_XDFFQ_MB VDD_DIV XD5_XDFFQ_MB 2.9445e-17
* device instance cc_VDD_DIV_XD5_XDFFQ_S r0 *1 0,0
Ccc_VDD_DIV_XD5_XDFFQ_S VDD_DIV XD5_XDFFQ_S 3.6302e-17
* device instance cc_VDD_DIV_XD5_XDFFQ_SB r0 *1 0,0
Ccc_VDD_DIV_XD5_XDFFQ_SB VDD_DIV XD5_XDFFQ_SB 4.1545e-17
* device instance cc_VDD_DIV_XD5_XN2_mid1 r0 *1 0,0
Ccc_VDD_DIV_XD5_XN2_mid1 VDD_DIV XD5_XN2_mid1 1.21e-17
* device instance cc_VDD_DIV_XD5_XN3_mid1 r0 *1 0,0
Ccc_VDD_DIV_XD5_XN3_mid1 VDD_DIV XD5_XN3_mid1 1.21e-17
* device instance cc_VDD_DIV_XD5_XN3_mid2 r0 *1 0,0
Ccc_VDD_DIV_XD5_XN3_mid2 VDD_DIV XD5_XN3_mid2 1.21e-17
* device instance cc_VDD_DIV_XD5_XNOR_midp r0 *1 0,0
Ccc_VDD_DIV_XD5_XNOR_midp VDD_DIV XD5_XNOR_midp 1.7344e-17
* device instance cc_VDD_DIV_XD5_dmodout r0 *1 0,0
Ccc_VDD_DIV_XD5_dmodout VDD_DIV XD5_dmodout 2.9445e-17
* device instance cc_VDD_DIV_XD5_dq r0 *1 0,0
Ccc_VDD_DIV_XD5_dq VDD_DIV XD5_dq 3.0251e-17
* device instance cc_VDD_DIV_XD5_nm r0 *1 0,0
Ccc_VDD_DIV_XD5_nm VDD_DIV XD5_nm 4.0738e-17
* device instance cc_VDD_DIV_XD5_nt r0 *1 0,0
Ccc_VDD_DIV_XD5_nt VDD_DIV XD5_nt 5.2032e-17
* device instance cc_VDD_DIV_XD5_t1 r0 *1 0,0
Ccc_VDD_DIV_XD5_t1 VDD_DIV XD5_t1 2.9445e-17
* device instance cc_VDD_DIV_XFRT_CLKB r0 *1 0,0
Ccc_VDD_DIV_XFRT_CLKB VDD_DIV XFRT_CLKB 4.1545e-17
* device instance cc_VDD_DIV_XFRT_M r0 *1 0,0
Ccc_VDD_DIV_XFRT_M VDD_DIV XFRT_M 4.8402e-17
* device instance cc_VDD_DIV_XFRT_MB r0 *1 0,0
Ccc_VDD_DIV_XFRT_MB VDD_DIV XFRT_MB 2.9445e-17
* device instance cc_VDD_DIV_XFRT_S r0 *1 0,0
Ccc_VDD_DIV_XFRT_S VDD_DIV XFRT_S 3.6302e-17
* device instance cc_VDD_DIV_XFRT_SB r0 *1 0,0
Ccc_VDD_DIV_XFRT_SB VDD_DIV XFRT_SB 4.1545e-17
* device instance cc_VDD_DIV_ck1 r0 *1 0,0
Ccc_VDD_DIV_ck1 VDD_DIV ck1 5.9696e-17
* device instance cc_VDD_DIV_ck2 r0 *1 0,0
Ccc_VDD_DIV_ck2 VDD_DIV ck2 5.9696e-17
* device instance cc_VDD_DIV_ck3 r0 *1 0,0
Ccc_VDD_DIV_ck3 VDD_DIV ck3 5.9696e-17
* device instance cc_VDD_DIV_ck4 r0 *1 0,0
Ccc_VDD_DIV_ck4 VDD_DIV ck4 5.9696e-17
* device instance cc_VDD_DIV_ck5 r0 *1 0,0
Ccc_VDD_DIV_ck5 VDD_DIV ck5 9.5997e-17
* device instance cc_VDD_DIV_mod0 r0 *1 0,0
Ccc_VDD_DIV_mod0 VDD_DIV mod0 2.9445e-17
* device instance cc_VDD_DIV_mod1 r0 *1 0,0
Ccc_VDD_DIV_mod1 VDD_DIV mod1 2.9445e-17
* device instance cc_VDD_DIV_mod2 r0 *1 0,0
Ccc_VDD_DIV_mod2 VDD_DIV mod2 2.9445e-17
* device instance cc_VDD_DIV_mod3 r0 *1 0,0
Ccc_VDD_DIV_mod3 VDD_DIV mod3 2.9445e-17
* device instance cc_VDD_DIV_mod4 r0 *1 0,0
Ccc_VDD_DIV_mod4 VDD_DIV mod4 4.1545e-17
* device instance cc_VDD_DIV_net1 r0 *1 0,0
Ccc_VDD_DIV_net1 VDD_DIV net1 1.7344e-17
* device instance cc_VSS_XD0_XDFFM_CLKB r0 *1 0,0
Ccc_VSS_XD0_XDFFM_CLKB VSS XD0_XDFFM_CLKB 2.3394e-17
* device instance cc_VSS_XD0_XDFFM_M r0 *1 0,0
Ccc_VSS_XD0_XDFFM_M VSS XD0_XDFFM_M 2.4201e-17
* device instance cc_VSS_XD0_XDFFM_MB r0 *1 0,0
Ccc_VSS_XD0_XDFFM_MB VSS XD0_XDFFM_MB 1.7344e-17
* device instance cc_VSS_XD0_XDFFM_S r0 *1 0,0
Ccc_VSS_XD0_XDFFM_S VSS XD0_XDFFM_S 1.8151e-17
* device instance cc_VSS_XD0_XDFFM_SB r0 *1 0,0
Ccc_VSS_XD0_XDFFM_SB VSS XD0_XDFFM_SB 2.3394e-17
* device instance cc_VSS_XD0_XDFFQ_CLKB r0 *1 0,0
Ccc_VSS_XD0_XDFFQ_CLKB VSS XD0_XDFFQ_CLKB 2.3394e-17
* device instance cc_VSS_XD0_XDFFQ_M r0 *1 0,0
Ccc_VSS_XD0_XDFFQ_M VSS XD0_XDFFQ_M 2.4201e-17
* device instance cc_VSS_XD0_XDFFQ_MB r0 *1 0,0
Ccc_VSS_XD0_XDFFQ_MB VSS XD0_XDFFQ_MB 1.7344e-17
* device instance cc_VSS_XD0_XDFFQ_S r0 *1 0,0
Ccc_VSS_XD0_XDFFQ_S VSS XD0_XDFFQ_S 1.8151e-17
* device instance cc_VSS_XD0_XDFFQ_SB r0 *1 0,0
Ccc_VSS_XD0_XDFFQ_SB VSS XD0_XDFFQ_SB 2.3394e-17
* device instance cc_VSS_XD0_XN2_mid1 r0 *1 0,0
Ccc_VSS_XD0_XN2_mid1 VSS XD0_XN2_mid1 1.7344e-17
* device instance cc_VSS_XD0_XN3_mid1 r0 *1 0,0
Ccc_VSS_XD0_XN3_mid1 VSS XD0_XN3_mid1 1.21e-17
* device instance cc_VSS_XD0_XN3_mid2 r0 *1 0,0
Ccc_VSS_XD0_XN3_mid2 VSS XD0_XN3_mid2 1.7344e-17
* device instance cc_VSS_XD0_dmodout r0 *1 0,0
Ccc_VSS_XD0_dmodout VSS XD0_dmodout 1.7344e-17
* device instance cc_VSS_XD0_dq r0 *1 0,0
Ccc_VSS_XD0_dq VSS XD0_dq 2.8638e-17
* device instance cc_VSS_XD0_nm r0 *1 0,0
Ccc_VSS_XD0_nm VSS XD0_nm 1.21e-17
* device instance cc_VSS_XD0_nt r0 *1 0,0
Ccc_VSS_XD0_nt VSS XD0_nt 1.21e-17
* device instance cc_VSS_XD0_t1 r0 *1 0,0
Ccc_VSS_XD0_t1 VSS XD0_t1 1.7344e-17
* device instance cc_VSS_XD1_XDFFM_CLKB r0 *1 0,0
Ccc_VSS_XD1_XDFFM_CLKB VSS XD1_XDFFM_CLKB 2.3394e-17
* device instance cc_VSS_XD1_XDFFM_M r0 *1 0,0
Ccc_VSS_XD1_XDFFM_M VSS XD1_XDFFM_M 2.4201e-17
* device instance cc_VSS_XD1_XDFFM_MB r0 *1 0,0
Ccc_VSS_XD1_XDFFM_MB VSS XD1_XDFFM_MB 1.7344e-17
* device instance cc_VSS_XD1_XDFFM_S r0 *1 0,0
Ccc_VSS_XD1_XDFFM_S VSS XD1_XDFFM_S 1.8151e-17
* device instance cc_VSS_XD1_XDFFM_SB r0 *1 0,0
Ccc_VSS_XD1_XDFFM_SB VSS XD1_XDFFM_SB 2.3394e-17
* device instance cc_VSS_XD1_XDFFQ_CLKB r0 *1 0,0
Ccc_VSS_XD1_XDFFQ_CLKB VSS XD1_XDFFQ_CLKB 2.3394e-17
* device instance cc_VSS_XD1_XDFFQ_M r0 *1 0,0
Ccc_VSS_XD1_XDFFQ_M VSS XD1_XDFFQ_M 2.4201e-17
* device instance cc_VSS_XD1_XDFFQ_MB r0 *1 0,0
Ccc_VSS_XD1_XDFFQ_MB VSS XD1_XDFFQ_MB 1.7344e-17
* device instance cc_VSS_XD1_XDFFQ_S r0 *1 0,0
Ccc_VSS_XD1_XDFFQ_S VSS XD1_XDFFQ_S 1.8151e-17
* device instance cc_VSS_XD1_XDFFQ_SB r0 *1 0,0
Ccc_VSS_XD1_XDFFQ_SB VSS XD1_XDFFQ_SB 2.3394e-17
* device instance cc_VSS_XD1_XN2_mid1 r0 *1 0,0
Ccc_VSS_XD1_XN2_mid1 VSS XD1_XN2_mid1 1.7344e-17
* device instance cc_VSS_XD1_XN3_mid1 r0 *1 0,0
Ccc_VSS_XD1_XN3_mid1 VSS XD1_XN3_mid1 1.21e-17
* device instance cc_VSS_XD1_XN3_mid2 r0 *1 0,0
Ccc_VSS_XD1_XN3_mid2 VSS XD1_XN3_mid2 1.7344e-17
* device instance cc_VSS_XD1_dmodout r0 *1 0,0
Ccc_VSS_XD1_dmodout VSS XD1_dmodout 1.7344e-17
* device instance cc_VSS_XD1_dq r0 *1 0,0
Ccc_VSS_XD1_dq VSS XD1_dq 2.8638e-17
* device instance cc_VSS_XD1_nm r0 *1 0,0
Ccc_VSS_XD1_nm VSS XD1_nm 1.21e-17
* device instance cc_VSS_XD1_nt r0 *1 0,0
Ccc_VSS_XD1_nt VSS XD1_nt 1.21e-17
* device instance cc_VSS_XD1_t1 r0 *1 0,0
Ccc_VSS_XD1_t1 VSS XD1_t1 1.7344e-17
* device instance cc_VSS_XD2_XDFFM_CLKB r0 *1 0,0
Ccc_VSS_XD2_XDFFM_CLKB VSS XD2_XDFFM_CLKB 2.3394e-17
* device instance cc_VSS_XD2_XDFFM_M r0 *1 0,0
Ccc_VSS_XD2_XDFFM_M VSS XD2_XDFFM_M 2.4201e-17
* device instance cc_VSS_XD2_XDFFM_MB r0 *1 0,0
Ccc_VSS_XD2_XDFFM_MB VSS XD2_XDFFM_MB 1.7344e-17
* device instance cc_VSS_XD2_XDFFM_S r0 *1 0,0
Ccc_VSS_XD2_XDFFM_S VSS XD2_XDFFM_S 1.8151e-17
* device instance cc_VSS_XD2_XDFFM_SB r0 *1 0,0
Ccc_VSS_XD2_XDFFM_SB VSS XD2_XDFFM_SB 2.3394e-17
* device instance cc_VSS_XD2_XDFFQ_CLKB r0 *1 0,0
Ccc_VSS_XD2_XDFFQ_CLKB VSS XD2_XDFFQ_CLKB 2.3394e-17
* device instance cc_VSS_XD2_XDFFQ_M r0 *1 0,0
Ccc_VSS_XD2_XDFFQ_M VSS XD2_XDFFQ_M 2.4201e-17
* device instance cc_VSS_XD2_XDFFQ_MB r0 *1 0,0
Ccc_VSS_XD2_XDFFQ_MB VSS XD2_XDFFQ_MB 1.7344e-17
* device instance cc_VSS_XD2_XDFFQ_S r0 *1 0,0
Ccc_VSS_XD2_XDFFQ_S VSS XD2_XDFFQ_S 1.8151e-17
* device instance cc_VSS_XD2_XDFFQ_SB r0 *1 0,0
Ccc_VSS_XD2_XDFFQ_SB VSS XD2_XDFFQ_SB 2.3394e-17
* device instance cc_VSS_XD2_XN2_mid1 r0 *1 0,0
Ccc_VSS_XD2_XN2_mid1 VSS XD2_XN2_mid1 1.7344e-17
* device instance cc_VSS_XD2_XN3_mid1 r0 *1 0,0
Ccc_VSS_XD2_XN3_mid1 VSS XD2_XN3_mid1 1.21e-17
* device instance cc_VSS_XD2_XN3_mid2 r0 *1 0,0
Ccc_VSS_XD2_XN3_mid2 VSS XD2_XN3_mid2 1.7344e-17
* device instance cc_VSS_XD2_dmodout r0 *1 0,0
Ccc_VSS_XD2_dmodout VSS XD2_dmodout 1.7344e-17
* device instance cc_VSS_XD2_dq r0 *1 0,0
Ccc_VSS_XD2_dq VSS XD2_dq 2.8638e-17
* device instance cc_VSS_XD2_nm r0 *1 0,0
Ccc_VSS_XD2_nm VSS XD2_nm 1.21e-17
* device instance cc_VSS_XD2_nt r0 *1 0,0
Ccc_VSS_XD2_nt VSS XD2_nt 1.21e-17
* device instance cc_VSS_XD2_t1 r0 *1 0,0
Ccc_VSS_XD2_t1 VSS XD2_t1 1.7344e-17
* device instance cc_VSS_XD3_XDFFM_CLKB r0 *1 0,0
Ccc_VSS_XD3_XDFFM_CLKB VSS XD3_XDFFM_CLKB 2.3394e-17
* device instance cc_VSS_XD3_XDFFM_M r0 *1 0,0
Ccc_VSS_XD3_XDFFM_M VSS XD3_XDFFM_M 2.4201e-17
* device instance cc_VSS_XD3_XDFFM_MB r0 *1 0,0
Ccc_VSS_XD3_XDFFM_MB VSS XD3_XDFFM_MB 1.7344e-17
* device instance cc_VSS_XD3_XDFFM_S r0 *1 0,0
Ccc_VSS_XD3_XDFFM_S VSS XD3_XDFFM_S 1.8151e-17
* device instance cc_VSS_XD3_XDFFM_SB r0 *1 0,0
Ccc_VSS_XD3_XDFFM_SB VSS XD3_XDFFM_SB 2.3394e-17
* device instance cc_VSS_XD3_XDFFQ_CLKB r0 *1 0,0
Ccc_VSS_XD3_XDFFQ_CLKB VSS XD3_XDFFQ_CLKB 2.3394e-17
* device instance cc_VSS_XD3_XDFFQ_M r0 *1 0,0
Ccc_VSS_XD3_XDFFQ_M VSS XD3_XDFFQ_M 2.4201e-17
* device instance cc_VSS_XD3_XDFFQ_MB r0 *1 0,0
Ccc_VSS_XD3_XDFFQ_MB VSS XD3_XDFFQ_MB 1.7344e-17
* device instance cc_VSS_XD3_XDFFQ_S r0 *1 0,0
Ccc_VSS_XD3_XDFFQ_S VSS XD3_XDFFQ_S 1.8151e-17
* device instance cc_VSS_XD3_XDFFQ_SB r0 *1 0,0
Ccc_VSS_XD3_XDFFQ_SB VSS XD3_XDFFQ_SB 2.3394e-17
* device instance cc_VSS_XD3_XN2_mid1 r0 *1 0,0
Ccc_VSS_XD3_XN2_mid1 VSS XD3_XN2_mid1 1.7344e-17
* device instance cc_VSS_XD3_XN3_mid1 r0 *1 0,0
Ccc_VSS_XD3_XN3_mid1 VSS XD3_XN3_mid1 1.21e-17
* device instance cc_VSS_XD3_XN3_mid2 r0 *1 0,0
Ccc_VSS_XD3_XN3_mid2 VSS XD3_XN3_mid2 1.7344e-17
* device instance cc_VSS_XD3_dmodout r0 *1 0,0
Ccc_VSS_XD3_dmodout VSS XD3_dmodout 1.7344e-17
* device instance cc_VSS_XD3_dq r0 *1 0,0
Ccc_VSS_XD3_dq VSS XD3_dq 2.8638e-17
* device instance cc_VSS_XD3_nm r0 *1 0,0
Ccc_VSS_XD3_nm VSS XD3_nm 1.21e-17
* device instance cc_VSS_XD3_nt r0 *1 0,0
Ccc_VSS_XD3_nt VSS XD3_nt 1.21e-17
* device instance cc_VSS_XD3_t1 r0 *1 0,0
Ccc_VSS_XD3_t1 VSS XD3_t1 1.7344e-17
* device instance cc_VSS_XD4_XDFFM_CLKB r0 *1 0,0
Ccc_VSS_XD4_XDFFM_CLKB VSS XD4_XDFFM_CLKB 2.3394e-17
* device instance cc_VSS_XD4_XDFFM_M r0 *1 0,0
Ccc_VSS_XD4_XDFFM_M VSS XD4_XDFFM_M 2.4201e-17
* device instance cc_VSS_XD4_XDFFM_MB r0 *1 0,0
Ccc_VSS_XD4_XDFFM_MB VSS XD4_XDFFM_MB 1.7344e-17
* device instance cc_VSS_XD4_XDFFM_S r0 *1 0,0
Ccc_VSS_XD4_XDFFM_S VSS XD4_XDFFM_S 1.8151e-17
* device instance cc_VSS_XD4_XDFFM_SB r0 *1 0,0
Ccc_VSS_XD4_XDFFM_SB VSS XD4_XDFFM_SB 2.3394e-17
* device instance cc_VSS_XD4_XDFFQ_CLKB r0 *1 0,0
Ccc_VSS_XD4_XDFFQ_CLKB VSS XD4_XDFFQ_CLKB 2.3394e-17
* device instance cc_VSS_XD4_XDFFQ_M r0 *1 0,0
Ccc_VSS_XD4_XDFFQ_M VSS XD4_XDFFQ_M 2.4201e-17
* device instance cc_VSS_XD4_XDFFQ_MB r0 *1 0,0
Ccc_VSS_XD4_XDFFQ_MB VSS XD4_XDFFQ_MB 1.7344e-17
* device instance cc_VSS_XD4_XDFFQ_S r0 *1 0,0
Ccc_VSS_XD4_XDFFQ_S VSS XD4_XDFFQ_S 1.8151e-17
* device instance cc_VSS_XD4_XDFFQ_SB r0 *1 0,0
Ccc_VSS_XD4_XDFFQ_SB VSS XD4_XDFFQ_SB 2.3394e-17
* device instance cc_VSS_XD4_XN2_mid1 r0 *1 0,0
Ccc_VSS_XD4_XN2_mid1 VSS XD4_XN2_mid1 1.7344e-17
* device instance cc_VSS_XD4_XN3_mid1 r0 *1 0,0
Ccc_VSS_XD4_XN3_mid1 VSS XD4_XN3_mid1 1.21e-17
* device instance cc_VSS_XD4_XN3_mid2 r0 *1 0,0
Ccc_VSS_XD4_XN3_mid2 VSS XD4_XN3_mid2 1.7344e-17
* device instance cc_VSS_XD4_dmodout r0 *1 0,0
Ccc_VSS_XD4_dmodout VSS XD4_dmodout 1.7344e-17
* device instance cc_VSS_XD4_dq r0 *1 0,0
Ccc_VSS_XD4_dq VSS XD4_dq 2.8638e-17
* device instance cc_VSS_XD4_nm r0 *1 0,0
Ccc_VSS_XD4_nm VSS XD4_nm 1.21e-17
* device instance cc_VSS_XD4_nt r0 *1 0,0
Ccc_VSS_XD4_nt VSS XD4_nt 1.21e-17
* device instance cc_VSS_XD4_t1 r0 *1 0,0
Ccc_VSS_XD4_t1 VSS XD4_t1 1.7344e-17
* device instance cc_VSS_XD5_XDFFM_CLKB r0 *1 0,0
Ccc_VSS_XD5_XDFFM_CLKB VSS XD5_XDFFM_CLKB 2.3394e-17
* device instance cc_VSS_XD5_XDFFM_M r0 *1 0,0
Ccc_VSS_XD5_XDFFM_M VSS XD5_XDFFM_M 2.4201e-17
* device instance cc_VSS_XD5_XDFFM_MB r0 *1 0,0
Ccc_VSS_XD5_XDFFM_MB VSS XD5_XDFFM_MB 1.7344e-17
* device instance cc_VSS_XD5_XDFFM_S r0 *1 0,0
Ccc_VSS_XD5_XDFFM_S VSS XD5_XDFFM_S 1.8151e-17
* device instance cc_VSS_XD5_XDFFM_SB r0 *1 0,0
Ccc_VSS_XD5_XDFFM_SB VSS XD5_XDFFM_SB 2.3394e-17
* device instance cc_VSS_XD5_XDFFQ_CLKB r0 *1 0,0
Ccc_VSS_XD5_XDFFQ_CLKB VSS XD5_XDFFQ_CLKB 2.3394e-17
* device instance cc_VSS_XD5_XDFFQ_M r0 *1 0,0
Ccc_VSS_XD5_XDFFQ_M VSS XD5_XDFFQ_M 2.4201e-17
* device instance cc_VSS_XD5_XDFFQ_MB r0 *1 0,0
Ccc_VSS_XD5_XDFFQ_MB VSS XD5_XDFFQ_MB 1.7344e-17
* device instance cc_VSS_XD5_XDFFQ_S r0 *1 0,0
Ccc_VSS_XD5_XDFFQ_S VSS XD5_XDFFQ_S 1.8151e-17
* device instance cc_VSS_XD5_XDFFQ_SB r0 *1 0,0
Ccc_VSS_XD5_XDFFQ_SB VSS XD5_XDFFQ_SB 2.3394e-17
* device instance cc_VSS_XD5_XN2_mid1 r0 *1 0,0
Ccc_VSS_XD5_XN2_mid1 VSS XD5_XN2_mid1 1.7344e-17
* device instance cc_VSS_XD5_XN3_mid1 r0 *1 0,0
Ccc_VSS_XD5_XN3_mid1 VSS XD5_XN3_mid1 1.21e-17
* device instance cc_VSS_XD5_XN3_mid2 r0 *1 0,0
Ccc_VSS_XD5_XN3_mid2 VSS XD5_XN3_mid2 1.7344e-17
* device instance cc_VSS_XD5_dmodout r0 *1 0,0
Ccc_VSS_XD5_dmodout VSS XD5_dmodout 1.7344e-17
* device instance cc_VSS_XD5_dq r0 *1 0,0
Ccc_VSS_XD5_dq VSS XD5_dq 2.8638e-17
* device instance cc_VSS_XD5_nm r0 *1 0,0
Ccc_VSS_XD5_nm VSS XD5_nm 1.21e-17
* device instance cc_VSS_XD5_nt r0 *1 0,0
Ccc_VSS_XD5_nt VSS XD5_nt 1.21e-17
* device instance cc_VSS_XD5_t1 r0 *1 0,0
Ccc_VSS_XD5_t1 VSS XD5_t1 1.7344e-17
* device instance cc_VSS_XFRT_CLKB r0 *1 0,0
Ccc_VSS_XFRT_CLKB VSS XFRT_CLKB 2.3394e-17
* device instance cc_VSS_XFRT_M r0 *1 0,0
Ccc_VSS_XFRT_M VSS XFRT_M 2.4201e-17
* device instance cc_VSS_XFRT_MB r0 *1 0,0
Ccc_VSS_XFRT_MB VSS XFRT_MB 1.7344e-17
* device instance cc_VSS_XFRT_S r0 *1 0,0
Ccc_VSS_XFRT_S VSS XFRT_S 1.8151e-17
* device instance cc_VSS_XFRT_SB r0 *1 0,0
Ccc_VSS_XFRT_SB VSS XFRT_SB 2.3394e-17
* device instance cc_VSS_ck1 r0 *1 0,0
Ccc_VSS_ck1 VSS ck1 5.9696e-17
* device instance cc_VSS_ck2 r0 *1 0,0
Ccc_VSS_ck2 VSS ck2 5.9696e-17
* device instance cc_VSS_ck3 r0 *1 0,0
Ccc_VSS_ck3 VSS ck3 5.9696e-17
* device instance cc_VSS_ck4 r0 *1 0,0
Ccc_VSS_ck4 VSS ck4 5.9696e-17
* device instance cc_VSS_ck5 r0 *1 0,0
Ccc_VSS_ck5 VSS ck5 5.9696e-17
* device instance cc_VSS_mod0 r0 *1 0,0
Ccc_VSS_mod0 VSS mod0 2.9445e-17
* device instance cc_VSS_mod1 r0 *1 0,0
Ccc_VSS_mod1 VSS mod1 2.9445e-17
* device instance cc_VSS_mod2 r0 *1 0,0
Ccc_VSS_mod2 VSS mod2 2.9445e-17
* device instance cc_VSS_mod3 r0 *1 0,0
Ccc_VSS_mod3 VSS mod3 2.9445e-17
* device instance cc_VSS_mod4 r0 *1 0,0
Ccc_VSS_mod4 VSS mod4 2.9445e-17
* device instance cc_VSS_net1 r0 *1 0,0
Ccc_VSS_net1 VSS net1 1.7344e-17
* device instance cc_XD0_XDFFM_CLKB_XD0_XDFFM_M r0 *1 0,0
Ccc_XD0_XDFFM_CLKB_XD0_XDFFM_M XD0_XDFFM_CLKB XD0_XDFFM_M 4.2352e-17
* device instance cc_XD0_XDFFM_CLKB_XD0_XDFFM_MB r0 *1 0,0
Ccc_XD0_XDFFM_CLKB_XD0_XDFFM_MB XD0_XDFFM_CLKB XD0_XDFFM_MB 2.4201e-17
* device instance cc_XD0_XDFFM_CLKB_XD0_XDFFM_S r0 *1 0,0
Ccc_XD0_XDFFM_CLKB_XD0_XDFFM_S XD0_XDFFM_CLKB XD0_XDFFM_S 1.8151e-17
* device instance cc_XD0_XDFFM_CLKB_XD0_XDFFM_SB r0 *1 0,0
Ccc_XD0_XDFFM_CLKB_XD0_XDFFM_SB XD0_XDFFM_CLKB XD0_XDFFM_SB 1.8151e-17
* device instance cc_XD0_XDFFM_CLKB_XD0_XDFFQ_CLKB r0 *1 0,0
Ccc_XD0_XDFFM_CLKB_XD0_XDFFQ_CLKB XD0_XDFFM_CLKB XD0_XDFFQ_CLKB 1.8151e-17
* device instance cc_XD0_XDFFM_CLKB_XD0_XDFFQ_M r0 *1 0,0
Ccc_XD0_XDFFM_CLKB_XD0_XDFFQ_M XD0_XDFFM_CLKB XD0_XDFFQ_M 2.4201e-17
* device instance cc_XD0_XDFFM_CLKB_XD0_XDFFQ_MB r0 *1 0,0
Ccc_XD0_XDFFM_CLKB_XD0_XDFFQ_MB XD0_XDFFM_CLKB XD0_XDFFQ_MB 1.21e-17
* device instance cc_XD0_XDFFM_CLKB_XD0_XDFFQ_S r0 *1 0,0
Ccc_XD0_XDFFM_CLKB_XD0_XDFFQ_S XD0_XDFFM_CLKB XD0_XDFFQ_S 1.8151e-17
* device instance cc_XD0_XDFFM_CLKB_XD0_XDFFQ_SB r0 *1 0,0
Ccc_XD0_XDFFM_CLKB_XD0_XDFFQ_SB XD0_XDFFM_CLKB XD0_XDFFQ_SB 1.8151e-17
* device instance cc_XD0_XDFFM_CLKB_XD0_XNOR_midp r0 *1 0,0
Ccc_XD0_XDFFM_CLKB_XD0_XNOR_midp XD0_XDFFM_CLKB XD0_XNOR_midp 1.21e-17
* device instance cc_XD0_XDFFM_CLKB_XD0_dmodout r0 *1 0,0
Ccc_XD0_XDFFM_CLKB_XD0_dmodout XD0_XDFFM_CLKB XD0_dmodout 1.8151e-17
* device instance cc_XD0_XDFFM_CLKB_XD0_dq r0 *1 0,0
Ccc_XD0_XDFFM_CLKB_XD0_dq XD0_XDFFM_CLKB XD0_dq 1.21e-17
* device instance cc_XD0_XDFFM_CLKB_XD0_nm r0 *1 0,0
Ccc_XD0_XDFFM_CLKB_XD0_nm XD0_XDFFM_CLKB XD0_nm 1.8151e-17
* device instance cc_XD0_XDFFM_CLKB_XD0_nt r0 *1 0,0
Ccc_XD0_XDFFM_CLKB_XD0_nt XD0_XDFFM_CLKB XD0_nt 2.4201e-17
* device instance cc_XD0_XDFFM_CLKB_XD0_t1 r0 *1 0,0
Ccc_XD0_XDFFM_CLKB_XD0_t1 XD0_XDFFM_CLKB XD0_t1 1.21e-17
* device instance cc_XD0_XDFFM_CLKB_XD1_XDFFM_CLKB r0 *1 0,0
Ccc_XD0_XDFFM_CLKB_XD1_XDFFM_CLKB XD0_XDFFM_CLKB XD1_XDFFM_CLKB 1.8151e-17
* device instance cc_XD0_XDFFM_CLKB_XD1_XDFFM_M r0 *1 0,0
Ccc_XD0_XDFFM_CLKB_XD1_XDFFM_M XD0_XDFFM_CLKB XD1_XDFFM_M 2.4201e-17
* device instance cc_XD0_XDFFM_CLKB_XD1_XDFFM_MB r0 *1 0,0
Ccc_XD0_XDFFM_CLKB_XD1_XDFFM_MB XD0_XDFFM_CLKB XD1_XDFFM_MB 1.21e-17
* device instance cc_XD0_XDFFM_CLKB_XD1_XDFFM_S r0 *1 0,0
Ccc_XD0_XDFFM_CLKB_XD1_XDFFM_S XD0_XDFFM_CLKB XD1_XDFFM_S 1.8151e-17
* device instance cc_XD0_XDFFM_CLKB_XD1_XDFFM_SB r0 *1 0,0
Ccc_XD0_XDFFM_CLKB_XD1_XDFFM_SB XD0_XDFFM_CLKB XD1_XDFFM_SB 1.8151e-17
* device instance cc_XD0_XDFFM_CLKB_XD1_XDFFQ_CLKB r0 *1 0,0
Ccc_XD0_XDFFM_CLKB_XD1_XDFFQ_CLKB XD0_XDFFM_CLKB XD1_XDFFQ_CLKB 1.8151e-17
* device instance cc_XD0_XDFFM_CLKB_XD1_XDFFQ_M r0 *1 0,0
Ccc_XD0_XDFFM_CLKB_XD1_XDFFQ_M XD0_XDFFM_CLKB XD1_XDFFQ_M 2.4201e-17
* device instance cc_XD0_XDFFM_CLKB_XD1_XDFFQ_MB r0 *1 0,0
Ccc_XD0_XDFFM_CLKB_XD1_XDFFQ_MB XD0_XDFFM_CLKB XD1_XDFFQ_MB 1.21e-17
* device instance cc_XD0_XDFFM_CLKB_XD1_XDFFQ_S r0 *1 0,0
Ccc_XD0_XDFFM_CLKB_XD1_XDFFQ_S XD0_XDFFM_CLKB XD1_XDFFQ_S 1.8151e-17
* device instance cc_XD0_XDFFM_CLKB_XD1_XDFFQ_SB r0 *1 0,0
Ccc_XD0_XDFFM_CLKB_XD1_XDFFQ_SB XD0_XDFFM_CLKB XD1_XDFFQ_SB 1.8151e-17
* device instance cc_XD0_XDFFM_CLKB_XD1_XN2_mid1 r0 *1 0,0
Ccc_XD0_XDFFM_CLKB_XD1_XN2_mid1 XD0_XDFFM_CLKB XD1_XN2_mid1 1.21e-17
* device instance cc_XD0_XDFFM_CLKB_XD1_XN3_mid1 r0 *1 0,0
Ccc_XD0_XDFFM_CLKB_XD1_XN3_mid1 XD0_XDFFM_CLKB XD1_XN3_mid1 1.21e-17
* device instance cc_XD0_XDFFM_CLKB_XD1_XN3_mid2 r0 *1 0,0
Ccc_XD0_XDFFM_CLKB_XD1_XN3_mid2 XD0_XDFFM_CLKB XD1_XN3_mid2 1.21e-17
* device instance cc_XD0_XDFFM_CLKB_XD1_dmodout r0 *1 0,0
Ccc_XD0_XDFFM_CLKB_XD1_dmodout XD0_XDFFM_CLKB XD1_dmodout 1.21e-17
* device instance cc_XD0_XDFFM_CLKB_XD1_dq r0 *1 0,0
Ccc_XD0_XDFFM_CLKB_XD1_dq XD0_XDFFM_CLKB XD1_dq 1.8151e-17
* device instance cc_XD0_XDFFM_CLKB_XD1_nm r0 *1 0,0
Ccc_XD0_XDFFM_CLKB_XD1_nm XD0_XDFFM_CLKB XD1_nm 1.21e-17
* device instance cc_XD0_XDFFM_CLKB_XD1_nt r0 *1 0,0
Ccc_XD0_XDFFM_CLKB_XD1_nt XD0_XDFFM_CLKB XD1_nt 1.21e-17
* device instance cc_XD0_XDFFM_CLKB_XD1_t1 r0 *1 0,0
Ccc_XD0_XDFFM_CLKB_XD1_t1 XD0_XDFFM_CLKB XD1_t1 1.21e-17
* device instance cc_XD0_XDFFM_CLKB_XD2_XDFFM_CLKB r0 *1 0,0
Ccc_XD0_XDFFM_CLKB_XD2_XDFFM_CLKB XD0_XDFFM_CLKB XD2_XDFFM_CLKB 1.8151e-17
* device instance cc_XD0_XDFFM_CLKB_XD2_XDFFM_M r0 *1 0,0
Ccc_XD0_XDFFM_CLKB_XD2_XDFFM_M XD0_XDFFM_CLKB XD2_XDFFM_M 2.4201e-17
* device instance cc_XD0_XDFFM_CLKB_XD2_XDFFM_MB r0 *1 0,0
Ccc_XD0_XDFFM_CLKB_XD2_XDFFM_MB XD0_XDFFM_CLKB XD2_XDFFM_MB 1.21e-17
* device instance cc_XD0_XDFFM_CLKB_XD2_XDFFM_S r0 *1 0,0
Ccc_XD0_XDFFM_CLKB_XD2_XDFFM_S XD0_XDFFM_CLKB XD2_XDFFM_S 1.8151e-17
* device instance cc_XD0_XDFFM_CLKB_XD2_XDFFM_SB r0 *1 0,0
Ccc_XD0_XDFFM_CLKB_XD2_XDFFM_SB XD0_XDFFM_CLKB XD2_XDFFM_SB 1.8151e-17
* device instance cc_XD0_XDFFM_CLKB_XD2_XDFFQ_CLKB r0 *1 0,0
Ccc_XD0_XDFFM_CLKB_XD2_XDFFQ_CLKB XD0_XDFFM_CLKB XD2_XDFFQ_CLKB 1.8151e-17
* device instance cc_XD0_XDFFM_CLKB_XD2_XDFFQ_M r0 *1 0,0
Ccc_XD0_XDFFM_CLKB_XD2_XDFFQ_M XD0_XDFFM_CLKB XD2_XDFFQ_M 2.4201e-17
* device instance cc_XD0_XDFFM_CLKB_XD2_XDFFQ_MB r0 *1 0,0
Ccc_XD0_XDFFM_CLKB_XD2_XDFFQ_MB XD0_XDFFM_CLKB XD2_XDFFQ_MB 1.21e-17
* device instance cc_XD0_XDFFM_CLKB_XD2_XDFFQ_S r0 *1 0,0
Ccc_XD0_XDFFM_CLKB_XD2_XDFFQ_S XD0_XDFFM_CLKB XD2_XDFFQ_S 1.8151e-17
* device instance cc_XD0_XDFFM_CLKB_XD2_XDFFQ_SB r0 *1 0,0
Ccc_XD0_XDFFM_CLKB_XD2_XDFFQ_SB XD0_XDFFM_CLKB XD2_XDFFQ_SB 1.8151e-17
* device instance cc_XD0_XDFFM_CLKB_XD2_XN2_mid1 r0 *1 0,0
Ccc_XD0_XDFFM_CLKB_XD2_XN2_mid1 XD0_XDFFM_CLKB XD2_XN2_mid1 1.21e-17
* device instance cc_XD0_XDFFM_CLKB_XD2_XN3_mid1 r0 *1 0,0
Ccc_XD0_XDFFM_CLKB_XD2_XN3_mid1 XD0_XDFFM_CLKB XD2_XN3_mid1 1.21e-17
* device instance cc_XD0_XDFFM_CLKB_XD2_XN3_mid2 r0 *1 0,0
Ccc_XD0_XDFFM_CLKB_XD2_XN3_mid2 XD0_XDFFM_CLKB XD2_XN3_mid2 1.21e-17
* device instance cc_XD0_XDFFM_CLKB_XD2_dmodout r0 *1 0,0
Ccc_XD0_XDFFM_CLKB_XD2_dmodout XD0_XDFFM_CLKB XD2_dmodout 1.21e-17
* device instance cc_XD0_XDFFM_CLKB_XD2_dq r0 *1 0,0
Ccc_XD0_XDFFM_CLKB_XD2_dq XD0_XDFFM_CLKB XD2_dq 1.8151e-17
* device instance cc_XD0_XDFFM_CLKB_XD2_nm r0 *1 0,0
Ccc_XD0_XDFFM_CLKB_XD2_nm XD0_XDFFM_CLKB XD2_nm 1.21e-17
* device instance cc_XD0_XDFFM_CLKB_XD2_nt r0 *1 0,0
Ccc_XD0_XDFFM_CLKB_XD2_nt XD0_XDFFM_CLKB XD2_nt 1.21e-17
* device instance cc_XD0_XDFFM_CLKB_XD2_t1 r0 *1 0,0
Ccc_XD0_XDFFM_CLKB_XD2_t1 XD0_XDFFM_CLKB XD2_t1 1.21e-17
* device instance cc_XD0_XDFFM_CLKB_XD3_XDFFM_CLKB r0 *1 0,0
Ccc_XD0_XDFFM_CLKB_XD3_XDFFM_CLKB XD0_XDFFM_CLKB XD3_XDFFM_CLKB 1.8151e-17
* device instance cc_XD0_XDFFM_CLKB_XD3_XDFFM_M r0 *1 0,0
Ccc_XD0_XDFFM_CLKB_XD3_XDFFM_M XD0_XDFFM_CLKB XD3_XDFFM_M 2.4201e-17
* device instance cc_XD0_XDFFM_CLKB_XD3_XDFFM_MB r0 *1 0,0
Ccc_XD0_XDFFM_CLKB_XD3_XDFFM_MB XD0_XDFFM_CLKB XD3_XDFFM_MB 1.21e-17
* device instance cc_XD0_XDFFM_CLKB_XD3_XDFFM_S r0 *1 0,0
Ccc_XD0_XDFFM_CLKB_XD3_XDFFM_S XD0_XDFFM_CLKB XD3_XDFFM_S 1.8151e-17
* device instance cc_XD0_XDFFM_CLKB_XD3_XDFFM_SB r0 *1 0,0
Ccc_XD0_XDFFM_CLKB_XD3_XDFFM_SB XD0_XDFFM_CLKB XD3_XDFFM_SB 1.8151e-17
* device instance cc_XD0_XDFFM_CLKB_XD3_XDFFQ_CLKB r0 *1 0,0
Ccc_XD0_XDFFM_CLKB_XD3_XDFFQ_CLKB XD0_XDFFM_CLKB XD3_XDFFQ_CLKB 1.8151e-17
* device instance cc_XD0_XDFFM_CLKB_XD3_XDFFQ_M r0 *1 0,0
Ccc_XD0_XDFFM_CLKB_XD3_XDFFQ_M XD0_XDFFM_CLKB XD3_XDFFQ_M 2.4201e-17
* device instance cc_XD0_XDFFM_CLKB_XD3_XDFFQ_MB r0 *1 0,0
Ccc_XD0_XDFFM_CLKB_XD3_XDFFQ_MB XD0_XDFFM_CLKB XD3_XDFFQ_MB 1.21e-17
* device instance cc_XD0_XDFFM_CLKB_XD3_XDFFQ_S r0 *1 0,0
Ccc_XD0_XDFFM_CLKB_XD3_XDFFQ_S XD0_XDFFM_CLKB XD3_XDFFQ_S 1.8151e-17
* device instance cc_XD0_XDFFM_CLKB_XD3_XDFFQ_SB r0 *1 0,0
Ccc_XD0_XDFFM_CLKB_XD3_XDFFQ_SB XD0_XDFFM_CLKB XD3_XDFFQ_SB 1.8151e-17
* device instance cc_XD0_XDFFM_CLKB_XD3_XN2_mid1 r0 *1 0,0
Ccc_XD0_XDFFM_CLKB_XD3_XN2_mid1 XD0_XDFFM_CLKB XD3_XN2_mid1 1.21e-17
* device instance cc_XD0_XDFFM_CLKB_XD3_XN3_mid1 r0 *1 0,0
Ccc_XD0_XDFFM_CLKB_XD3_XN3_mid1 XD0_XDFFM_CLKB XD3_XN3_mid1 1.21e-17
* device instance cc_XD0_XDFFM_CLKB_XD3_XN3_mid2 r0 *1 0,0
Ccc_XD0_XDFFM_CLKB_XD3_XN3_mid2 XD0_XDFFM_CLKB XD3_XN3_mid2 1.21e-17
* device instance cc_XD0_XDFFM_CLKB_XD3_dmodout r0 *1 0,0
Ccc_XD0_XDFFM_CLKB_XD3_dmodout XD0_XDFFM_CLKB XD3_dmodout 1.21e-17
* device instance cc_XD0_XDFFM_CLKB_XD3_dq r0 *1 0,0
Ccc_XD0_XDFFM_CLKB_XD3_dq XD0_XDFFM_CLKB XD3_dq 1.8151e-17
* device instance cc_XD0_XDFFM_CLKB_XD3_nm r0 *1 0,0
Ccc_XD0_XDFFM_CLKB_XD3_nm XD0_XDFFM_CLKB XD3_nm 1.21e-17
* device instance cc_XD0_XDFFM_CLKB_XD3_nt r0 *1 0,0
Ccc_XD0_XDFFM_CLKB_XD3_nt XD0_XDFFM_CLKB XD3_nt 1.21e-17
* device instance cc_XD0_XDFFM_CLKB_XD3_t1 r0 *1 0,0
Ccc_XD0_XDFFM_CLKB_XD3_t1 XD0_XDFFM_CLKB XD3_t1 1.21e-17
* device instance cc_XD0_XDFFM_CLKB_XD4_XDFFM_CLKB r0 *1 0,0
Ccc_XD0_XDFFM_CLKB_XD4_XDFFM_CLKB XD0_XDFFM_CLKB XD4_XDFFM_CLKB 1.8151e-17
* device instance cc_XD0_XDFFM_CLKB_XD4_XDFFM_M r0 *1 0,0
Ccc_XD0_XDFFM_CLKB_XD4_XDFFM_M XD0_XDFFM_CLKB XD4_XDFFM_M 2.4201e-17
* device instance cc_XD0_XDFFM_CLKB_XD4_XDFFM_MB r0 *1 0,0
Ccc_XD0_XDFFM_CLKB_XD4_XDFFM_MB XD0_XDFFM_CLKB XD4_XDFFM_MB 1.21e-17
* device instance cc_XD0_XDFFM_CLKB_XD4_XDFFM_S r0 *1 0,0
Ccc_XD0_XDFFM_CLKB_XD4_XDFFM_S XD0_XDFFM_CLKB XD4_XDFFM_S 1.8151e-17
* device instance cc_XD0_XDFFM_CLKB_XD4_XDFFM_SB r0 *1 0,0
Ccc_XD0_XDFFM_CLKB_XD4_XDFFM_SB XD0_XDFFM_CLKB XD4_XDFFM_SB 1.8151e-17
* device instance cc_XD0_XDFFM_CLKB_XD4_XDFFQ_CLKB r0 *1 0,0
Ccc_XD0_XDFFM_CLKB_XD4_XDFFQ_CLKB XD0_XDFFM_CLKB XD4_XDFFQ_CLKB 1.8151e-17
* device instance cc_XD0_XDFFM_CLKB_XD4_XDFFQ_M r0 *1 0,0
Ccc_XD0_XDFFM_CLKB_XD4_XDFFQ_M XD0_XDFFM_CLKB XD4_XDFFQ_M 2.4201e-17
* device instance cc_XD0_XDFFM_CLKB_XD4_XDFFQ_MB r0 *1 0,0
Ccc_XD0_XDFFM_CLKB_XD4_XDFFQ_MB XD0_XDFFM_CLKB XD4_XDFFQ_MB 1.21e-17
* device instance cc_XD0_XDFFM_CLKB_XD4_XDFFQ_S r0 *1 0,0
Ccc_XD0_XDFFM_CLKB_XD4_XDFFQ_S XD0_XDFFM_CLKB XD4_XDFFQ_S 1.8151e-17
* device instance cc_XD0_XDFFM_CLKB_XD4_XDFFQ_SB r0 *1 0,0
Ccc_XD0_XDFFM_CLKB_XD4_XDFFQ_SB XD0_XDFFM_CLKB XD4_XDFFQ_SB 1.8151e-17
* device instance cc_XD0_XDFFM_CLKB_XD4_XN2_mid1 r0 *1 0,0
Ccc_XD0_XDFFM_CLKB_XD4_XN2_mid1 XD0_XDFFM_CLKB XD4_XN2_mid1 1.21e-17
* device instance cc_XD0_XDFFM_CLKB_XD4_XN3_mid1 r0 *1 0,0
Ccc_XD0_XDFFM_CLKB_XD4_XN3_mid1 XD0_XDFFM_CLKB XD4_XN3_mid1 1.21e-17
* device instance cc_XD0_XDFFM_CLKB_XD4_XN3_mid2 r0 *1 0,0
Ccc_XD0_XDFFM_CLKB_XD4_XN3_mid2 XD0_XDFFM_CLKB XD4_XN3_mid2 1.21e-17
* device instance cc_XD0_XDFFM_CLKB_XD4_dmodout r0 *1 0,0
Ccc_XD0_XDFFM_CLKB_XD4_dmodout XD0_XDFFM_CLKB XD4_dmodout 1.21e-17
* device instance cc_XD0_XDFFM_CLKB_XD4_dq r0 *1 0,0
Ccc_XD0_XDFFM_CLKB_XD4_dq XD0_XDFFM_CLKB XD4_dq 1.8151e-17
* device instance cc_XD0_XDFFM_CLKB_XD4_nm r0 *1 0,0
Ccc_XD0_XDFFM_CLKB_XD4_nm XD0_XDFFM_CLKB XD4_nm 1.21e-17
* device instance cc_XD0_XDFFM_CLKB_XD4_nt r0 *1 0,0
Ccc_XD0_XDFFM_CLKB_XD4_nt XD0_XDFFM_CLKB XD4_nt 1.21e-17
* device instance cc_XD0_XDFFM_CLKB_XD4_t1 r0 *1 0,0
Ccc_XD0_XDFFM_CLKB_XD4_t1 XD0_XDFFM_CLKB XD4_t1 1.21e-17
* device instance cc_XD0_XDFFM_CLKB_XD5_XDFFM_CLKB r0 *1 0,0
Ccc_XD0_XDFFM_CLKB_XD5_XDFFM_CLKB XD0_XDFFM_CLKB XD5_XDFFM_CLKB 1.8151e-17
* device instance cc_XD0_XDFFM_CLKB_XD5_XDFFM_M r0 *1 0,0
Ccc_XD0_XDFFM_CLKB_XD5_XDFFM_M XD0_XDFFM_CLKB XD5_XDFFM_M 2.4201e-17
* device instance cc_XD0_XDFFM_CLKB_XD5_XDFFM_MB r0 *1 0,0
Ccc_XD0_XDFFM_CLKB_XD5_XDFFM_MB XD0_XDFFM_CLKB XD5_XDFFM_MB 1.21e-17
* device instance cc_XD0_XDFFM_CLKB_XD5_XDFFM_S r0 *1 0,0
Ccc_XD0_XDFFM_CLKB_XD5_XDFFM_S XD0_XDFFM_CLKB XD5_XDFFM_S 1.8151e-17
* device instance cc_XD0_XDFFM_CLKB_XD5_XDFFM_SB r0 *1 0,0
Ccc_XD0_XDFFM_CLKB_XD5_XDFFM_SB XD0_XDFFM_CLKB XD5_XDFFM_SB 1.8151e-17
* device instance cc_XD0_XDFFM_CLKB_XD5_XDFFQ_CLKB r0 *1 0,0
Ccc_XD0_XDFFM_CLKB_XD5_XDFFQ_CLKB XD0_XDFFM_CLKB XD5_XDFFQ_CLKB 1.8151e-17
* device instance cc_XD0_XDFFM_CLKB_XD5_XDFFQ_M r0 *1 0,0
Ccc_XD0_XDFFM_CLKB_XD5_XDFFQ_M XD0_XDFFM_CLKB XD5_XDFFQ_M 2.4201e-17
* device instance cc_XD0_XDFFM_CLKB_XD5_XDFFQ_MB r0 *1 0,0
Ccc_XD0_XDFFM_CLKB_XD5_XDFFQ_MB XD0_XDFFM_CLKB XD5_XDFFQ_MB 1.21e-17
* device instance cc_XD0_XDFFM_CLKB_XD5_XDFFQ_S r0 *1 0,0
Ccc_XD0_XDFFM_CLKB_XD5_XDFFQ_S XD0_XDFFM_CLKB XD5_XDFFQ_S 1.8151e-17
* device instance cc_XD0_XDFFM_CLKB_XD5_XDFFQ_SB r0 *1 0,0
Ccc_XD0_XDFFM_CLKB_XD5_XDFFQ_SB XD0_XDFFM_CLKB XD5_XDFFQ_SB 1.8151e-17
* device instance cc_XD0_XDFFM_CLKB_XD5_XN2_mid1 r0 *1 0,0
Ccc_XD0_XDFFM_CLKB_XD5_XN2_mid1 XD0_XDFFM_CLKB XD5_XN2_mid1 1.21e-17
* device instance cc_XD0_XDFFM_CLKB_XD5_XN3_mid1 r0 *1 0,0
Ccc_XD0_XDFFM_CLKB_XD5_XN3_mid1 XD0_XDFFM_CLKB XD5_XN3_mid1 1.21e-17
* device instance cc_XD0_XDFFM_CLKB_XD5_XN3_mid2 r0 *1 0,0
Ccc_XD0_XDFFM_CLKB_XD5_XN3_mid2 XD0_XDFFM_CLKB XD5_XN3_mid2 1.21e-17
* device instance cc_XD0_XDFFM_CLKB_XD5_dmodout r0 *1 0,0
Ccc_XD0_XDFFM_CLKB_XD5_dmodout XD0_XDFFM_CLKB XD5_dmodout 1.21e-17
* device instance cc_XD0_XDFFM_CLKB_XD5_dq r0 *1 0,0
Ccc_XD0_XDFFM_CLKB_XD5_dq XD0_XDFFM_CLKB XD5_dq 1.8151e-17
* device instance cc_XD0_XDFFM_CLKB_XD5_nm r0 *1 0,0
Ccc_XD0_XDFFM_CLKB_XD5_nm XD0_XDFFM_CLKB XD5_nm 1.21e-17
* device instance cc_XD0_XDFFM_CLKB_XD5_nt r0 *1 0,0
Ccc_XD0_XDFFM_CLKB_XD5_nt XD0_XDFFM_CLKB XD5_nt 1.21e-17
* device instance cc_XD0_XDFFM_CLKB_XD5_t1 r0 *1 0,0
Ccc_XD0_XDFFM_CLKB_XD5_t1 XD0_XDFFM_CLKB XD5_t1 1.21e-17
* device instance cc_XD0_XDFFM_CLKB_XFRT_CLKB r0 *1 0,0
Ccc_XD0_XDFFM_CLKB_XFRT_CLKB XD0_XDFFM_CLKB XFRT_CLKB 1.8151e-17
* device instance cc_XD0_XDFFM_CLKB_XFRT_M r0 *1 0,0
Ccc_XD0_XDFFM_CLKB_XFRT_M XD0_XDFFM_CLKB XFRT_M 2.4201e-17
* device instance cc_XD0_XDFFM_CLKB_XFRT_MB r0 *1 0,0
Ccc_XD0_XDFFM_CLKB_XFRT_MB XD0_XDFFM_CLKB XFRT_MB 1.21e-17
* device instance cc_XD0_XDFFM_CLKB_XFRT_S r0 *1 0,0
Ccc_XD0_XDFFM_CLKB_XFRT_S XD0_XDFFM_CLKB XFRT_S 1.8151e-17
* device instance cc_XD0_XDFFM_CLKB_XFRT_SB r0 *1 0,0
Ccc_XD0_XDFFM_CLKB_XFRT_SB XD0_XDFFM_CLKB XFRT_SB 1.8151e-17
* device instance cc_XD0_XDFFM_CLKB_ck1 r0 *1 0,0
Ccc_XD0_XDFFM_CLKB_ck1 XD0_XDFFM_CLKB ck1 5.4452e-17
* device instance cc_XD0_XDFFM_CLKB_ck2 r0 *1 0,0
Ccc_XD0_XDFFM_CLKB_ck2 XD0_XDFFM_CLKB ck2 5.4452e-17
* device instance cc_XD0_XDFFM_CLKB_ck3 r0 *1 0,0
Ccc_XD0_XDFFM_CLKB_ck3 XD0_XDFFM_CLKB ck3 5.4452e-17
* device instance cc_XD0_XDFFM_CLKB_ck4 r0 *1 0,0
Ccc_XD0_XDFFM_CLKB_ck4 XD0_XDFFM_CLKB ck4 5.4452e-17
* device instance cc_XD0_XDFFM_CLKB_ck5 r0 *1 0,0
Ccc_XD0_XDFFM_CLKB_ck5 XD0_XDFFM_CLKB ck5 5.4452e-17
* device instance cc_XD0_XDFFM_CLKB_mod0 r0 *1 0,0
Ccc_XD0_XDFFM_CLKB_mod0 XD0_XDFFM_CLKB mod0 2.4201e-17
* device instance cc_XD0_XDFFM_CLKB_mod1 r0 *1 0,0
Ccc_XD0_XDFFM_CLKB_mod1 XD0_XDFFM_CLKB mod1 2.4201e-17
* device instance cc_XD0_XDFFM_CLKB_mod2 r0 *1 0,0
Ccc_XD0_XDFFM_CLKB_mod2 XD0_XDFFM_CLKB mod2 2.4201e-17
* device instance cc_XD0_XDFFM_CLKB_mod3 r0 *1 0,0
Ccc_XD0_XDFFM_CLKB_mod3 XD0_XDFFM_CLKB mod3 2.4201e-17
* device instance cc_XD0_XDFFM_CLKB_mod4 r0 *1 0,0
Ccc_XD0_XDFFM_CLKB_mod4 XD0_XDFFM_CLKB mod4 2.4201e-17
* device instance cc_XD0_XDFFM_CLKB_net1 r0 *1 0,0
Ccc_XD0_XDFFM_CLKB_net1 XD0_XDFFM_CLKB net1 1.21e-17
* device instance cc_XD0_XDFFM_M_XD0_XDFFM_MB r0 *1 0,0
Ccc_XD0_XDFFM_M_XD0_XDFFM_MB XD0_XDFFM_M XD0_XDFFM_MB 3.4688e-17
* device instance cc_XD0_XDFFM_M_XD0_XDFFM_S r0 *1 0,0
Ccc_XD0_XDFFM_M_XD0_XDFFM_S XD0_XDFFM_M XD0_XDFFM_S 2.8638e-17
* device instance cc_XD0_XDFFM_M_XD0_XDFFM_SB r0 *1 0,0
Ccc_XD0_XDFFM_M_XD0_XDFFM_SB XD0_XDFFM_M XD0_XDFFM_SB 1.8151e-17
* device instance cc_XD0_XDFFM_M_XD0_XDFFQ_CLKB r0 *1 0,0
Ccc_XD0_XDFFM_M_XD0_XDFFQ_CLKB XD0_XDFFM_M XD0_XDFFQ_CLKB 1.8151e-17
* device instance cc_XD0_XDFFM_M_XD0_XDFFQ_M r0 *1 0,0
Ccc_XD0_XDFFM_M_XD0_XDFFQ_M XD0_XDFFM_M XD0_XDFFQ_M 2.4201e-17
* device instance cc_XD0_XDFFM_M_XD0_XDFFQ_MB r0 *1 0,0
Ccc_XD0_XDFFM_M_XD0_XDFFQ_MB XD0_XDFFM_M XD0_XDFFQ_MB 1.21e-17
* device instance cc_XD0_XDFFM_M_XD0_XDFFQ_S r0 *1 0,0
Ccc_XD0_XDFFM_M_XD0_XDFFQ_S XD0_XDFFM_M XD0_XDFFQ_S 1.8151e-17
* device instance cc_XD0_XDFFM_M_XD0_XDFFQ_SB r0 *1 0,0
Ccc_XD0_XDFFM_M_XD0_XDFFQ_SB XD0_XDFFM_M XD0_XDFFQ_SB 1.8151e-17
* device instance cc_XD0_XDFFM_M_XD0_XNOR_midp r0 *1 0,0
Ccc_XD0_XDFFM_M_XD0_XNOR_midp XD0_XDFFM_M XD0_XNOR_midp 1.21e-17
* device instance cc_XD0_XDFFM_M_XD0_dmodout r0 *1 0,0
Ccc_XD0_XDFFM_M_XD0_dmodout XD0_XDFFM_M XD0_dmodout 2.8638e-17
* device instance cc_XD0_XDFFM_M_XD0_dq r0 *1 0,0
Ccc_XD0_XDFFM_M_XD0_dq XD0_XDFFM_M XD0_dq 1.21e-17
* device instance cc_XD0_XDFFM_M_XD0_nm r0 *1 0,0
Ccc_XD0_XDFFM_M_XD0_nm XD0_XDFFM_M XD0_nm 1.8151e-17
* device instance cc_XD0_XDFFM_M_XD0_nt r0 *1 0,0
Ccc_XD0_XDFFM_M_XD0_nt XD0_XDFFM_M XD0_nt 2.4201e-17
* device instance cc_XD0_XDFFM_M_XD0_t1 r0 *1 0,0
Ccc_XD0_XDFFM_M_XD0_t1 XD0_XDFFM_M XD0_t1 1.21e-17
* device instance cc_XD0_XDFFM_M_XD1_XDFFM_CLKB r0 *1 0,0
Ccc_XD0_XDFFM_M_XD1_XDFFM_CLKB XD0_XDFFM_M XD1_XDFFM_CLKB 1.8151e-17
* device instance cc_XD0_XDFFM_M_XD1_XDFFM_M r0 *1 0,0
Ccc_XD0_XDFFM_M_XD1_XDFFM_M XD0_XDFFM_M XD1_XDFFM_M 2.4201e-17
* device instance cc_XD0_XDFFM_M_XD1_XDFFM_MB r0 *1 0,0
Ccc_XD0_XDFFM_M_XD1_XDFFM_MB XD0_XDFFM_M XD1_XDFFM_MB 1.21e-17
* device instance cc_XD0_XDFFM_M_XD1_XDFFM_S r0 *1 0,0
Ccc_XD0_XDFFM_M_XD1_XDFFM_S XD0_XDFFM_M XD1_XDFFM_S 1.8151e-17
* device instance cc_XD0_XDFFM_M_XD1_XDFFM_SB r0 *1 0,0
Ccc_XD0_XDFFM_M_XD1_XDFFM_SB XD0_XDFFM_M XD1_XDFFM_SB 1.8151e-17
* device instance cc_XD0_XDFFM_M_XD1_XDFFQ_CLKB r0 *1 0,0
Ccc_XD0_XDFFM_M_XD1_XDFFQ_CLKB XD0_XDFFM_M XD1_XDFFQ_CLKB 1.8151e-17
* device instance cc_XD0_XDFFM_M_XD1_XDFFQ_M r0 *1 0,0
Ccc_XD0_XDFFM_M_XD1_XDFFQ_M XD0_XDFFM_M XD1_XDFFQ_M 2.4201e-17
* device instance cc_XD0_XDFFM_M_XD1_XDFFQ_MB r0 *1 0,0
Ccc_XD0_XDFFM_M_XD1_XDFFQ_MB XD0_XDFFM_M XD1_XDFFQ_MB 1.21e-17
* device instance cc_XD0_XDFFM_M_XD1_XDFFQ_S r0 *1 0,0
Ccc_XD0_XDFFM_M_XD1_XDFFQ_S XD0_XDFFM_M XD1_XDFFQ_S 1.8151e-17
* device instance cc_XD0_XDFFM_M_XD1_XDFFQ_SB r0 *1 0,0
Ccc_XD0_XDFFM_M_XD1_XDFFQ_SB XD0_XDFFM_M XD1_XDFFQ_SB 1.8151e-17
* device instance cc_XD0_XDFFM_M_XD1_XN2_mid1 r0 *1 0,0
Ccc_XD0_XDFFM_M_XD1_XN2_mid1 XD0_XDFFM_M XD1_XN2_mid1 1.21e-17
* device instance cc_XD0_XDFFM_M_XD1_XN3_mid1 r0 *1 0,0
Ccc_XD0_XDFFM_M_XD1_XN3_mid1 XD0_XDFFM_M XD1_XN3_mid1 1.21e-17
* device instance cc_XD0_XDFFM_M_XD1_XN3_mid2 r0 *1 0,0
Ccc_XD0_XDFFM_M_XD1_XN3_mid2 XD0_XDFFM_M XD1_XN3_mid2 1.21e-17
* device instance cc_XD0_XDFFM_M_XD1_dmodout r0 *1 0,0
Ccc_XD0_XDFFM_M_XD1_dmodout XD0_XDFFM_M XD1_dmodout 1.21e-17
* device instance cc_XD0_XDFFM_M_XD1_dq r0 *1 0,0
Ccc_XD0_XDFFM_M_XD1_dq XD0_XDFFM_M XD1_dq 1.8151e-17
* device instance cc_XD0_XDFFM_M_XD1_nm r0 *1 0,0
Ccc_XD0_XDFFM_M_XD1_nm XD0_XDFFM_M XD1_nm 1.21e-17
* device instance cc_XD0_XDFFM_M_XD1_nt r0 *1 0,0
Ccc_XD0_XDFFM_M_XD1_nt XD0_XDFFM_M XD1_nt 1.21e-17
* device instance cc_XD0_XDFFM_M_XD1_t1 r0 *1 0,0
Ccc_XD0_XDFFM_M_XD1_t1 XD0_XDFFM_M XD1_t1 1.21e-17
* device instance cc_XD0_XDFFM_M_XD2_XDFFM_CLKB r0 *1 0,0
Ccc_XD0_XDFFM_M_XD2_XDFFM_CLKB XD0_XDFFM_M XD2_XDFFM_CLKB 1.8151e-17
* device instance cc_XD0_XDFFM_M_XD2_XDFFM_M r0 *1 0,0
Ccc_XD0_XDFFM_M_XD2_XDFFM_M XD0_XDFFM_M XD2_XDFFM_M 2.4201e-17
* device instance cc_XD0_XDFFM_M_XD2_XDFFM_MB r0 *1 0,0
Ccc_XD0_XDFFM_M_XD2_XDFFM_MB XD0_XDFFM_M XD2_XDFFM_MB 1.21e-17
* device instance cc_XD0_XDFFM_M_XD2_XDFFM_S r0 *1 0,0
Ccc_XD0_XDFFM_M_XD2_XDFFM_S XD0_XDFFM_M XD2_XDFFM_S 1.8151e-17
* device instance cc_XD0_XDFFM_M_XD2_XDFFM_SB r0 *1 0,0
Ccc_XD0_XDFFM_M_XD2_XDFFM_SB XD0_XDFFM_M XD2_XDFFM_SB 1.8151e-17
* device instance cc_XD0_XDFFM_M_XD2_XDFFQ_CLKB r0 *1 0,0
Ccc_XD0_XDFFM_M_XD2_XDFFQ_CLKB XD0_XDFFM_M XD2_XDFFQ_CLKB 1.8151e-17
* device instance cc_XD0_XDFFM_M_XD2_XDFFQ_M r0 *1 0,0
Ccc_XD0_XDFFM_M_XD2_XDFFQ_M XD0_XDFFM_M XD2_XDFFQ_M 2.4201e-17
* device instance cc_XD0_XDFFM_M_XD2_XDFFQ_MB r0 *1 0,0
Ccc_XD0_XDFFM_M_XD2_XDFFQ_MB XD0_XDFFM_M XD2_XDFFQ_MB 1.21e-17
* device instance cc_XD0_XDFFM_M_XD2_XDFFQ_S r0 *1 0,0
Ccc_XD0_XDFFM_M_XD2_XDFFQ_S XD0_XDFFM_M XD2_XDFFQ_S 1.8151e-17
* device instance cc_XD0_XDFFM_M_XD2_XDFFQ_SB r0 *1 0,0
Ccc_XD0_XDFFM_M_XD2_XDFFQ_SB XD0_XDFFM_M XD2_XDFFQ_SB 1.8151e-17
* device instance cc_XD0_XDFFM_M_XD2_XN2_mid1 r0 *1 0,0
Ccc_XD0_XDFFM_M_XD2_XN2_mid1 XD0_XDFFM_M XD2_XN2_mid1 1.21e-17
* device instance cc_XD0_XDFFM_M_XD2_XN3_mid1 r0 *1 0,0
Ccc_XD0_XDFFM_M_XD2_XN3_mid1 XD0_XDFFM_M XD2_XN3_mid1 1.21e-17
* device instance cc_XD0_XDFFM_M_XD2_XN3_mid2 r0 *1 0,0
Ccc_XD0_XDFFM_M_XD2_XN3_mid2 XD0_XDFFM_M XD2_XN3_mid2 1.21e-17
* device instance cc_XD0_XDFFM_M_XD2_dmodout r0 *1 0,0
Ccc_XD0_XDFFM_M_XD2_dmodout XD0_XDFFM_M XD2_dmodout 1.21e-17
* device instance cc_XD0_XDFFM_M_XD2_dq r0 *1 0,0
Ccc_XD0_XDFFM_M_XD2_dq XD0_XDFFM_M XD2_dq 1.8151e-17
* device instance cc_XD0_XDFFM_M_XD2_nm r0 *1 0,0
Ccc_XD0_XDFFM_M_XD2_nm XD0_XDFFM_M XD2_nm 1.21e-17
* device instance cc_XD0_XDFFM_M_XD2_nt r0 *1 0,0
Ccc_XD0_XDFFM_M_XD2_nt XD0_XDFFM_M XD2_nt 1.21e-17
* device instance cc_XD0_XDFFM_M_XD2_t1 r0 *1 0,0
Ccc_XD0_XDFFM_M_XD2_t1 XD0_XDFFM_M XD2_t1 1.21e-17
* device instance cc_XD0_XDFFM_M_XD3_XDFFM_CLKB r0 *1 0,0
Ccc_XD0_XDFFM_M_XD3_XDFFM_CLKB XD0_XDFFM_M XD3_XDFFM_CLKB 1.8151e-17
* device instance cc_XD0_XDFFM_M_XD3_XDFFM_M r0 *1 0,0
Ccc_XD0_XDFFM_M_XD3_XDFFM_M XD0_XDFFM_M XD3_XDFFM_M 2.4201e-17
* device instance cc_XD0_XDFFM_M_XD3_XDFFM_MB r0 *1 0,0
Ccc_XD0_XDFFM_M_XD3_XDFFM_MB XD0_XDFFM_M XD3_XDFFM_MB 1.21e-17
* device instance cc_XD0_XDFFM_M_XD3_XDFFM_S r0 *1 0,0
Ccc_XD0_XDFFM_M_XD3_XDFFM_S XD0_XDFFM_M XD3_XDFFM_S 1.8151e-17
* device instance cc_XD0_XDFFM_M_XD3_XDFFM_SB r0 *1 0,0
Ccc_XD0_XDFFM_M_XD3_XDFFM_SB XD0_XDFFM_M XD3_XDFFM_SB 1.8151e-17
* device instance cc_XD0_XDFFM_M_XD3_XDFFQ_CLKB r0 *1 0,0
Ccc_XD0_XDFFM_M_XD3_XDFFQ_CLKB XD0_XDFFM_M XD3_XDFFQ_CLKB 1.8151e-17
* device instance cc_XD0_XDFFM_M_XD3_XDFFQ_M r0 *1 0,0
Ccc_XD0_XDFFM_M_XD3_XDFFQ_M XD0_XDFFM_M XD3_XDFFQ_M 2.4201e-17
* device instance cc_XD0_XDFFM_M_XD3_XDFFQ_MB r0 *1 0,0
Ccc_XD0_XDFFM_M_XD3_XDFFQ_MB XD0_XDFFM_M XD3_XDFFQ_MB 1.21e-17
* device instance cc_XD0_XDFFM_M_XD3_XDFFQ_S r0 *1 0,0
Ccc_XD0_XDFFM_M_XD3_XDFFQ_S XD0_XDFFM_M XD3_XDFFQ_S 1.8151e-17
* device instance cc_XD0_XDFFM_M_XD3_XDFFQ_SB r0 *1 0,0
Ccc_XD0_XDFFM_M_XD3_XDFFQ_SB XD0_XDFFM_M XD3_XDFFQ_SB 1.8151e-17
* device instance cc_XD0_XDFFM_M_XD3_XN2_mid1 r0 *1 0,0
Ccc_XD0_XDFFM_M_XD3_XN2_mid1 XD0_XDFFM_M XD3_XN2_mid1 1.21e-17
* device instance cc_XD0_XDFFM_M_XD3_XN3_mid1 r0 *1 0,0
Ccc_XD0_XDFFM_M_XD3_XN3_mid1 XD0_XDFFM_M XD3_XN3_mid1 1.21e-17
* device instance cc_XD0_XDFFM_M_XD3_XN3_mid2 r0 *1 0,0
Ccc_XD0_XDFFM_M_XD3_XN3_mid2 XD0_XDFFM_M XD3_XN3_mid2 1.21e-17
* device instance cc_XD0_XDFFM_M_XD3_dmodout r0 *1 0,0
Ccc_XD0_XDFFM_M_XD3_dmodout XD0_XDFFM_M XD3_dmodout 1.21e-17
* device instance cc_XD0_XDFFM_M_XD3_dq r0 *1 0,0
Ccc_XD0_XDFFM_M_XD3_dq XD0_XDFFM_M XD3_dq 1.8151e-17
* device instance cc_XD0_XDFFM_M_XD3_nm r0 *1 0,0
Ccc_XD0_XDFFM_M_XD3_nm XD0_XDFFM_M XD3_nm 1.21e-17
* device instance cc_XD0_XDFFM_M_XD3_nt r0 *1 0,0
Ccc_XD0_XDFFM_M_XD3_nt XD0_XDFFM_M XD3_nt 1.21e-17
* device instance cc_XD0_XDFFM_M_XD3_t1 r0 *1 0,0
Ccc_XD0_XDFFM_M_XD3_t1 XD0_XDFFM_M XD3_t1 1.21e-17
* device instance cc_XD0_XDFFM_M_XD4_XDFFM_CLKB r0 *1 0,0
Ccc_XD0_XDFFM_M_XD4_XDFFM_CLKB XD0_XDFFM_M XD4_XDFFM_CLKB 1.8151e-17
* device instance cc_XD0_XDFFM_M_XD4_XDFFM_M r0 *1 0,0
Ccc_XD0_XDFFM_M_XD4_XDFFM_M XD0_XDFFM_M XD4_XDFFM_M 2.4201e-17
* device instance cc_XD0_XDFFM_M_XD4_XDFFM_MB r0 *1 0,0
Ccc_XD0_XDFFM_M_XD4_XDFFM_MB XD0_XDFFM_M XD4_XDFFM_MB 1.21e-17
* device instance cc_XD0_XDFFM_M_XD4_XDFFM_S r0 *1 0,0
Ccc_XD0_XDFFM_M_XD4_XDFFM_S XD0_XDFFM_M XD4_XDFFM_S 1.8151e-17
* device instance cc_XD0_XDFFM_M_XD4_XDFFM_SB r0 *1 0,0
Ccc_XD0_XDFFM_M_XD4_XDFFM_SB XD0_XDFFM_M XD4_XDFFM_SB 1.8151e-17
* device instance cc_XD0_XDFFM_M_XD4_XDFFQ_CLKB r0 *1 0,0
Ccc_XD0_XDFFM_M_XD4_XDFFQ_CLKB XD0_XDFFM_M XD4_XDFFQ_CLKB 1.8151e-17
* device instance cc_XD0_XDFFM_M_XD4_XDFFQ_M r0 *1 0,0
Ccc_XD0_XDFFM_M_XD4_XDFFQ_M XD0_XDFFM_M XD4_XDFFQ_M 2.4201e-17
* device instance cc_XD0_XDFFM_M_XD4_XDFFQ_MB r0 *1 0,0
Ccc_XD0_XDFFM_M_XD4_XDFFQ_MB XD0_XDFFM_M XD4_XDFFQ_MB 1.21e-17
* device instance cc_XD0_XDFFM_M_XD4_XDFFQ_S r0 *1 0,0
Ccc_XD0_XDFFM_M_XD4_XDFFQ_S XD0_XDFFM_M XD4_XDFFQ_S 1.8151e-17
* device instance cc_XD0_XDFFM_M_XD4_XDFFQ_SB r0 *1 0,0
Ccc_XD0_XDFFM_M_XD4_XDFFQ_SB XD0_XDFFM_M XD4_XDFFQ_SB 1.8151e-17
* device instance cc_XD0_XDFFM_M_XD4_XN2_mid1 r0 *1 0,0
Ccc_XD0_XDFFM_M_XD4_XN2_mid1 XD0_XDFFM_M XD4_XN2_mid1 1.21e-17
* device instance cc_XD0_XDFFM_M_XD4_XN3_mid1 r0 *1 0,0
Ccc_XD0_XDFFM_M_XD4_XN3_mid1 XD0_XDFFM_M XD4_XN3_mid1 1.21e-17
* device instance cc_XD0_XDFFM_M_XD4_XN3_mid2 r0 *1 0,0
Ccc_XD0_XDFFM_M_XD4_XN3_mid2 XD0_XDFFM_M XD4_XN3_mid2 1.21e-17
* device instance cc_XD0_XDFFM_M_XD4_dmodout r0 *1 0,0
Ccc_XD0_XDFFM_M_XD4_dmodout XD0_XDFFM_M XD4_dmodout 1.21e-17
* device instance cc_XD0_XDFFM_M_XD4_dq r0 *1 0,0
Ccc_XD0_XDFFM_M_XD4_dq XD0_XDFFM_M XD4_dq 1.8151e-17
* device instance cc_XD0_XDFFM_M_XD4_nm r0 *1 0,0
Ccc_XD0_XDFFM_M_XD4_nm XD0_XDFFM_M XD4_nm 1.21e-17
* device instance cc_XD0_XDFFM_M_XD4_nt r0 *1 0,0
Ccc_XD0_XDFFM_M_XD4_nt XD0_XDFFM_M XD4_nt 1.21e-17
* device instance cc_XD0_XDFFM_M_XD4_t1 r0 *1 0,0
Ccc_XD0_XDFFM_M_XD4_t1 XD0_XDFFM_M XD4_t1 1.21e-17
* device instance cc_XD0_XDFFM_M_XD5_XDFFM_CLKB r0 *1 0,0
Ccc_XD0_XDFFM_M_XD5_XDFFM_CLKB XD0_XDFFM_M XD5_XDFFM_CLKB 1.8151e-17
* device instance cc_XD0_XDFFM_M_XD5_XDFFM_M r0 *1 0,0
Ccc_XD0_XDFFM_M_XD5_XDFFM_M XD0_XDFFM_M XD5_XDFFM_M 2.4201e-17
* device instance cc_XD0_XDFFM_M_XD5_XDFFM_MB r0 *1 0,0
Ccc_XD0_XDFFM_M_XD5_XDFFM_MB XD0_XDFFM_M XD5_XDFFM_MB 1.21e-17
* device instance cc_XD0_XDFFM_M_XD5_XDFFM_S r0 *1 0,0
Ccc_XD0_XDFFM_M_XD5_XDFFM_S XD0_XDFFM_M XD5_XDFFM_S 1.8151e-17
* device instance cc_XD0_XDFFM_M_XD5_XDFFM_SB r0 *1 0,0
Ccc_XD0_XDFFM_M_XD5_XDFFM_SB XD0_XDFFM_M XD5_XDFFM_SB 1.8151e-17
* device instance cc_XD0_XDFFM_M_XD5_XDFFQ_CLKB r0 *1 0,0
Ccc_XD0_XDFFM_M_XD5_XDFFQ_CLKB XD0_XDFFM_M XD5_XDFFQ_CLKB 1.8151e-17
* device instance cc_XD0_XDFFM_M_XD5_XDFFQ_M r0 *1 0,0
Ccc_XD0_XDFFM_M_XD5_XDFFQ_M XD0_XDFFM_M XD5_XDFFQ_M 2.4201e-17
* device instance cc_XD0_XDFFM_M_XD5_XDFFQ_MB r0 *1 0,0
Ccc_XD0_XDFFM_M_XD5_XDFFQ_MB XD0_XDFFM_M XD5_XDFFQ_MB 1.21e-17
* device instance cc_XD0_XDFFM_M_XD5_XDFFQ_S r0 *1 0,0
Ccc_XD0_XDFFM_M_XD5_XDFFQ_S XD0_XDFFM_M XD5_XDFFQ_S 1.8151e-17
* device instance cc_XD0_XDFFM_M_XD5_XDFFQ_SB r0 *1 0,0
Ccc_XD0_XDFFM_M_XD5_XDFFQ_SB XD0_XDFFM_M XD5_XDFFQ_SB 1.8151e-17
* device instance cc_XD0_XDFFM_M_XD5_XN2_mid1 r0 *1 0,0
Ccc_XD0_XDFFM_M_XD5_XN2_mid1 XD0_XDFFM_M XD5_XN2_mid1 1.21e-17
* device instance cc_XD0_XDFFM_M_XD5_XN3_mid1 r0 *1 0,0
Ccc_XD0_XDFFM_M_XD5_XN3_mid1 XD0_XDFFM_M XD5_XN3_mid1 1.21e-17
* device instance cc_XD0_XDFFM_M_XD5_XN3_mid2 r0 *1 0,0
Ccc_XD0_XDFFM_M_XD5_XN3_mid2 XD0_XDFFM_M XD5_XN3_mid2 1.21e-17
* device instance cc_XD0_XDFFM_M_XD5_dmodout r0 *1 0,0
Ccc_XD0_XDFFM_M_XD5_dmodout XD0_XDFFM_M XD5_dmodout 1.21e-17
* device instance cc_XD0_XDFFM_M_XD5_dq r0 *1 0,0
Ccc_XD0_XDFFM_M_XD5_dq XD0_XDFFM_M XD5_dq 1.8151e-17
* device instance cc_XD0_XDFFM_M_XD5_nm r0 *1 0,0
Ccc_XD0_XDFFM_M_XD5_nm XD0_XDFFM_M XD5_nm 1.21e-17
* device instance cc_XD0_XDFFM_M_XD5_nt r0 *1 0,0
Ccc_XD0_XDFFM_M_XD5_nt XD0_XDFFM_M XD5_nt 1.21e-17
* device instance cc_XD0_XDFFM_M_XD5_t1 r0 *1 0,0
Ccc_XD0_XDFFM_M_XD5_t1 XD0_XDFFM_M XD5_t1 1.21e-17
* device instance cc_XD0_XDFFM_M_XFRT_CLKB r0 *1 0,0
Ccc_XD0_XDFFM_M_XFRT_CLKB XD0_XDFFM_M XFRT_CLKB 1.8151e-17
* device instance cc_XD0_XDFFM_M_XFRT_M r0 *1 0,0
Ccc_XD0_XDFFM_M_XFRT_M XD0_XDFFM_M XFRT_M 2.4201e-17
* device instance cc_XD0_XDFFM_M_XFRT_MB r0 *1 0,0
Ccc_XD0_XDFFM_M_XFRT_MB XD0_XDFFM_M XFRT_MB 1.21e-17
* device instance cc_XD0_XDFFM_M_XFRT_S r0 *1 0,0
Ccc_XD0_XDFFM_M_XFRT_S XD0_XDFFM_M XFRT_S 1.8151e-17
* device instance cc_XD0_XDFFM_M_XFRT_SB r0 *1 0,0
Ccc_XD0_XDFFM_M_XFRT_SB XD0_XDFFM_M XFRT_SB 1.8151e-17
* device instance cc_XD0_XDFFM_M_ck1 r0 *1 0,0
Ccc_XD0_XDFFM_M_ck1 XD0_XDFFM_M ck1 5.4452e-17
* device instance cc_XD0_XDFFM_M_ck2 r0 *1 0,0
Ccc_XD0_XDFFM_M_ck2 XD0_XDFFM_M ck2 5.4452e-17
* device instance cc_XD0_XDFFM_M_ck3 r0 *1 0,0
Ccc_XD0_XDFFM_M_ck3 XD0_XDFFM_M ck3 5.4452e-17
* device instance cc_XD0_XDFFM_M_ck4 r0 *1 0,0
Ccc_XD0_XDFFM_M_ck4 XD0_XDFFM_M ck4 5.4452e-17
* device instance cc_XD0_XDFFM_M_ck5 r0 *1 0,0
Ccc_XD0_XDFFM_M_ck5 XD0_XDFFM_M ck5 5.4452e-17
* device instance cc_XD0_XDFFM_M_mod0 r0 *1 0,0
Ccc_XD0_XDFFM_M_mod0 XD0_XDFFM_M mod0 2.4201e-17
* device instance cc_XD0_XDFFM_M_mod1 r0 *1 0,0
Ccc_XD0_XDFFM_M_mod1 XD0_XDFFM_M mod1 2.4201e-17
* device instance cc_XD0_XDFFM_M_mod2 r0 *1 0,0
Ccc_XD0_XDFFM_M_mod2 XD0_XDFFM_M mod2 2.4201e-17
* device instance cc_XD0_XDFFM_M_mod3 r0 *1 0,0
Ccc_XD0_XDFFM_M_mod3 XD0_XDFFM_M mod3 2.4201e-17
* device instance cc_XD0_XDFFM_M_mod4 r0 *1 0,0
Ccc_XD0_XDFFM_M_mod4 XD0_XDFFM_M mod4 2.4201e-17
* device instance cc_XD0_XDFFM_M_net1 r0 *1 0,0
Ccc_XD0_XDFFM_M_net1 XD0_XDFFM_M net1 1.21e-17
* device instance cc_XD0_XDFFM_MB_XD0_XDFFM_S r0 *1 0,0
Ccc_XD0_XDFFM_MB_XD0_XDFFM_S XD0_XDFFM_MB XD0_XDFFM_S 1.8151e-17
* device instance cc_XD0_XDFFM_MB_XD0_XDFFM_SB r0 *1 0,0
Ccc_XD0_XDFFM_MB_XD0_XDFFM_SB XD0_XDFFM_MB XD0_XDFFM_SB 1.8151e-17
* device instance cc_XD0_XDFFM_MB_XD0_XDFFQ_CLKB r0 *1 0,0
Ccc_XD0_XDFFM_MB_XD0_XDFFQ_CLKB XD0_XDFFM_MB XD0_XDFFQ_CLKB 1.8151e-17
* device instance cc_XD0_XDFFM_MB_XD0_XDFFQ_M r0 *1 0,0
Ccc_XD0_XDFFM_MB_XD0_XDFFQ_M XD0_XDFFM_MB XD0_XDFFQ_M 2.4201e-17
* device instance cc_XD0_XDFFM_MB_XD0_XDFFQ_MB r0 *1 0,0
Ccc_XD0_XDFFM_MB_XD0_XDFFQ_MB XD0_XDFFM_MB XD0_XDFFQ_MB 1.21e-17
* device instance cc_XD0_XDFFM_MB_XD0_XDFFQ_S r0 *1 0,0
Ccc_XD0_XDFFM_MB_XD0_XDFFQ_S XD0_XDFFM_MB XD0_XDFFQ_S 1.8151e-17
* device instance cc_XD0_XDFFM_MB_XD0_XDFFQ_SB r0 *1 0,0
Ccc_XD0_XDFFM_MB_XD0_XDFFQ_SB XD0_XDFFM_MB XD0_XDFFQ_SB 1.8151e-17
* device instance cc_XD0_XDFFM_MB_XD0_XNOR_midp r0 *1 0,0
Ccc_XD0_XDFFM_MB_XD0_XNOR_midp XD0_XDFFM_MB XD0_XNOR_midp 1.21e-17
* device instance cc_XD0_XDFFM_MB_XD0_dmodout r0 *1 0,0
Ccc_XD0_XDFFM_MB_XD0_dmodout XD0_XDFFM_MB XD0_dmodout 1.21e-17
* device instance cc_XD0_XDFFM_MB_XD0_dq r0 *1 0,0
Ccc_XD0_XDFFM_MB_XD0_dq XD0_XDFFM_MB XD0_dq 1.21e-17
* device instance cc_XD0_XDFFM_MB_XD0_nm r0 *1 0,0
Ccc_XD0_XDFFM_MB_XD0_nm XD0_XDFFM_MB XD0_nm 1.8151e-17
* device instance cc_XD0_XDFFM_MB_XD0_nt r0 *1 0,0
Ccc_XD0_XDFFM_MB_XD0_nt XD0_XDFFM_MB XD0_nt 2.4201e-17
* device instance cc_XD0_XDFFM_MB_XD0_t1 r0 *1 0,0
Ccc_XD0_XDFFM_MB_XD0_t1 XD0_XDFFM_MB XD0_t1 1.21e-17
* device instance cc_XD0_XDFFM_MB_XD1_XDFFM_CLKB r0 *1 0,0
Ccc_XD0_XDFFM_MB_XD1_XDFFM_CLKB XD0_XDFFM_MB XD1_XDFFM_CLKB 1.8151e-17
* device instance cc_XD0_XDFFM_MB_XD1_XDFFM_M r0 *1 0,0
Ccc_XD0_XDFFM_MB_XD1_XDFFM_M XD0_XDFFM_MB XD1_XDFFM_M 2.4201e-17
* device instance cc_XD0_XDFFM_MB_XD1_XDFFM_MB r0 *1 0,0
Ccc_XD0_XDFFM_MB_XD1_XDFFM_MB XD0_XDFFM_MB XD1_XDFFM_MB 1.21e-17
* device instance cc_XD0_XDFFM_MB_XD1_XDFFM_S r0 *1 0,0
Ccc_XD0_XDFFM_MB_XD1_XDFFM_S XD0_XDFFM_MB XD1_XDFFM_S 1.8151e-17
* device instance cc_XD0_XDFFM_MB_XD1_XDFFM_SB r0 *1 0,0
Ccc_XD0_XDFFM_MB_XD1_XDFFM_SB XD0_XDFFM_MB XD1_XDFFM_SB 1.8151e-17
* device instance cc_XD0_XDFFM_MB_XD1_XDFFQ_CLKB r0 *1 0,0
Ccc_XD0_XDFFM_MB_XD1_XDFFQ_CLKB XD0_XDFFM_MB XD1_XDFFQ_CLKB 1.8151e-17
* device instance cc_XD0_XDFFM_MB_XD1_XDFFQ_M r0 *1 0,0
Ccc_XD0_XDFFM_MB_XD1_XDFFQ_M XD0_XDFFM_MB XD1_XDFFQ_M 2.4201e-17
* device instance cc_XD0_XDFFM_MB_XD1_XDFFQ_MB r0 *1 0,0
Ccc_XD0_XDFFM_MB_XD1_XDFFQ_MB XD0_XDFFM_MB XD1_XDFFQ_MB 1.21e-17
* device instance cc_XD0_XDFFM_MB_XD1_XDFFQ_S r0 *1 0,0
Ccc_XD0_XDFFM_MB_XD1_XDFFQ_S XD0_XDFFM_MB XD1_XDFFQ_S 1.8151e-17
* device instance cc_XD0_XDFFM_MB_XD1_XDFFQ_SB r0 *1 0,0
Ccc_XD0_XDFFM_MB_XD1_XDFFQ_SB XD0_XDFFM_MB XD1_XDFFQ_SB 1.8151e-17
* device instance cc_XD0_XDFFM_MB_XD1_XN2_mid1 r0 *1 0,0
Ccc_XD0_XDFFM_MB_XD1_XN2_mid1 XD0_XDFFM_MB XD1_XN2_mid1 1.21e-17
* device instance cc_XD0_XDFFM_MB_XD1_XN3_mid1 r0 *1 0,0
Ccc_XD0_XDFFM_MB_XD1_XN3_mid1 XD0_XDFFM_MB XD1_XN3_mid1 1.21e-17
* device instance cc_XD0_XDFFM_MB_XD1_XN3_mid2 r0 *1 0,0
Ccc_XD0_XDFFM_MB_XD1_XN3_mid2 XD0_XDFFM_MB XD1_XN3_mid2 1.21e-17
* device instance cc_XD0_XDFFM_MB_XD1_dmodout r0 *1 0,0
Ccc_XD0_XDFFM_MB_XD1_dmodout XD0_XDFFM_MB XD1_dmodout 1.21e-17
* device instance cc_XD0_XDFFM_MB_XD1_dq r0 *1 0,0
Ccc_XD0_XDFFM_MB_XD1_dq XD0_XDFFM_MB XD1_dq 1.8151e-17
* device instance cc_XD0_XDFFM_MB_XD1_nm r0 *1 0,0
Ccc_XD0_XDFFM_MB_XD1_nm XD0_XDFFM_MB XD1_nm 1.21e-17
* device instance cc_XD0_XDFFM_MB_XD1_nt r0 *1 0,0
Ccc_XD0_XDFFM_MB_XD1_nt XD0_XDFFM_MB XD1_nt 1.21e-17
* device instance cc_XD0_XDFFM_MB_XD1_t1 r0 *1 0,0
Ccc_XD0_XDFFM_MB_XD1_t1 XD0_XDFFM_MB XD1_t1 1.21e-17
* device instance cc_XD0_XDFFM_MB_XD2_XDFFM_CLKB r0 *1 0,0
Ccc_XD0_XDFFM_MB_XD2_XDFFM_CLKB XD0_XDFFM_MB XD2_XDFFM_CLKB 1.8151e-17
* device instance cc_XD0_XDFFM_MB_XD2_XDFFM_M r0 *1 0,0
Ccc_XD0_XDFFM_MB_XD2_XDFFM_M XD0_XDFFM_MB XD2_XDFFM_M 2.4201e-17
* device instance cc_XD0_XDFFM_MB_XD2_XDFFM_MB r0 *1 0,0
Ccc_XD0_XDFFM_MB_XD2_XDFFM_MB XD0_XDFFM_MB XD2_XDFFM_MB 1.21e-17
* device instance cc_XD0_XDFFM_MB_XD2_XDFFM_S r0 *1 0,0
Ccc_XD0_XDFFM_MB_XD2_XDFFM_S XD0_XDFFM_MB XD2_XDFFM_S 1.8151e-17
* device instance cc_XD0_XDFFM_MB_XD2_XDFFM_SB r0 *1 0,0
Ccc_XD0_XDFFM_MB_XD2_XDFFM_SB XD0_XDFFM_MB XD2_XDFFM_SB 1.8151e-17
* device instance cc_XD0_XDFFM_MB_XD2_XDFFQ_CLKB r0 *1 0,0
Ccc_XD0_XDFFM_MB_XD2_XDFFQ_CLKB XD0_XDFFM_MB XD2_XDFFQ_CLKB 1.8151e-17
* device instance cc_XD0_XDFFM_MB_XD2_XDFFQ_M r0 *1 0,0
Ccc_XD0_XDFFM_MB_XD2_XDFFQ_M XD0_XDFFM_MB XD2_XDFFQ_M 2.4201e-17
* device instance cc_XD0_XDFFM_MB_XD2_XDFFQ_MB r0 *1 0,0
Ccc_XD0_XDFFM_MB_XD2_XDFFQ_MB XD0_XDFFM_MB XD2_XDFFQ_MB 1.21e-17
* device instance cc_XD0_XDFFM_MB_XD2_XDFFQ_S r0 *1 0,0
Ccc_XD0_XDFFM_MB_XD2_XDFFQ_S XD0_XDFFM_MB XD2_XDFFQ_S 1.8151e-17
* device instance cc_XD0_XDFFM_MB_XD2_XDFFQ_SB r0 *1 0,0
Ccc_XD0_XDFFM_MB_XD2_XDFFQ_SB XD0_XDFFM_MB XD2_XDFFQ_SB 1.8151e-17
* device instance cc_XD0_XDFFM_MB_XD2_XN2_mid1 r0 *1 0,0
Ccc_XD0_XDFFM_MB_XD2_XN2_mid1 XD0_XDFFM_MB XD2_XN2_mid1 1.21e-17
* device instance cc_XD0_XDFFM_MB_XD2_XN3_mid1 r0 *1 0,0
Ccc_XD0_XDFFM_MB_XD2_XN3_mid1 XD0_XDFFM_MB XD2_XN3_mid1 1.21e-17
* device instance cc_XD0_XDFFM_MB_XD2_XN3_mid2 r0 *1 0,0
Ccc_XD0_XDFFM_MB_XD2_XN3_mid2 XD0_XDFFM_MB XD2_XN3_mid2 1.21e-17
* device instance cc_XD0_XDFFM_MB_XD2_dmodout r0 *1 0,0
Ccc_XD0_XDFFM_MB_XD2_dmodout XD0_XDFFM_MB XD2_dmodout 1.21e-17
* device instance cc_XD0_XDFFM_MB_XD2_dq r0 *1 0,0
Ccc_XD0_XDFFM_MB_XD2_dq XD0_XDFFM_MB XD2_dq 1.8151e-17
* device instance cc_XD0_XDFFM_MB_XD2_nm r0 *1 0,0
Ccc_XD0_XDFFM_MB_XD2_nm XD0_XDFFM_MB XD2_nm 1.21e-17
* device instance cc_XD0_XDFFM_MB_XD2_nt r0 *1 0,0
Ccc_XD0_XDFFM_MB_XD2_nt XD0_XDFFM_MB XD2_nt 1.21e-17
* device instance cc_XD0_XDFFM_MB_XD2_t1 r0 *1 0,0
Ccc_XD0_XDFFM_MB_XD2_t1 XD0_XDFFM_MB XD2_t1 1.21e-17
* device instance cc_XD0_XDFFM_MB_XD3_XDFFM_CLKB r0 *1 0,0
Ccc_XD0_XDFFM_MB_XD3_XDFFM_CLKB XD0_XDFFM_MB XD3_XDFFM_CLKB 1.8151e-17
* device instance cc_XD0_XDFFM_MB_XD3_XDFFM_M r0 *1 0,0
Ccc_XD0_XDFFM_MB_XD3_XDFFM_M XD0_XDFFM_MB XD3_XDFFM_M 2.4201e-17
* device instance cc_XD0_XDFFM_MB_XD3_XDFFM_MB r0 *1 0,0
Ccc_XD0_XDFFM_MB_XD3_XDFFM_MB XD0_XDFFM_MB XD3_XDFFM_MB 1.21e-17
* device instance cc_XD0_XDFFM_MB_XD3_XDFFM_S r0 *1 0,0
Ccc_XD0_XDFFM_MB_XD3_XDFFM_S XD0_XDFFM_MB XD3_XDFFM_S 1.8151e-17
* device instance cc_XD0_XDFFM_MB_XD3_XDFFM_SB r0 *1 0,0
Ccc_XD0_XDFFM_MB_XD3_XDFFM_SB XD0_XDFFM_MB XD3_XDFFM_SB 1.8151e-17
* device instance cc_XD0_XDFFM_MB_XD3_XDFFQ_CLKB r0 *1 0,0
Ccc_XD0_XDFFM_MB_XD3_XDFFQ_CLKB XD0_XDFFM_MB XD3_XDFFQ_CLKB 1.8151e-17
* device instance cc_XD0_XDFFM_MB_XD3_XDFFQ_M r0 *1 0,0
Ccc_XD0_XDFFM_MB_XD3_XDFFQ_M XD0_XDFFM_MB XD3_XDFFQ_M 2.4201e-17
* device instance cc_XD0_XDFFM_MB_XD3_XDFFQ_MB r0 *1 0,0
Ccc_XD0_XDFFM_MB_XD3_XDFFQ_MB XD0_XDFFM_MB XD3_XDFFQ_MB 1.21e-17
* device instance cc_XD0_XDFFM_MB_XD3_XDFFQ_S r0 *1 0,0
Ccc_XD0_XDFFM_MB_XD3_XDFFQ_S XD0_XDFFM_MB XD3_XDFFQ_S 1.8151e-17
* device instance cc_XD0_XDFFM_MB_XD3_XDFFQ_SB r0 *1 0,0
Ccc_XD0_XDFFM_MB_XD3_XDFFQ_SB XD0_XDFFM_MB XD3_XDFFQ_SB 1.8151e-17
* device instance cc_XD0_XDFFM_MB_XD3_XN2_mid1 r0 *1 0,0
Ccc_XD0_XDFFM_MB_XD3_XN2_mid1 XD0_XDFFM_MB XD3_XN2_mid1 1.21e-17
* device instance cc_XD0_XDFFM_MB_XD3_XN3_mid1 r0 *1 0,0
Ccc_XD0_XDFFM_MB_XD3_XN3_mid1 XD0_XDFFM_MB XD3_XN3_mid1 1.21e-17
* device instance cc_XD0_XDFFM_MB_XD3_XN3_mid2 r0 *1 0,0
Ccc_XD0_XDFFM_MB_XD3_XN3_mid2 XD0_XDFFM_MB XD3_XN3_mid2 1.21e-17
* device instance cc_XD0_XDFFM_MB_XD3_dmodout r0 *1 0,0
Ccc_XD0_XDFFM_MB_XD3_dmodout XD0_XDFFM_MB XD3_dmodout 1.21e-17
* device instance cc_XD0_XDFFM_MB_XD3_dq r0 *1 0,0
Ccc_XD0_XDFFM_MB_XD3_dq XD0_XDFFM_MB XD3_dq 1.8151e-17
* device instance cc_XD0_XDFFM_MB_XD3_nm r0 *1 0,0
Ccc_XD0_XDFFM_MB_XD3_nm XD0_XDFFM_MB XD3_nm 1.21e-17
* device instance cc_XD0_XDFFM_MB_XD3_nt r0 *1 0,0
Ccc_XD0_XDFFM_MB_XD3_nt XD0_XDFFM_MB XD3_nt 1.21e-17
* device instance cc_XD0_XDFFM_MB_XD3_t1 r0 *1 0,0
Ccc_XD0_XDFFM_MB_XD3_t1 XD0_XDFFM_MB XD3_t1 1.21e-17
* device instance cc_XD0_XDFFM_MB_XD4_XDFFM_CLKB r0 *1 0,0
Ccc_XD0_XDFFM_MB_XD4_XDFFM_CLKB XD0_XDFFM_MB XD4_XDFFM_CLKB 1.8151e-17
* device instance cc_XD0_XDFFM_MB_XD4_XDFFM_M r0 *1 0,0
Ccc_XD0_XDFFM_MB_XD4_XDFFM_M XD0_XDFFM_MB XD4_XDFFM_M 2.4201e-17
* device instance cc_XD0_XDFFM_MB_XD4_XDFFM_MB r0 *1 0,0
Ccc_XD0_XDFFM_MB_XD4_XDFFM_MB XD0_XDFFM_MB XD4_XDFFM_MB 1.21e-17
* device instance cc_XD0_XDFFM_MB_XD4_XDFFM_S r0 *1 0,0
Ccc_XD0_XDFFM_MB_XD4_XDFFM_S XD0_XDFFM_MB XD4_XDFFM_S 1.8151e-17
* device instance cc_XD0_XDFFM_MB_XD4_XDFFM_SB r0 *1 0,0
Ccc_XD0_XDFFM_MB_XD4_XDFFM_SB XD0_XDFFM_MB XD4_XDFFM_SB 1.8151e-17
* device instance cc_XD0_XDFFM_MB_XD4_XDFFQ_CLKB r0 *1 0,0
Ccc_XD0_XDFFM_MB_XD4_XDFFQ_CLKB XD0_XDFFM_MB XD4_XDFFQ_CLKB 1.8151e-17
* device instance cc_XD0_XDFFM_MB_XD4_XDFFQ_M r0 *1 0,0
Ccc_XD0_XDFFM_MB_XD4_XDFFQ_M XD0_XDFFM_MB XD4_XDFFQ_M 2.4201e-17
* device instance cc_XD0_XDFFM_MB_XD4_XDFFQ_MB r0 *1 0,0
Ccc_XD0_XDFFM_MB_XD4_XDFFQ_MB XD0_XDFFM_MB XD4_XDFFQ_MB 1.21e-17
* device instance cc_XD0_XDFFM_MB_XD4_XDFFQ_S r0 *1 0,0
Ccc_XD0_XDFFM_MB_XD4_XDFFQ_S XD0_XDFFM_MB XD4_XDFFQ_S 1.8151e-17
* device instance cc_XD0_XDFFM_MB_XD4_XDFFQ_SB r0 *1 0,0
Ccc_XD0_XDFFM_MB_XD4_XDFFQ_SB XD0_XDFFM_MB XD4_XDFFQ_SB 1.8151e-17
* device instance cc_XD0_XDFFM_MB_XD4_XN2_mid1 r0 *1 0,0
Ccc_XD0_XDFFM_MB_XD4_XN2_mid1 XD0_XDFFM_MB XD4_XN2_mid1 1.21e-17
* device instance cc_XD0_XDFFM_MB_XD4_XN3_mid1 r0 *1 0,0
Ccc_XD0_XDFFM_MB_XD4_XN3_mid1 XD0_XDFFM_MB XD4_XN3_mid1 1.21e-17
* device instance cc_XD0_XDFFM_MB_XD4_XN3_mid2 r0 *1 0,0
Ccc_XD0_XDFFM_MB_XD4_XN3_mid2 XD0_XDFFM_MB XD4_XN3_mid2 1.21e-17
* device instance cc_XD0_XDFFM_MB_XD4_dmodout r0 *1 0,0
Ccc_XD0_XDFFM_MB_XD4_dmodout XD0_XDFFM_MB XD4_dmodout 1.21e-17
* device instance cc_XD0_XDFFM_MB_XD4_dq r0 *1 0,0
Ccc_XD0_XDFFM_MB_XD4_dq XD0_XDFFM_MB XD4_dq 1.8151e-17
* device instance cc_XD0_XDFFM_MB_XD4_nm r0 *1 0,0
Ccc_XD0_XDFFM_MB_XD4_nm XD0_XDFFM_MB XD4_nm 1.21e-17
* device instance cc_XD0_XDFFM_MB_XD4_nt r0 *1 0,0
Ccc_XD0_XDFFM_MB_XD4_nt XD0_XDFFM_MB XD4_nt 1.21e-17
* device instance cc_XD0_XDFFM_MB_XD4_t1 r0 *1 0,0
Ccc_XD0_XDFFM_MB_XD4_t1 XD0_XDFFM_MB XD4_t1 1.21e-17
* device instance cc_XD0_XDFFM_MB_XD5_XDFFM_CLKB r0 *1 0,0
Ccc_XD0_XDFFM_MB_XD5_XDFFM_CLKB XD0_XDFFM_MB XD5_XDFFM_CLKB 1.8151e-17
* device instance cc_XD0_XDFFM_MB_XD5_XDFFM_M r0 *1 0,0
Ccc_XD0_XDFFM_MB_XD5_XDFFM_M XD0_XDFFM_MB XD5_XDFFM_M 2.4201e-17
* device instance cc_XD0_XDFFM_MB_XD5_XDFFM_MB r0 *1 0,0
Ccc_XD0_XDFFM_MB_XD5_XDFFM_MB XD0_XDFFM_MB XD5_XDFFM_MB 1.21e-17
* device instance cc_XD0_XDFFM_MB_XD5_XDFFM_S r0 *1 0,0
Ccc_XD0_XDFFM_MB_XD5_XDFFM_S XD0_XDFFM_MB XD5_XDFFM_S 1.8151e-17
* device instance cc_XD0_XDFFM_MB_XD5_XDFFM_SB r0 *1 0,0
Ccc_XD0_XDFFM_MB_XD5_XDFFM_SB XD0_XDFFM_MB XD5_XDFFM_SB 1.8151e-17
* device instance cc_XD0_XDFFM_MB_XD5_XDFFQ_CLKB r0 *1 0,0
Ccc_XD0_XDFFM_MB_XD5_XDFFQ_CLKB XD0_XDFFM_MB XD5_XDFFQ_CLKB 1.8151e-17
* device instance cc_XD0_XDFFM_MB_XD5_XDFFQ_M r0 *1 0,0
Ccc_XD0_XDFFM_MB_XD5_XDFFQ_M XD0_XDFFM_MB XD5_XDFFQ_M 2.4201e-17
* device instance cc_XD0_XDFFM_MB_XD5_XDFFQ_MB r0 *1 0,0
Ccc_XD0_XDFFM_MB_XD5_XDFFQ_MB XD0_XDFFM_MB XD5_XDFFQ_MB 1.21e-17
* device instance cc_XD0_XDFFM_MB_XD5_XDFFQ_S r0 *1 0,0
Ccc_XD0_XDFFM_MB_XD5_XDFFQ_S XD0_XDFFM_MB XD5_XDFFQ_S 1.8151e-17
* device instance cc_XD0_XDFFM_MB_XD5_XDFFQ_SB r0 *1 0,0
Ccc_XD0_XDFFM_MB_XD5_XDFFQ_SB XD0_XDFFM_MB XD5_XDFFQ_SB 1.8151e-17
* device instance cc_XD0_XDFFM_MB_XD5_XN2_mid1 r0 *1 0,0
Ccc_XD0_XDFFM_MB_XD5_XN2_mid1 XD0_XDFFM_MB XD5_XN2_mid1 1.21e-17
* device instance cc_XD0_XDFFM_MB_XD5_XN3_mid1 r0 *1 0,0
Ccc_XD0_XDFFM_MB_XD5_XN3_mid1 XD0_XDFFM_MB XD5_XN3_mid1 1.21e-17
* device instance cc_XD0_XDFFM_MB_XD5_XN3_mid2 r0 *1 0,0
Ccc_XD0_XDFFM_MB_XD5_XN3_mid2 XD0_XDFFM_MB XD5_XN3_mid2 1.21e-17
* device instance cc_XD0_XDFFM_MB_XD5_dmodout r0 *1 0,0
Ccc_XD0_XDFFM_MB_XD5_dmodout XD0_XDFFM_MB XD5_dmodout 1.21e-17
* device instance cc_XD0_XDFFM_MB_XD5_dq r0 *1 0,0
Ccc_XD0_XDFFM_MB_XD5_dq XD0_XDFFM_MB XD5_dq 1.8151e-17
* device instance cc_XD0_XDFFM_MB_XD5_nm r0 *1 0,0
Ccc_XD0_XDFFM_MB_XD5_nm XD0_XDFFM_MB XD5_nm 1.21e-17
* device instance cc_XD0_XDFFM_MB_XD5_nt r0 *1 0,0
Ccc_XD0_XDFFM_MB_XD5_nt XD0_XDFFM_MB XD5_nt 1.21e-17
* device instance cc_XD0_XDFFM_MB_XD5_t1 r0 *1 0,0
Ccc_XD0_XDFFM_MB_XD5_t1 XD0_XDFFM_MB XD5_t1 1.21e-17
* device instance cc_XD0_XDFFM_MB_XFRT_CLKB r0 *1 0,0
Ccc_XD0_XDFFM_MB_XFRT_CLKB XD0_XDFFM_MB XFRT_CLKB 1.8151e-17
* device instance cc_XD0_XDFFM_MB_XFRT_M r0 *1 0,0
Ccc_XD0_XDFFM_MB_XFRT_M XD0_XDFFM_MB XFRT_M 2.4201e-17
* device instance cc_XD0_XDFFM_MB_XFRT_MB r0 *1 0,0
Ccc_XD0_XDFFM_MB_XFRT_MB XD0_XDFFM_MB XFRT_MB 1.21e-17
* device instance cc_XD0_XDFFM_MB_XFRT_S r0 *1 0,0
Ccc_XD0_XDFFM_MB_XFRT_S XD0_XDFFM_MB XFRT_S 1.8151e-17
* device instance cc_XD0_XDFFM_MB_XFRT_SB r0 *1 0,0
Ccc_XD0_XDFFM_MB_XFRT_SB XD0_XDFFM_MB XFRT_SB 1.8151e-17
* device instance cc_XD0_XDFFM_MB_ck1 r0 *1 0,0
Ccc_XD0_XDFFM_MB_ck1 XD0_XDFFM_MB ck1 5.4452e-17
* device instance cc_XD0_XDFFM_MB_ck2 r0 *1 0,0
Ccc_XD0_XDFFM_MB_ck2 XD0_XDFFM_MB ck2 5.4452e-17
* device instance cc_XD0_XDFFM_MB_ck3 r0 *1 0,0
Ccc_XD0_XDFFM_MB_ck3 XD0_XDFFM_MB ck3 5.4452e-17
* device instance cc_XD0_XDFFM_MB_ck4 r0 *1 0,0
Ccc_XD0_XDFFM_MB_ck4 XD0_XDFFM_MB ck4 5.4452e-17
* device instance cc_XD0_XDFFM_MB_ck5 r0 *1 0,0
Ccc_XD0_XDFFM_MB_ck5 XD0_XDFFM_MB ck5 5.4452e-17
* device instance cc_XD0_XDFFM_MB_mod0 r0 *1 0,0
Ccc_XD0_XDFFM_MB_mod0 XD0_XDFFM_MB mod0 2.4201e-17
* device instance cc_XD0_XDFFM_MB_mod1 r0 *1 0,0
Ccc_XD0_XDFFM_MB_mod1 XD0_XDFFM_MB mod1 2.4201e-17
* device instance cc_XD0_XDFFM_MB_mod2 r0 *1 0,0
Ccc_XD0_XDFFM_MB_mod2 XD0_XDFFM_MB mod2 2.4201e-17
* device instance cc_XD0_XDFFM_MB_mod3 r0 *1 0,0
Ccc_XD0_XDFFM_MB_mod3 XD0_XDFFM_MB mod3 2.4201e-17
* device instance cc_XD0_XDFFM_MB_mod4 r0 *1 0,0
Ccc_XD0_XDFFM_MB_mod4 XD0_XDFFM_MB mod4 2.4201e-17
* device instance cc_XD0_XDFFM_MB_net1 r0 *1 0,0
Ccc_XD0_XDFFM_MB_net1 XD0_XDFFM_MB net1 1.21e-17
* device instance cc_XD0_XDFFM_S_XD0_XDFFM_SB r0 *1 0,0
Ccc_XD0_XDFFM_S_XD0_XDFFM_SB XD0_XDFFM_S XD0_XDFFM_SB 4.0738e-17
* device instance cc_XD0_XDFFM_S_XD0_XDFFQ_CLKB r0 *1 0,0
Ccc_XD0_XDFFM_S_XD0_XDFFQ_CLKB XD0_XDFFM_S XD0_XDFFQ_CLKB 1.8151e-17
* device instance cc_XD0_XDFFM_S_XD0_XDFFQ_M r0 *1 0,0
Ccc_XD0_XDFFM_S_XD0_XDFFQ_M XD0_XDFFM_S XD0_XDFFQ_M 2.4201e-17
* device instance cc_XD0_XDFFM_S_XD0_XDFFQ_MB r0 *1 0,0
Ccc_XD0_XDFFM_S_XD0_XDFFQ_MB XD0_XDFFM_S XD0_XDFFQ_MB 1.21e-17
* device instance cc_XD0_XDFFM_S_XD0_XDFFQ_S r0 *1 0,0
Ccc_XD0_XDFFM_S_XD0_XDFFQ_S XD0_XDFFM_S XD0_XDFFQ_S 1.8151e-17
* device instance cc_XD0_XDFFM_S_XD0_XDFFQ_SB r0 *1 0,0
Ccc_XD0_XDFFM_S_XD0_XDFFQ_SB XD0_XDFFM_S XD0_XDFFQ_SB 1.8151e-17
* device instance cc_XD0_XDFFM_S_XD0_XNOR_midp r0 *1 0,0
Ccc_XD0_XDFFM_S_XD0_XNOR_midp XD0_XDFFM_S XD0_XNOR_midp 1.21e-17
* device instance cc_XD0_XDFFM_S_XD0_dmodout r0 *1 0,0
Ccc_XD0_XDFFM_S_XD0_dmodout XD0_XDFFM_S XD0_dmodout 1.21e-17
* device instance cc_XD0_XDFFM_S_XD0_dq r0 *1 0,0
Ccc_XD0_XDFFM_S_XD0_dq XD0_XDFFM_S XD0_dq 1.21e-17
* device instance cc_XD0_XDFFM_S_XD0_nm r0 *1 0,0
Ccc_XD0_XDFFM_S_XD0_nm XD0_XDFFM_S XD0_nm 1.8151e-17
* device instance cc_XD0_XDFFM_S_XD0_nt r0 *1 0,0
Ccc_XD0_XDFFM_S_XD0_nt XD0_XDFFM_S XD0_nt 2.4201e-17
* device instance cc_XD0_XDFFM_S_XD0_t1 r0 *1 0,0
Ccc_XD0_XDFFM_S_XD0_t1 XD0_XDFFM_S XD0_t1 1.21e-17
* device instance cc_XD0_XDFFM_S_XD1_XDFFM_CLKB r0 *1 0,0
Ccc_XD0_XDFFM_S_XD1_XDFFM_CLKB XD0_XDFFM_S XD1_XDFFM_CLKB 1.8151e-17
* device instance cc_XD0_XDFFM_S_XD1_XDFFM_M r0 *1 0,0
Ccc_XD0_XDFFM_S_XD1_XDFFM_M XD0_XDFFM_S XD1_XDFFM_M 2.4201e-17
* device instance cc_XD0_XDFFM_S_XD1_XDFFM_MB r0 *1 0,0
Ccc_XD0_XDFFM_S_XD1_XDFFM_MB XD0_XDFFM_S XD1_XDFFM_MB 1.21e-17
* device instance cc_XD0_XDFFM_S_XD1_XDFFM_S r0 *1 0,0
Ccc_XD0_XDFFM_S_XD1_XDFFM_S XD0_XDFFM_S XD1_XDFFM_S 1.8151e-17
* device instance cc_XD0_XDFFM_S_XD1_XDFFM_SB r0 *1 0,0
Ccc_XD0_XDFFM_S_XD1_XDFFM_SB XD0_XDFFM_S XD1_XDFFM_SB 1.8151e-17
* device instance cc_XD0_XDFFM_S_XD1_XDFFQ_CLKB r0 *1 0,0
Ccc_XD0_XDFFM_S_XD1_XDFFQ_CLKB XD0_XDFFM_S XD1_XDFFQ_CLKB 1.8151e-17
* device instance cc_XD0_XDFFM_S_XD1_XDFFQ_M r0 *1 0,0
Ccc_XD0_XDFFM_S_XD1_XDFFQ_M XD0_XDFFM_S XD1_XDFFQ_M 2.4201e-17
* device instance cc_XD0_XDFFM_S_XD1_XDFFQ_MB r0 *1 0,0
Ccc_XD0_XDFFM_S_XD1_XDFFQ_MB XD0_XDFFM_S XD1_XDFFQ_MB 1.21e-17
* device instance cc_XD0_XDFFM_S_XD1_XDFFQ_S r0 *1 0,0
Ccc_XD0_XDFFM_S_XD1_XDFFQ_S XD0_XDFFM_S XD1_XDFFQ_S 1.8151e-17
* device instance cc_XD0_XDFFM_S_XD1_XDFFQ_SB r0 *1 0,0
Ccc_XD0_XDFFM_S_XD1_XDFFQ_SB XD0_XDFFM_S XD1_XDFFQ_SB 1.8151e-17
* device instance cc_XD0_XDFFM_S_XD1_XN2_mid1 r0 *1 0,0
Ccc_XD0_XDFFM_S_XD1_XN2_mid1 XD0_XDFFM_S XD1_XN2_mid1 1.21e-17
* device instance cc_XD0_XDFFM_S_XD1_XN3_mid1 r0 *1 0,0
Ccc_XD0_XDFFM_S_XD1_XN3_mid1 XD0_XDFFM_S XD1_XN3_mid1 1.21e-17
* device instance cc_XD0_XDFFM_S_XD1_XN3_mid2 r0 *1 0,0
Ccc_XD0_XDFFM_S_XD1_XN3_mid2 XD0_XDFFM_S XD1_XN3_mid2 1.21e-17
* device instance cc_XD0_XDFFM_S_XD1_dmodout r0 *1 0,0
Ccc_XD0_XDFFM_S_XD1_dmodout XD0_XDFFM_S XD1_dmodout 1.21e-17
* device instance cc_XD0_XDFFM_S_XD1_dq r0 *1 0,0
Ccc_XD0_XDFFM_S_XD1_dq XD0_XDFFM_S XD1_dq 1.8151e-17
* device instance cc_XD0_XDFFM_S_XD1_nm r0 *1 0,0
Ccc_XD0_XDFFM_S_XD1_nm XD0_XDFFM_S XD1_nm 1.21e-17
* device instance cc_XD0_XDFFM_S_XD1_nt r0 *1 0,0
Ccc_XD0_XDFFM_S_XD1_nt XD0_XDFFM_S XD1_nt 1.21e-17
* device instance cc_XD0_XDFFM_S_XD1_t1 r0 *1 0,0
Ccc_XD0_XDFFM_S_XD1_t1 XD0_XDFFM_S XD1_t1 1.21e-17
* device instance cc_XD0_XDFFM_S_XD2_XDFFM_CLKB r0 *1 0,0
Ccc_XD0_XDFFM_S_XD2_XDFFM_CLKB XD0_XDFFM_S XD2_XDFFM_CLKB 1.8151e-17
* device instance cc_XD0_XDFFM_S_XD2_XDFFM_M r0 *1 0,0
Ccc_XD0_XDFFM_S_XD2_XDFFM_M XD0_XDFFM_S XD2_XDFFM_M 2.4201e-17
* device instance cc_XD0_XDFFM_S_XD2_XDFFM_MB r0 *1 0,0
Ccc_XD0_XDFFM_S_XD2_XDFFM_MB XD0_XDFFM_S XD2_XDFFM_MB 1.21e-17
* device instance cc_XD0_XDFFM_S_XD2_XDFFM_S r0 *1 0,0
Ccc_XD0_XDFFM_S_XD2_XDFFM_S XD0_XDFFM_S XD2_XDFFM_S 1.8151e-17
* device instance cc_XD0_XDFFM_S_XD2_XDFFM_SB r0 *1 0,0
Ccc_XD0_XDFFM_S_XD2_XDFFM_SB XD0_XDFFM_S XD2_XDFFM_SB 1.8151e-17
* device instance cc_XD0_XDFFM_S_XD2_XDFFQ_CLKB r0 *1 0,0
Ccc_XD0_XDFFM_S_XD2_XDFFQ_CLKB XD0_XDFFM_S XD2_XDFFQ_CLKB 1.8151e-17
* device instance cc_XD0_XDFFM_S_XD2_XDFFQ_M r0 *1 0,0
Ccc_XD0_XDFFM_S_XD2_XDFFQ_M XD0_XDFFM_S XD2_XDFFQ_M 2.4201e-17
* device instance cc_XD0_XDFFM_S_XD2_XDFFQ_MB r0 *1 0,0
Ccc_XD0_XDFFM_S_XD2_XDFFQ_MB XD0_XDFFM_S XD2_XDFFQ_MB 1.21e-17
* device instance cc_XD0_XDFFM_S_XD2_XDFFQ_S r0 *1 0,0
Ccc_XD0_XDFFM_S_XD2_XDFFQ_S XD0_XDFFM_S XD2_XDFFQ_S 1.8151e-17
* device instance cc_XD0_XDFFM_S_XD2_XDFFQ_SB r0 *1 0,0
Ccc_XD0_XDFFM_S_XD2_XDFFQ_SB XD0_XDFFM_S XD2_XDFFQ_SB 1.8151e-17
* device instance cc_XD0_XDFFM_S_XD2_XN2_mid1 r0 *1 0,0
Ccc_XD0_XDFFM_S_XD2_XN2_mid1 XD0_XDFFM_S XD2_XN2_mid1 1.21e-17
* device instance cc_XD0_XDFFM_S_XD2_XN3_mid1 r0 *1 0,0
Ccc_XD0_XDFFM_S_XD2_XN3_mid1 XD0_XDFFM_S XD2_XN3_mid1 1.21e-17
* device instance cc_XD0_XDFFM_S_XD2_XN3_mid2 r0 *1 0,0
Ccc_XD0_XDFFM_S_XD2_XN3_mid2 XD0_XDFFM_S XD2_XN3_mid2 1.21e-17
* device instance cc_XD0_XDFFM_S_XD2_dmodout r0 *1 0,0
Ccc_XD0_XDFFM_S_XD2_dmodout XD0_XDFFM_S XD2_dmodout 1.21e-17
* device instance cc_XD0_XDFFM_S_XD2_dq r0 *1 0,0
Ccc_XD0_XDFFM_S_XD2_dq XD0_XDFFM_S XD2_dq 1.8151e-17
* device instance cc_XD0_XDFFM_S_XD2_nm r0 *1 0,0
Ccc_XD0_XDFFM_S_XD2_nm XD0_XDFFM_S XD2_nm 1.21e-17
* device instance cc_XD0_XDFFM_S_XD2_nt r0 *1 0,0
Ccc_XD0_XDFFM_S_XD2_nt XD0_XDFFM_S XD2_nt 1.21e-17
* device instance cc_XD0_XDFFM_S_XD2_t1 r0 *1 0,0
Ccc_XD0_XDFFM_S_XD2_t1 XD0_XDFFM_S XD2_t1 1.21e-17
* device instance cc_XD0_XDFFM_S_XD3_XDFFM_CLKB r0 *1 0,0
Ccc_XD0_XDFFM_S_XD3_XDFFM_CLKB XD0_XDFFM_S XD3_XDFFM_CLKB 1.8151e-17
* device instance cc_XD0_XDFFM_S_XD3_XDFFM_M r0 *1 0,0
Ccc_XD0_XDFFM_S_XD3_XDFFM_M XD0_XDFFM_S XD3_XDFFM_M 2.4201e-17
* device instance cc_XD0_XDFFM_S_XD3_XDFFM_MB r0 *1 0,0
Ccc_XD0_XDFFM_S_XD3_XDFFM_MB XD0_XDFFM_S XD3_XDFFM_MB 1.21e-17
* device instance cc_XD0_XDFFM_S_XD3_XDFFM_S r0 *1 0,0
Ccc_XD0_XDFFM_S_XD3_XDFFM_S XD0_XDFFM_S XD3_XDFFM_S 1.8151e-17
* device instance cc_XD0_XDFFM_S_XD3_XDFFM_SB r0 *1 0,0
Ccc_XD0_XDFFM_S_XD3_XDFFM_SB XD0_XDFFM_S XD3_XDFFM_SB 1.8151e-17
* device instance cc_XD0_XDFFM_S_XD3_XDFFQ_CLKB r0 *1 0,0
Ccc_XD0_XDFFM_S_XD3_XDFFQ_CLKB XD0_XDFFM_S XD3_XDFFQ_CLKB 1.8151e-17
* device instance cc_XD0_XDFFM_S_XD3_XDFFQ_M r0 *1 0,0
Ccc_XD0_XDFFM_S_XD3_XDFFQ_M XD0_XDFFM_S XD3_XDFFQ_M 2.4201e-17
* device instance cc_XD0_XDFFM_S_XD3_XDFFQ_MB r0 *1 0,0
Ccc_XD0_XDFFM_S_XD3_XDFFQ_MB XD0_XDFFM_S XD3_XDFFQ_MB 1.21e-17
* device instance cc_XD0_XDFFM_S_XD3_XDFFQ_S r0 *1 0,0
Ccc_XD0_XDFFM_S_XD3_XDFFQ_S XD0_XDFFM_S XD3_XDFFQ_S 1.8151e-17
* device instance cc_XD0_XDFFM_S_XD3_XDFFQ_SB r0 *1 0,0
Ccc_XD0_XDFFM_S_XD3_XDFFQ_SB XD0_XDFFM_S XD3_XDFFQ_SB 1.8151e-17
* device instance cc_XD0_XDFFM_S_XD3_XN2_mid1 r0 *1 0,0
Ccc_XD0_XDFFM_S_XD3_XN2_mid1 XD0_XDFFM_S XD3_XN2_mid1 1.21e-17
* device instance cc_XD0_XDFFM_S_XD3_XN3_mid1 r0 *1 0,0
Ccc_XD0_XDFFM_S_XD3_XN3_mid1 XD0_XDFFM_S XD3_XN3_mid1 1.21e-17
* device instance cc_XD0_XDFFM_S_XD3_XN3_mid2 r0 *1 0,0
Ccc_XD0_XDFFM_S_XD3_XN3_mid2 XD0_XDFFM_S XD3_XN3_mid2 1.21e-17
* device instance cc_XD0_XDFFM_S_XD3_dmodout r0 *1 0,0
Ccc_XD0_XDFFM_S_XD3_dmodout XD0_XDFFM_S XD3_dmodout 1.21e-17
* device instance cc_XD0_XDFFM_S_XD3_dq r0 *1 0,0
Ccc_XD0_XDFFM_S_XD3_dq XD0_XDFFM_S XD3_dq 1.8151e-17
* device instance cc_XD0_XDFFM_S_XD3_nm r0 *1 0,0
Ccc_XD0_XDFFM_S_XD3_nm XD0_XDFFM_S XD3_nm 1.21e-17
* device instance cc_XD0_XDFFM_S_XD3_nt r0 *1 0,0
Ccc_XD0_XDFFM_S_XD3_nt XD0_XDFFM_S XD3_nt 1.21e-17
* device instance cc_XD0_XDFFM_S_XD3_t1 r0 *1 0,0
Ccc_XD0_XDFFM_S_XD3_t1 XD0_XDFFM_S XD3_t1 1.21e-17
* device instance cc_XD0_XDFFM_S_XD4_XDFFM_CLKB r0 *1 0,0
Ccc_XD0_XDFFM_S_XD4_XDFFM_CLKB XD0_XDFFM_S XD4_XDFFM_CLKB 1.8151e-17
* device instance cc_XD0_XDFFM_S_XD4_XDFFM_M r0 *1 0,0
Ccc_XD0_XDFFM_S_XD4_XDFFM_M XD0_XDFFM_S XD4_XDFFM_M 2.4201e-17
* device instance cc_XD0_XDFFM_S_XD4_XDFFM_MB r0 *1 0,0
Ccc_XD0_XDFFM_S_XD4_XDFFM_MB XD0_XDFFM_S XD4_XDFFM_MB 1.21e-17
* device instance cc_XD0_XDFFM_S_XD4_XDFFM_S r0 *1 0,0
Ccc_XD0_XDFFM_S_XD4_XDFFM_S XD0_XDFFM_S XD4_XDFFM_S 1.8151e-17
* device instance cc_XD0_XDFFM_S_XD4_XDFFM_SB r0 *1 0,0
Ccc_XD0_XDFFM_S_XD4_XDFFM_SB XD0_XDFFM_S XD4_XDFFM_SB 1.8151e-17
* device instance cc_XD0_XDFFM_S_XD4_XDFFQ_CLKB r0 *1 0,0
Ccc_XD0_XDFFM_S_XD4_XDFFQ_CLKB XD0_XDFFM_S XD4_XDFFQ_CLKB 1.8151e-17
* device instance cc_XD0_XDFFM_S_XD4_XDFFQ_M r0 *1 0,0
Ccc_XD0_XDFFM_S_XD4_XDFFQ_M XD0_XDFFM_S XD4_XDFFQ_M 2.4201e-17
* device instance cc_XD0_XDFFM_S_XD4_XDFFQ_MB r0 *1 0,0
Ccc_XD0_XDFFM_S_XD4_XDFFQ_MB XD0_XDFFM_S XD4_XDFFQ_MB 1.21e-17
* device instance cc_XD0_XDFFM_S_XD4_XDFFQ_S r0 *1 0,0
Ccc_XD0_XDFFM_S_XD4_XDFFQ_S XD0_XDFFM_S XD4_XDFFQ_S 1.8151e-17
* device instance cc_XD0_XDFFM_S_XD4_XDFFQ_SB r0 *1 0,0
Ccc_XD0_XDFFM_S_XD4_XDFFQ_SB XD0_XDFFM_S XD4_XDFFQ_SB 1.8151e-17
* device instance cc_XD0_XDFFM_S_XD4_XN2_mid1 r0 *1 0,0
Ccc_XD0_XDFFM_S_XD4_XN2_mid1 XD0_XDFFM_S XD4_XN2_mid1 1.21e-17
* device instance cc_XD0_XDFFM_S_XD4_XN3_mid1 r0 *1 0,0
Ccc_XD0_XDFFM_S_XD4_XN3_mid1 XD0_XDFFM_S XD4_XN3_mid1 1.21e-17
* device instance cc_XD0_XDFFM_S_XD4_XN3_mid2 r0 *1 0,0
Ccc_XD0_XDFFM_S_XD4_XN3_mid2 XD0_XDFFM_S XD4_XN3_mid2 1.21e-17
* device instance cc_XD0_XDFFM_S_XD4_dmodout r0 *1 0,0
Ccc_XD0_XDFFM_S_XD4_dmodout XD0_XDFFM_S XD4_dmodout 1.21e-17
* device instance cc_XD0_XDFFM_S_XD4_dq r0 *1 0,0
Ccc_XD0_XDFFM_S_XD4_dq XD0_XDFFM_S XD4_dq 1.8151e-17
* device instance cc_XD0_XDFFM_S_XD4_nm r0 *1 0,0
Ccc_XD0_XDFFM_S_XD4_nm XD0_XDFFM_S XD4_nm 1.21e-17
* device instance cc_XD0_XDFFM_S_XD4_nt r0 *1 0,0
Ccc_XD0_XDFFM_S_XD4_nt XD0_XDFFM_S XD4_nt 1.21e-17
* device instance cc_XD0_XDFFM_S_XD4_t1 r0 *1 0,0
Ccc_XD0_XDFFM_S_XD4_t1 XD0_XDFFM_S XD4_t1 1.21e-17
* device instance cc_XD0_XDFFM_S_XD5_XDFFM_CLKB r0 *1 0,0
Ccc_XD0_XDFFM_S_XD5_XDFFM_CLKB XD0_XDFFM_S XD5_XDFFM_CLKB 1.8151e-17
* device instance cc_XD0_XDFFM_S_XD5_XDFFM_M r0 *1 0,0
Ccc_XD0_XDFFM_S_XD5_XDFFM_M XD0_XDFFM_S XD5_XDFFM_M 2.4201e-17
* device instance cc_XD0_XDFFM_S_XD5_XDFFM_MB r0 *1 0,0
Ccc_XD0_XDFFM_S_XD5_XDFFM_MB XD0_XDFFM_S XD5_XDFFM_MB 1.21e-17
* device instance cc_XD0_XDFFM_S_XD5_XDFFM_S r0 *1 0,0
Ccc_XD0_XDFFM_S_XD5_XDFFM_S XD0_XDFFM_S XD5_XDFFM_S 1.8151e-17
* device instance cc_XD0_XDFFM_S_XD5_XDFFM_SB r0 *1 0,0
Ccc_XD0_XDFFM_S_XD5_XDFFM_SB XD0_XDFFM_S XD5_XDFFM_SB 1.8151e-17
* device instance cc_XD0_XDFFM_S_XD5_XDFFQ_CLKB r0 *1 0,0
Ccc_XD0_XDFFM_S_XD5_XDFFQ_CLKB XD0_XDFFM_S XD5_XDFFQ_CLKB 1.8151e-17
* device instance cc_XD0_XDFFM_S_XD5_XDFFQ_M r0 *1 0,0
Ccc_XD0_XDFFM_S_XD5_XDFFQ_M XD0_XDFFM_S XD5_XDFFQ_M 2.4201e-17
* device instance cc_XD0_XDFFM_S_XD5_XDFFQ_MB r0 *1 0,0
Ccc_XD0_XDFFM_S_XD5_XDFFQ_MB XD0_XDFFM_S XD5_XDFFQ_MB 1.21e-17
* device instance cc_XD0_XDFFM_S_XD5_XDFFQ_S r0 *1 0,0
Ccc_XD0_XDFFM_S_XD5_XDFFQ_S XD0_XDFFM_S XD5_XDFFQ_S 1.8151e-17
* device instance cc_XD0_XDFFM_S_XD5_XDFFQ_SB r0 *1 0,0
Ccc_XD0_XDFFM_S_XD5_XDFFQ_SB XD0_XDFFM_S XD5_XDFFQ_SB 1.8151e-17
* device instance cc_XD0_XDFFM_S_XD5_XN2_mid1 r0 *1 0,0
Ccc_XD0_XDFFM_S_XD5_XN2_mid1 XD0_XDFFM_S XD5_XN2_mid1 1.21e-17
* device instance cc_XD0_XDFFM_S_XD5_XN3_mid1 r0 *1 0,0
Ccc_XD0_XDFFM_S_XD5_XN3_mid1 XD0_XDFFM_S XD5_XN3_mid1 1.21e-17
* device instance cc_XD0_XDFFM_S_XD5_XN3_mid2 r0 *1 0,0
Ccc_XD0_XDFFM_S_XD5_XN3_mid2 XD0_XDFFM_S XD5_XN3_mid2 1.21e-17
* device instance cc_XD0_XDFFM_S_XD5_dmodout r0 *1 0,0
Ccc_XD0_XDFFM_S_XD5_dmodout XD0_XDFFM_S XD5_dmodout 1.21e-17
* device instance cc_XD0_XDFFM_S_XD5_dq r0 *1 0,0
Ccc_XD0_XDFFM_S_XD5_dq XD0_XDFFM_S XD5_dq 1.8151e-17
* device instance cc_XD0_XDFFM_S_XD5_nm r0 *1 0,0
Ccc_XD0_XDFFM_S_XD5_nm XD0_XDFFM_S XD5_nm 1.21e-17
* device instance cc_XD0_XDFFM_S_XD5_nt r0 *1 0,0
Ccc_XD0_XDFFM_S_XD5_nt XD0_XDFFM_S XD5_nt 1.21e-17
* device instance cc_XD0_XDFFM_S_XD5_t1 r0 *1 0,0
Ccc_XD0_XDFFM_S_XD5_t1 XD0_XDFFM_S XD5_t1 1.21e-17
* device instance cc_XD0_XDFFM_S_XFRT_CLKB r0 *1 0,0
Ccc_XD0_XDFFM_S_XFRT_CLKB XD0_XDFFM_S XFRT_CLKB 1.8151e-17
* device instance cc_XD0_XDFFM_S_XFRT_M r0 *1 0,0
Ccc_XD0_XDFFM_S_XFRT_M XD0_XDFFM_S XFRT_M 2.4201e-17
* device instance cc_XD0_XDFFM_S_XFRT_MB r0 *1 0,0
Ccc_XD0_XDFFM_S_XFRT_MB XD0_XDFFM_S XFRT_MB 1.21e-17
* device instance cc_XD0_XDFFM_S_XFRT_S r0 *1 0,0
Ccc_XD0_XDFFM_S_XFRT_S XD0_XDFFM_S XFRT_S 1.8151e-17
* device instance cc_XD0_XDFFM_S_XFRT_SB r0 *1 0,0
Ccc_XD0_XDFFM_S_XFRT_SB XD0_XDFFM_S XFRT_SB 1.8151e-17
* device instance cc_XD0_XDFFM_S_ck1 r0 *1 0,0
Ccc_XD0_XDFFM_S_ck1 XD0_XDFFM_S ck1 5.4452e-17
* device instance cc_XD0_XDFFM_S_ck2 r0 *1 0,0
Ccc_XD0_XDFFM_S_ck2 XD0_XDFFM_S ck2 5.4452e-17
* device instance cc_XD0_XDFFM_S_ck3 r0 *1 0,0
Ccc_XD0_XDFFM_S_ck3 XD0_XDFFM_S ck3 5.4452e-17
* device instance cc_XD0_XDFFM_S_ck4 r0 *1 0,0
Ccc_XD0_XDFFM_S_ck4 XD0_XDFFM_S ck4 5.4452e-17
* device instance cc_XD0_XDFFM_S_ck5 r0 *1 0,0
Ccc_XD0_XDFFM_S_ck5 XD0_XDFFM_S ck5 5.4452e-17
* device instance cc_XD0_XDFFM_S_mod0 r0 *1 0,0
Ccc_XD0_XDFFM_S_mod0 XD0_XDFFM_S mod0 2.4201e-17
* device instance cc_XD0_XDFFM_S_mod1 r0 *1 0,0
Ccc_XD0_XDFFM_S_mod1 XD0_XDFFM_S mod1 2.4201e-17
* device instance cc_XD0_XDFFM_S_mod2 r0 *1 0,0
Ccc_XD0_XDFFM_S_mod2 XD0_XDFFM_S mod2 2.4201e-17
* device instance cc_XD0_XDFFM_S_mod3 r0 *1 0,0
Ccc_XD0_XDFFM_S_mod3 XD0_XDFFM_S mod3 2.4201e-17
* device instance cc_XD0_XDFFM_S_mod4 r0 *1 0,0
Ccc_XD0_XDFFM_S_mod4 XD0_XDFFM_S mod4 2.4201e-17
* device instance cc_XD0_XDFFM_S_net1 r0 *1 0,0
Ccc_XD0_XDFFM_S_net1 XD0_XDFFM_S net1 1.21e-17
* device instance cc_XD0_XDFFM_SB_XD0_XDFFQ_CLKB r0 *1 0,0
Ccc_XD0_XDFFM_SB_XD0_XDFFQ_CLKB XD0_XDFFM_SB XD0_XDFFQ_CLKB 1.8151e-17
* device instance cc_XD0_XDFFM_SB_XD0_XDFFQ_M r0 *1 0,0
Ccc_XD0_XDFFM_SB_XD0_XDFFQ_M XD0_XDFFM_SB XD0_XDFFQ_M 2.4201e-17
* device instance cc_XD0_XDFFM_SB_XD0_XDFFQ_MB r0 *1 0,0
Ccc_XD0_XDFFM_SB_XD0_XDFFQ_MB XD0_XDFFM_SB XD0_XDFFQ_MB 1.21e-17
* device instance cc_XD0_XDFFM_SB_XD0_XDFFQ_S r0 *1 0,0
Ccc_XD0_XDFFM_SB_XD0_XDFFQ_S XD0_XDFFM_SB XD0_XDFFQ_S 1.8151e-17
* device instance cc_XD0_XDFFM_SB_XD0_XDFFQ_SB r0 *1 0,0
Ccc_XD0_XDFFM_SB_XD0_XDFFQ_SB XD0_XDFFM_SB XD0_XDFFQ_SB 1.8151e-17
* device instance cc_XD0_XDFFM_SB_XD0_XNOR_midp r0 *1 0,0
Ccc_XD0_XDFFM_SB_XD0_XNOR_midp XD0_XDFFM_SB XD0_XNOR_midp 1.21e-17
* device instance cc_XD0_XDFFM_SB_XD0_dmodout r0 *1 0,0
Ccc_XD0_XDFFM_SB_XD0_dmodout XD0_XDFFM_SB XD0_dmodout 1.21e-17
* device instance cc_XD0_XDFFM_SB_XD0_dq r0 *1 0,0
Ccc_XD0_XDFFM_SB_XD0_dq XD0_XDFFM_SB XD0_dq 1.21e-17
* device instance cc_XD0_XDFFM_SB_XD0_nm r0 *1 0,0
Ccc_XD0_XDFFM_SB_XD0_nm XD0_XDFFM_SB XD0_nm 1.8151e-17
* device instance cc_XD0_XDFFM_SB_XD0_nt r0 *1 0,0
Ccc_XD0_XDFFM_SB_XD0_nt XD0_XDFFM_SB XD0_nt 2.4201e-17
* device instance cc_XD0_XDFFM_SB_XD0_t1 r0 *1 0,0
Ccc_XD0_XDFFM_SB_XD0_t1 XD0_XDFFM_SB XD0_t1 1.21e-17
* device instance cc_XD0_XDFFM_SB_XD1_XDFFM_CLKB r0 *1 0,0
Ccc_XD0_XDFFM_SB_XD1_XDFFM_CLKB XD0_XDFFM_SB XD1_XDFFM_CLKB 1.8151e-17
* device instance cc_XD0_XDFFM_SB_XD1_XDFFM_M r0 *1 0,0
Ccc_XD0_XDFFM_SB_XD1_XDFFM_M XD0_XDFFM_SB XD1_XDFFM_M 2.4201e-17
* device instance cc_XD0_XDFFM_SB_XD1_XDFFM_MB r0 *1 0,0
Ccc_XD0_XDFFM_SB_XD1_XDFFM_MB XD0_XDFFM_SB XD1_XDFFM_MB 1.21e-17
* device instance cc_XD0_XDFFM_SB_XD1_XDFFM_S r0 *1 0,0
Ccc_XD0_XDFFM_SB_XD1_XDFFM_S XD0_XDFFM_SB XD1_XDFFM_S 1.8151e-17
* device instance cc_XD0_XDFFM_SB_XD1_XDFFM_SB r0 *1 0,0
Ccc_XD0_XDFFM_SB_XD1_XDFFM_SB XD0_XDFFM_SB XD1_XDFFM_SB 1.8151e-17
* device instance cc_XD0_XDFFM_SB_XD1_XDFFQ_CLKB r0 *1 0,0
Ccc_XD0_XDFFM_SB_XD1_XDFFQ_CLKB XD0_XDFFM_SB XD1_XDFFQ_CLKB 1.8151e-17
* device instance cc_XD0_XDFFM_SB_XD1_XDFFQ_M r0 *1 0,0
Ccc_XD0_XDFFM_SB_XD1_XDFFQ_M XD0_XDFFM_SB XD1_XDFFQ_M 2.4201e-17
* device instance cc_XD0_XDFFM_SB_XD1_XDFFQ_MB r0 *1 0,0
Ccc_XD0_XDFFM_SB_XD1_XDFFQ_MB XD0_XDFFM_SB XD1_XDFFQ_MB 1.21e-17
* device instance cc_XD0_XDFFM_SB_XD1_XDFFQ_S r0 *1 0,0
Ccc_XD0_XDFFM_SB_XD1_XDFFQ_S XD0_XDFFM_SB XD1_XDFFQ_S 1.8151e-17
* device instance cc_XD0_XDFFM_SB_XD1_XDFFQ_SB r0 *1 0,0
Ccc_XD0_XDFFM_SB_XD1_XDFFQ_SB XD0_XDFFM_SB XD1_XDFFQ_SB 1.8151e-17
* device instance cc_XD0_XDFFM_SB_XD1_XN2_mid1 r0 *1 0,0
Ccc_XD0_XDFFM_SB_XD1_XN2_mid1 XD0_XDFFM_SB XD1_XN2_mid1 1.21e-17
* device instance cc_XD0_XDFFM_SB_XD1_XN3_mid1 r0 *1 0,0
Ccc_XD0_XDFFM_SB_XD1_XN3_mid1 XD0_XDFFM_SB XD1_XN3_mid1 1.21e-17
* device instance cc_XD0_XDFFM_SB_XD1_XN3_mid2 r0 *1 0,0
Ccc_XD0_XDFFM_SB_XD1_XN3_mid2 XD0_XDFFM_SB XD1_XN3_mid2 1.21e-17
* device instance cc_XD0_XDFFM_SB_XD1_dmodout r0 *1 0,0
Ccc_XD0_XDFFM_SB_XD1_dmodout XD0_XDFFM_SB XD1_dmodout 1.21e-17
* device instance cc_XD0_XDFFM_SB_XD1_dq r0 *1 0,0
Ccc_XD0_XDFFM_SB_XD1_dq XD0_XDFFM_SB XD1_dq 1.8151e-17
* device instance cc_XD0_XDFFM_SB_XD1_nm r0 *1 0,0
Ccc_XD0_XDFFM_SB_XD1_nm XD0_XDFFM_SB XD1_nm 1.21e-17
* device instance cc_XD0_XDFFM_SB_XD1_nt r0 *1 0,0
Ccc_XD0_XDFFM_SB_XD1_nt XD0_XDFFM_SB XD1_nt 1.21e-17
* device instance cc_XD0_XDFFM_SB_XD1_t1 r0 *1 0,0
Ccc_XD0_XDFFM_SB_XD1_t1 XD0_XDFFM_SB XD1_t1 1.21e-17
* device instance cc_XD0_XDFFM_SB_XD2_XDFFM_CLKB r0 *1 0,0
Ccc_XD0_XDFFM_SB_XD2_XDFFM_CLKB XD0_XDFFM_SB XD2_XDFFM_CLKB 1.8151e-17
* device instance cc_XD0_XDFFM_SB_XD2_XDFFM_M r0 *1 0,0
Ccc_XD0_XDFFM_SB_XD2_XDFFM_M XD0_XDFFM_SB XD2_XDFFM_M 2.4201e-17
* device instance cc_XD0_XDFFM_SB_XD2_XDFFM_MB r0 *1 0,0
Ccc_XD0_XDFFM_SB_XD2_XDFFM_MB XD0_XDFFM_SB XD2_XDFFM_MB 1.21e-17
* device instance cc_XD0_XDFFM_SB_XD2_XDFFM_S r0 *1 0,0
Ccc_XD0_XDFFM_SB_XD2_XDFFM_S XD0_XDFFM_SB XD2_XDFFM_S 1.8151e-17
* device instance cc_XD0_XDFFM_SB_XD2_XDFFM_SB r0 *1 0,0
Ccc_XD0_XDFFM_SB_XD2_XDFFM_SB XD0_XDFFM_SB XD2_XDFFM_SB 1.8151e-17
* device instance cc_XD0_XDFFM_SB_XD2_XDFFQ_CLKB r0 *1 0,0
Ccc_XD0_XDFFM_SB_XD2_XDFFQ_CLKB XD0_XDFFM_SB XD2_XDFFQ_CLKB 1.8151e-17
* device instance cc_XD0_XDFFM_SB_XD2_XDFFQ_M r0 *1 0,0
Ccc_XD0_XDFFM_SB_XD2_XDFFQ_M XD0_XDFFM_SB XD2_XDFFQ_M 2.4201e-17
* device instance cc_XD0_XDFFM_SB_XD2_XDFFQ_MB r0 *1 0,0
Ccc_XD0_XDFFM_SB_XD2_XDFFQ_MB XD0_XDFFM_SB XD2_XDFFQ_MB 1.21e-17
* device instance cc_XD0_XDFFM_SB_XD2_XDFFQ_S r0 *1 0,0
Ccc_XD0_XDFFM_SB_XD2_XDFFQ_S XD0_XDFFM_SB XD2_XDFFQ_S 1.8151e-17
* device instance cc_XD0_XDFFM_SB_XD2_XDFFQ_SB r0 *1 0,0
Ccc_XD0_XDFFM_SB_XD2_XDFFQ_SB XD0_XDFFM_SB XD2_XDFFQ_SB 1.8151e-17
* device instance cc_XD0_XDFFM_SB_XD2_XN2_mid1 r0 *1 0,0
Ccc_XD0_XDFFM_SB_XD2_XN2_mid1 XD0_XDFFM_SB XD2_XN2_mid1 1.21e-17
* device instance cc_XD0_XDFFM_SB_XD2_XN3_mid1 r0 *1 0,0
Ccc_XD0_XDFFM_SB_XD2_XN3_mid1 XD0_XDFFM_SB XD2_XN3_mid1 1.21e-17
* device instance cc_XD0_XDFFM_SB_XD2_XN3_mid2 r0 *1 0,0
Ccc_XD0_XDFFM_SB_XD2_XN3_mid2 XD0_XDFFM_SB XD2_XN3_mid2 1.21e-17
* device instance cc_XD0_XDFFM_SB_XD2_dmodout r0 *1 0,0
Ccc_XD0_XDFFM_SB_XD2_dmodout XD0_XDFFM_SB XD2_dmodout 1.21e-17
* device instance cc_XD0_XDFFM_SB_XD2_dq r0 *1 0,0
Ccc_XD0_XDFFM_SB_XD2_dq XD0_XDFFM_SB XD2_dq 1.8151e-17
* device instance cc_XD0_XDFFM_SB_XD2_nm r0 *1 0,0
Ccc_XD0_XDFFM_SB_XD2_nm XD0_XDFFM_SB XD2_nm 1.21e-17
* device instance cc_XD0_XDFFM_SB_XD2_nt r0 *1 0,0
Ccc_XD0_XDFFM_SB_XD2_nt XD0_XDFFM_SB XD2_nt 1.21e-17
* device instance cc_XD0_XDFFM_SB_XD2_t1 r0 *1 0,0
Ccc_XD0_XDFFM_SB_XD2_t1 XD0_XDFFM_SB XD2_t1 1.21e-17
* device instance cc_XD0_XDFFM_SB_XD3_XDFFM_CLKB r0 *1 0,0
Ccc_XD0_XDFFM_SB_XD3_XDFFM_CLKB XD0_XDFFM_SB XD3_XDFFM_CLKB 1.8151e-17
* device instance cc_XD0_XDFFM_SB_XD3_XDFFM_M r0 *1 0,0
Ccc_XD0_XDFFM_SB_XD3_XDFFM_M XD0_XDFFM_SB XD3_XDFFM_M 2.4201e-17
* device instance cc_XD0_XDFFM_SB_XD3_XDFFM_MB r0 *1 0,0
Ccc_XD0_XDFFM_SB_XD3_XDFFM_MB XD0_XDFFM_SB XD3_XDFFM_MB 1.21e-17
* device instance cc_XD0_XDFFM_SB_XD3_XDFFM_S r0 *1 0,0
Ccc_XD0_XDFFM_SB_XD3_XDFFM_S XD0_XDFFM_SB XD3_XDFFM_S 1.8151e-17
* device instance cc_XD0_XDFFM_SB_XD3_XDFFM_SB r0 *1 0,0
Ccc_XD0_XDFFM_SB_XD3_XDFFM_SB XD0_XDFFM_SB XD3_XDFFM_SB 1.8151e-17
* device instance cc_XD0_XDFFM_SB_XD3_XDFFQ_CLKB r0 *1 0,0
Ccc_XD0_XDFFM_SB_XD3_XDFFQ_CLKB XD0_XDFFM_SB XD3_XDFFQ_CLKB 1.8151e-17
* device instance cc_XD0_XDFFM_SB_XD3_XDFFQ_M r0 *1 0,0
Ccc_XD0_XDFFM_SB_XD3_XDFFQ_M XD0_XDFFM_SB XD3_XDFFQ_M 2.4201e-17
* device instance cc_XD0_XDFFM_SB_XD3_XDFFQ_MB r0 *1 0,0
Ccc_XD0_XDFFM_SB_XD3_XDFFQ_MB XD0_XDFFM_SB XD3_XDFFQ_MB 1.21e-17
* device instance cc_XD0_XDFFM_SB_XD3_XDFFQ_S r0 *1 0,0
Ccc_XD0_XDFFM_SB_XD3_XDFFQ_S XD0_XDFFM_SB XD3_XDFFQ_S 1.8151e-17
* device instance cc_XD0_XDFFM_SB_XD3_XDFFQ_SB r0 *1 0,0
Ccc_XD0_XDFFM_SB_XD3_XDFFQ_SB XD0_XDFFM_SB XD3_XDFFQ_SB 1.8151e-17
* device instance cc_XD0_XDFFM_SB_XD3_XN2_mid1 r0 *1 0,0
Ccc_XD0_XDFFM_SB_XD3_XN2_mid1 XD0_XDFFM_SB XD3_XN2_mid1 1.21e-17
* device instance cc_XD0_XDFFM_SB_XD3_XN3_mid1 r0 *1 0,0
Ccc_XD0_XDFFM_SB_XD3_XN3_mid1 XD0_XDFFM_SB XD3_XN3_mid1 1.21e-17
* device instance cc_XD0_XDFFM_SB_XD3_XN3_mid2 r0 *1 0,0
Ccc_XD0_XDFFM_SB_XD3_XN3_mid2 XD0_XDFFM_SB XD3_XN3_mid2 1.21e-17
* device instance cc_XD0_XDFFM_SB_XD3_dmodout r0 *1 0,0
Ccc_XD0_XDFFM_SB_XD3_dmodout XD0_XDFFM_SB XD3_dmodout 1.21e-17
* device instance cc_XD0_XDFFM_SB_XD3_dq r0 *1 0,0
Ccc_XD0_XDFFM_SB_XD3_dq XD0_XDFFM_SB XD3_dq 1.8151e-17
* device instance cc_XD0_XDFFM_SB_XD3_nm r0 *1 0,0
Ccc_XD0_XDFFM_SB_XD3_nm XD0_XDFFM_SB XD3_nm 1.21e-17
* device instance cc_XD0_XDFFM_SB_XD3_nt r0 *1 0,0
Ccc_XD0_XDFFM_SB_XD3_nt XD0_XDFFM_SB XD3_nt 1.21e-17
* device instance cc_XD0_XDFFM_SB_XD3_t1 r0 *1 0,0
Ccc_XD0_XDFFM_SB_XD3_t1 XD0_XDFFM_SB XD3_t1 1.21e-17
* device instance cc_XD0_XDFFM_SB_XD4_XDFFM_CLKB r0 *1 0,0
Ccc_XD0_XDFFM_SB_XD4_XDFFM_CLKB XD0_XDFFM_SB XD4_XDFFM_CLKB 1.8151e-17
* device instance cc_XD0_XDFFM_SB_XD4_XDFFM_M r0 *1 0,0
Ccc_XD0_XDFFM_SB_XD4_XDFFM_M XD0_XDFFM_SB XD4_XDFFM_M 2.4201e-17
* device instance cc_XD0_XDFFM_SB_XD4_XDFFM_MB r0 *1 0,0
Ccc_XD0_XDFFM_SB_XD4_XDFFM_MB XD0_XDFFM_SB XD4_XDFFM_MB 1.21e-17
* device instance cc_XD0_XDFFM_SB_XD4_XDFFM_S r0 *1 0,0
Ccc_XD0_XDFFM_SB_XD4_XDFFM_S XD0_XDFFM_SB XD4_XDFFM_S 1.8151e-17
* device instance cc_XD0_XDFFM_SB_XD4_XDFFM_SB r0 *1 0,0
Ccc_XD0_XDFFM_SB_XD4_XDFFM_SB XD0_XDFFM_SB XD4_XDFFM_SB 1.8151e-17
* device instance cc_XD0_XDFFM_SB_XD4_XDFFQ_CLKB r0 *1 0,0
Ccc_XD0_XDFFM_SB_XD4_XDFFQ_CLKB XD0_XDFFM_SB XD4_XDFFQ_CLKB 1.8151e-17
* device instance cc_XD0_XDFFM_SB_XD4_XDFFQ_M r0 *1 0,0
Ccc_XD0_XDFFM_SB_XD4_XDFFQ_M XD0_XDFFM_SB XD4_XDFFQ_M 2.4201e-17
* device instance cc_XD0_XDFFM_SB_XD4_XDFFQ_MB r0 *1 0,0
Ccc_XD0_XDFFM_SB_XD4_XDFFQ_MB XD0_XDFFM_SB XD4_XDFFQ_MB 1.21e-17
* device instance cc_XD0_XDFFM_SB_XD4_XDFFQ_S r0 *1 0,0
Ccc_XD0_XDFFM_SB_XD4_XDFFQ_S XD0_XDFFM_SB XD4_XDFFQ_S 1.8151e-17
* device instance cc_XD0_XDFFM_SB_XD4_XDFFQ_SB r0 *1 0,0
Ccc_XD0_XDFFM_SB_XD4_XDFFQ_SB XD0_XDFFM_SB XD4_XDFFQ_SB 1.8151e-17
* device instance cc_XD0_XDFFM_SB_XD4_XN2_mid1 r0 *1 0,0
Ccc_XD0_XDFFM_SB_XD4_XN2_mid1 XD0_XDFFM_SB XD4_XN2_mid1 1.21e-17
* device instance cc_XD0_XDFFM_SB_XD4_XN3_mid1 r0 *1 0,0
Ccc_XD0_XDFFM_SB_XD4_XN3_mid1 XD0_XDFFM_SB XD4_XN3_mid1 1.21e-17
* device instance cc_XD0_XDFFM_SB_XD4_XN3_mid2 r0 *1 0,0
Ccc_XD0_XDFFM_SB_XD4_XN3_mid2 XD0_XDFFM_SB XD4_XN3_mid2 1.21e-17
* device instance cc_XD0_XDFFM_SB_XD4_dmodout r0 *1 0,0
Ccc_XD0_XDFFM_SB_XD4_dmodout XD0_XDFFM_SB XD4_dmodout 1.21e-17
* device instance cc_XD0_XDFFM_SB_XD4_dq r0 *1 0,0
Ccc_XD0_XDFFM_SB_XD4_dq XD0_XDFFM_SB XD4_dq 1.8151e-17
* device instance cc_XD0_XDFFM_SB_XD4_nm r0 *1 0,0
Ccc_XD0_XDFFM_SB_XD4_nm XD0_XDFFM_SB XD4_nm 1.21e-17
* device instance cc_XD0_XDFFM_SB_XD4_nt r0 *1 0,0
Ccc_XD0_XDFFM_SB_XD4_nt XD0_XDFFM_SB XD4_nt 1.21e-17
* device instance cc_XD0_XDFFM_SB_XD4_t1 r0 *1 0,0
Ccc_XD0_XDFFM_SB_XD4_t1 XD0_XDFFM_SB XD4_t1 1.21e-17
* device instance cc_XD0_XDFFM_SB_XD5_XDFFM_CLKB r0 *1 0,0
Ccc_XD0_XDFFM_SB_XD5_XDFFM_CLKB XD0_XDFFM_SB XD5_XDFFM_CLKB 1.8151e-17
* device instance cc_XD0_XDFFM_SB_XD5_XDFFM_M r0 *1 0,0
Ccc_XD0_XDFFM_SB_XD5_XDFFM_M XD0_XDFFM_SB XD5_XDFFM_M 2.4201e-17
* device instance cc_XD0_XDFFM_SB_XD5_XDFFM_MB r0 *1 0,0
Ccc_XD0_XDFFM_SB_XD5_XDFFM_MB XD0_XDFFM_SB XD5_XDFFM_MB 1.21e-17
* device instance cc_XD0_XDFFM_SB_XD5_XDFFM_S r0 *1 0,0
Ccc_XD0_XDFFM_SB_XD5_XDFFM_S XD0_XDFFM_SB XD5_XDFFM_S 1.8151e-17
* device instance cc_XD0_XDFFM_SB_XD5_XDFFM_SB r0 *1 0,0
Ccc_XD0_XDFFM_SB_XD5_XDFFM_SB XD0_XDFFM_SB XD5_XDFFM_SB 1.8151e-17
* device instance cc_XD0_XDFFM_SB_XD5_XDFFQ_CLKB r0 *1 0,0
Ccc_XD0_XDFFM_SB_XD5_XDFFQ_CLKB XD0_XDFFM_SB XD5_XDFFQ_CLKB 1.8151e-17
* device instance cc_XD0_XDFFM_SB_XD5_XDFFQ_M r0 *1 0,0
Ccc_XD0_XDFFM_SB_XD5_XDFFQ_M XD0_XDFFM_SB XD5_XDFFQ_M 2.4201e-17
* device instance cc_XD0_XDFFM_SB_XD5_XDFFQ_MB r0 *1 0,0
Ccc_XD0_XDFFM_SB_XD5_XDFFQ_MB XD0_XDFFM_SB XD5_XDFFQ_MB 1.21e-17
* device instance cc_XD0_XDFFM_SB_XD5_XDFFQ_S r0 *1 0,0
Ccc_XD0_XDFFM_SB_XD5_XDFFQ_S XD0_XDFFM_SB XD5_XDFFQ_S 1.8151e-17
* device instance cc_XD0_XDFFM_SB_XD5_XDFFQ_SB r0 *1 0,0
Ccc_XD0_XDFFM_SB_XD5_XDFFQ_SB XD0_XDFFM_SB XD5_XDFFQ_SB 1.8151e-17
* device instance cc_XD0_XDFFM_SB_XD5_XN2_mid1 r0 *1 0,0
Ccc_XD0_XDFFM_SB_XD5_XN2_mid1 XD0_XDFFM_SB XD5_XN2_mid1 1.21e-17
* device instance cc_XD0_XDFFM_SB_XD5_XN3_mid1 r0 *1 0,0
Ccc_XD0_XDFFM_SB_XD5_XN3_mid1 XD0_XDFFM_SB XD5_XN3_mid1 1.21e-17
* device instance cc_XD0_XDFFM_SB_XD5_XN3_mid2 r0 *1 0,0
Ccc_XD0_XDFFM_SB_XD5_XN3_mid2 XD0_XDFFM_SB XD5_XN3_mid2 1.21e-17
* device instance cc_XD0_XDFFM_SB_XD5_dmodout r0 *1 0,0
Ccc_XD0_XDFFM_SB_XD5_dmodout XD0_XDFFM_SB XD5_dmodout 1.21e-17
* device instance cc_XD0_XDFFM_SB_XD5_dq r0 *1 0,0
Ccc_XD0_XDFFM_SB_XD5_dq XD0_XDFFM_SB XD5_dq 1.8151e-17
* device instance cc_XD0_XDFFM_SB_XD5_nm r0 *1 0,0
Ccc_XD0_XDFFM_SB_XD5_nm XD0_XDFFM_SB XD5_nm 1.21e-17
* device instance cc_XD0_XDFFM_SB_XD5_nt r0 *1 0,0
Ccc_XD0_XDFFM_SB_XD5_nt XD0_XDFFM_SB XD5_nt 1.21e-17
* device instance cc_XD0_XDFFM_SB_XD5_t1 r0 *1 0,0
Ccc_XD0_XDFFM_SB_XD5_t1 XD0_XDFFM_SB XD5_t1 1.21e-17
* device instance cc_XD0_XDFFM_SB_XFRT_CLKB r0 *1 0,0
Ccc_XD0_XDFFM_SB_XFRT_CLKB XD0_XDFFM_SB XFRT_CLKB 1.8151e-17
* device instance cc_XD0_XDFFM_SB_XFRT_M r0 *1 0,0
Ccc_XD0_XDFFM_SB_XFRT_M XD0_XDFFM_SB XFRT_M 2.4201e-17
* device instance cc_XD0_XDFFM_SB_XFRT_MB r0 *1 0,0
Ccc_XD0_XDFFM_SB_XFRT_MB XD0_XDFFM_SB XFRT_MB 1.21e-17
* device instance cc_XD0_XDFFM_SB_XFRT_S r0 *1 0,0
Ccc_XD0_XDFFM_SB_XFRT_S XD0_XDFFM_SB XFRT_S 1.8151e-17
* device instance cc_XD0_XDFFM_SB_XFRT_SB r0 *1 0,0
Ccc_XD0_XDFFM_SB_XFRT_SB XD0_XDFFM_SB XFRT_SB 1.8151e-17
* device instance cc_XD0_XDFFM_SB_ck1 r0 *1 0,0
Ccc_XD0_XDFFM_SB_ck1 XD0_XDFFM_SB ck1 5.4452e-17
* device instance cc_XD0_XDFFM_SB_ck2 r0 *1 0,0
Ccc_XD0_XDFFM_SB_ck2 XD0_XDFFM_SB ck2 5.4452e-17
* device instance cc_XD0_XDFFM_SB_ck3 r0 *1 0,0
Ccc_XD0_XDFFM_SB_ck3 XD0_XDFFM_SB ck3 5.4452e-17
* device instance cc_XD0_XDFFM_SB_ck4 r0 *1 0,0
Ccc_XD0_XDFFM_SB_ck4 XD0_XDFFM_SB ck4 5.4452e-17
* device instance cc_XD0_XDFFM_SB_ck5 r0 *1 0,0
Ccc_XD0_XDFFM_SB_ck5 XD0_XDFFM_SB ck5 5.4452e-17
* device instance cc_XD0_XDFFM_SB_mod0 r0 *1 0,0
Ccc_XD0_XDFFM_SB_mod0 XD0_XDFFM_SB mod0 2.4201e-17
* device instance cc_XD0_XDFFM_SB_mod1 r0 *1 0,0
Ccc_XD0_XDFFM_SB_mod1 XD0_XDFFM_SB mod1 2.4201e-17
* device instance cc_XD0_XDFFM_SB_mod2 r0 *1 0,0
Ccc_XD0_XDFFM_SB_mod2 XD0_XDFFM_SB mod2 2.4201e-17
* device instance cc_XD0_XDFFM_SB_mod3 r0 *1 0,0
Ccc_XD0_XDFFM_SB_mod3 XD0_XDFFM_SB mod3 2.4201e-17
* device instance cc_XD0_XDFFM_SB_mod4 r0 *1 0,0
Ccc_XD0_XDFFM_SB_mod4 XD0_XDFFM_SB mod4 2.4201e-17
* device instance cc_XD0_XDFFM_SB_net1 r0 *1 0,0
Ccc_XD0_XDFFM_SB_net1 XD0_XDFFM_SB net1 1.21e-17
* device instance cc_XD0_XDFFQ_CLKB_XD0_XDFFQ_M r0 *1 0,0
Ccc_XD0_XDFFQ_CLKB_XD0_XDFFQ_M XD0_XDFFQ_CLKB XD0_XDFFQ_M 4.2352e-17
* device instance cc_XD0_XDFFQ_CLKB_XD0_XDFFQ_MB r0 *1 0,0
Ccc_XD0_XDFFQ_CLKB_XD0_XDFFQ_MB XD0_XDFFQ_CLKB XD0_XDFFQ_MB 2.4201e-17
* device instance cc_XD0_XDFFQ_CLKB_XD0_XDFFQ_S r0 *1 0,0
Ccc_XD0_XDFFQ_CLKB_XD0_XDFFQ_S XD0_XDFFQ_CLKB XD0_XDFFQ_S 1.8151e-17
* device instance cc_XD0_XDFFQ_CLKB_XD0_XDFFQ_SB r0 *1 0,0
Ccc_XD0_XDFFQ_CLKB_XD0_XDFFQ_SB XD0_XDFFQ_CLKB XD0_XDFFQ_SB 1.8151e-17
* device instance cc_XD0_XDFFQ_CLKB_XD0_XN2_mid1 r0 *1 0,0
Ccc_XD0_XDFFQ_CLKB_XD0_XN2_mid1 XD0_XDFFQ_CLKB XD0_XN2_mid1 1.21e-17
* device instance cc_XD0_XDFFQ_CLKB_XD0_XNOR_midp r0 *1 0,0
Ccc_XD0_XDFFQ_CLKB_XD0_XNOR_midp XD0_XDFFQ_CLKB XD0_XNOR_midp 1.21e-17
* device instance cc_XD0_XDFFQ_CLKB_XD0_dmodout r0 *1 0,0
Ccc_XD0_XDFFQ_CLKB_XD0_dmodout XD0_XDFFQ_CLKB XD0_dmodout 1.21e-17
* device instance cc_XD0_XDFFQ_CLKB_XD0_dq r0 *1 0,0
Ccc_XD0_XDFFQ_CLKB_XD0_dq XD0_XDFFQ_CLKB XD0_dq 1.8151e-17
* device instance cc_XD0_XDFFQ_CLKB_XD0_nm r0 *1 0,0
Ccc_XD0_XDFFQ_CLKB_XD0_nm XD0_XDFFQ_CLKB XD0_nm 1.21e-17
* device instance cc_XD0_XDFFQ_CLKB_XD0_nt r0 *1 0,0
Ccc_XD0_XDFFQ_CLKB_XD0_nt XD0_XDFFQ_CLKB XD0_nt 2.4201e-17
* device instance cc_XD0_XDFFQ_CLKB_XD0_t1 r0 *1 0,0
Ccc_XD0_XDFFQ_CLKB_XD0_t1 XD0_XDFFQ_CLKB XD0_t1 1.21e-17
* device instance cc_XD0_XDFFQ_CLKB_XD1_XDFFM_CLKB r0 *1 0,0
Ccc_XD0_XDFFQ_CLKB_XD1_XDFFM_CLKB XD0_XDFFQ_CLKB XD1_XDFFM_CLKB 1.8151e-17
* device instance cc_XD0_XDFFQ_CLKB_XD1_XDFFM_M r0 *1 0,0
Ccc_XD0_XDFFQ_CLKB_XD1_XDFFM_M XD0_XDFFQ_CLKB XD1_XDFFM_M 2.4201e-17
* device instance cc_XD0_XDFFQ_CLKB_XD1_XDFFM_MB r0 *1 0,0
Ccc_XD0_XDFFQ_CLKB_XD1_XDFFM_MB XD0_XDFFQ_CLKB XD1_XDFFM_MB 1.21e-17
* device instance cc_XD0_XDFFQ_CLKB_XD1_XDFFM_S r0 *1 0,0
Ccc_XD0_XDFFQ_CLKB_XD1_XDFFM_S XD0_XDFFQ_CLKB XD1_XDFFM_S 1.8151e-17
* device instance cc_XD0_XDFFQ_CLKB_XD1_XDFFM_SB r0 *1 0,0
Ccc_XD0_XDFFQ_CLKB_XD1_XDFFM_SB XD0_XDFFQ_CLKB XD1_XDFFM_SB 1.8151e-17
* device instance cc_XD0_XDFFQ_CLKB_XD1_XDFFQ_CLKB r0 *1 0,0
Ccc_XD0_XDFFQ_CLKB_XD1_XDFFQ_CLKB XD0_XDFFQ_CLKB XD1_XDFFQ_CLKB 1.8151e-17
* device instance cc_XD0_XDFFQ_CLKB_XD1_XDFFQ_M r0 *1 0,0
Ccc_XD0_XDFFQ_CLKB_XD1_XDFFQ_M XD0_XDFFQ_CLKB XD1_XDFFQ_M 2.4201e-17
* device instance cc_XD0_XDFFQ_CLKB_XD1_XDFFQ_MB r0 *1 0,0
Ccc_XD0_XDFFQ_CLKB_XD1_XDFFQ_MB XD0_XDFFQ_CLKB XD1_XDFFQ_MB 1.21e-17
* device instance cc_XD0_XDFFQ_CLKB_XD1_XDFFQ_S r0 *1 0,0
Ccc_XD0_XDFFQ_CLKB_XD1_XDFFQ_S XD0_XDFFQ_CLKB XD1_XDFFQ_S 1.8151e-17
* device instance cc_XD0_XDFFQ_CLKB_XD1_XDFFQ_SB r0 *1 0,0
Ccc_XD0_XDFFQ_CLKB_XD1_XDFFQ_SB XD0_XDFFQ_CLKB XD1_XDFFQ_SB 1.8151e-17
* device instance cc_XD0_XDFFQ_CLKB_XD1_XN2_mid1 r0 *1 0,0
Ccc_XD0_XDFFQ_CLKB_XD1_XN2_mid1 XD0_XDFFQ_CLKB XD1_XN2_mid1 1.21e-17
* device instance cc_XD0_XDFFQ_CLKB_XD1_XN3_mid1 r0 *1 0,0
Ccc_XD0_XDFFQ_CLKB_XD1_XN3_mid1 XD0_XDFFQ_CLKB XD1_XN3_mid1 1.21e-17
* device instance cc_XD0_XDFFQ_CLKB_XD1_XN3_mid2 r0 *1 0,0
Ccc_XD0_XDFFQ_CLKB_XD1_XN3_mid2 XD0_XDFFQ_CLKB XD1_XN3_mid2 1.21e-17
* device instance cc_XD0_XDFFQ_CLKB_XD1_dmodout r0 *1 0,0
Ccc_XD0_XDFFQ_CLKB_XD1_dmodout XD0_XDFFQ_CLKB XD1_dmodout 1.21e-17
* device instance cc_XD0_XDFFQ_CLKB_XD1_dq r0 *1 0,0
Ccc_XD0_XDFFQ_CLKB_XD1_dq XD0_XDFFQ_CLKB XD1_dq 1.8151e-17
* device instance cc_XD0_XDFFQ_CLKB_XD1_nm r0 *1 0,0
Ccc_XD0_XDFFQ_CLKB_XD1_nm XD0_XDFFQ_CLKB XD1_nm 1.21e-17
* device instance cc_XD0_XDFFQ_CLKB_XD1_nt r0 *1 0,0
Ccc_XD0_XDFFQ_CLKB_XD1_nt XD0_XDFFQ_CLKB XD1_nt 1.21e-17
* device instance cc_XD0_XDFFQ_CLKB_XD1_t1 r0 *1 0,0
Ccc_XD0_XDFFQ_CLKB_XD1_t1 XD0_XDFFQ_CLKB XD1_t1 1.21e-17
* device instance cc_XD0_XDFFQ_CLKB_XD2_XDFFM_CLKB r0 *1 0,0
Ccc_XD0_XDFFQ_CLKB_XD2_XDFFM_CLKB XD0_XDFFQ_CLKB XD2_XDFFM_CLKB 1.8151e-17
* device instance cc_XD0_XDFFQ_CLKB_XD2_XDFFM_M r0 *1 0,0
Ccc_XD0_XDFFQ_CLKB_XD2_XDFFM_M XD0_XDFFQ_CLKB XD2_XDFFM_M 2.4201e-17
* device instance cc_XD0_XDFFQ_CLKB_XD2_XDFFM_MB r0 *1 0,0
Ccc_XD0_XDFFQ_CLKB_XD2_XDFFM_MB XD0_XDFFQ_CLKB XD2_XDFFM_MB 1.21e-17
* device instance cc_XD0_XDFFQ_CLKB_XD2_XDFFM_S r0 *1 0,0
Ccc_XD0_XDFFQ_CLKB_XD2_XDFFM_S XD0_XDFFQ_CLKB XD2_XDFFM_S 1.8151e-17
* device instance cc_XD0_XDFFQ_CLKB_XD2_XDFFM_SB r0 *1 0,0
Ccc_XD0_XDFFQ_CLKB_XD2_XDFFM_SB XD0_XDFFQ_CLKB XD2_XDFFM_SB 1.8151e-17
* device instance cc_XD0_XDFFQ_CLKB_XD2_XDFFQ_CLKB r0 *1 0,0
Ccc_XD0_XDFFQ_CLKB_XD2_XDFFQ_CLKB XD0_XDFFQ_CLKB XD2_XDFFQ_CLKB 1.8151e-17
* device instance cc_XD0_XDFFQ_CLKB_XD2_XDFFQ_M r0 *1 0,0
Ccc_XD0_XDFFQ_CLKB_XD2_XDFFQ_M XD0_XDFFQ_CLKB XD2_XDFFQ_M 2.4201e-17
* device instance cc_XD0_XDFFQ_CLKB_XD2_XDFFQ_MB r0 *1 0,0
Ccc_XD0_XDFFQ_CLKB_XD2_XDFFQ_MB XD0_XDFFQ_CLKB XD2_XDFFQ_MB 1.21e-17
* device instance cc_XD0_XDFFQ_CLKB_XD2_XDFFQ_S r0 *1 0,0
Ccc_XD0_XDFFQ_CLKB_XD2_XDFFQ_S XD0_XDFFQ_CLKB XD2_XDFFQ_S 1.8151e-17
* device instance cc_XD0_XDFFQ_CLKB_XD2_XDFFQ_SB r0 *1 0,0
Ccc_XD0_XDFFQ_CLKB_XD2_XDFFQ_SB XD0_XDFFQ_CLKB XD2_XDFFQ_SB 1.8151e-17
* device instance cc_XD0_XDFFQ_CLKB_XD2_XN2_mid1 r0 *1 0,0
Ccc_XD0_XDFFQ_CLKB_XD2_XN2_mid1 XD0_XDFFQ_CLKB XD2_XN2_mid1 1.21e-17
* device instance cc_XD0_XDFFQ_CLKB_XD2_XN3_mid1 r0 *1 0,0
Ccc_XD0_XDFFQ_CLKB_XD2_XN3_mid1 XD0_XDFFQ_CLKB XD2_XN3_mid1 1.21e-17
* device instance cc_XD0_XDFFQ_CLKB_XD2_XN3_mid2 r0 *1 0,0
Ccc_XD0_XDFFQ_CLKB_XD2_XN3_mid2 XD0_XDFFQ_CLKB XD2_XN3_mid2 1.21e-17
* device instance cc_XD0_XDFFQ_CLKB_XD2_dmodout r0 *1 0,0
Ccc_XD0_XDFFQ_CLKB_XD2_dmodout XD0_XDFFQ_CLKB XD2_dmodout 1.21e-17
* device instance cc_XD0_XDFFQ_CLKB_XD2_dq r0 *1 0,0
Ccc_XD0_XDFFQ_CLKB_XD2_dq XD0_XDFFQ_CLKB XD2_dq 1.8151e-17
* device instance cc_XD0_XDFFQ_CLKB_XD2_nm r0 *1 0,0
Ccc_XD0_XDFFQ_CLKB_XD2_nm XD0_XDFFQ_CLKB XD2_nm 1.21e-17
* device instance cc_XD0_XDFFQ_CLKB_XD2_nt r0 *1 0,0
Ccc_XD0_XDFFQ_CLKB_XD2_nt XD0_XDFFQ_CLKB XD2_nt 1.21e-17
* device instance cc_XD0_XDFFQ_CLKB_XD2_t1 r0 *1 0,0
Ccc_XD0_XDFFQ_CLKB_XD2_t1 XD0_XDFFQ_CLKB XD2_t1 1.21e-17
* device instance cc_XD0_XDFFQ_CLKB_XD3_XDFFM_CLKB r0 *1 0,0
Ccc_XD0_XDFFQ_CLKB_XD3_XDFFM_CLKB XD0_XDFFQ_CLKB XD3_XDFFM_CLKB 1.8151e-17
* device instance cc_XD0_XDFFQ_CLKB_XD3_XDFFM_M r0 *1 0,0
Ccc_XD0_XDFFQ_CLKB_XD3_XDFFM_M XD0_XDFFQ_CLKB XD3_XDFFM_M 2.4201e-17
* device instance cc_XD0_XDFFQ_CLKB_XD3_XDFFM_MB r0 *1 0,0
Ccc_XD0_XDFFQ_CLKB_XD3_XDFFM_MB XD0_XDFFQ_CLKB XD3_XDFFM_MB 1.21e-17
* device instance cc_XD0_XDFFQ_CLKB_XD3_XDFFM_S r0 *1 0,0
Ccc_XD0_XDFFQ_CLKB_XD3_XDFFM_S XD0_XDFFQ_CLKB XD3_XDFFM_S 1.8151e-17
* device instance cc_XD0_XDFFQ_CLKB_XD3_XDFFM_SB r0 *1 0,0
Ccc_XD0_XDFFQ_CLKB_XD3_XDFFM_SB XD0_XDFFQ_CLKB XD3_XDFFM_SB 1.8151e-17
* device instance cc_XD0_XDFFQ_CLKB_XD3_XDFFQ_CLKB r0 *1 0,0
Ccc_XD0_XDFFQ_CLKB_XD3_XDFFQ_CLKB XD0_XDFFQ_CLKB XD3_XDFFQ_CLKB 1.8151e-17
* device instance cc_XD0_XDFFQ_CLKB_XD3_XDFFQ_M r0 *1 0,0
Ccc_XD0_XDFFQ_CLKB_XD3_XDFFQ_M XD0_XDFFQ_CLKB XD3_XDFFQ_M 2.4201e-17
* device instance cc_XD0_XDFFQ_CLKB_XD3_XDFFQ_MB r0 *1 0,0
Ccc_XD0_XDFFQ_CLKB_XD3_XDFFQ_MB XD0_XDFFQ_CLKB XD3_XDFFQ_MB 1.21e-17
* device instance cc_XD0_XDFFQ_CLKB_XD3_XDFFQ_S r0 *1 0,0
Ccc_XD0_XDFFQ_CLKB_XD3_XDFFQ_S XD0_XDFFQ_CLKB XD3_XDFFQ_S 1.8151e-17
* device instance cc_XD0_XDFFQ_CLKB_XD3_XDFFQ_SB r0 *1 0,0
Ccc_XD0_XDFFQ_CLKB_XD3_XDFFQ_SB XD0_XDFFQ_CLKB XD3_XDFFQ_SB 1.8151e-17
* device instance cc_XD0_XDFFQ_CLKB_XD3_XN2_mid1 r0 *1 0,0
Ccc_XD0_XDFFQ_CLKB_XD3_XN2_mid1 XD0_XDFFQ_CLKB XD3_XN2_mid1 1.21e-17
* device instance cc_XD0_XDFFQ_CLKB_XD3_XN3_mid1 r0 *1 0,0
Ccc_XD0_XDFFQ_CLKB_XD3_XN3_mid1 XD0_XDFFQ_CLKB XD3_XN3_mid1 1.21e-17
* device instance cc_XD0_XDFFQ_CLKB_XD3_XN3_mid2 r0 *1 0,0
Ccc_XD0_XDFFQ_CLKB_XD3_XN3_mid2 XD0_XDFFQ_CLKB XD3_XN3_mid2 1.21e-17
* device instance cc_XD0_XDFFQ_CLKB_XD3_dmodout r0 *1 0,0
Ccc_XD0_XDFFQ_CLKB_XD3_dmodout XD0_XDFFQ_CLKB XD3_dmodout 1.21e-17
* device instance cc_XD0_XDFFQ_CLKB_XD3_dq r0 *1 0,0
Ccc_XD0_XDFFQ_CLKB_XD3_dq XD0_XDFFQ_CLKB XD3_dq 1.8151e-17
* device instance cc_XD0_XDFFQ_CLKB_XD3_nm r0 *1 0,0
Ccc_XD0_XDFFQ_CLKB_XD3_nm XD0_XDFFQ_CLKB XD3_nm 1.21e-17
* device instance cc_XD0_XDFFQ_CLKB_XD3_nt r0 *1 0,0
Ccc_XD0_XDFFQ_CLKB_XD3_nt XD0_XDFFQ_CLKB XD3_nt 1.21e-17
* device instance cc_XD0_XDFFQ_CLKB_XD3_t1 r0 *1 0,0
Ccc_XD0_XDFFQ_CLKB_XD3_t1 XD0_XDFFQ_CLKB XD3_t1 1.21e-17
* device instance cc_XD0_XDFFQ_CLKB_XD4_XDFFM_CLKB r0 *1 0,0
Ccc_XD0_XDFFQ_CLKB_XD4_XDFFM_CLKB XD0_XDFFQ_CLKB XD4_XDFFM_CLKB 1.8151e-17
* device instance cc_XD0_XDFFQ_CLKB_XD4_XDFFM_M r0 *1 0,0
Ccc_XD0_XDFFQ_CLKB_XD4_XDFFM_M XD0_XDFFQ_CLKB XD4_XDFFM_M 2.4201e-17
* device instance cc_XD0_XDFFQ_CLKB_XD4_XDFFM_MB r0 *1 0,0
Ccc_XD0_XDFFQ_CLKB_XD4_XDFFM_MB XD0_XDFFQ_CLKB XD4_XDFFM_MB 1.21e-17
* device instance cc_XD0_XDFFQ_CLKB_XD4_XDFFM_S r0 *1 0,0
Ccc_XD0_XDFFQ_CLKB_XD4_XDFFM_S XD0_XDFFQ_CLKB XD4_XDFFM_S 1.8151e-17
* device instance cc_XD0_XDFFQ_CLKB_XD4_XDFFM_SB r0 *1 0,0
Ccc_XD0_XDFFQ_CLKB_XD4_XDFFM_SB XD0_XDFFQ_CLKB XD4_XDFFM_SB 1.8151e-17
* device instance cc_XD0_XDFFQ_CLKB_XD4_XDFFQ_CLKB r0 *1 0,0
Ccc_XD0_XDFFQ_CLKB_XD4_XDFFQ_CLKB XD0_XDFFQ_CLKB XD4_XDFFQ_CLKB 1.8151e-17
* device instance cc_XD0_XDFFQ_CLKB_XD4_XDFFQ_M r0 *1 0,0
Ccc_XD0_XDFFQ_CLKB_XD4_XDFFQ_M XD0_XDFFQ_CLKB XD4_XDFFQ_M 2.4201e-17
* device instance cc_XD0_XDFFQ_CLKB_XD4_XDFFQ_MB r0 *1 0,0
Ccc_XD0_XDFFQ_CLKB_XD4_XDFFQ_MB XD0_XDFFQ_CLKB XD4_XDFFQ_MB 1.21e-17
* device instance cc_XD0_XDFFQ_CLKB_XD4_XDFFQ_S r0 *1 0,0
Ccc_XD0_XDFFQ_CLKB_XD4_XDFFQ_S XD0_XDFFQ_CLKB XD4_XDFFQ_S 1.8151e-17
* device instance cc_XD0_XDFFQ_CLKB_XD4_XDFFQ_SB r0 *1 0,0
Ccc_XD0_XDFFQ_CLKB_XD4_XDFFQ_SB XD0_XDFFQ_CLKB XD4_XDFFQ_SB 1.8151e-17
* device instance cc_XD0_XDFFQ_CLKB_XD4_XN2_mid1 r0 *1 0,0
Ccc_XD0_XDFFQ_CLKB_XD4_XN2_mid1 XD0_XDFFQ_CLKB XD4_XN2_mid1 1.21e-17
* device instance cc_XD0_XDFFQ_CLKB_XD4_XN3_mid1 r0 *1 0,0
Ccc_XD0_XDFFQ_CLKB_XD4_XN3_mid1 XD0_XDFFQ_CLKB XD4_XN3_mid1 1.21e-17
* device instance cc_XD0_XDFFQ_CLKB_XD4_XN3_mid2 r0 *1 0,0
Ccc_XD0_XDFFQ_CLKB_XD4_XN3_mid2 XD0_XDFFQ_CLKB XD4_XN3_mid2 1.21e-17
* device instance cc_XD0_XDFFQ_CLKB_XD4_dmodout r0 *1 0,0
Ccc_XD0_XDFFQ_CLKB_XD4_dmodout XD0_XDFFQ_CLKB XD4_dmodout 1.21e-17
* device instance cc_XD0_XDFFQ_CLKB_XD4_dq r0 *1 0,0
Ccc_XD0_XDFFQ_CLKB_XD4_dq XD0_XDFFQ_CLKB XD4_dq 1.8151e-17
* device instance cc_XD0_XDFFQ_CLKB_XD4_nm r0 *1 0,0
Ccc_XD0_XDFFQ_CLKB_XD4_nm XD0_XDFFQ_CLKB XD4_nm 1.21e-17
* device instance cc_XD0_XDFFQ_CLKB_XD4_nt r0 *1 0,0
Ccc_XD0_XDFFQ_CLKB_XD4_nt XD0_XDFFQ_CLKB XD4_nt 1.21e-17
* device instance cc_XD0_XDFFQ_CLKB_XD4_t1 r0 *1 0,0
Ccc_XD0_XDFFQ_CLKB_XD4_t1 XD0_XDFFQ_CLKB XD4_t1 1.21e-17
* device instance cc_XD0_XDFFQ_CLKB_XD5_XDFFM_CLKB r0 *1 0,0
Ccc_XD0_XDFFQ_CLKB_XD5_XDFFM_CLKB XD0_XDFFQ_CLKB XD5_XDFFM_CLKB 1.8151e-17
* device instance cc_XD0_XDFFQ_CLKB_XD5_XDFFM_M r0 *1 0,0
Ccc_XD0_XDFFQ_CLKB_XD5_XDFFM_M XD0_XDFFQ_CLKB XD5_XDFFM_M 2.4201e-17
* device instance cc_XD0_XDFFQ_CLKB_XD5_XDFFM_MB r0 *1 0,0
Ccc_XD0_XDFFQ_CLKB_XD5_XDFFM_MB XD0_XDFFQ_CLKB XD5_XDFFM_MB 1.21e-17
* device instance cc_XD0_XDFFQ_CLKB_XD5_XDFFM_S r0 *1 0,0
Ccc_XD0_XDFFQ_CLKB_XD5_XDFFM_S XD0_XDFFQ_CLKB XD5_XDFFM_S 1.8151e-17
* device instance cc_XD0_XDFFQ_CLKB_XD5_XDFFM_SB r0 *1 0,0
Ccc_XD0_XDFFQ_CLKB_XD5_XDFFM_SB XD0_XDFFQ_CLKB XD5_XDFFM_SB 1.8151e-17
* device instance cc_XD0_XDFFQ_CLKB_XD5_XDFFQ_CLKB r0 *1 0,0
Ccc_XD0_XDFFQ_CLKB_XD5_XDFFQ_CLKB XD0_XDFFQ_CLKB XD5_XDFFQ_CLKB 1.8151e-17
* device instance cc_XD0_XDFFQ_CLKB_XD5_XDFFQ_M r0 *1 0,0
Ccc_XD0_XDFFQ_CLKB_XD5_XDFFQ_M XD0_XDFFQ_CLKB XD5_XDFFQ_M 2.4201e-17
* device instance cc_XD0_XDFFQ_CLKB_XD5_XDFFQ_MB r0 *1 0,0
Ccc_XD0_XDFFQ_CLKB_XD5_XDFFQ_MB XD0_XDFFQ_CLKB XD5_XDFFQ_MB 1.21e-17
* device instance cc_XD0_XDFFQ_CLKB_XD5_XDFFQ_S r0 *1 0,0
Ccc_XD0_XDFFQ_CLKB_XD5_XDFFQ_S XD0_XDFFQ_CLKB XD5_XDFFQ_S 1.8151e-17
* device instance cc_XD0_XDFFQ_CLKB_XD5_XDFFQ_SB r0 *1 0,0
Ccc_XD0_XDFFQ_CLKB_XD5_XDFFQ_SB XD0_XDFFQ_CLKB XD5_XDFFQ_SB 1.8151e-17
* device instance cc_XD0_XDFFQ_CLKB_XD5_XN2_mid1 r0 *1 0,0
Ccc_XD0_XDFFQ_CLKB_XD5_XN2_mid1 XD0_XDFFQ_CLKB XD5_XN2_mid1 1.21e-17
* device instance cc_XD0_XDFFQ_CLKB_XD5_XN3_mid1 r0 *1 0,0
Ccc_XD0_XDFFQ_CLKB_XD5_XN3_mid1 XD0_XDFFQ_CLKB XD5_XN3_mid1 1.21e-17
* device instance cc_XD0_XDFFQ_CLKB_XD5_XN3_mid2 r0 *1 0,0
Ccc_XD0_XDFFQ_CLKB_XD5_XN3_mid2 XD0_XDFFQ_CLKB XD5_XN3_mid2 1.21e-17
* device instance cc_XD0_XDFFQ_CLKB_XD5_dmodout r0 *1 0,0
Ccc_XD0_XDFFQ_CLKB_XD5_dmodout XD0_XDFFQ_CLKB XD5_dmodout 1.21e-17
* device instance cc_XD0_XDFFQ_CLKB_XD5_dq r0 *1 0,0
Ccc_XD0_XDFFQ_CLKB_XD5_dq XD0_XDFFQ_CLKB XD5_dq 1.8151e-17
* device instance cc_XD0_XDFFQ_CLKB_XD5_nm r0 *1 0,0
Ccc_XD0_XDFFQ_CLKB_XD5_nm XD0_XDFFQ_CLKB XD5_nm 1.21e-17
* device instance cc_XD0_XDFFQ_CLKB_XD5_nt r0 *1 0,0
Ccc_XD0_XDFFQ_CLKB_XD5_nt XD0_XDFFQ_CLKB XD5_nt 1.21e-17
* device instance cc_XD0_XDFFQ_CLKB_XD5_t1 r0 *1 0,0
Ccc_XD0_XDFFQ_CLKB_XD5_t1 XD0_XDFFQ_CLKB XD5_t1 1.21e-17
* device instance cc_XD0_XDFFQ_CLKB_XFRT_CLKB r0 *1 0,0
Ccc_XD0_XDFFQ_CLKB_XFRT_CLKB XD0_XDFFQ_CLKB XFRT_CLKB 1.8151e-17
* device instance cc_XD0_XDFFQ_CLKB_XFRT_M r0 *1 0,0
Ccc_XD0_XDFFQ_CLKB_XFRT_M XD0_XDFFQ_CLKB XFRT_M 2.4201e-17
* device instance cc_XD0_XDFFQ_CLKB_XFRT_MB r0 *1 0,0
Ccc_XD0_XDFFQ_CLKB_XFRT_MB XD0_XDFFQ_CLKB XFRT_MB 1.21e-17
* device instance cc_XD0_XDFFQ_CLKB_XFRT_S r0 *1 0,0
Ccc_XD0_XDFFQ_CLKB_XFRT_S XD0_XDFFQ_CLKB XFRT_S 1.8151e-17
* device instance cc_XD0_XDFFQ_CLKB_XFRT_SB r0 *1 0,0
Ccc_XD0_XDFFQ_CLKB_XFRT_SB XD0_XDFFQ_CLKB XFRT_SB 1.8151e-17
* device instance cc_XD0_XDFFQ_CLKB_ck1 r0 *1 0,0
Ccc_XD0_XDFFQ_CLKB_ck1 XD0_XDFFQ_CLKB ck1 5.4452e-17
* device instance cc_XD0_XDFFQ_CLKB_ck2 r0 *1 0,0
Ccc_XD0_XDFFQ_CLKB_ck2 XD0_XDFFQ_CLKB ck2 5.4452e-17
* device instance cc_XD0_XDFFQ_CLKB_ck3 r0 *1 0,0
Ccc_XD0_XDFFQ_CLKB_ck3 XD0_XDFFQ_CLKB ck3 5.4452e-17
* device instance cc_XD0_XDFFQ_CLKB_ck4 r0 *1 0,0
Ccc_XD0_XDFFQ_CLKB_ck4 XD0_XDFFQ_CLKB ck4 5.4452e-17
* device instance cc_XD0_XDFFQ_CLKB_ck5 r0 *1 0,0
Ccc_XD0_XDFFQ_CLKB_ck5 XD0_XDFFQ_CLKB ck5 5.4452e-17
* device instance cc_XD0_XDFFQ_CLKB_mod0 r0 *1 0,0
Ccc_XD0_XDFFQ_CLKB_mod0 XD0_XDFFQ_CLKB mod0 2.4201e-17
* device instance cc_XD0_XDFFQ_CLKB_mod1 r0 *1 0,0
Ccc_XD0_XDFFQ_CLKB_mod1 XD0_XDFFQ_CLKB mod1 2.4201e-17
* device instance cc_XD0_XDFFQ_CLKB_mod2 r0 *1 0,0
Ccc_XD0_XDFFQ_CLKB_mod2 XD0_XDFFQ_CLKB mod2 2.4201e-17
* device instance cc_XD0_XDFFQ_CLKB_mod3 r0 *1 0,0
Ccc_XD0_XDFFQ_CLKB_mod3 XD0_XDFFQ_CLKB mod3 2.4201e-17
* device instance cc_XD0_XDFFQ_CLKB_mod4 r0 *1 0,0
Ccc_XD0_XDFFQ_CLKB_mod4 XD0_XDFFQ_CLKB mod4 2.4201e-17
* device instance cc_XD0_XDFFQ_CLKB_net1 r0 *1 0,0
Ccc_XD0_XDFFQ_CLKB_net1 XD0_XDFFQ_CLKB net1 1.21e-17
* device instance cc_XD0_XDFFQ_M_XD0_XDFFQ_MB r0 *1 0,0
Ccc_XD0_XDFFQ_M_XD0_XDFFQ_MB XD0_XDFFQ_M XD0_XDFFQ_MB 3.4688e-17
* device instance cc_XD0_XDFFQ_M_XD0_XDFFQ_S r0 *1 0,0
Ccc_XD0_XDFFQ_M_XD0_XDFFQ_S XD0_XDFFQ_M XD0_XDFFQ_S 2.8638e-17
* device instance cc_XD0_XDFFQ_M_XD0_XDFFQ_SB r0 *1 0,0
Ccc_XD0_XDFFQ_M_XD0_XDFFQ_SB XD0_XDFFQ_M XD0_XDFFQ_SB 1.8151e-17
* device instance cc_XD0_XDFFQ_M_XD0_XN2_mid1 r0 *1 0,0
Ccc_XD0_XDFFQ_M_XD0_XN2_mid1 XD0_XDFFQ_M XD0_XN2_mid1 1.21e-17
* device instance cc_XD0_XDFFQ_M_XD0_XNOR_midp r0 *1 0,0
Ccc_XD0_XDFFQ_M_XD0_XNOR_midp XD0_XDFFQ_M XD0_XNOR_midp 1.21e-17
* device instance cc_XD0_XDFFQ_M_XD0_dmodout r0 *1 0,0
Ccc_XD0_XDFFQ_M_XD0_dmodout XD0_XDFFQ_M XD0_dmodout 1.21e-17
* device instance cc_XD0_XDFFQ_M_XD0_dq r0 *1 0,0
Ccc_XD0_XDFFQ_M_XD0_dq XD0_XDFFQ_M XD0_dq 2.8638e-17
* device instance cc_XD0_XDFFQ_M_XD0_nm r0 *1 0,0
Ccc_XD0_XDFFQ_M_XD0_nm XD0_XDFFQ_M XD0_nm 1.21e-17
* device instance cc_XD0_XDFFQ_M_XD0_nt r0 *1 0,0
Ccc_XD0_XDFFQ_M_XD0_nt XD0_XDFFQ_M XD0_nt 2.4201e-17
* device instance cc_XD0_XDFFQ_M_XD0_t1 r0 *1 0,0
Ccc_XD0_XDFFQ_M_XD0_t1 XD0_XDFFQ_M XD0_t1 1.21e-17
* device instance cc_XD0_XDFFQ_M_XD1_XDFFM_CLKB r0 *1 0,0
Ccc_XD0_XDFFQ_M_XD1_XDFFM_CLKB XD0_XDFFQ_M XD1_XDFFM_CLKB 1.8151e-17
* device instance cc_XD0_XDFFQ_M_XD1_XDFFM_M r0 *1 0,0
Ccc_XD0_XDFFQ_M_XD1_XDFFM_M XD0_XDFFQ_M XD1_XDFFM_M 2.4201e-17
* device instance cc_XD0_XDFFQ_M_XD1_XDFFM_MB r0 *1 0,0
Ccc_XD0_XDFFQ_M_XD1_XDFFM_MB XD0_XDFFQ_M XD1_XDFFM_MB 1.21e-17
* device instance cc_XD0_XDFFQ_M_XD1_XDFFM_S r0 *1 0,0
Ccc_XD0_XDFFQ_M_XD1_XDFFM_S XD0_XDFFQ_M XD1_XDFFM_S 1.8151e-17
* device instance cc_XD0_XDFFQ_M_XD1_XDFFM_SB r0 *1 0,0
Ccc_XD0_XDFFQ_M_XD1_XDFFM_SB XD0_XDFFQ_M XD1_XDFFM_SB 1.8151e-17
* device instance cc_XD0_XDFFQ_M_XD1_XDFFQ_CLKB r0 *1 0,0
Ccc_XD0_XDFFQ_M_XD1_XDFFQ_CLKB XD0_XDFFQ_M XD1_XDFFQ_CLKB 1.8151e-17
* device instance cc_XD0_XDFFQ_M_XD1_XDFFQ_M r0 *1 0,0
Ccc_XD0_XDFFQ_M_XD1_XDFFQ_M XD0_XDFFQ_M XD1_XDFFQ_M 2.4201e-17
* device instance cc_XD0_XDFFQ_M_XD1_XDFFQ_MB r0 *1 0,0
Ccc_XD0_XDFFQ_M_XD1_XDFFQ_MB XD0_XDFFQ_M XD1_XDFFQ_MB 1.21e-17
* device instance cc_XD0_XDFFQ_M_XD1_XDFFQ_S r0 *1 0,0
Ccc_XD0_XDFFQ_M_XD1_XDFFQ_S XD0_XDFFQ_M XD1_XDFFQ_S 1.8151e-17
* device instance cc_XD0_XDFFQ_M_XD1_XDFFQ_SB r0 *1 0,0
Ccc_XD0_XDFFQ_M_XD1_XDFFQ_SB XD0_XDFFQ_M XD1_XDFFQ_SB 1.8151e-17
* device instance cc_XD0_XDFFQ_M_XD1_XN2_mid1 r0 *1 0,0
Ccc_XD0_XDFFQ_M_XD1_XN2_mid1 XD0_XDFFQ_M XD1_XN2_mid1 1.21e-17
* device instance cc_XD0_XDFFQ_M_XD1_XN3_mid1 r0 *1 0,0
Ccc_XD0_XDFFQ_M_XD1_XN3_mid1 XD0_XDFFQ_M XD1_XN3_mid1 1.21e-17
* device instance cc_XD0_XDFFQ_M_XD1_XN3_mid2 r0 *1 0,0
Ccc_XD0_XDFFQ_M_XD1_XN3_mid2 XD0_XDFFQ_M XD1_XN3_mid2 1.21e-17
* device instance cc_XD0_XDFFQ_M_XD1_dmodout r0 *1 0,0
Ccc_XD0_XDFFQ_M_XD1_dmodout XD0_XDFFQ_M XD1_dmodout 1.21e-17
* device instance cc_XD0_XDFFQ_M_XD1_dq r0 *1 0,0
Ccc_XD0_XDFFQ_M_XD1_dq XD0_XDFFQ_M XD1_dq 1.8151e-17
* device instance cc_XD0_XDFFQ_M_XD1_nm r0 *1 0,0
Ccc_XD0_XDFFQ_M_XD1_nm XD0_XDFFQ_M XD1_nm 1.21e-17
* device instance cc_XD0_XDFFQ_M_XD1_nt r0 *1 0,0
Ccc_XD0_XDFFQ_M_XD1_nt XD0_XDFFQ_M XD1_nt 1.21e-17
* device instance cc_XD0_XDFFQ_M_XD1_t1 r0 *1 0,0
Ccc_XD0_XDFFQ_M_XD1_t1 XD0_XDFFQ_M XD1_t1 1.21e-17
* device instance cc_XD0_XDFFQ_M_XD2_XDFFM_CLKB r0 *1 0,0
Ccc_XD0_XDFFQ_M_XD2_XDFFM_CLKB XD0_XDFFQ_M XD2_XDFFM_CLKB 1.8151e-17
* device instance cc_XD0_XDFFQ_M_XD2_XDFFM_M r0 *1 0,0
Ccc_XD0_XDFFQ_M_XD2_XDFFM_M XD0_XDFFQ_M XD2_XDFFM_M 2.4201e-17
* device instance cc_XD0_XDFFQ_M_XD2_XDFFM_MB r0 *1 0,0
Ccc_XD0_XDFFQ_M_XD2_XDFFM_MB XD0_XDFFQ_M XD2_XDFFM_MB 1.21e-17
* device instance cc_XD0_XDFFQ_M_XD2_XDFFM_S r0 *1 0,0
Ccc_XD0_XDFFQ_M_XD2_XDFFM_S XD0_XDFFQ_M XD2_XDFFM_S 1.8151e-17
* device instance cc_XD0_XDFFQ_M_XD2_XDFFM_SB r0 *1 0,0
Ccc_XD0_XDFFQ_M_XD2_XDFFM_SB XD0_XDFFQ_M XD2_XDFFM_SB 1.8151e-17
* device instance cc_XD0_XDFFQ_M_XD2_XDFFQ_CLKB r0 *1 0,0
Ccc_XD0_XDFFQ_M_XD2_XDFFQ_CLKB XD0_XDFFQ_M XD2_XDFFQ_CLKB 1.8151e-17
* device instance cc_XD0_XDFFQ_M_XD2_XDFFQ_M r0 *1 0,0
Ccc_XD0_XDFFQ_M_XD2_XDFFQ_M XD0_XDFFQ_M XD2_XDFFQ_M 2.4201e-17
* device instance cc_XD0_XDFFQ_M_XD2_XDFFQ_MB r0 *1 0,0
Ccc_XD0_XDFFQ_M_XD2_XDFFQ_MB XD0_XDFFQ_M XD2_XDFFQ_MB 1.21e-17
* device instance cc_XD0_XDFFQ_M_XD2_XDFFQ_S r0 *1 0,0
Ccc_XD0_XDFFQ_M_XD2_XDFFQ_S XD0_XDFFQ_M XD2_XDFFQ_S 1.8151e-17
* device instance cc_XD0_XDFFQ_M_XD2_XDFFQ_SB r0 *1 0,0
Ccc_XD0_XDFFQ_M_XD2_XDFFQ_SB XD0_XDFFQ_M XD2_XDFFQ_SB 1.8151e-17
* device instance cc_XD0_XDFFQ_M_XD2_XN2_mid1 r0 *1 0,0
Ccc_XD0_XDFFQ_M_XD2_XN2_mid1 XD0_XDFFQ_M XD2_XN2_mid1 1.21e-17
* device instance cc_XD0_XDFFQ_M_XD2_XN3_mid1 r0 *1 0,0
Ccc_XD0_XDFFQ_M_XD2_XN3_mid1 XD0_XDFFQ_M XD2_XN3_mid1 1.21e-17
* device instance cc_XD0_XDFFQ_M_XD2_XN3_mid2 r0 *1 0,0
Ccc_XD0_XDFFQ_M_XD2_XN3_mid2 XD0_XDFFQ_M XD2_XN3_mid2 1.21e-17
* device instance cc_XD0_XDFFQ_M_XD2_dmodout r0 *1 0,0
Ccc_XD0_XDFFQ_M_XD2_dmodout XD0_XDFFQ_M XD2_dmodout 1.21e-17
* device instance cc_XD0_XDFFQ_M_XD2_dq r0 *1 0,0
Ccc_XD0_XDFFQ_M_XD2_dq XD0_XDFFQ_M XD2_dq 1.8151e-17
* device instance cc_XD0_XDFFQ_M_XD2_nm r0 *1 0,0
Ccc_XD0_XDFFQ_M_XD2_nm XD0_XDFFQ_M XD2_nm 1.21e-17
* device instance cc_XD0_XDFFQ_M_XD2_nt r0 *1 0,0
Ccc_XD0_XDFFQ_M_XD2_nt XD0_XDFFQ_M XD2_nt 1.21e-17
* device instance cc_XD0_XDFFQ_M_XD2_t1 r0 *1 0,0
Ccc_XD0_XDFFQ_M_XD2_t1 XD0_XDFFQ_M XD2_t1 1.21e-17
* device instance cc_XD0_XDFFQ_M_XD3_XDFFM_CLKB r0 *1 0,0
Ccc_XD0_XDFFQ_M_XD3_XDFFM_CLKB XD0_XDFFQ_M XD3_XDFFM_CLKB 1.8151e-17
* device instance cc_XD0_XDFFQ_M_XD3_XDFFM_M r0 *1 0,0
Ccc_XD0_XDFFQ_M_XD3_XDFFM_M XD0_XDFFQ_M XD3_XDFFM_M 2.4201e-17
* device instance cc_XD0_XDFFQ_M_XD3_XDFFM_MB r0 *1 0,0
Ccc_XD0_XDFFQ_M_XD3_XDFFM_MB XD0_XDFFQ_M XD3_XDFFM_MB 1.21e-17
* device instance cc_XD0_XDFFQ_M_XD3_XDFFM_S r0 *1 0,0
Ccc_XD0_XDFFQ_M_XD3_XDFFM_S XD0_XDFFQ_M XD3_XDFFM_S 1.8151e-17
* device instance cc_XD0_XDFFQ_M_XD3_XDFFM_SB r0 *1 0,0
Ccc_XD0_XDFFQ_M_XD3_XDFFM_SB XD0_XDFFQ_M XD3_XDFFM_SB 1.8151e-17
* device instance cc_XD0_XDFFQ_M_XD3_XDFFQ_CLKB r0 *1 0,0
Ccc_XD0_XDFFQ_M_XD3_XDFFQ_CLKB XD0_XDFFQ_M XD3_XDFFQ_CLKB 1.8151e-17
* device instance cc_XD0_XDFFQ_M_XD3_XDFFQ_M r0 *1 0,0
Ccc_XD0_XDFFQ_M_XD3_XDFFQ_M XD0_XDFFQ_M XD3_XDFFQ_M 2.4201e-17
* device instance cc_XD0_XDFFQ_M_XD3_XDFFQ_MB r0 *1 0,0
Ccc_XD0_XDFFQ_M_XD3_XDFFQ_MB XD0_XDFFQ_M XD3_XDFFQ_MB 1.21e-17
* device instance cc_XD0_XDFFQ_M_XD3_XDFFQ_S r0 *1 0,0
Ccc_XD0_XDFFQ_M_XD3_XDFFQ_S XD0_XDFFQ_M XD3_XDFFQ_S 1.8151e-17
* device instance cc_XD0_XDFFQ_M_XD3_XDFFQ_SB r0 *1 0,0
Ccc_XD0_XDFFQ_M_XD3_XDFFQ_SB XD0_XDFFQ_M XD3_XDFFQ_SB 1.8151e-17
* device instance cc_XD0_XDFFQ_M_XD3_XN2_mid1 r0 *1 0,0
Ccc_XD0_XDFFQ_M_XD3_XN2_mid1 XD0_XDFFQ_M XD3_XN2_mid1 1.21e-17
* device instance cc_XD0_XDFFQ_M_XD3_XN3_mid1 r0 *1 0,0
Ccc_XD0_XDFFQ_M_XD3_XN3_mid1 XD0_XDFFQ_M XD3_XN3_mid1 1.21e-17
* device instance cc_XD0_XDFFQ_M_XD3_XN3_mid2 r0 *1 0,0
Ccc_XD0_XDFFQ_M_XD3_XN3_mid2 XD0_XDFFQ_M XD3_XN3_mid2 1.21e-17
* device instance cc_XD0_XDFFQ_M_XD3_dmodout r0 *1 0,0
Ccc_XD0_XDFFQ_M_XD3_dmodout XD0_XDFFQ_M XD3_dmodout 1.21e-17
* device instance cc_XD0_XDFFQ_M_XD3_dq r0 *1 0,0
Ccc_XD0_XDFFQ_M_XD3_dq XD0_XDFFQ_M XD3_dq 1.8151e-17
* device instance cc_XD0_XDFFQ_M_XD3_nm r0 *1 0,0
Ccc_XD0_XDFFQ_M_XD3_nm XD0_XDFFQ_M XD3_nm 1.21e-17
* device instance cc_XD0_XDFFQ_M_XD3_nt r0 *1 0,0
Ccc_XD0_XDFFQ_M_XD3_nt XD0_XDFFQ_M XD3_nt 1.21e-17
* device instance cc_XD0_XDFFQ_M_XD3_t1 r0 *1 0,0
Ccc_XD0_XDFFQ_M_XD3_t1 XD0_XDFFQ_M XD3_t1 1.21e-17
* device instance cc_XD0_XDFFQ_M_XD4_XDFFM_CLKB r0 *1 0,0
Ccc_XD0_XDFFQ_M_XD4_XDFFM_CLKB XD0_XDFFQ_M XD4_XDFFM_CLKB 1.8151e-17
* device instance cc_XD0_XDFFQ_M_XD4_XDFFM_M r0 *1 0,0
Ccc_XD0_XDFFQ_M_XD4_XDFFM_M XD0_XDFFQ_M XD4_XDFFM_M 2.4201e-17
* device instance cc_XD0_XDFFQ_M_XD4_XDFFM_MB r0 *1 0,0
Ccc_XD0_XDFFQ_M_XD4_XDFFM_MB XD0_XDFFQ_M XD4_XDFFM_MB 1.21e-17
* device instance cc_XD0_XDFFQ_M_XD4_XDFFM_S r0 *1 0,0
Ccc_XD0_XDFFQ_M_XD4_XDFFM_S XD0_XDFFQ_M XD4_XDFFM_S 1.8151e-17
* device instance cc_XD0_XDFFQ_M_XD4_XDFFM_SB r0 *1 0,0
Ccc_XD0_XDFFQ_M_XD4_XDFFM_SB XD0_XDFFQ_M XD4_XDFFM_SB 1.8151e-17
* device instance cc_XD0_XDFFQ_M_XD4_XDFFQ_CLKB r0 *1 0,0
Ccc_XD0_XDFFQ_M_XD4_XDFFQ_CLKB XD0_XDFFQ_M XD4_XDFFQ_CLKB 1.8151e-17
* device instance cc_XD0_XDFFQ_M_XD4_XDFFQ_M r0 *1 0,0
Ccc_XD0_XDFFQ_M_XD4_XDFFQ_M XD0_XDFFQ_M XD4_XDFFQ_M 2.4201e-17
* device instance cc_XD0_XDFFQ_M_XD4_XDFFQ_MB r0 *1 0,0
Ccc_XD0_XDFFQ_M_XD4_XDFFQ_MB XD0_XDFFQ_M XD4_XDFFQ_MB 1.21e-17
* device instance cc_XD0_XDFFQ_M_XD4_XDFFQ_S r0 *1 0,0
Ccc_XD0_XDFFQ_M_XD4_XDFFQ_S XD0_XDFFQ_M XD4_XDFFQ_S 1.8151e-17
* device instance cc_XD0_XDFFQ_M_XD4_XDFFQ_SB r0 *1 0,0
Ccc_XD0_XDFFQ_M_XD4_XDFFQ_SB XD0_XDFFQ_M XD4_XDFFQ_SB 1.8151e-17
* device instance cc_XD0_XDFFQ_M_XD4_XN2_mid1 r0 *1 0,0
Ccc_XD0_XDFFQ_M_XD4_XN2_mid1 XD0_XDFFQ_M XD4_XN2_mid1 1.21e-17
* device instance cc_XD0_XDFFQ_M_XD4_XN3_mid1 r0 *1 0,0
Ccc_XD0_XDFFQ_M_XD4_XN3_mid1 XD0_XDFFQ_M XD4_XN3_mid1 1.21e-17
* device instance cc_XD0_XDFFQ_M_XD4_XN3_mid2 r0 *1 0,0
Ccc_XD0_XDFFQ_M_XD4_XN3_mid2 XD0_XDFFQ_M XD4_XN3_mid2 1.21e-17
* device instance cc_XD0_XDFFQ_M_XD4_dmodout r0 *1 0,0
Ccc_XD0_XDFFQ_M_XD4_dmodout XD0_XDFFQ_M XD4_dmodout 1.21e-17
* device instance cc_XD0_XDFFQ_M_XD4_dq r0 *1 0,0
Ccc_XD0_XDFFQ_M_XD4_dq XD0_XDFFQ_M XD4_dq 1.8151e-17
* device instance cc_XD0_XDFFQ_M_XD4_nm r0 *1 0,0
Ccc_XD0_XDFFQ_M_XD4_nm XD0_XDFFQ_M XD4_nm 1.21e-17
* device instance cc_XD0_XDFFQ_M_XD4_nt r0 *1 0,0
Ccc_XD0_XDFFQ_M_XD4_nt XD0_XDFFQ_M XD4_nt 1.21e-17
* device instance cc_XD0_XDFFQ_M_XD4_t1 r0 *1 0,0
Ccc_XD0_XDFFQ_M_XD4_t1 XD0_XDFFQ_M XD4_t1 1.21e-17
* device instance cc_XD0_XDFFQ_M_XD5_XDFFM_CLKB r0 *1 0,0
Ccc_XD0_XDFFQ_M_XD5_XDFFM_CLKB XD0_XDFFQ_M XD5_XDFFM_CLKB 1.8151e-17
* device instance cc_XD0_XDFFQ_M_XD5_XDFFM_M r0 *1 0,0
Ccc_XD0_XDFFQ_M_XD5_XDFFM_M XD0_XDFFQ_M XD5_XDFFM_M 2.4201e-17
* device instance cc_XD0_XDFFQ_M_XD5_XDFFM_MB r0 *1 0,0
Ccc_XD0_XDFFQ_M_XD5_XDFFM_MB XD0_XDFFQ_M XD5_XDFFM_MB 1.21e-17
* device instance cc_XD0_XDFFQ_M_XD5_XDFFM_S r0 *1 0,0
Ccc_XD0_XDFFQ_M_XD5_XDFFM_S XD0_XDFFQ_M XD5_XDFFM_S 1.8151e-17
* device instance cc_XD0_XDFFQ_M_XD5_XDFFM_SB r0 *1 0,0
Ccc_XD0_XDFFQ_M_XD5_XDFFM_SB XD0_XDFFQ_M XD5_XDFFM_SB 1.8151e-17
* device instance cc_XD0_XDFFQ_M_XD5_XDFFQ_CLKB r0 *1 0,0
Ccc_XD0_XDFFQ_M_XD5_XDFFQ_CLKB XD0_XDFFQ_M XD5_XDFFQ_CLKB 1.8151e-17
* device instance cc_XD0_XDFFQ_M_XD5_XDFFQ_M r0 *1 0,0
Ccc_XD0_XDFFQ_M_XD5_XDFFQ_M XD0_XDFFQ_M XD5_XDFFQ_M 2.4201e-17
* device instance cc_XD0_XDFFQ_M_XD5_XDFFQ_MB r0 *1 0,0
Ccc_XD0_XDFFQ_M_XD5_XDFFQ_MB XD0_XDFFQ_M XD5_XDFFQ_MB 1.21e-17
* device instance cc_XD0_XDFFQ_M_XD5_XDFFQ_S r0 *1 0,0
Ccc_XD0_XDFFQ_M_XD5_XDFFQ_S XD0_XDFFQ_M XD5_XDFFQ_S 1.8151e-17
* device instance cc_XD0_XDFFQ_M_XD5_XDFFQ_SB r0 *1 0,0
Ccc_XD0_XDFFQ_M_XD5_XDFFQ_SB XD0_XDFFQ_M XD5_XDFFQ_SB 1.8151e-17
* device instance cc_XD0_XDFFQ_M_XD5_XN2_mid1 r0 *1 0,0
Ccc_XD0_XDFFQ_M_XD5_XN2_mid1 XD0_XDFFQ_M XD5_XN2_mid1 1.21e-17
* device instance cc_XD0_XDFFQ_M_XD5_XN3_mid1 r0 *1 0,0
Ccc_XD0_XDFFQ_M_XD5_XN3_mid1 XD0_XDFFQ_M XD5_XN3_mid1 1.21e-17
* device instance cc_XD0_XDFFQ_M_XD5_XN3_mid2 r0 *1 0,0
Ccc_XD0_XDFFQ_M_XD5_XN3_mid2 XD0_XDFFQ_M XD5_XN3_mid2 1.21e-17
* device instance cc_XD0_XDFFQ_M_XD5_dmodout r0 *1 0,0
Ccc_XD0_XDFFQ_M_XD5_dmodout XD0_XDFFQ_M XD5_dmodout 1.21e-17
* device instance cc_XD0_XDFFQ_M_XD5_dq r0 *1 0,0
Ccc_XD0_XDFFQ_M_XD5_dq XD0_XDFFQ_M XD5_dq 1.8151e-17
* device instance cc_XD0_XDFFQ_M_XD5_nm r0 *1 0,0
Ccc_XD0_XDFFQ_M_XD5_nm XD0_XDFFQ_M XD5_nm 1.21e-17
* device instance cc_XD0_XDFFQ_M_XD5_nt r0 *1 0,0
Ccc_XD0_XDFFQ_M_XD5_nt XD0_XDFFQ_M XD5_nt 1.21e-17
* device instance cc_XD0_XDFFQ_M_XD5_t1 r0 *1 0,0
Ccc_XD0_XDFFQ_M_XD5_t1 XD0_XDFFQ_M XD5_t1 1.21e-17
* device instance cc_XD0_XDFFQ_M_XFRT_CLKB r0 *1 0,0
Ccc_XD0_XDFFQ_M_XFRT_CLKB XD0_XDFFQ_M XFRT_CLKB 1.8151e-17
* device instance cc_XD0_XDFFQ_M_XFRT_M r0 *1 0,0
Ccc_XD0_XDFFQ_M_XFRT_M XD0_XDFFQ_M XFRT_M 2.4201e-17
* device instance cc_XD0_XDFFQ_M_XFRT_MB r0 *1 0,0
Ccc_XD0_XDFFQ_M_XFRT_MB XD0_XDFFQ_M XFRT_MB 1.21e-17
* device instance cc_XD0_XDFFQ_M_XFRT_S r0 *1 0,0
Ccc_XD0_XDFFQ_M_XFRT_S XD0_XDFFQ_M XFRT_S 1.8151e-17
* device instance cc_XD0_XDFFQ_M_XFRT_SB r0 *1 0,0
Ccc_XD0_XDFFQ_M_XFRT_SB XD0_XDFFQ_M XFRT_SB 1.8151e-17
* device instance cc_XD0_XDFFQ_M_ck1 r0 *1 0,0
Ccc_XD0_XDFFQ_M_ck1 XD0_XDFFQ_M ck1 5.4452e-17
* device instance cc_XD0_XDFFQ_M_ck2 r0 *1 0,0
Ccc_XD0_XDFFQ_M_ck2 XD0_XDFFQ_M ck2 5.4452e-17
* device instance cc_XD0_XDFFQ_M_ck3 r0 *1 0,0
Ccc_XD0_XDFFQ_M_ck3 XD0_XDFFQ_M ck3 5.4452e-17
* device instance cc_XD0_XDFFQ_M_ck4 r0 *1 0,0
Ccc_XD0_XDFFQ_M_ck4 XD0_XDFFQ_M ck4 5.4452e-17
* device instance cc_XD0_XDFFQ_M_ck5 r0 *1 0,0
Ccc_XD0_XDFFQ_M_ck5 XD0_XDFFQ_M ck5 5.4452e-17
* device instance cc_XD0_XDFFQ_M_mod0 r0 *1 0,0
Ccc_XD0_XDFFQ_M_mod0 XD0_XDFFQ_M mod0 2.4201e-17
* device instance cc_XD0_XDFFQ_M_mod1 r0 *1 0,0
Ccc_XD0_XDFFQ_M_mod1 XD0_XDFFQ_M mod1 2.4201e-17
* device instance cc_XD0_XDFFQ_M_mod2 r0 *1 0,0
Ccc_XD0_XDFFQ_M_mod2 XD0_XDFFQ_M mod2 2.4201e-17
* device instance cc_XD0_XDFFQ_M_mod3 r0 *1 0,0
Ccc_XD0_XDFFQ_M_mod3 XD0_XDFFQ_M mod3 2.4201e-17
* device instance cc_XD0_XDFFQ_M_mod4 r0 *1 0,0
Ccc_XD0_XDFFQ_M_mod4 XD0_XDFFQ_M mod4 2.4201e-17
* device instance cc_XD0_XDFFQ_M_net1 r0 *1 0,0
Ccc_XD0_XDFFQ_M_net1 XD0_XDFFQ_M net1 1.21e-17
* device instance cc_XD0_XDFFQ_MB_XD0_XDFFQ_S r0 *1 0,0
Ccc_XD0_XDFFQ_MB_XD0_XDFFQ_S XD0_XDFFQ_MB XD0_XDFFQ_S 1.8151e-17
* device instance cc_XD0_XDFFQ_MB_XD0_XDFFQ_SB r0 *1 0,0
Ccc_XD0_XDFFQ_MB_XD0_XDFFQ_SB XD0_XDFFQ_MB XD0_XDFFQ_SB 1.8151e-17
* device instance cc_XD0_XDFFQ_MB_XD0_XN2_mid1 r0 *1 0,0
Ccc_XD0_XDFFQ_MB_XD0_XN2_mid1 XD0_XDFFQ_MB XD0_XN2_mid1 1.21e-17
* device instance cc_XD0_XDFFQ_MB_XD0_XNOR_midp r0 *1 0,0
Ccc_XD0_XDFFQ_MB_XD0_XNOR_midp XD0_XDFFQ_MB XD0_XNOR_midp 1.21e-17
* device instance cc_XD0_XDFFQ_MB_XD0_dmodout r0 *1 0,0
Ccc_XD0_XDFFQ_MB_XD0_dmodout XD0_XDFFQ_MB XD0_dmodout 1.21e-17
* device instance cc_XD0_XDFFQ_MB_XD0_dq r0 *1 0,0
Ccc_XD0_XDFFQ_MB_XD0_dq XD0_XDFFQ_MB XD0_dq 1.21e-17
* device instance cc_XD0_XDFFQ_MB_XD0_nm r0 *1 0,0
Ccc_XD0_XDFFQ_MB_XD0_nm XD0_XDFFQ_MB XD0_nm 1.21e-17
* device instance cc_XD0_XDFFQ_MB_XD0_nt r0 *1 0,0
Ccc_XD0_XDFFQ_MB_XD0_nt XD0_XDFFQ_MB XD0_nt 2.4201e-17
* device instance cc_XD0_XDFFQ_MB_XD0_t1 r0 *1 0,0
Ccc_XD0_XDFFQ_MB_XD0_t1 XD0_XDFFQ_MB XD0_t1 1.21e-17
* device instance cc_XD0_XDFFQ_MB_XD1_XDFFM_CLKB r0 *1 0,0
Ccc_XD0_XDFFQ_MB_XD1_XDFFM_CLKB XD0_XDFFQ_MB XD1_XDFFM_CLKB 1.8151e-17
* device instance cc_XD0_XDFFQ_MB_XD1_XDFFM_M r0 *1 0,0
Ccc_XD0_XDFFQ_MB_XD1_XDFFM_M XD0_XDFFQ_MB XD1_XDFFM_M 2.4201e-17
* device instance cc_XD0_XDFFQ_MB_XD1_XDFFM_MB r0 *1 0,0
Ccc_XD0_XDFFQ_MB_XD1_XDFFM_MB XD0_XDFFQ_MB XD1_XDFFM_MB 1.21e-17
* device instance cc_XD0_XDFFQ_MB_XD1_XDFFM_S r0 *1 0,0
Ccc_XD0_XDFFQ_MB_XD1_XDFFM_S XD0_XDFFQ_MB XD1_XDFFM_S 1.8151e-17
* device instance cc_XD0_XDFFQ_MB_XD1_XDFFM_SB r0 *1 0,0
Ccc_XD0_XDFFQ_MB_XD1_XDFFM_SB XD0_XDFFQ_MB XD1_XDFFM_SB 1.8151e-17
* device instance cc_XD0_XDFFQ_MB_XD1_XDFFQ_CLKB r0 *1 0,0
Ccc_XD0_XDFFQ_MB_XD1_XDFFQ_CLKB XD0_XDFFQ_MB XD1_XDFFQ_CLKB 1.8151e-17
* device instance cc_XD0_XDFFQ_MB_XD1_XDFFQ_M r0 *1 0,0
Ccc_XD0_XDFFQ_MB_XD1_XDFFQ_M XD0_XDFFQ_MB XD1_XDFFQ_M 2.4201e-17
* device instance cc_XD0_XDFFQ_MB_XD1_XDFFQ_MB r0 *1 0,0
Ccc_XD0_XDFFQ_MB_XD1_XDFFQ_MB XD0_XDFFQ_MB XD1_XDFFQ_MB 1.21e-17
* device instance cc_XD0_XDFFQ_MB_XD1_XDFFQ_S r0 *1 0,0
Ccc_XD0_XDFFQ_MB_XD1_XDFFQ_S XD0_XDFFQ_MB XD1_XDFFQ_S 1.8151e-17
* device instance cc_XD0_XDFFQ_MB_XD1_XDFFQ_SB r0 *1 0,0
Ccc_XD0_XDFFQ_MB_XD1_XDFFQ_SB XD0_XDFFQ_MB XD1_XDFFQ_SB 1.8151e-17
* device instance cc_XD0_XDFFQ_MB_XD1_XN2_mid1 r0 *1 0,0
Ccc_XD0_XDFFQ_MB_XD1_XN2_mid1 XD0_XDFFQ_MB XD1_XN2_mid1 1.21e-17
* device instance cc_XD0_XDFFQ_MB_XD1_XN3_mid1 r0 *1 0,0
Ccc_XD0_XDFFQ_MB_XD1_XN3_mid1 XD0_XDFFQ_MB XD1_XN3_mid1 1.21e-17
* device instance cc_XD0_XDFFQ_MB_XD1_XN3_mid2 r0 *1 0,0
Ccc_XD0_XDFFQ_MB_XD1_XN3_mid2 XD0_XDFFQ_MB XD1_XN3_mid2 1.21e-17
* device instance cc_XD0_XDFFQ_MB_XD1_dmodout r0 *1 0,0
Ccc_XD0_XDFFQ_MB_XD1_dmodout XD0_XDFFQ_MB XD1_dmodout 1.21e-17
* device instance cc_XD0_XDFFQ_MB_XD1_dq r0 *1 0,0
Ccc_XD0_XDFFQ_MB_XD1_dq XD0_XDFFQ_MB XD1_dq 1.8151e-17
* device instance cc_XD0_XDFFQ_MB_XD1_nm r0 *1 0,0
Ccc_XD0_XDFFQ_MB_XD1_nm XD0_XDFFQ_MB XD1_nm 1.21e-17
* device instance cc_XD0_XDFFQ_MB_XD1_nt r0 *1 0,0
Ccc_XD0_XDFFQ_MB_XD1_nt XD0_XDFFQ_MB XD1_nt 1.21e-17
* device instance cc_XD0_XDFFQ_MB_XD1_t1 r0 *1 0,0
Ccc_XD0_XDFFQ_MB_XD1_t1 XD0_XDFFQ_MB XD1_t1 1.21e-17
* device instance cc_XD0_XDFFQ_MB_XD2_XDFFM_CLKB r0 *1 0,0
Ccc_XD0_XDFFQ_MB_XD2_XDFFM_CLKB XD0_XDFFQ_MB XD2_XDFFM_CLKB 1.8151e-17
* device instance cc_XD0_XDFFQ_MB_XD2_XDFFM_M r0 *1 0,0
Ccc_XD0_XDFFQ_MB_XD2_XDFFM_M XD0_XDFFQ_MB XD2_XDFFM_M 2.4201e-17
* device instance cc_XD0_XDFFQ_MB_XD2_XDFFM_MB r0 *1 0,0
Ccc_XD0_XDFFQ_MB_XD2_XDFFM_MB XD0_XDFFQ_MB XD2_XDFFM_MB 1.21e-17
* device instance cc_XD0_XDFFQ_MB_XD2_XDFFM_S r0 *1 0,0
Ccc_XD0_XDFFQ_MB_XD2_XDFFM_S XD0_XDFFQ_MB XD2_XDFFM_S 1.8151e-17
* device instance cc_XD0_XDFFQ_MB_XD2_XDFFM_SB r0 *1 0,0
Ccc_XD0_XDFFQ_MB_XD2_XDFFM_SB XD0_XDFFQ_MB XD2_XDFFM_SB 1.8151e-17
* device instance cc_XD0_XDFFQ_MB_XD2_XDFFQ_CLKB r0 *1 0,0
Ccc_XD0_XDFFQ_MB_XD2_XDFFQ_CLKB XD0_XDFFQ_MB XD2_XDFFQ_CLKB 1.8151e-17
* device instance cc_XD0_XDFFQ_MB_XD2_XDFFQ_M r0 *1 0,0
Ccc_XD0_XDFFQ_MB_XD2_XDFFQ_M XD0_XDFFQ_MB XD2_XDFFQ_M 2.4201e-17
* device instance cc_XD0_XDFFQ_MB_XD2_XDFFQ_MB r0 *1 0,0
Ccc_XD0_XDFFQ_MB_XD2_XDFFQ_MB XD0_XDFFQ_MB XD2_XDFFQ_MB 1.21e-17
* device instance cc_XD0_XDFFQ_MB_XD2_XDFFQ_S r0 *1 0,0
Ccc_XD0_XDFFQ_MB_XD2_XDFFQ_S XD0_XDFFQ_MB XD2_XDFFQ_S 1.8151e-17
* device instance cc_XD0_XDFFQ_MB_XD2_XDFFQ_SB r0 *1 0,0
Ccc_XD0_XDFFQ_MB_XD2_XDFFQ_SB XD0_XDFFQ_MB XD2_XDFFQ_SB 1.8151e-17
* device instance cc_XD0_XDFFQ_MB_XD2_XN2_mid1 r0 *1 0,0
Ccc_XD0_XDFFQ_MB_XD2_XN2_mid1 XD0_XDFFQ_MB XD2_XN2_mid1 1.21e-17
* device instance cc_XD0_XDFFQ_MB_XD2_XN3_mid1 r0 *1 0,0
Ccc_XD0_XDFFQ_MB_XD2_XN3_mid1 XD0_XDFFQ_MB XD2_XN3_mid1 1.21e-17
* device instance cc_XD0_XDFFQ_MB_XD2_XN3_mid2 r0 *1 0,0
Ccc_XD0_XDFFQ_MB_XD2_XN3_mid2 XD0_XDFFQ_MB XD2_XN3_mid2 1.21e-17
* device instance cc_XD0_XDFFQ_MB_XD2_dmodout r0 *1 0,0
Ccc_XD0_XDFFQ_MB_XD2_dmodout XD0_XDFFQ_MB XD2_dmodout 1.21e-17
* device instance cc_XD0_XDFFQ_MB_XD2_dq r0 *1 0,0
Ccc_XD0_XDFFQ_MB_XD2_dq XD0_XDFFQ_MB XD2_dq 1.8151e-17
* device instance cc_XD0_XDFFQ_MB_XD2_nm r0 *1 0,0
Ccc_XD0_XDFFQ_MB_XD2_nm XD0_XDFFQ_MB XD2_nm 1.21e-17
* device instance cc_XD0_XDFFQ_MB_XD2_nt r0 *1 0,0
Ccc_XD0_XDFFQ_MB_XD2_nt XD0_XDFFQ_MB XD2_nt 1.21e-17
* device instance cc_XD0_XDFFQ_MB_XD2_t1 r0 *1 0,0
Ccc_XD0_XDFFQ_MB_XD2_t1 XD0_XDFFQ_MB XD2_t1 1.21e-17
* device instance cc_XD0_XDFFQ_MB_XD3_XDFFM_CLKB r0 *1 0,0
Ccc_XD0_XDFFQ_MB_XD3_XDFFM_CLKB XD0_XDFFQ_MB XD3_XDFFM_CLKB 1.8151e-17
* device instance cc_XD0_XDFFQ_MB_XD3_XDFFM_M r0 *1 0,0
Ccc_XD0_XDFFQ_MB_XD3_XDFFM_M XD0_XDFFQ_MB XD3_XDFFM_M 2.4201e-17
* device instance cc_XD0_XDFFQ_MB_XD3_XDFFM_MB r0 *1 0,0
Ccc_XD0_XDFFQ_MB_XD3_XDFFM_MB XD0_XDFFQ_MB XD3_XDFFM_MB 1.21e-17
* device instance cc_XD0_XDFFQ_MB_XD3_XDFFM_S r0 *1 0,0
Ccc_XD0_XDFFQ_MB_XD3_XDFFM_S XD0_XDFFQ_MB XD3_XDFFM_S 1.8151e-17
* device instance cc_XD0_XDFFQ_MB_XD3_XDFFM_SB r0 *1 0,0
Ccc_XD0_XDFFQ_MB_XD3_XDFFM_SB XD0_XDFFQ_MB XD3_XDFFM_SB 1.8151e-17
* device instance cc_XD0_XDFFQ_MB_XD3_XDFFQ_CLKB r0 *1 0,0
Ccc_XD0_XDFFQ_MB_XD3_XDFFQ_CLKB XD0_XDFFQ_MB XD3_XDFFQ_CLKB 1.8151e-17
* device instance cc_XD0_XDFFQ_MB_XD3_XDFFQ_M r0 *1 0,0
Ccc_XD0_XDFFQ_MB_XD3_XDFFQ_M XD0_XDFFQ_MB XD3_XDFFQ_M 2.4201e-17
* device instance cc_XD0_XDFFQ_MB_XD3_XDFFQ_MB r0 *1 0,0
Ccc_XD0_XDFFQ_MB_XD3_XDFFQ_MB XD0_XDFFQ_MB XD3_XDFFQ_MB 1.21e-17
* device instance cc_XD0_XDFFQ_MB_XD3_XDFFQ_S r0 *1 0,0
Ccc_XD0_XDFFQ_MB_XD3_XDFFQ_S XD0_XDFFQ_MB XD3_XDFFQ_S 1.8151e-17
* device instance cc_XD0_XDFFQ_MB_XD3_XDFFQ_SB r0 *1 0,0
Ccc_XD0_XDFFQ_MB_XD3_XDFFQ_SB XD0_XDFFQ_MB XD3_XDFFQ_SB 1.8151e-17
* device instance cc_XD0_XDFFQ_MB_XD3_XN2_mid1 r0 *1 0,0
Ccc_XD0_XDFFQ_MB_XD3_XN2_mid1 XD0_XDFFQ_MB XD3_XN2_mid1 1.21e-17
* device instance cc_XD0_XDFFQ_MB_XD3_XN3_mid1 r0 *1 0,0
Ccc_XD0_XDFFQ_MB_XD3_XN3_mid1 XD0_XDFFQ_MB XD3_XN3_mid1 1.21e-17
* device instance cc_XD0_XDFFQ_MB_XD3_XN3_mid2 r0 *1 0,0
Ccc_XD0_XDFFQ_MB_XD3_XN3_mid2 XD0_XDFFQ_MB XD3_XN3_mid2 1.21e-17
* device instance cc_XD0_XDFFQ_MB_XD3_dmodout r0 *1 0,0
Ccc_XD0_XDFFQ_MB_XD3_dmodout XD0_XDFFQ_MB XD3_dmodout 1.21e-17
* device instance cc_XD0_XDFFQ_MB_XD3_dq r0 *1 0,0
Ccc_XD0_XDFFQ_MB_XD3_dq XD0_XDFFQ_MB XD3_dq 1.8151e-17
* device instance cc_XD0_XDFFQ_MB_XD3_nm r0 *1 0,0
Ccc_XD0_XDFFQ_MB_XD3_nm XD0_XDFFQ_MB XD3_nm 1.21e-17
* device instance cc_XD0_XDFFQ_MB_XD3_nt r0 *1 0,0
Ccc_XD0_XDFFQ_MB_XD3_nt XD0_XDFFQ_MB XD3_nt 1.21e-17
* device instance cc_XD0_XDFFQ_MB_XD3_t1 r0 *1 0,0
Ccc_XD0_XDFFQ_MB_XD3_t1 XD0_XDFFQ_MB XD3_t1 1.21e-17
* device instance cc_XD0_XDFFQ_MB_XD4_XDFFM_CLKB r0 *1 0,0
Ccc_XD0_XDFFQ_MB_XD4_XDFFM_CLKB XD0_XDFFQ_MB XD4_XDFFM_CLKB 1.8151e-17
* device instance cc_XD0_XDFFQ_MB_XD4_XDFFM_M r0 *1 0,0
Ccc_XD0_XDFFQ_MB_XD4_XDFFM_M XD0_XDFFQ_MB XD4_XDFFM_M 2.4201e-17
* device instance cc_XD0_XDFFQ_MB_XD4_XDFFM_MB r0 *1 0,0
Ccc_XD0_XDFFQ_MB_XD4_XDFFM_MB XD0_XDFFQ_MB XD4_XDFFM_MB 1.21e-17
* device instance cc_XD0_XDFFQ_MB_XD4_XDFFM_S r0 *1 0,0
Ccc_XD0_XDFFQ_MB_XD4_XDFFM_S XD0_XDFFQ_MB XD4_XDFFM_S 1.8151e-17
* device instance cc_XD0_XDFFQ_MB_XD4_XDFFM_SB r0 *1 0,0
Ccc_XD0_XDFFQ_MB_XD4_XDFFM_SB XD0_XDFFQ_MB XD4_XDFFM_SB 1.8151e-17
* device instance cc_XD0_XDFFQ_MB_XD4_XDFFQ_CLKB r0 *1 0,0
Ccc_XD0_XDFFQ_MB_XD4_XDFFQ_CLKB XD0_XDFFQ_MB XD4_XDFFQ_CLKB 1.8151e-17
* device instance cc_XD0_XDFFQ_MB_XD4_XDFFQ_M r0 *1 0,0
Ccc_XD0_XDFFQ_MB_XD4_XDFFQ_M XD0_XDFFQ_MB XD4_XDFFQ_M 2.4201e-17
* device instance cc_XD0_XDFFQ_MB_XD4_XDFFQ_MB r0 *1 0,0
Ccc_XD0_XDFFQ_MB_XD4_XDFFQ_MB XD0_XDFFQ_MB XD4_XDFFQ_MB 1.21e-17
* device instance cc_XD0_XDFFQ_MB_XD4_XDFFQ_S r0 *1 0,0
Ccc_XD0_XDFFQ_MB_XD4_XDFFQ_S XD0_XDFFQ_MB XD4_XDFFQ_S 1.8151e-17
* device instance cc_XD0_XDFFQ_MB_XD4_XDFFQ_SB r0 *1 0,0
Ccc_XD0_XDFFQ_MB_XD4_XDFFQ_SB XD0_XDFFQ_MB XD4_XDFFQ_SB 1.8151e-17
* device instance cc_XD0_XDFFQ_MB_XD4_XN2_mid1 r0 *1 0,0
Ccc_XD0_XDFFQ_MB_XD4_XN2_mid1 XD0_XDFFQ_MB XD4_XN2_mid1 1.21e-17
* device instance cc_XD0_XDFFQ_MB_XD4_XN3_mid1 r0 *1 0,0
Ccc_XD0_XDFFQ_MB_XD4_XN3_mid1 XD0_XDFFQ_MB XD4_XN3_mid1 1.21e-17
* device instance cc_XD0_XDFFQ_MB_XD4_XN3_mid2 r0 *1 0,0
Ccc_XD0_XDFFQ_MB_XD4_XN3_mid2 XD0_XDFFQ_MB XD4_XN3_mid2 1.21e-17
* device instance cc_XD0_XDFFQ_MB_XD4_dmodout r0 *1 0,0
Ccc_XD0_XDFFQ_MB_XD4_dmodout XD0_XDFFQ_MB XD4_dmodout 1.21e-17
* device instance cc_XD0_XDFFQ_MB_XD4_dq r0 *1 0,0
Ccc_XD0_XDFFQ_MB_XD4_dq XD0_XDFFQ_MB XD4_dq 1.8151e-17
* device instance cc_XD0_XDFFQ_MB_XD4_nm r0 *1 0,0
Ccc_XD0_XDFFQ_MB_XD4_nm XD0_XDFFQ_MB XD4_nm 1.21e-17
* device instance cc_XD0_XDFFQ_MB_XD4_nt r0 *1 0,0
Ccc_XD0_XDFFQ_MB_XD4_nt XD0_XDFFQ_MB XD4_nt 1.21e-17
* device instance cc_XD0_XDFFQ_MB_XD4_t1 r0 *1 0,0
Ccc_XD0_XDFFQ_MB_XD4_t1 XD0_XDFFQ_MB XD4_t1 1.21e-17
* device instance cc_XD0_XDFFQ_MB_XD5_XDFFM_CLKB r0 *1 0,0
Ccc_XD0_XDFFQ_MB_XD5_XDFFM_CLKB XD0_XDFFQ_MB XD5_XDFFM_CLKB 1.8151e-17
* device instance cc_XD0_XDFFQ_MB_XD5_XDFFM_M r0 *1 0,0
Ccc_XD0_XDFFQ_MB_XD5_XDFFM_M XD0_XDFFQ_MB XD5_XDFFM_M 2.4201e-17
* device instance cc_XD0_XDFFQ_MB_XD5_XDFFM_MB r0 *1 0,0
Ccc_XD0_XDFFQ_MB_XD5_XDFFM_MB XD0_XDFFQ_MB XD5_XDFFM_MB 1.21e-17
* device instance cc_XD0_XDFFQ_MB_XD5_XDFFM_S r0 *1 0,0
Ccc_XD0_XDFFQ_MB_XD5_XDFFM_S XD0_XDFFQ_MB XD5_XDFFM_S 1.8151e-17
* device instance cc_XD0_XDFFQ_MB_XD5_XDFFM_SB r0 *1 0,0
Ccc_XD0_XDFFQ_MB_XD5_XDFFM_SB XD0_XDFFQ_MB XD5_XDFFM_SB 1.8151e-17
* device instance cc_XD0_XDFFQ_MB_XD5_XDFFQ_CLKB r0 *1 0,0
Ccc_XD0_XDFFQ_MB_XD5_XDFFQ_CLKB XD0_XDFFQ_MB XD5_XDFFQ_CLKB 1.8151e-17
* device instance cc_XD0_XDFFQ_MB_XD5_XDFFQ_M r0 *1 0,0
Ccc_XD0_XDFFQ_MB_XD5_XDFFQ_M XD0_XDFFQ_MB XD5_XDFFQ_M 2.4201e-17
* device instance cc_XD0_XDFFQ_MB_XD5_XDFFQ_MB r0 *1 0,0
Ccc_XD0_XDFFQ_MB_XD5_XDFFQ_MB XD0_XDFFQ_MB XD5_XDFFQ_MB 1.21e-17
* device instance cc_XD0_XDFFQ_MB_XD5_XDFFQ_S r0 *1 0,0
Ccc_XD0_XDFFQ_MB_XD5_XDFFQ_S XD0_XDFFQ_MB XD5_XDFFQ_S 1.8151e-17
* device instance cc_XD0_XDFFQ_MB_XD5_XDFFQ_SB r0 *1 0,0
Ccc_XD0_XDFFQ_MB_XD5_XDFFQ_SB XD0_XDFFQ_MB XD5_XDFFQ_SB 1.8151e-17
* device instance cc_XD0_XDFFQ_MB_XD5_XN2_mid1 r0 *1 0,0
Ccc_XD0_XDFFQ_MB_XD5_XN2_mid1 XD0_XDFFQ_MB XD5_XN2_mid1 1.21e-17
* device instance cc_XD0_XDFFQ_MB_XD5_XN3_mid1 r0 *1 0,0
Ccc_XD0_XDFFQ_MB_XD5_XN3_mid1 XD0_XDFFQ_MB XD5_XN3_mid1 1.21e-17
* device instance cc_XD0_XDFFQ_MB_XD5_XN3_mid2 r0 *1 0,0
Ccc_XD0_XDFFQ_MB_XD5_XN3_mid2 XD0_XDFFQ_MB XD5_XN3_mid2 1.21e-17
* device instance cc_XD0_XDFFQ_MB_XD5_dmodout r0 *1 0,0
Ccc_XD0_XDFFQ_MB_XD5_dmodout XD0_XDFFQ_MB XD5_dmodout 1.21e-17
* device instance cc_XD0_XDFFQ_MB_XD5_dq r0 *1 0,0
Ccc_XD0_XDFFQ_MB_XD5_dq XD0_XDFFQ_MB XD5_dq 1.8151e-17
* device instance cc_XD0_XDFFQ_MB_XD5_nm r0 *1 0,0
Ccc_XD0_XDFFQ_MB_XD5_nm XD0_XDFFQ_MB XD5_nm 1.21e-17
* device instance cc_XD0_XDFFQ_MB_XD5_nt r0 *1 0,0
Ccc_XD0_XDFFQ_MB_XD5_nt XD0_XDFFQ_MB XD5_nt 1.21e-17
* device instance cc_XD0_XDFFQ_MB_XD5_t1 r0 *1 0,0
Ccc_XD0_XDFFQ_MB_XD5_t1 XD0_XDFFQ_MB XD5_t1 1.21e-17
* device instance cc_XD0_XDFFQ_MB_XFRT_CLKB r0 *1 0,0
Ccc_XD0_XDFFQ_MB_XFRT_CLKB XD0_XDFFQ_MB XFRT_CLKB 1.8151e-17
* device instance cc_XD0_XDFFQ_MB_XFRT_M r0 *1 0,0
Ccc_XD0_XDFFQ_MB_XFRT_M XD0_XDFFQ_MB XFRT_M 2.4201e-17
* device instance cc_XD0_XDFFQ_MB_XFRT_MB r0 *1 0,0
Ccc_XD0_XDFFQ_MB_XFRT_MB XD0_XDFFQ_MB XFRT_MB 1.21e-17
* device instance cc_XD0_XDFFQ_MB_XFRT_S r0 *1 0,0
Ccc_XD0_XDFFQ_MB_XFRT_S XD0_XDFFQ_MB XFRT_S 1.8151e-17
* device instance cc_XD0_XDFFQ_MB_XFRT_SB r0 *1 0,0
Ccc_XD0_XDFFQ_MB_XFRT_SB XD0_XDFFQ_MB XFRT_SB 1.8151e-17
* device instance cc_XD0_XDFFQ_MB_ck1 r0 *1 0,0
Ccc_XD0_XDFFQ_MB_ck1 XD0_XDFFQ_MB ck1 5.4452e-17
* device instance cc_XD0_XDFFQ_MB_ck2 r0 *1 0,0
Ccc_XD0_XDFFQ_MB_ck2 XD0_XDFFQ_MB ck2 5.4452e-17
* device instance cc_XD0_XDFFQ_MB_ck3 r0 *1 0,0
Ccc_XD0_XDFFQ_MB_ck3 XD0_XDFFQ_MB ck3 5.4452e-17
* device instance cc_XD0_XDFFQ_MB_ck4 r0 *1 0,0
Ccc_XD0_XDFFQ_MB_ck4 XD0_XDFFQ_MB ck4 5.4452e-17
* device instance cc_XD0_XDFFQ_MB_ck5 r0 *1 0,0
Ccc_XD0_XDFFQ_MB_ck5 XD0_XDFFQ_MB ck5 5.4452e-17
* device instance cc_XD0_XDFFQ_MB_mod0 r0 *1 0,0
Ccc_XD0_XDFFQ_MB_mod0 XD0_XDFFQ_MB mod0 2.4201e-17
* device instance cc_XD0_XDFFQ_MB_mod1 r0 *1 0,0
Ccc_XD0_XDFFQ_MB_mod1 XD0_XDFFQ_MB mod1 2.4201e-17
* device instance cc_XD0_XDFFQ_MB_mod2 r0 *1 0,0
Ccc_XD0_XDFFQ_MB_mod2 XD0_XDFFQ_MB mod2 2.4201e-17
* device instance cc_XD0_XDFFQ_MB_mod3 r0 *1 0,0
Ccc_XD0_XDFFQ_MB_mod3 XD0_XDFFQ_MB mod3 2.4201e-17
* device instance cc_XD0_XDFFQ_MB_mod4 r0 *1 0,0
Ccc_XD0_XDFFQ_MB_mod4 XD0_XDFFQ_MB mod4 2.4201e-17
* device instance cc_XD0_XDFFQ_MB_net1 r0 *1 0,0
Ccc_XD0_XDFFQ_MB_net1 XD0_XDFFQ_MB net1 1.21e-17
* device instance cc_XD0_XDFFQ_S_XD0_XDFFQ_SB r0 *1 0,0
Ccc_XD0_XDFFQ_S_XD0_XDFFQ_SB XD0_XDFFQ_S XD0_XDFFQ_SB 4.0738e-17
* device instance cc_XD0_XDFFQ_S_XD0_XN2_mid1 r0 *1 0,0
Ccc_XD0_XDFFQ_S_XD0_XN2_mid1 XD0_XDFFQ_S XD0_XN2_mid1 1.21e-17
* device instance cc_XD0_XDFFQ_S_XD0_XNOR_midp r0 *1 0,0
Ccc_XD0_XDFFQ_S_XD0_XNOR_midp XD0_XDFFQ_S XD0_XNOR_midp 1.21e-17
* device instance cc_XD0_XDFFQ_S_XD0_dmodout r0 *1 0,0
Ccc_XD0_XDFFQ_S_XD0_dmodout XD0_XDFFQ_S XD0_dmodout 1.21e-17
* device instance cc_XD0_XDFFQ_S_XD0_dq r0 *1 0,0
Ccc_XD0_XDFFQ_S_XD0_dq XD0_XDFFQ_S XD0_dq 1.21e-17
* device instance cc_XD0_XDFFQ_S_XD0_nm r0 *1 0,0
Ccc_XD0_XDFFQ_S_XD0_nm XD0_XDFFQ_S XD0_nm 1.21e-17
* device instance cc_XD0_XDFFQ_S_XD0_nt r0 *1 0,0
Ccc_XD0_XDFFQ_S_XD0_nt XD0_XDFFQ_S XD0_nt 2.4201e-17
* device instance cc_XD0_XDFFQ_S_XD0_t1 r0 *1 0,0
Ccc_XD0_XDFFQ_S_XD0_t1 XD0_XDFFQ_S XD0_t1 1.21e-17
* device instance cc_XD0_XDFFQ_S_XD1_XDFFM_CLKB r0 *1 0,0
Ccc_XD0_XDFFQ_S_XD1_XDFFM_CLKB XD0_XDFFQ_S XD1_XDFFM_CLKB 1.8151e-17
* device instance cc_XD0_XDFFQ_S_XD1_XDFFM_M r0 *1 0,0
Ccc_XD0_XDFFQ_S_XD1_XDFFM_M XD0_XDFFQ_S XD1_XDFFM_M 2.4201e-17
* device instance cc_XD0_XDFFQ_S_XD1_XDFFM_MB r0 *1 0,0
Ccc_XD0_XDFFQ_S_XD1_XDFFM_MB XD0_XDFFQ_S XD1_XDFFM_MB 1.21e-17
* device instance cc_XD0_XDFFQ_S_XD1_XDFFM_S r0 *1 0,0
Ccc_XD0_XDFFQ_S_XD1_XDFFM_S XD0_XDFFQ_S XD1_XDFFM_S 1.8151e-17
* device instance cc_XD0_XDFFQ_S_XD1_XDFFM_SB r0 *1 0,0
Ccc_XD0_XDFFQ_S_XD1_XDFFM_SB XD0_XDFFQ_S XD1_XDFFM_SB 1.8151e-17
* device instance cc_XD0_XDFFQ_S_XD1_XDFFQ_CLKB r0 *1 0,0
Ccc_XD0_XDFFQ_S_XD1_XDFFQ_CLKB XD0_XDFFQ_S XD1_XDFFQ_CLKB 1.8151e-17
* device instance cc_XD0_XDFFQ_S_XD1_XDFFQ_M r0 *1 0,0
Ccc_XD0_XDFFQ_S_XD1_XDFFQ_M XD0_XDFFQ_S XD1_XDFFQ_M 2.4201e-17
* device instance cc_XD0_XDFFQ_S_XD1_XDFFQ_MB r0 *1 0,0
Ccc_XD0_XDFFQ_S_XD1_XDFFQ_MB XD0_XDFFQ_S XD1_XDFFQ_MB 1.21e-17
* device instance cc_XD0_XDFFQ_S_XD1_XDFFQ_S r0 *1 0,0
Ccc_XD0_XDFFQ_S_XD1_XDFFQ_S XD0_XDFFQ_S XD1_XDFFQ_S 1.8151e-17
* device instance cc_XD0_XDFFQ_S_XD1_XDFFQ_SB r0 *1 0,0
Ccc_XD0_XDFFQ_S_XD1_XDFFQ_SB XD0_XDFFQ_S XD1_XDFFQ_SB 1.8151e-17
* device instance cc_XD0_XDFFQ_S_XD1_XN2_mid1 r0 *1 0,0
Ccc_XD0_XDFFQ_S_XD1_XN2_mid1 XD0_XDFFQ_S XD1_XN2_mid1 1.21e-17
* device instance cc_XD0_XDFFQ_S_XD1_XN3_mid1 r0 *1 0,0
Ccc_XD0_XDFFQ_S_XD1_XN3_mid1 XD0_XDFFQ_S XD1_XN3_mid1 1.21e-17
* device instance cc_XD0_XDFFQ_S_XD1_XN3_mid2 r0 *1 0,0
Ccc_XD0_XDFFQ_S_XD1_XN3_mid2 XD0_XDFFQ_S XD1_XN3_mid2 1.21e-17
* device instance cc_XD0_XDFFQ_S_XD1_dmodout r0 *1 0,0
Ccc_XD0_XDFFQ_S_XD1_dmodout XD0_XDFFQ_S XD1_dmodout 1.21e-17
* device instance cc_XD0_XDFFQ_S_XD1_dq r0 *1 0,0
Ccc_XD0_XDFFQ_S_XD1_dq XD0_XDFFQ_S XD1_dq 1.8151e-17
* device instance cc_XD0_XDFFQ_S_XD1_nm r0 *1 0,0
Ccc_XD0_XDFFQ_S_XD1_nm XD0_XDFFQ_S XD1_nm 1.21e-17
* device instance cc_XD0_XDFFQ_S_XD1_nt r0 *1 0,0
Ccc_XD0_XDFFQ_S_XD1_nt XD0_XDFFQ_S XD1_nt 1.21e-17
* device instance cc_XD0_XDFFQ_S_XD1_t1 r0 *1 0,0
Ccc_XD0_XDFFQ_S_XD1_t1 XD0_XDFFQ_S XD1_t1 1.21e-17
* device instance cc_XD0_XDFFQ_S_XD2_XDFFM_CLKB r0 *1 0,0
Ccc_XD0_XDFFQ_S_XD2_XDFFM_CLKB XD0_XDFFQ_S XD2_XDFFM_CLKB 1.8151e-17
* device instance cc_XD0_XDFFQ_S_XD2_XDFFM_M r0 *1 0,0
Ccc_XD0_XDFFQ_S_XD2_XDFFM_M XD0_XDFFQ_S XD2_XDFFM_M 2.4201e-17
* device instance cc_XD0_XDFFQ_S_XD2_XDFFM_MB r0 *1 0,0
Ccc_XD0_XDFFQ_S_XD2_XDFFM_MB XD0_XDFFQ_S XD2_XDFFM_MB 1.21e-17
* device instance cc_XD0_XDFFQ_S_XD2_XDFFM_S r0 *1 0,0
Ccc_XD0_XDFFQ_S_XD2_XDFFM_S XD0_XDFFQ_S XD2_XDFFM_S 1.8151e-17
* device instance cc_XD0_XDFFQ_S_XD2_XDFFM_SB r0 *1 0,0
Ccc_XD0_XDFFQ_S_XD2_XDFFM_SB XD0_XDFFQ_S XD2_XDFFM_SB 1.8151e-17
* device instance cc_XD0_XDFFQ_S_XD2_XDFFQ_CLKB r0 *1 0,0
Ccc_XD0_XDFFQ_S_XD2_XDFFQ_CLKB XD0_XDFFQ_S XD2_XDFFQ_CLKB 1.8151e-17
* device instance cc_XD0_XDFFQ_S_XD2_XDFFQ_M r0 *1 0,0
Ccc_XD0_XDFFQ_S_XD2_XDFFQ_M XD0_XDFFQ_S XD2_XDFFQ_M 2.4201e-17
* device instance cc_XD0_XDFFQ_S_XD2_XDFFQ_MB r0 *1 0,0
Ccc_XD0_XDFFQ_S_XD2_XDFFQ_MB XD0_XDFFQ_S XD2_XDFFQ_MB 1.21e-17
* device instance cc_XD0_XDFFQ_S_XD2_XDFFQ_S r0 *1 0,0
Ccc_XD0_XDFFQ_S_XD2_XDFFQ_S XD0_XDFFQ_S XD2_XDFFQ_S 1.8151e-17
* device instance cc_XD0_XDFFQ_S_XD2_XDFFQ_SB r0 *1 0,0
Ccc_XD0_XDFFQ_S_XD2_XDFFQ_SB XD0_XDFFQ_S XD2_XDFFQ_SB 1.8151e-17
* device instance cc_XD0_XDFFQ_S_XD2_XN2_mid1 r0 *1 0,0
Ccc_XD0_XDFFQ_S_XD2_XN2_mid1 XD0_XDFFQ_S XD2_XN2_mid1 1.21e-17
* device instance cc_XD0_XDFFQ_S_XD2_XN3_mid1 r0 *1 0,0
Ccc_XD0_XDFFQ_S_XD2_XN3_mid1 XD0_XDFFQ_S XD2_XN3_mid1 1.21e-17
* device instance cc_XD0_XDFFQ_S_XD2_XN3_mid2 r0 *1 0,0
Ccc_XD0_XDFFQ_S_XD2_XN3_mid2 XD0_XDFFQ_S XD2_XN3_mid2 1.21e-17
* device instance cc_XD0_XDFFQ_S_XD2_dmodout r0 *1 0,0
Ccc_XD0_XDFFQ_S_XD2_dmodout XD0_XDFFQ_S XD2_dmodout 1.21e-17
* device instance cc_XD0_XDFFQ_S_XD2_dq r0 *1 0,0
Ccc_XD0_XDFFQ_S_XD2_dq XD0_XDFFQ_S XD2_dq 1.8151e-17
* device instance cc_XD0_XDFFQ_S_XD2_nm r0 *1 0,0
Ccc_XD0_XDFFQ_S_XD2_nm XD0_XDFFQ_S XD2_nm 1.21e-17
* device instance cc_XD0_XDFFQ_S_XD2_nt r0 *1 0,0
Ccc_XD0_XDFFQ_S_XD2_nt XD0_XDFFQ_S XD2_nt 1.21e-17
* device instance cc_XD0_XDFFQ_S_XD2_t1 r0 *1 0,0
Ccc_XD0_XDFFQ_S_XD2_t1 XD0_XDFFQ_S XD2_t1 1.21e-17
* device instance cc_XD0_XDFFQ_S_XD3_XDFFM_CLKB r0 *1 0,0
Ccc_XD0_XDFFQ_S_XD3_XDFFM_CLKB XD0_XDFFQ_S XD3_XDFFM_CLKB 1.8151e-17
* device instance cc_XD0_XDFFQ_S_XD3_XDFFM_M r0 *1 0,0
Ccc_XD0_XDFFQ_S_XD3_XDFFM_M XD0_XDFFQ_S XD3_XDFFM_M 2.4201e-17
* device instance cc_XD0_XDFFQ_S_XD3_XDFFM_MB r0 *1 0,0
Ccc_XD0_XDFFQ_S_XD3_XDFFM_MB XD0_XDFFQ_S XD3_XDFFM_MB 1.21e-17
* device instance cc_XD0_XDFFQ_S_XD3_XDFFM_S r0 *1 0,0
Ccc_XD0_XDFFQ_S_XD3_XDFFM_S XD0_XDFFQ_S XD3_XDFFM_S 1.8151e-17
* device instance cc_XD0_XDFFQ_S_XD3_XDFFM_SB r0 *1 0,0
Ccc_XD0_XDFFQ_S_XD3_XDFFM_SB XD0_XDFFQ_S XD3_XDFFM_SB 1.8151e-17
* device instance cc_XD0_XDFFQ_S_XD3_XDFFQ_CLKB r0 *1 0,0
Ccc_XD0_XDFFQ_S_XD3_XDFFQ_CLKB XD0_XDFFQ_S XD3_XDFFQ_CLKB 1.8151e-17
* device instance cc_XD0_XDFFQ_S_XD3_XDFFQ_M r0 *1 0,0
Ccc_XD0_XDFFQ_S_XD3_XDFFQ_M XD0_XDFFQ_S XD3_XDFFQ_M 2.4201e-17
* device instance cc_XD0_XDFFQ_S_XD3_XDFFQ_MB r0 *1 0,0
Ccc_XD0_XDFFQ_S_XD3_XDFFQ_MB XD0_XDFFQ_S XD3_XDFFQ_MB 1.21e-17
* device instance cc_XD0_XDFFQ_S_XD3_XDFFQ_S r0 *1 0,0
Ccc_XD0_XDFFQ_S_XD3_XDFFQ_S XD0_XDFFQ_S XD3_XDFFQ_S 1.8151e-17
* device instance cc_XD0_XDFFQ_S_XD3_XDFFQ_SB r0 *1 0,0
Ccc_XD0_XDFFQ_S_XD3_XDFFQ_SB XD0_XDFFQ_S XD3_XDFFQ_SB 1.8151e-17
* device instance cc_XD0_XDFFQ_S_XD3_XN2_mid1 r0 *1 0,0
Ccc_XD0_XDFFQ_S_XD3_XN2_mid1 XD0_XDFFQ_S XD3_XN2_mid1 1.21e-17
* device instance cc_XD0_XDFFQ_S_XD3_XN3_mid1 r0 *1 0,0
Ccc_XD0_XDFFQ_S_XD3_XN3_mid1 XD0_XDFFQ_S XD3_XN3_mid1 1.21e-17
* device instance cc_XD0_XDFFQ_S_XD3_XN3_mid2 r0 *1 0,0
Ccc_XD0_XDFFQ_S_XD3_XN3_mid2 XD0_XDFFQ_S XD3_XN3_mid2 1.21e-17
* device instance cc_XD0_XDFFQ_S_XD3_dmodout r0 *1 0,0
Ccc_XD0_XDFFQ_S_XD3_dmodout XD0_XDFFQ_S XD3_dmodout 1.21e-17
* device instance cc_XD0_XDFFQ_S_XD3_dq r0 *1 0,0
Ccc_XD0_XDFFQ_S_XD3_dq XD0_XDFFQ_S XD3_dq 1.8151e-17
* device instance cc_XD0_XDFFQ_S_XD3_nm r0 *1 0,0
Ccc_XD0_XDFFQ_S_XD3_nm XD0_XDFFQ_S XD3_nm 1.21e-17
* device instance cc_XD0_XDFFQ_S_XD3_nt r0 *1 0,0
Ccc_XD0_XDFFQ_S_XD3_nt XD0_XDFFQ_S XD3_nt 1.21e-17
* device instance cc_XD0_XDFFQ_S_XD3_t1 r0 *1 0,0
Ccc_XD0_XDFFQ_S_XD3_t1 XD0_XDFFQ_S XD3_t1 1.21e-17
* device instance cc_XD0_XDFFQ_S_XD4_XDFFM_CLKB r0 *1 0,0
Ccc_XD0_XDFFQ_S_XD4_XDFFM_CLKB XD0_XDFFQ_S XD4_XDFFM_CLKB 1.8151e-17
* device instance cc_XD0_XDFFQ_S_XD4_XDFFM_M r0 *1 0,0
Ccc_XD0_XDFFQ_S_XD4_XDFFM_M XD0_XDFFQ_S XD4_XDFFM_M 2.4201e-17
* device instance cc_XD0_XDFFQ_S_XD4_XDFFM_MB r0 *1 0,0
Ccc_XD0_XDFFQ_S_XD4_XDFFM_MB XD0_XDFFQ_S XD4_XDFFM_MB 1.21e-17
* device instance cc_XD0_XDFFQ_S_XD4_XDFFM_S r0 *1 0,0
Ccc_XD0_XDFFQ_S_XD4_XDFFM_S XD0_XDFFQ_S XD4_XDFFM_S 1.8151e-17
* device instance cc_XD0_XDFFQ_S_XD4_XDFFM_SB r0 *1 0,0
Ccc_XD0_XDFFQ_S_XD4_XDFFM_SB XD0_XDFFQ_S XD4_XDFFM_SB 1.8151e-17
* device instance cc_XD0_XDFFQ_S_XD4_XDFFQ_CLKB r0 *1 0,0
Ccc_XD0_XDFFQ_S_XD4_XDFFQ_CLKB XD0_XDFFQ_S XD4_XDFFQ_CLKB 1.8151e-17
* device instance cc_XD0_XDFFQ_S_XD4_XDFFQ_M r0 *1 0,0
Ccc_XD0_XDFFQ_S_XD4_XDFFQ_M XD0_XDFFQ_S XD4_XDFFQ_M 2.4201e-17
* device instance cc_XD0_XDFFQ_S_XD4_XDFFQ_MB r0 *1 0,0
Ccc_XD0_XDFFQ_S_XD4_XDFFQ_MB XD0_XDFFQ_S XD4_XDFFQ_MB 1.21e-17
* device instance cc_XD0_XDFFQ_S_XD4_XDFFQ_S r0 *1 0,0
Ccc_XD0_XDFFQ_S_XD4_XDFFQ_S XD0_XDFFQ_S XD4_XDFFQ_S 1.8151e-17
* device instance cc_XD0_XDFFQ_S_XD4_XDFFQ_SB r0 *1 0,0
Ccc_XD0_XDFFQ_S_XD4_XDFFQ_SB XD0_XDFFQ_S XD4_XDFFQ_SB 1.8151e-17
* device instance cc_XD0_XDFFQ_S_XD4_XN2_mid1 r0 *1 0,0
Ccc_XD0_XDFFQ_S_XD4_XN2_mid1 XD0_XDFFQ_S XD4_XN2_mid1 1.21e-17
* device instance cc_XD0_XDFFQ_S_XD4_XN3_mid1 r0 *1 0,0
Ccc_XD0_XDFFQ_S_XD4_XN3_mid1 XD0_XDFFQ_S XD4_XN3_mid1 1.21e-17
* device instance cc_XD0_XDFFQ_S_XD4_XN3_mid2 r0 *1 0,0
Ccc_XD0_XDFFQ_S_XD4_XN3_mid2 XD0_XDFFQ_S XD4_XN3_mid2 1.21e-17
* device instance cc_XD0_XDFFQ_S_XD4_dmodout r0 *1 0,0
Ccc_XD0_XDFFQ_S_XD4_dmodout XD0_XDFFQ_S XD4_dmodout 1.21e-17
* device instance cc_XD0_XDFFQ_S_XD4_dq r0 *1 0,0
Ccc_XD0_XDFFQ_S_XD4_dq XD0_XDFFQ_S XD4_dq 1.8151e-17
* device instance cc_XD0_XDFFQ_S_XD4_nm r0 *1 0,0
Ccc_XD0_XDFFQ_S_XD4_nm XD0_XDFFQ_S XD4_nm 1.21e-17
* device instance cc_XD0_XDFFQ_S_XD4_nt r0 *1 0,0
Ccc_XD0_XDFFQ_S_XD4_nt XD0_XDFFQ_S XD4_nt 1.21e-17
* device instance cc_XD0_XDFFQ_S_XD4_t1 r0 *1 0,0
Ccc_XD0_XDFFQ_S_XD4_t1 XD0_XDFFQ_S XD4_t1 1.21e-17
* device instance cc_XD0_XDFFQ_S_XD5_XDFFM_CLKB r0 *1 0,0
Ccc_XD0_XDFFQ_S_XD5_XDFFM_CLKB XD0_XDFFQ_S XD5_XDFFM_CLKB 1.8151e-17
* device instance cc_XD0_XDFFQ_S_XD5_XDFFM_M r0 *1 0,0
Ccc_XD0_XDFFQ_S_XD5_XDFFM_M XD0_XDFFQ_S XD5_XDFFM_M 2.4201e-17
* device instance cc_XD0_XDFFQ_S_XD5_XDFFM_MB r0 *1 0,0
Ccc_XD0_XDFFQ_S_XD5_XDFFM_MB XD0_XDFFQ_S XD5_XDFFM_MB 1.21e-17
* device instance cc_XD0_XDFFQ_S_XD5_XDFFM_S r0 *1 0,0
Ccc_XD0_XDFFQ_S_XD5_XDFFM_S XD0_XDFFQ_S XD5_XDFFM_S 1.8151e-17
* device instance cc_XD0_XDFFQ_S_XD5_XDFFM_SB r0 *1 0,0
Ccc_XD0_XDFFQ_S_XD5_XDFFM_SB XD0_XDFFQ_S XD5_XDFFM_SB 1.8151e-17
* device instance cc_XD0_XDFFQ_S_XD5_XDFFQ_CLKB r0 *1 0,0
Ccc_XD0_XDFFQ_S_XD5_XDFFQ_CLKB XD0_XDFFQ_S XD5_XDFFQ_CLKB 1.8151e-17
* device instance cc_XD0_XDFFQ_S_XD5_XDFFQ_M r0 *1 0,0
Ccc_XD0_XDFFQ_S_XD5_XDFFQ_M XD0_XDFFQ_S XD5_XDFFQ_M 2.4201e-17
* device instance cc_XD0_XDFFQ_S_XD5_XDFFQ_MB r0 *1 0,0
Ccc_XD0_XDFFQ_S_XD5_XDFFQ_MB XD0_XDFFQ_S XD5_XDFFQ_MB 1.21e-17
* device instance cc_XD0_XDFFQ_S_XD5_XDFFQ_S r0 *1 0,0
Ccc_XD0_XDFFQ_S_XD5_XDFFQ_S XD0_XDFFQ_S XD5_XDFFQ_S 1.8151e-17
* device instance cc_XD0_XDFFQ_S_XD5_XDFFQ_SB r0 *1 0,0
Ccc_XD0_XDFFQ_S_XD5_XDFFQ_SB XD0_XDFFQ_S XD5_XDFFQ_SB 1.8151e-17
* device instance cc_XD0_XDFFQ_S_XD5_XN2_mid1 r0 *1 0,0
Ccc_XD0_XDFFQ_S_XD5_XN2_mid1 XD0_XDFFQ_S XD5_XN2_mid1 1.21e-17
* device instance cc_XD0_XDFFQ_S_XD5_XN3_mid1 r0 *1 0,0
Ccc_XD0_XDFFQ_S_XD5_XN3_mid1 XD0_XDFFQ_S XD5_XN3_mid1 1.21e-17
* device instance cc_XD0_XDFFQ_S_XD5_XN3_mid2 r0 *1 0,0
Ccc_XD0_XDFFQ_S_XD5_XN3_mid2 XD0_XDFFQ_S XD5_XN3_mid2 1.21e-17
* device instance cc_XD0_XDFFQ_S_XD5_dmodout r0 *1 0,0
Ccc_XD0_XDFFQ_S_XD5_dmodout XD0_XDFFQ_S XD5_dmodout 1.21e-17
* device instance cc_XD0_XDFFQ_S_XD5_dq r0 *1 0,0
Ccc_XD0_XDFFQ_S_XD5_dq XD0_XDFFQ_S XD5_dq 1.8151e-17
* device instance cc_XD0_XDFFQ_S_XD5_nm r0 *1 0,0
Ccc_XD0_XDFFQ_S_XD5_nm XD0_XDFFQ_S XD5_nm 1.21e-17
* device instance cc_XD0_XDFFQ_S_XD5_nt r0 *1 0,0
Ccc_XD0_XDFFQ_S_XD5_nt XD0_XDFFQ_S XD5_nt 1.21e-17
* device instance cc_XD0_XDFFQ_S_XD5_t1 r0 *1 0,0
Ccc_XD0_XDFFQ_S_XD5_t1 XD0_XDFFQ_S XD5_t1 1.21e-17
* device instance cc_XD0_XDFFQ_S_XFRT_CLKB r0 *1 0,0
Ccc_XD0_XDFFQ_S_XFRT_CLKB XD0_XDFFQ_S XFRT_CLKB 1.8151e-17
* device instance cc_XD0_XDFFQ_S_XFRT_M r0 *1 0,0
Ccc_XD0_XDFFQ_S_XFRT_M XD0_XDFFQ_S XFRT_M 2.4201e-17
* device instance cc_XD0_XDFFQ_S_XFRT_MB r0 *1 0,0
Ccc_XD0_XDFFQ_S_XFRT_MB XD0_XDFFQ_S XFRT_MB 1.21e-17
* device instance cc_XD0_XDFFQ_S_XFRT_S r0 *1 0,0
Ccc_XD0_XDFFQ_S_XFRT_S XD0_XDFFQ_S XFRT_S 1.8151e-17
* device instance cc_XD0_XDFFQ_S_XFRT_SB r0 *1 0,0
Ccc_XD0_XDFFQ_S_XFRT_SB XD0_XDFFQ_S XFRT_SB 1.8151e-17
* device instance cc_XD0_XDFFQ_S_ck1 r0 *1 0,0
Ccc_XD0_XDFFQ_S_ck1 XD0_XDFFQ_S ck1 5.4452e-17
* device instance cc_XD0_XDFFQ_S_ck2 r0 *1 0,0
Ccc_XD0_XDFFQ_S_ck2 XD0_XDFFQ_S ck2 5.4452e-17
* device instance cc_XD0_XDFFQ_S_ck3 r0 *1 0,0
Ccc_XD0_XDFFQ_S_ck3 XD0_XDFFQ_S ck3 5.4452e-17
* device instance cc_XD0_XDFFQ_S_ck4 r0 *1 0,0
Ccc_XD0_XDFFQ_S_ck4 XD0_XDFFQ_S ck4 5.4452e-17
* device instance cc_XD0_XDFFQ_S_ck5 r0 *1 0,0
Ccc_XD0_XDFFQ_S_ck5 XD0_XDFFQ_S ck5 5.4452e-17
* device instance cc_XD0_XDFFQ_S_mod0 r0 *1 0,0
Ccc_XD0_XDFFQ_S_mod0 XD0_XDFFQ_S mod0 2.4201e-17
* device instance cc_XD0_XDFFQ_S_mod1 r0 *1 0,0
Ccc_XD0_XDFFQ_S_mod1 XD0_XDFFQ_S mod1 2.4201e-17
* device instance cc_XD0_XDFFQ_S_mod2 r0 *1 0,0
Ccc_XD0_XDFFQ_S_mod2 XD0_XDFFQ_S mod2 2.4201e-17
* device instance cc_XD0_XDFFQ_S_mod3 r0 *1 0,0
Ccc_XD0_XDFFQ_S_mod3 XD0_XDFFQ_S mod3 2.4201e-17
* device instance cc_XD0_XDFFQ_S_mod4 r0 *1 0,0
Ccc_XD0_XDFFQ_S_mod4 XD0_XDFFQ_S mod4 2.4201e-17
* device instance cc_XD0_XDFFQ_S_net1 r0 *1 0,0
Ccc_XD0_XDFFQ_S_net1 XD0_XDFFQ_S net1 1.21e-17
* device instance cc_XD0_XDFFQ_SB_XD0_XN2_mid1 r0 *1 0,0
Ccc_XD0_XDFFQ_SB_XD0_XN2_mid1 XD0_XDFFQ_SB XD0_XN2_mid1 1.21e-17
* device instance cc_XD0_XDFFQ_SB_XD0_XNOR_midp r0 *1 0,0
Ccc_XD0_XDFFQ_SB_XD0_XNOR_midp XD0_XDFFQ_SB XD0_XNOR_midp 1.21e-17
* device instance cc_XD0_XDFFQ_SB_XD0_dmodout r0 *1 0,0
Ccc_XD0_XDFFQ_SB_XD0_dmodout XD0_XDFFQ_SB XD0_dmodout 1.21e-17
* device instance cc_XD0_XDFFQ_SB_XD0_dq r0 *1 0,0
Ccc_XD0_XDFFQ_SB_XD0_dq XD0_XDFFQ_SB XD0_dq 1.21e-17
* device instance cc_XD0_XDFFQ_SB_XD0_nm r0 *1 0,0
Ccc_XD0_XDFFQ_SB_XD0_nm XD0_XDFFQ_SB XD0_nm 1.21e-17
* device instance cc_XD0_XDFFQ_SB_XD0_nt r0 *1 0,0
Ccc_XD0_XDFFQ_SB_XD0_nt XD0_XDFFQ_SB XD0_nt 2.4201e-17
* device instance cc_XD0_XDFFQ_SB_XD0_t1 r0 *1 0,0
Ccc_XD0_XDFFQ_SB_XD0_t1 XD0_XDFFQ_SB XD0_t1 1.21e-17
* device instance cc_XD0_XDFFQ_SB_XD1_XDFFM_CLKB r0 *1 0,0
Ccc_XD0_XDFFQ_SB_XD1_XDFFM_CLKB XD0_XDFFQ_SB XD1_XDFFM_CLKB 1.8151e-17
* device instance cc_XD0_XDFFQ_SB_XD1_XDFFM_M r0 *1 0,0
Ccc_XD0_XDFFQ_SB_XD1_XDFFM_M XD0_XDFFQ_SB XD1_XDFFM_M 2.4201e-17
* device instance cc_XD0_XDFFQ_SB_XD1_XDFFM_MB r0 *1 0,0
Ccc_XD0_XDFFQ_SB_XD1_XDFFM_MB XD0_XDFFQ_SB XD1_XDFFM_MB 1.21e-17
* device instance cc_XD0_XDFFQ_SB_XD1_XDFFM_S r0 *1 0,0
Ccc_XD0_XDFFQ_SB_XD1_XDFFM_S XD0_XDFFQ_SB XD1_XDFFM_S 1.8151e-17
* device instance cc_XD0_XDFFQ_SB_XD1_XDFFM_SB r0 *1 0,0
Ccc_XD0_XDFFQ_SB_XD1_XDFFM_SB XD0_XDFFQ_SB XD1_XDFFM_SB 1.8151e-17
* device instance cc_XD0_XDFFQ_SB_XD1_XDFFQ_CLKB r0 *1 0,0
Ccc_XD0_XDFFQ_SB_XD1_XDFFQ_CLKB XD0_XDFFQ_SB XD1_XDFFQ_CLKB 1.8151e-17
* device instance cc_XD0_XDFFQ_SB_XD1_XDFFQ_M r0 *1 0,0
Ccc_XD0_XDFFQ_SB_XD1_XDFFQ_M XD0_XDFFQ_SB XD1_XDFFQ_M 2.4201e-17
* device instance cc_XD0_XDFFQ_SB_XD1_XDFFQ_MB r0 *1 0,0
Ccc_XD0_XDFFQ_SB_XD1_XDFFQ_MB XD0_XDFFQ_SB XD1_XDFFQ_MB 1.21e-17
* device instance cc_XD0_XDFFQ_SB_XD1_XDFFQ_S r0 *1 0,0
Ccc_XD0_XDFFQ_SB_XD1_XDFFQ_S XD0_XDFFQ_SB XD1_XDFFQ_S 1.8151e-17
* device instance cc_XD0_XDFFQ_SB_XD1_XDFFQ_SB r0 *1 0,0
Ccc_XD0_XDFFQ_SB_XD1_XDFFQ_SB XD0_XDFFQ_SB XD1_XDFFQ_SB 1.8151e-17
* device instance cc_XD0_XDFFQ_SB_XD1_XN2_mid1 r0 *1 0,0
Ccc_XD0_XDFFQ_SB_XD1_XN2_mid1 XD0_XDFFQ_SB XD1_XN2_mid1 1.21e-17
* device instance cc_XD0_XDFFQ_SB_XD1_XN3_mid1 r0 *1 0,0
Ccc_XD0_XDFFQ_SB_XD1_XN3_mid1 XD0_XDFFQ_SB XD1_XN3_mid1 1.21e-17
* device instance cc_XD0_XDFFQ_SB_XD1_XN3_mid2 r0 *1 0,0
Ccc_XD0_XDFFQ_SB_XD1_XN3_mid2 XD0_XDFFQ_SB XD1_XN3_mid2 1.21e-17
* device instance cc_XD0_XDFFQ_SB_XD1_dmodout r0 *1 0,0
Ccc_XD0_XDFFQ_SB_XD1_dmodout XD0_XDFFQ_SB XD1_dmodout 1.21e-17
* device instance cc_XD0_XDFFQ_SB_XD1_dq r0 *1 0,0
Ccc_XD0_XDFFQ_SB_XD1_dq XD0_XDFFQ_SB XD1_dq 1.8151e-17
* device instance cc_XD0_XDFFQ_SB_XD1_nm r0 *1 0,0
Ccc_XD0_XDFFQ_SB_XD1_nm XD0_XDFFQ_SB XD1_nm 1.21e-17
* device instance cc_XD0_XDFFQ_SB_XD1_nt r0 *1 0,0
Ccc_XD0_XDFFQ_SB_XD1_nt XD0_XDFFQ_SB XD1_nt 1.21e-17
* device instance cc_XD0_XDFFQ_SB_XD1_t1 r0 *1 0,0
Ccc_XD0_XDFFQ_SB_XD1_t1 XD0_XDFFQ_SB XD1_t1 1.21e-17
* device instance cc_XD0_XDFFQ_SB_XD2_XDFFM_CLKB r0 *1 0,0
Ccc_XD0_XDFFQ_SB_XD2_XDFFM_CLKB XD0_XDFFQ_SB XD2_XDFFM_CLKB 1.8151e-17
* device instance cc_XD0_XDFFQ_SB_XD2_XDFFM_M r0 *1 0,0
Ccc_XD0_XDFFQ_SB_XD2_XDFFM_M XD0_XDFFQ_SB XD2_XDFFM_M 2.4201e-17
* device instance cc_XD0_XDFFQ_SB_XD2_XDFFM_MB r0 *1 0,0
Ccc_XD0_XDFFQ_SB_XD2_XDFFM_MB XD0_XDFFQ_SB XD2_XDFFM_MB 1.21e-17
* device instance cc_XD0_XDFFQ_SB_XD2_XDFFM_S r0 *1 0,0
Ccc_XD0_XDFFQ_SB_XD2_XDFFM_S XD0_XDFFQ_SB XD2_XDFFM_S 1.8151e-17
* device instance cc_XD0_XDFFQ_SB_XD2_XDFFM_SB r0 *1 0,0
Ccc_XD0_XDFFQ_SB_XD2_XDFFM_SB XD0_XDFFQ_SB XD2_XDFFM_SB 1.8151e-17
* device instance cc_XD0_XDFFQ_SB_XD2_XDFFQ_CLKB r0 *1 0,0
Ccc_XD0_XDFFQ_SB_XD2_XDFFQ_CLKB XD0_XDFFQ_SB XD2_XDFFQ_CLKB 1.8151e-17
* device instance cc_XD0_XDFFQ_SB_XD2_XDFFQ_M r0 *1 0,0
Ccc_XD0_XDFFQ_SB_XD2_XDFFQ_M XD0_XDFFQ_SB XD2_XDFFQ_M 2.4201e-17
* device instance cc_XD0_XDFFQ_SB_XD2_XDFFQ_MB r0 *1 0,0
Ccc_XD0_XDFFQ_SB_XD2_XDFFQ_MB XD0_XDFFQ_SB XD2_XDFFQ_MB 1.21e-17
* device instance cc_XD0_XDFFQ_SB_XD2_XDFFQ_S r0 *1 0,0
Ccc_XD0_XDFFQ_SB_XD2_XDFFQ_S XD0_XDFFQ_SB XD2_XDFFQ_S 1.8151e-17
* device instance cc_XD0_XDFFQ_SB_XD2_XDFFQ_SB r0 *1 0,0
Ccc_XD0_XDFFQ_SB_XD2_XDFFQ_SB XD0_XDFFQ_SB XD2_XDFFQ_SB 1.8151e-17
* device instance cc_XD0_XDFFQ_SB_XD2_XN2_mid1 r0 *1 0,0
Ccc_XD0_XDFFQ_SB_XD2_XN2_mid1 XD0_XDFFQ_SB XD2_XN2_mid1 1.21e-17
* device instance cc_XD0_XDFFQ_SB_XD2_XN3_mid1 r0 *1 0,0
Ccc_XD0_XDFFQ_SB_XD2_XN3_mid1 XD0_XDFFQ_SB XD2_XN3_mid1 1.21e-17
* device instance cc_XD0_XDFFQ_SB_XD2_XN3_mid2 r0 *1 0,0
Ccc_XD0_XDFFQ_SB_XD2_XN3_mid2 XD0_XDFFQ_SB XD2_XN3_mid2 1.21e-17
* device instance cc_XD0_XDFFQ_SB_XD2_dmodout r0 *1 0,0
Ccc_XD0_XDFFQ_SB_XD2_dmodout XD0_XDFFQ_SB XD2_dmodout 1.21e-17
* device instance cc_XD0_XDFFQ_SB_XD2_dq r0 *1 0,0
Ccc_XD0_XDFFQ_SB_XD2_dq XD0_XDFFQ_SB XD2_dq 1.8151e-17
* device instance cc_XD0_XDFFQ_SB_XD2_nm r0 *1 0,0
Ccc_XD0_XDFFQ_SB_XD2_nm XD0_XDFFQ_SB XD2_nm 1.21e-17
* device instance cc_XD0_XDFFQ_SB_XD2_nt r0 *1 0,0
Ccc_XD0_XDFFQ_SB_XD2_nt XD0_XDFFQ_SB XD2_nt 1.21e-17
* device instance cc_XD0_XDFFQ_SB_XD2_t1 r0 *1 0,0
Ccc_XD0_XDFFQ_SB_XD2_t1 XD0_XDFFQ_SB XD2_t1 1.21e-17
* device instance cc_XD0_XDFFQ_SB_XD3_XDFFM_CLKB r0 *1 0,0
Ccc_XD0_XDFFQ_SB_XD3_XDFFM_CLKB XD0_XDFFQ_SB XD3_XDFFM_CLKB 1.8151e-17
* device instance cc_XD0_XDFFQ_SB_XD3_XDFFM_M r0 *1 0,0
Ccc_XD0_XDFFQ_SB_XD3_XDFFM_M XD0_XDFFQ_SB XD3_XDFFM_M 2.4201e-17
* device instance cc_XD0_XDFFQ_SB_XD3_XDFFM_MB r0 *1 0,0
Ccc_XD0_XDFFQ_SB_XD3_XDFFM_MB XD0_XDFFQ_SB XD3_XDFFM_MB 1.21e-17
* device instance cc_XD0_XDFFQ_SB_XD3_XDFFM_S r0 *1 0,0
Ccc_XD0_XDFFQ_SB_XD3_XDFFM_S XD0_XDFFQ_SB XD3_XDFFM_S 1.8151e-17
* device instance cc_XD0_XDFFQ_SB_XD3_XDFFM_SB r0 *1 0,0
Ccc_XD0_XDFFQ_SB_XD3_XDFFM_SB XD0_XDFFQ_SB XD3_XDFFM_SB 1.8151e-17
* device instance cc_XD0_XDFFQ_SB_XD3_XDFFQ_CLKB r0 *1 0,0
Ccc_XD0_XDFFQ_SB_XD3_XDFFQ_CLKB XD0_XDFFQ_SB XD3_XDFFQ_CLKB 1.8151e-17
* device instance cc_XD0_XDFFQ_SB_XD3_XDFFQ_M r0 *1 0,0
Ccc_XD0_XDFFQ_SB_XD3_XDFFQ_M XD0_XDFFQ_SB XD3_XDFFQ_M 2.4201e-17
* device instance cc_XD0_XDFFQ_SB_XD3_XDFFQ_MB r0 *1 0,0
Ccc_XD0_XDFFQ_SB_XD3_XDFFQ_MB XD0_XDFFQ_SB XD3_XDFFQ_MB 1.21e-17
* device instance cc_XD0_XDFFQ_SB_XD3_XDFFQ_S r0 *1 0,0
Ccc_XD0_XDFFQ_SB_XD3_XDFFQ_S XD0_XDFFQ_SB XD3_XDFFQ_S 1.8151e-17
* device instance cc_XD0_XDFFQ_SB_XD3_XDFFQ_SB r0 *1 0,0
Ccc_XD0_XDFFQ_SB_XD3_XDFFQ_SB XD0_XDFFQ_SB XD3_XDFFQ_SB 1.8151e-17
* device instance cc_XD0_XDFFQ_SB_XD3_XN2_mid1 r0 *1 0,0
Ccc_XD0_XDFFQ_SB_XD3_XN2_mid1 XD0_XDFFQ_SB XD3_XN2_mid1 1.21e-17
* device instance cc_XD0_XDFFQ_SB_XD3_XN3_mid1 r0 *1 0,0
Ccc_XD0_XDFFQ_SB_XD3_XN3_mid1 XD0_XDFFQ_SB XD3_XN3_mid1 1.21e-17
* device instance cc_XD0_XDFFQ_SB_XD3_XN3_mid2 r0 *1 0,0
Ccc_XD0_XDFFQ_SB_XD3_XN3_mid2 XD0_XDFFQ_SB XD3_XN3_mid2 1.21e-17
* device instance cc_XD0_XDFFQ_SB_XD3_dmodout r0 *1 0,0
Ccc_XD0_XDFFQ_SB_XD3_dmodout XD0_XDFFQ_SB XD3_dmodout 1.21e-17
* device instance cc_XD0_XDFFQ_SB_XD3_dq r0 *1 0,0
Ccc_XD0_XDFFQ_SB_XD3_dq XD0_XDFFQ_SB XD3_dq 1.8151e-17
* device instance cc_XD0_XDFFQ_SB_XD3_nm r0 *1 0,0
Ccc_XD0_XDFFQ_SB_XD3_nm XD0_XDFFQ_SB XD3_nm 1.21e-17
* device instance cc_XD0_XDFFQ_SB_XD3_nt r0 *1 0,0
Ccc_XD0_XDFFQ_SB_XD3_nt XD0_XDFFQ_SB XD3_nt 1.21e-17
* device instance cc_XD0_XDFFQ_SB_XD3_t1 r0 *1 0,0
Ccc_XD0_XDFFQ_SB_XD3_t1 XD0_XDFFQ_SB XD3_t1 1.21e-17
* device instance cc_XD0_XDFFQ_SB_XD4_XDFFM_CLKB r0 *1 0,0
Ccc_XD0_XDFFQ_SB_XD4_XDFFM_CLKB XD0_XDFFQ_SB XD4_XDFFM_CLKB 1.8151e-17
* device instance cc_XD0_XDFFQ_SB_XD4_XDFFM_M r0 *1 0,0
Ccc_XD0_XDFFQ_SB_XD4_XDFFM_M XD0_XDFFQ_SB XD4_XDFFM_M 2.4201e-17
* device instance cc_XD0_XDFFQ_SB_XD4_XDFFM_MB r0 *1 0,0
Ccc_XD0_XDFFQ_SB_XD4_XDFFM_MB XD0_XDFFQ_SB XD4_XDFFM_MB 1.21e-17
* device instance cc_XD0_XDFFQ_SB_XD4_XDFFM_S r0 *1 0,0
Ccc_XD0_XDFFQ_SB_XD4_XDFFM_S XD0_XDFFQ_SB XD4_XDFFM_S 1.8151e-17
* device instance cc_XD0_XDFFQ_SB_XD4_XDFFM_SB r0 *1 0,0
Ccc_XD0_XDFFQ_SB_XD4_XDFFM_SB XD0_XDFFQ_SB XD4_XDFFM_SB 1.8151e-17
* device instance cc_XD0_XDFFQ_SB_XD4_XDFFQ_CLKB r0 *1 0,0
Ccc_XD0_XDFFQ_SB_XD4_XDFFQ_CLKB XD0_XDFFQ_SB XD4_XDFFQ_CLKB 1.8151e-17
* device instance cc_XD0_XDFFQ_SB_XD4_XDFFQ_M r0 *1 0,0
Ccc_XD0_XDFFQ_SB_XD4_XDFFQ_M XD0_XDFFQ_SB XD4_XDFFQ_M 2.4201e-17
* device instance cc_XD0_XDFFQ_SB_XD4_XDFFQ_MB r0 *1 0,0
Ccc_XD0_XDFFQ_SB_XD4_XDFFQ_MB XD0_XDFFQ_SB XD4_XDFFQ_MB 1.21e-17
* device instance cc_XD0_XDFFQ_SB_XD4_XDFFQ_S r0 *1 0,0
Ccc_XD0_XDFFQ_SB_XD4_XDFFQ_S XD0_XDFFQ_SB XD4_XDFFQ_S 1.8151e-17
* device instance cc_XD0_XDFFQ_SB_XD4_XDFFQ_SB r0 *1 0,0
Ccc_XD0_XDFFQ_SB_XD4_XDFFQ_SB XD0_XDFFQ_SB XD4_XDFFQ_SB 1.8151e-17
* device instance cc_XD0_XDFFQ_SB_XD4_XN2_mid1 r0 *1 0,0
Ccc_XD0_XDFFQ_SB_XD4_XN2_mid1 XD0_XDFFQ_SB XD4_XN2_mid1 1.21e-17
* device instance cc_XD0_XDFFQ_SB_XD4_XN3_mid1 r0 *1 0,0
Ccc_XD0_XDFFQ_SB_XD4_XN3_mid1 XD0_XDFFQ_SB XD4_XN3_mid1 1.21e-17
* device instance cc_XD0_XDFFQ_SB_XD4_XN3_mid2 r0 *1 0,0
Ccc_XD0_XDFFQ_SB_XD4_XN3_mid2 XD0_XDFFQ_SB XD4_XN3_mid2 1.21e-17
* device instance cc_XD0_XDFFQ_SB_XD4_dmodout r0 *1 0,0
Ccc_XD0_XDFFQ_SB_XD4_dmodout XD0_XDFFQ_SB XD4_dmodout 1.21e-17
* device instance cc_XD0_XDFFQ_SB_XD4_dq r0 *1 0,0
Ccc_XD0_XDFFQ_SB_XD4_dq XD0_XDFFQ_SB XD4_dq 1.8151e-17
* device instance cc_XD0_XDFFQ_SB_XD4_nm r0 *1 0,0
Ccc_XD0_XDFFQ_SB_XD4_nm XD0_XDFFQ_SB XD4_nm 1.21e-17
* device instance cc_XD0_XDFFQ_SB_XD4_nt r0 *1 0,0
Ccc_XD0_XDFFQ_SB_XD4_nt XD0_XDFFQ_SB XD4_nt 1.21e-17
* device instance cc_XD0_XDFFQ_SB_XD4_t1 r0 *1 0,0
Ccc_XD0_XDFFQ_SB_XD4_t1 XD0_XDFFQ_SB XD4_t1 1.21e-17
* device instance cc_XD0_XDFFQ_SB_XD5_XDFFM_CLKB r0 *1 0,0
Ccc_XD0_XDFFQ_SB_XD5_XDFFM_CLKB XD0_XDFFQ_SB XD5_XDFFM_CLKB 1.8151e-17
* device instance cc_XD0_XDFFQ_SB_XD5_XDFFM_M r0 *1 0,0
Ccc_XD0_XDFFQ_SB_XD5_XDFFM_M XD0_XDFFQ_SB XD5_XDFFM_M 2.4201e-17
* device instance cc_XD0_XDFFQ_SB_XD5_XDFFM_MB r0 *1 0,0
Ccc_XD0_XDFFQ_SB_XD5_XDFFM_MB XD0_XDFFQ_SB XD5_XDFFM_MB 1.21e-17
* device instance cc_XD0_XDFFQ_SB_XD5_XDFFM_S r0 *1 0,0
Ccc_XD0_XDFFQ_SB_XD5_XDFFM_S XD0_XDFFQ_SB XD5_XDFFM_S 1.8151e-17
* device instance cc_XD0_XDFFQ_SB_XD5_XDFFM_SB r0 *1 0,0
Ccc_XD0_XDFFQ_SB_XD5_XDFFM_SB XD0_XDFFQ_SB XD5_XDFFM_SB 1.8151e-17
* device instance cc_XD0_XDFFQ_SB_XD5_XDFFQ_CLKB r0 *1 0,0
Ccc_XD0_XDFFQ_SB_XD5_XDFFQ_CLKB XD0_XDFFQ_SB XD5_XDFFQ_CLKB 1.8151e-17
* device instance cc_XD0_XDFFQ_SB_XD5_XDFFQ_M r0 *1 0,0
Ccc_XD0_XDFFQ_SB_XD5_XDFFQ_M XD0_XDFFQ_SB XD5_XDFFQ_M 2.4201e-17
* device instance cc_XD0_XDFFQ_SB_XD5_XDFFQ_MB r0 *1 0,0
Ccc_XD0_XDFFQ_SB_XD5_XDFFQ_MB XD0_XDFFQ_SB XD5_XDFFQ_MB 1.21e-17
* device instance cc_XD0_XDFFQ_SB_XD5_XDFFQ_S r0 *1 0,0
Ccc_XD0_XDFFQ_SB_XD5_XDFFQ_S XD0_XDFFQ_SB XD5_XDFFQ_S 1.8151e-17
* device instance cc_XD0_XDFFQ_SB_XD5_XDFFQ_SB r0 *1 0,0
Ccc_XD0_XDFFQ_SB_XD5_XDFFQ_SB XD0_XDFFQ_SB XD5_XDFFQ_SB 1.8151e-17
* device instance cc_XD0_XDFFQ_SB_XD5_XN2_mid1 r0 *1 0,0
Ccc_XD0_XDFFQ_SB_XD5_XN2_mid1 XD0_XDFFQ_SB XD5_XN2_mid1 1.21e-17
* device instance cc_XD0_XDFFQ_SB_XD5_XN3_mid1 r0 *1 0,0
Ccc_XD0_XDFFQ_SB_XD5_XN3_mid1 XD0_XDFFQ_SB XD5_XN3_mid1 1.21e-17
* device instance cc_XD0_XDFFQ_SB_XD5_XN3_mid2 r0 *1 0,0
Ccc_XD0_XDFFQ_SB_XD5_XN3_mid2 XD0_XDFFQ_SB XD5_XN3_mid2 1.21e-17
* device instance cc_XD0_XDFFQ_SB_XD5_dmodout r0 *1 0,0
Ccc_XD0_XDFFQ_SB_XD5_dmodout XD0_XDFFQ_SB XD5_dmodout 1.21e-17
* device instance cc_XD0_XDFFQ_SB_XD5_dq r0 *1 0,0
Ccc_XD0_XDFFQ_SB_XD5_dq XD0_XDFFQ_SB XD5_dq 1.8151e-17
* device instance cc_XD0_XDFFQ_SB_XD5_nm r0 *1 0,0
Ccc_XD0_XDFFQ_SB_XD5_nm XD0_XDFFQ_SB XD5_nm 1.21e-17
* device instance cc_XD0_XDFFQ_SB_XD5_nt r0 *1 0,0
Ccc_XD0_XDFFQ_SB_XD5_nt XD0_XDFFQ_SB XD5_nt 1.21e-17
* device instance cc_XD0_XDFFQ_SB_XD5_t1 r0 *1 0,0
Ccc_XD0_XDFFQ_SB_XD5_t1 XD0_XDFFQ_SB XD5_t1 1.21e-17
* device instance cc_XD0_XDFFQ_SB_XFRT_CLKB r0 *1 0,0
Ccc_XD0_XDFFQ_SB_XFRT_CLKB XD0_XDFFQ_SB XFRT_CLKB 1.8151e-17
* device instance cc_XD0_XDFFQ_SB_XFRT_M r0 *1 0,0
Ccc_XD0_XDFFQ_SB_XFRT_M XD0_XDFFQ_SB XFRT_M 2.4201e-17
* device instance cc_XD0_XDFFQ_SB_XFRT_MB r0 *1 0,0
Ccc_XD0_XDFFQ_SB_XFRT_MB XD0_XDFFQ_SB XFRT_MB 1.21e-17
* device instance cc_XD0_XDFFQ_SB_XFRT_S r0 *1 0,0
Ccc_XD0_XDFFQ_SB_XFRT_S XD0_XDFFQ_SB XFRT_S 1.8151e-17
* device instance cc_XD0_XDFFQ_SB_XFRT_SB r0 *1 0,0
Ccc_XD0_XDFFQ_SB_XFRT_SB XD0_XDFFQ_SB XFRT_SB 1.8151e-17
* device instance cc_XD0_XDFFQ_SB_ck1 r0 *1 0,0
Ccc_XD0_XDFFQ_SB_ck1 XD0_XDFFQ_SB ck1 5.4452e-17
* device instance cc_XD0_XDFFQ_SB_ck2 r0 *1 0,0
Ccc_XD0_XDFFQ_SB_ck2 XD0_XDFFQ_SB ck2 5.4452e-17
* device instance cc_XD0_XDFFQ_SB_ck3 r0 *1 0,0
Ccc_XD0_XDFFQ_SB_ck3 XD0_XDFFQ_SB ck3 5.4452e-17
* device instance cc_XD0_XDFFQ_SB_ck4 r0 *1 0,0
Ccc_XD0_XDFFQ_SB_ck4 XD0_XDFFQ_SB ck4 5.4452e-17
* device instance cc_XD0_XDFFQ_SB_ck5 r0 *1 0,0
Ccc_XD0_XDFFQ_SB_ck5 XD0_XDFFQ_SB ck5 5.4452e-17
* device instance cc_XD0_XDFFQ_SB_mod0 r0 *1 0,0
Ccc_XD0_XDFFQ_SB_mod0 XD0_XDFFQ_SB mod0 2.4201e-17
* device instance cc_XD0_XDFFQ_SB_mod1 r0 *1 0,0
Ccc_XD0_XDFFQ_SB_mod1 XD0_XDFFQ_SB mod1 2.4201e-17
* device instance cc_XD0_XDFFQ_SB_mod2 r0 *1 0,0
Ccc_XD0_XDFFQ_SB_mod2 XD0_XDFFQ_SB mod2 2.4201e-17
* device instance cc_XD0_XDFFQ_SB_mod3 r0 *1 0,0
Ccc_XD0_XDFFQ_SB_mod3 XD0_XDFFQ_SB mod3 2.4201e-17
* device instance cc_XD0_XDFFQ_SB_mod4 r0 *1 0,0
Ccc_XD0_XDFFQ_SB_mod4 XD0_XDFFQ_SB mod4 2.4201e-17
* device instance cc_XD0_XDFFQ_SB_net1 r0 *1 0,0
Ccc_XD0_XDFFQ_SB_net1 XD0_XDFFQ_SB net1 1.21e-17
* device instance cc_XD0_XN2_mid1_XD0_nm r0 *1 0,0
Ccc_XD0_XN2_mid1_XD0_nm XD0_XN2_mid1 XD0_nm 1.1294e-17
* device instance cc_XD0_XN2_mid1_ck1 r0 *1 0,0
Ccc_XD0_XN2_mid1_ck1 XD0_XN2_mid1 ck1 6.05e-18
* device instance cc_XD0_XN3_mid1_XD0_XN3_mid2 r0 *1 0,0
Ccc_XD0_XN3_mid1_XD0_XN3_mid2 XD0_XN3_mid1 XD0_XN3_mid2 1.1294e-17
* device instance cc_XD0_XN3_mid1_XD0_nt r0 *1 0,0
Ccc_XD0_XN3_mid1_XD0_nt XD0_XN3_mid1 XD0_nt 1.1294e-17
* device instance cc_XD0_XN3_mid2_net1 r0 *1 0,0
Ccc_XD0_XN3_mid2_net1 XD0_XN3_mid2 net1 6.05e-18
* device instance cc_XD0_XNOR_midp_XD0_dq r0 *1 0,0
Ccc_XD0_XNOR_midp_XD0_dq XD0_XNOR_midp XD0_dq 5.244e-18
* device instance cc_XD0_XNOR_midp_XD0_t1 r0 *1 0,0
Ccc_XD0_XNOR_midp_XD0_t1 XD0_XNOR_midp XD0_t1 6.05e-18
* device instance cc_XD0_dmodout_XD0_dq r0 *1 0,0
Ccc_XD0_dmodout_XD0_dq XD0_dmodout XD0_dq 1.21e-17
* device instance cc_XD0_dmodout_XD0_nm r0 *1 0,0
Ccc_XD0_dmodout_XD0_nm XD0_dmodout XD0_nm 1.8151e-17
* device instance cc_XD0_dmodout_XD0_nt r0 *1 0,0
Ccc_XD0_dmodout_XD0_nt XD0_dmodout XD0_nt 2.4201e-17
* device instance cc_XD0_dmodout_XD0_t1 r0 *1 0,0
Ccc_XD0_dmodout_XD0_t1 XD0_dmodout XD0_t1 1.21e-17
* device instance cc_XD0_dmodout_XD1_XDFFM_CLKB r0 *1 0,0
Ccc_XD0_dmodout_XD1_XDFFM_CLKB XD0_dmodout XD1_XDFFM_CLKB 1.8151e-17
* device instance cc_XD0_dmodout_XD1_XDFFM_M r0 *1 0,0
Ccc_XD0_dmodout_XD1_XDFFM_M XD0_dmodout XD1_XDFFM_M 2.4201e-17
* device instance cc_XD0_dmodout_XD1_XDFFM_MB r0 *1 0,0
Ccc_XD0_dmodout_XD1_XDFFM_MB XD0_dmodout XD1_XDFFM_MB 1.21e-17
* device instance cc_XD0_dmodout_XD1_XDFFM_S r0 *1 0,0
Ccc_XD0_dmodout_XD1_XDFFM_S XD0_dmodout XD1_XDFFM_S 1.8151e-17
* device instance cc_XD0_dmodout_XD1_XDFFM_SB r0 *1 0,0
Ccc_XD0_dmodout_XD1_XDFFM_SB XD0_dmodout XD1_XDFFM_SB 1.8151e-17
* device instance cc_XD0_dmodout_XD1_XDFFQ_CLKB r0 *1 0,0
Ccc_XD0_dmodout_XD1_XDFFQ_CLKB XD0_dmodout XD1_XDFFQ_CLKB 1.8151e-17
* device instance cc_XD0_dmodout_XD1_XDFFQ_M r0 *1 0,0
Ccc_XD0_dmodout_XD1_XDFFQ_M XD0_dmodout XD1_XDFFQ_M 2.4201e-17
* device instance cc_XD0_dmodout_XD1_XDFFQ_MB r0 *1 0,0
Ccc_XD0_dmodout_XD1_XDFFQ_MB XD0_dmodout XD1_XDFFQ_MB 1.21e-17
* device instance cc_XD0_dmodout_XD1_XDFFQ_S r0 *1 0,0
Ccc_XD0_dmodout_XD1_XDFFQ_S XD0_dmodout XD1_XDFFQ_S 1.8151e-17
* device instance cc_XD0_dmodout_XD1_XDFFQ_SB r0 *1 0,0
Ccc_XD0_dmodout_XD1_XDFFQ_SB XD0_dmodout XD1_XDFFQ_SB 1.8151e-17
* device instance cc_XD0_dmodout_XD1_XN2_mid1 r0 *1 0,0
Ccc_XD0_dmodout_XD1_XN2_mid1 XD0_dmodout XD1_XN2_mid1 1.21e-17
* device instance cc_XD0_dmodout_XD1_XN3_mid1 r0 *1 0,0
Ccc_XD0_dmodout_XD1_XN3_mid1 XD0_dmodout XD1_XN3_mid1 1.21e-17
* device instance cc_XD0_dmodout_XD1_XN3_mid2 r0 *1 0,0
Ccc_XD0_dmodout_XD1_XN3_mid2 XD0_dmodout XD1_XN3_mid2 1.21e-17
* device instance cc_XD0_dmodout_XD1_dmodout r0 *1 0,0
Ccc_XD0_dmodout_XD1_dmodout XD0_dmodout XD1_dmodout 1.21e-17
* device instance cc_XD0_dmodout_XD1_dq r0 *1 0,0
Ccc_XD0_dmodout_XD1_dq XD0_dmodout XD1_dq 1.8151e-17
* device instance cc_XD0_dmodout_XD1_nm r0 *1 0,0
Ccc_XD0_dmodout_XD1_nm XD0_dmodout XD1_nm 1.21e-17
* device instance cc_XD0_dmodout_XD1_nt r0 *1 0,0
Ccc_XD0_dmodout_XD1_nt XD0_dmodout XD1_nt 1.21e-17
* device instance cc_XD0_dmodout_XD1_t1 r0 *1 0,0
Ccc_XD0_dmodout_XD1_t1 XD0_dmodout XD1_t1 1.21e-17
* device instance cc_XD0_dmodout_XD2_XDFFM_CLKB r0 *1 0,0
Ccc_XD0_dmodout_XD2_XDFFM_CLKB XD0_dmodout XD2_XDFFM_CLKB 1.8151e-17
* device instance cc_XD0_dmodout_XD2_XDFFM_M r0 *1 0,0
Ccc_XD0_dmodout_XD2_XDFFM_M XD0_dmodout XD2_XDFFM_M 2.4201e-17
* device instance cc_XD0_dmodout_XD2_XDFFM_MB r0 *1 0,0
Ccc_XD0_dmodout_XD2_XDFFM_MB XD0_dmodout XD2_XDFFM_MB 1.21e-17
* device instance cc_XD0_dmodout_XD2_XDFFM_S r0 *1 0,0
Ccc_XD0_dmodout_XD2_XDFFM_S XD0_dmodout XD2_XDFFM_S 1.8151e-17
* device instance cc_XD0_dmodout_XD2_XDFFM_SB r0 *1 0,0
Ccc_XD0_dmodout_XD2_XDFFM_SB XD0_dmodout XD2_XDFFM_SB 1.8151e-17
* device instance cc_XD0_dmodout_XD2_XDFFQ_CLKB r0 *1 0,0
Ccc_XD0_dmodout_XD2_XDFFQ_CLKB XD0_dmodout XD2_XDFFQ_CLKB 1.8151e-17
* device instance cc_XD0_dmodout_XD2_XDFFQ_M r0 *1 0,0
Ccc_XD0_dmodout_XD2_XDFFQ_M XD0_dmodout XD2_XDFFQ_M 2.4201e-17
* device instance cc_XD0_dmodout_XD2_XDFFQ_MB r0 *1 0,0
Ccc_XD0_dmodout_XD2_XDFFQ_MB XD0_dmodout XD2_XDFFQ_MB 1.21e-17
* device instance cc_XD0_dmodout_XD2_XDFFQ_S r0 *1 0,0
Ccc_XD0_dmodout_XD2_XDFFQ_S XD0_dmodout XD2_XDFFQ_S 1.8151e-17
* device instance cc_XD0_dmodout_XD2_XDFFQ_SB r0 *1 0,0
Ccc_XD0_dmodout_XD2_XDFFQ_SB XD0_dmodout XD2_XDFFQ_SB 1.8151e-17
* device instance cc_XD0_dmodout_XD2_XN2_mid1 r0 *1 0,0
Ccc_XD0_dmodout_XD2_XN2_mid1 XD0_dmodout XD2_XN2_mid1 1.21e-17
* device instance cc_XD0_dmodout_XD2_XN3_mid1 r0 *1 0,0
Ccc_XD0_dmodout_XD2_XN3_mid1 XD0_dmodout XD2_XN3_mid1 1.21e-17
* device instance cc_XD0_dmodout_XD2_XN3_mid2 r0 *1 0,0
Ccc_XD0_dmodout_XD2_XN3_mid2 XD0_dmodout XD2_XN3_mid2 1.21e-17
* device instance cc_XD0_dmodout_XD2_dmodout r0 *1 0,0
Ccc_XD0_dmodout_XD2_dmodout XD0_dmodout XD2_dmodout 1.21e-17
* device instance cc_XD0_dmodout_XD2_dq r0 *1 0,0
Ccc_XD0_dmodout_XD2_dq XD0_dmodout XD2_dq 1.8151e-17
* device instance cc_XD0_dmodout_XD2_nm r0 *1 0,0
Ccc_XD0_dmodout_XD2_nm XD0_dmodout XD2_nm 1.21e-17
* device instance cc_XD0_dmodout_XD2_nt r0 *1 0,0
Ccc_XD0_dmodout_XD2_nt XD0_dmodout XD2_nt 1.21e-17
* device instance cc_XD0_dmodout_XD2_t1 r0 *1 0,0
Ccc_XD0_dmodout_XD2_t1 XD0_dmodout XD2_t1 1.21e-17
* device instance cc_XD0_dmodout_XD3_XDFFM_CLKB r0 *1 0,0
Ccc_XD0_dmodout_XD3_XDFFM_CLKB XD0_dmodout XD3_XDFFM_CLKB 1.8151e-17
* device instance cc_XD0_dmodout_XD3_XDFFM_M r0 *1 0,0
Ccc_XD0_dmodout_XD3_XDFFM_M XD0_dmodout XD3_XDFFM_M 2.4201e-17
* device instance cc_XD0_dmodout_XD3_XDFFM_MB r0 *1 0,0
Ccc_XD0_dmodout_XD3_XDFFM_MB XD0_dmodout XD3_XDFFM_MB 1.21e-17
* device instance cc_XD0_dmodout_XD3_XDFFM_S r0 *1 0,0
Ccc_XD0_dmodout_XD3_XDFFM_S XD0_dmodout XD3_XDFFM_S 1.8151e-17
* device instance cc_XD0_dmodout_XD3_XDFFM_SB r0 *1 0,0
Ccc_XD0_dmodout_XD3_XDFFM_SB XD0_dmodout XD3_XDFFM_SB 1.8151e-17
* device instance cc_XD0_dmodout_XD3_XDFFQ_CLKB r0 *1 0,0
Ccc_XD0_dmodout_XD3_XDFFQ_CLKB XD0_dmodout XD3_XDFFQ_CLKB 1.8151e-17
* device instance cc_XD0_dmodout_XD3_XDFFQ_M r0 *1 0,0
Ccc_XD0_dmodout_XD3_XDFFQ_M XD0_dmodout XD3_XDFFQ_M 2.4201e-17
* device instance cc_XD0_dmodout_XD3_XDFFQ_MB r0 *1 0,0
Ccc_XD0_dmodout_XD3_XDFFQ_MB XD0_dmodout XD3_XDFFQ_MB 1.21e-17
* device instance cc_XD0_dmodout_XD3_XDFFQ_S r0 *1 0,0
Ccc_XD0_dmodout_XD3_XDFFQ_S XD0_dmodout XD3_XDFFQ_S 1.8151e-17
* device instance cc_XD0_dmodout_XD3_XDFFQ_SB r0 *1 0,0
Ccc_XD0_dmodout_XD3_XDFFQ_SB XD0_dmodout XD3_XDFFQ_SB 1.8151e-17
* device instance cc_XD0_dmodout_XD3_XN2_mid1 r0 *1 0,0
Ccc_XD0_dmodout_XD3_XN2_mid1 XD0_dmodout XD3_XN2_mid1 1.21e-17
* device instance cc_XD0_dmodout_XD3_XN3_mid1 r0 *1 0,0
Ccc_XD0_dmodout_XD3_XN3_mid1 XD0_dmodout XD3_XN3_mid1 1.21e-17
* device instance cc_XD0_dmodout_XD3_XN3_mid2 r0 *1 0,0
Ccc_XD0_dmodout_XD3_XN3_mid2 XD0_dmodout XD3_XN3_mid2 1.21e-17
* device instance cc_XD0_dmodout_XD3_dmodout r0 *1 0,0
Ccc_XD0_dmodout_XD3_dmodout XD0_dmodout XD3_dmodout 1.21e-17
* device instance cc_XD0_dmodout_XD3_dq r0 *1 0,0
Ccc_XD0_dmodout_XD3_dq XD0_dmodout XD3_dq 1.8151e-17
* device instance cc_XD0_dmodout_XD3_nm r0 *1 0,0
Ccc_XD0_dmodout_XD3_nm XD0_dmodout XD3_nm 1.21e-17
* device instance cc_XD0_dmodout_XD3_nt r0 *1 0,0
Ccc_XD0_dmodout_XD3_nt XD0_dmodout XD3_nt 1.21e-17
* device instance cc_XD0_dmodout_XD3_t1 r0 *1 0,0
Ccc_XD0_dmodout_XD3_t1 XD0_dmodout XD3_t1 1.21e-17
* device instance cc_XD0_dmodout_XD4_XDFFM_CLKB r0 *1 0,0
Ccc_XD0_dmodout_XD4_XDFFM_CLKB XD0_dmodout XD4_XDFFM_CLKB 1.8151e-17
* device instance cc_XD0_dmodout_XD4_XDFFM_M r0 *1 0,0
Ccc_XD0_dmodout_XD4_XDFFM_M XD0_dmodout XD4_XDFFM_M 2.4201e-17
* device instance cc_XD0_dmodout_XD4_XDFFM_MB r0 *1 0,0
Ccc_XD0_dmodout_XD4_XDFFM_MB XD0_dmodout XD4_XDFFM_MB 1.21e-17
* device instance cc_XD0_dmodout_XD4_XDFFM_S r0 *1 0,0
Ccc_XD0_dmodout_XD4_XDFFM_S XD0_dmodout XD4_XDFFM_S 1.8151e-17
* device instance cc_XD0_dmodout_XD4_XDFFM_SB r0 *1 0,0
Ccc_XD0_dmodout_XD4_XDFFM_SB XD0_dmodout XD4_XDFFM_SB 1.8151e-17
* device instance cc_XD0_dmodout_XD4_XDFFQ_CLKB r0 *1 0,0
Ccc_XD0_dmodout_XD4_XDFFQ_CLKB XD0_dmodout XD4_XDFFQ_CLKB 1.8151e-17
* device instance cc_XD0_dmodout_XD4_XDFFQ_M r0 *1 0,0
Ccc_XD0_dmodout_XD4_XDFFQ_M XD0_dmodout XD4_XDFFQ_M 2.4201e-17
* device instance cc_XD0_dmodout_XD4_XDFFQ_MB r0 *1 0,0
Ccc_XD0_dmodout_XD4_XDFFQ_MB XD0_dmodout XD4_XDFFQ_MB 1.21e-17
* device instance cc_XD0_dmodout_XD4_XDFFQ_S r0 *1 0,0
Ccc_XD0_dmodout_XD4_XDFFQ_S XD0_dmodout XD4_XDFFQ_S 1.8151e-17
* device instance cc_XD0_dmodout_XD4_XDFFQ_SB r0 *1 0,0
Ccc_XD0_dmodout_XD4_XDFFQ_SB XD0_dmodout XD4_XDFFQ_SB 1.8151e-17
* device instance cc_XD0_dmodout_XD4_XN2_mid1 r0 *1 0,0
Ccc_XD0_dmodout_XD4_XN2_mid1 XD0_dmodout XD4_XN2_mid1 1.21e-17
* device instance cc_XD0_dmodout_XD4_XN3_mid1 r0 *1 0,0
Ccc_XD0_dmodout_XD4_XN3_mid1 XD0_dmodout XD4_XN3_mid1 1.21e-17
* device instance cc_XD0_dmodout_XD4_XN3_mid2 r0 *1 0,0
Ccc_XD0_dmodout_XD4_XN3_mid2 XD0_dmodout XD4_XN3_mid2 1.21e-17
* device instance cc_XD0_dmodout_XD4_dmodout r0 *1 0,0
Ccc_XD0_dmodout_XD4_dmodout XD0_dmodout XD4_dmodout 1.21e-17
* device instance cc_XD0_dmodout_XD4_dq r0 *1 0,0
Ccc_XD0_dmodout_XD4_dq XD0_dmodout XD4_dq 1.8151e-17
* device instance cc_XD0_dmodout_XD4_nm r0 *1 0,0
Ccc_XD0_dmodout_XD4_nm XD0_dmodout XD4_nm 1.21e-17
* device instance cc_XD0_dmodout_XD4_nt r0 *1 0,0
Ccc_XD0_dmodout_XD4_nt XD0_dmodout XD4_nt 1.21e-17
* device instance cc_XD0_dmodout_XD4_t1 r0 *1 0,0
Ccc_XD0_dmodout_XD4_t1 XD0_dmodout XD4_t1 1.21e-17
* device instance cc_XD0_dmodout_XD5_XDFFM_CLKB r0 *1 0,0
Ccc_XD0_dmodout_XD5_XDFFM_CLKB XD0_dmodout XD5_XDFFM_CLKB 1.8151e-17
* device instance cc_XD0_dmodout_XD5_XDFFM_M r0 *1 0,0
Ccc_XD0_dmodout_XD5_XDFFM_M XD0_dmodout XD5_XDFFM_M 2.4201e-17
* device instance cc_XD0_dmodout_XD5_XDFFM_MB r0 *1 0,0
Ccc_XD0_dmodout_XD5_XDFFM_MB XD0_dmodout XD5_XDFFM_MB 1.21e-17
* device instance cc_XD0_dmodout_XD5_XDFFM_S r0 *1 0,0
Ccc_XD0_dmodout_XD5_XDFFM_S XD0_dmodout XD5_XDFFM_S 1.8151e-17
* device instance cc_XD0_dmodout_XD5_XDFFM_SB r0 *1 0,0
Ccc_XD0_dmodout_XD5_XDFFM_SB XD0_dmodout XD5_XDFFM_SB 1.8151e-17
* device instance cc_XD0_dmodout_XD5_XDFFQ_CLKB r0 *1 0,0
Ccc_XD0_dmodout_XD5_XDFFQ_CLKB XD0_dmodout XD5_XDFFQ_CLKB 1.8151e-17
* device instance cc_XD0_dmodout_XD5_XDFFQ_M r0 *1 0,0
Ccc_XD0_dmodout_XD5_XDFFQ_M XD0_dmodout XD5_XDFFQ_M 2.4201e-17
* device instance cc_XD0_dmodout_XD5_XDFFQ_MB r0 *1 0,0
Ccc_XD0_dmodout_XD5_XDFFQ_MB XD0_dmodout XD5_XDFFQ_MB 1.21e-17
* device instance cc_XD0_dmodout_XD5_XDFFQ_S r0 *1 0,0
Ccc_XD0_dmodout_XD5_XDFFQ_S XD0_dmodout XD5_XDFFQ_S 1.8151e-17
* device instance cc_XD0_dmodout_XD5_XDFFQ_SB r0 *1 0,0
Ccc_XD0_dmodout_XD5_XDFFQ_SB XD0_dmodout XD5_XDFFQ_SB 1.8151e-17
* device instance cc_XD0_dmodout_XD5_XN2_mid1 r0 *1 0,0
Ccc_XD0_dmodout_XD5_XN2_mid1 XD0_dmodout XD5_XN2_mid1 1.21e-17
* device instance cc_XD0_dmodout_XD5_XN3_mid1 r0 *1 0,0
Ccc_XD0_dmodout_XD5_XN3_mid1 XD0_dmodout XD5_XN3_mid1 1.21e-17
* device instance cc_XD0_dmodout_XD5_XN3_mid2 r0 *1 0,0
Ccc_XD0_dmodout_XD5_XN3_mid2 XD0_dmodout XD5_XN3_mid2 1.21e-17
* device instance cc_XD0_dmodout_XD5_dmodout r0 *1 0,0
Ccc_XD0_dmodout_XD5_dmodout XD0_dmodout XD5_dmodout 1.21e-17
* device instance cc_XD0_dmodout_XD5_dq r0 *1 0,0
Ccc_XD0_dmodout_XD5_dq XD0_dmodout XD5_dq 1.8151e-17
* device instance cc_XD0_dmodout_XD5_nm r0 *1 0,0
Ccc_XD0_dmodout_XD5_nm XD0_dmodout XD5_nm 1.21e-17
* device instance cc_XD0_dmodout_XD5_nt r0 *1 0,0
Ccc_XD0_dmodout_XD5_nt XD0_dmodout XD5_nt 1.21e-17
* device instance cc_XD0_dmodout_XD5_t1 r0 *1 0,0
Ccc_XD0_dmodout_XD5_t1 XD0_dmodout XD5_t1 1.21e-17
* device instance cc_XD0_dmodout_XFRT_CLKB r0 *1 0,0
Ccc_XD0_dmodout_XFRT_CLKB XD0_dmodout XFRT_CLKB 1.8151e-17
* device instance cc_XD0_dmodout_XFRT_M r0 *1 0,0
Ccc_XD0_dmodout_XFRT_M XD0_dmodout XFRT_M 2.4201e-17
* device instance cc_XD0_dmodout_XFRT_MB r0 *1 0,0
Ccc_XD0_dmodout_XFRT_MB XD0_dmodout XFRT_MB 1.21e-17
* device instance cc_XD0_dmodout_XFRT_S r0 *1 0,0
Ccc_XD0_dmodout_XFRT_S XD0_dmodout XFRT_S 1.8151e-17
* device instance cc_XD0_dmodout_XFRT_SB r0 *1 0,0
Ccc_XD0_dmodout_XFRT_SB XD0_dmodout XFRT_SB 1.8151e-17
* device instance cc_XD0_dmodout_ck1 r0 *1 0,0
Ccc_XD0_dmodout_ck1 XD0_dmodout ck1 5.4452e-17
* device instance cc_XD0_dmodout_ck2 r0 *1 0,0
Ccc_XD0_dmodout_ck2 XD0_dmodout ck2 5.4452e-17
* device instance cc_XD0_dmodout_ck3 r0 *1 0,0
Ccc_XD0_dmodout_ck3 XD0_dmodout ck3 5.4452e-17
* device instance cc_XD0_dmodout_ck4 r0 *1 0,0
Ccc_XD0_dmodout_ck4 XD0_dmodout ck4 5.4452e-17
* device instance cc_XD0_dmodout_ck5 r0 *1 0,0
Ccc_XD0_dmodout_ck5 XD0_dmodout ck5 5.4452e-17
* device instance cc_XD0_dmodout_mod0 r0 *1 0,0
Ccc_XD0_dmodout_mod0 XD0_dmodout mod0 2.4201e-17
* device instance cc_XD0_dmodout_mod1 r0 *1 0,0
Ccc_XD0_dmodout_mod1 XD0_dmodout mod1 2.4201e-17
* device instance cc_XD0_dmodout_mod2 r0 *1 0,0
Ccc_XD0_dmodout_mod2 XD0_dmodout mod2 2.4201e-17
* device instance cc_XD0_dmodout_mod3 r0 *1 0,0
Ccc_XD0_dmodout_mod3 XD0_dmodout mod3 2.4201e-17
* device instance cc_XD0_dmodout_mod4 r0 *1 0,0
Ccc_XD0_dmodout_mod4 XD0_dmodout mod4 2.4201e-17
* device instance cc_XD0_dmodout_net1 r0 *1 0,0
Ccc_XD0_dmodout_net1 XD0_dmodout net1 1.21e-17
* device instance cc_XD0_dq_XD0_nm r0 *1 0,0
Ccc_XD0_dq_XD0_nm XD0_dq XD0_nm 1.21e-17
* device instance cc_XD0_dq_XD0_nt r0 *1 0,0
Ccc_XD0_dq_XD0_nt XD0_dq XD0_nt 2.4201e-17
* device instance cc_XD0_dq_XD0_t1 r0 *1 0,0
Ccc_XD0_dq_XD0_t1 XD0_dq XD0_t1 1.8151e-17
* device instance cc_XD0_dq_XD1_XDFFM_CLKB r0 *1 0,0
Ccc_XD0_dq_XD1_XDFFM_CLKB XD0_dq XD1_XDFFM_CLKB 1.8151e-17
* device instance cc_XD0_dq_XD1_XDFFM_M r0 *1 0,0
Ccc_XD0_dq_XD1_XDFFM_M XD0_dq XD1_XDFFM_M 2.4201e-17
* device instance cc_XD0_dq_XD1_XDFFM_MB r0 *1 0,0
Ccc_XD0_dq_XD1_XDFFM_MB XD0_dq XD1_XDFFM_MB 1.21e-17
* device instance cc_XD0_dq_XD1_XDFFM_S r0 *1 0,0
Ccc_XD0_dq_XD1_XDFFM_S XD0_dq XD1_XDFFM_S 1.8151e-17
* device instance cc_XD0_dq_XD1_XDFFM_SB r0 *1 0,0
Ccc_XD0_dq_XD1_XDFFM_SB XD0_dq XD1_XDFFM_SB 1.8151e-17
* device instance cc_XD0_dq_XD1_XDFFQ_CLKB r0 *1 0,0
Ccc_XD0_dq_XD1_XDFFQ_CLKB XD0_dq XD1_XDFFQ_CLKB 1.8151e-17
* device instance cc_XD0_dq_XD1_XDFFQ_M r0 *1 0,0
Ccc_XD0_dq_XD1_XDFFQ_M XD0_dq XD1_XDFFQ_M 2.4201e-17
* device instance cc_XD0_dq_XD1_XDFFQ_MB r0 *1 0,0
Ccc_XD0_dq_XD1_XDFFQ_MB XD0_dq XD1_XDFFQ_MB 1.21e-17
* device instance cc_XD0_dq_XD1_XDFFQ_S r0 *1 0,0
Ccc_XD0_dq_XD1_XDFFQ_S XD0_dq XD1_XDFFQ_S 1.8151e-17
* device instance cc_XD0_dq_XD1_XDFFQ_SB r0 *1 0,0
Ccc_XD0_dq_XD1_XDFFQ_SB XD0_dq XD1_XDFFQ_SB 1.8151e-17
* device instance cc_XD0_dq_XD1_XN2_mid1 r0 *1 0,0
Ccc_XD0_dq_XD1_XN2_mid1 XD0_dq XD1_XN2_mid1 1.21e-17
* device instance cc_XD0_dq_XD1_XN3_mid1 r0 *1 0,0
Ccc_XD0_dq_XD1_XN3_mid1 XD0_dq XD1_XN3_mid1 1.21e-17
* device instance cc_XD0_dq_XD1_XN3_mid2 r0 *1 0,0
Ccc_XD0_dq_XD1_XN3_mid2 XD0_dq XD1_XN3_mid2 1.21e-17
* device instance cc_XD0_dq_XD1_dmodout r0 *1 0,0
Ccc_XD0_dq_XD1_dmodout XD0_dq XD1_dmodout 1.21e-17
* device instance cc_XD0_dq_XD1_dq r0 *1 0,0
Ccc_XD0_dq_XD1_dq XD0_dq XD1_dq 1.8151e-17
* device instance cc_XD0_dq_XD1_nm r0 *1 0,0
Ccc_XD0_dq_XD1_nm XD0_dq XD1_nm 1.21e-17
* device instance cc_XD0_dq_XD1_nt r0 *1 0,0
Ccc_XD0_dq_XD1_nt XD0_dq XD1_nt 1.21e-17
* device instance cc_XD0_dq_XD1_t1 r0 *1 0,0
Ccc_XD0_dq_XD1_t1 XD0_dq XD1_t1 1.21e-17
* device instance cc_XD0_dq_XD2_XDFFM_CLKB r0 *1 0,0
Ccc_XD0_dq_XD2_XDFFM_CLKB XD0_dq XD2_XDFFM_CLKB 1.8151e-17
* device instance cc_XD0_dq_XD2_XDFFM_M r0 *1 0,0
Ccc_XD0_dq_XD2_XDFFM_M XD0_dq XD2_XDFFM_M 2.4201e-17
* device instance cc_XD0_dq_XD2_XDFFM_MB r0 *1 0,0
Ccc_XD0_dq_XD2_XDFFM_MB XD0_dq XD2_XDFFM_MB 1.21e-17
* device instance cc_XD0_dq_XD2_XDFFM_S r0 *1 0,0
Ccc_XD0_dq_XD2_XDFFM_S XD0_dq XD2_XDFFM_S 1.8151e-17
* device instance cc_XD0_dq_XD2_XDFFM_SB r0 *1 0,0
Ccc_XD0_dq_XD2_XDFFM_SB XD0_dq XD2_XDFFM_SB 1.8151e-17
* device instance cc_XD0_dq_XD2_XDFFQ_CLKB r0 *1 0,0
Ccc_XD0_dq_XD2_XDFFQ_CLKB XD0_dq XD2_XDFFQ_CLKB 1.8151e-17
* device instance cc_XD0_dq_XD2_XDFFQ_M r0 *1 0,0
Ccc_XD0_dq_XD2_XDFFQ_M XD0_dq XD2_XDFFQ_M 2.4201e-17
* device instance cc_XD0_dq_XD2_XDFFQ_MB r0 *1 0,0
Ccc_XD0_dq_XD2_XDFFQ_MB XD0_dq XD2_XDFFQ_MB 1.21e-17
* device instance cc_XD0_dq_XD2_XDFFQ_S r0 *1 0,0
Ccc_XD0_dq_XD2_XDFFQ_S XD0_dq XD2_XDFFQ_S 1.8151e-17
* device instance cc_XD0_dq_XD2_XDFFQ_SB r0 *1 0,0
Ccc_XD0_dq_XD2_XDFFQ_SB XD0_dq XD2_XDFFQ_SB 1.8151e-17
* device instance cc_XD0_dq_XD2_XN2_mid1 r0 *1 0,0
Ccc_XD0_dq_XD2_XN2_mid1 XD0_dq XD2_XN2_mid1 1.21e-17
* device instance cc_XD0_dq_XD2_XN3_mid1 r0 *1 0,0
Ccc_XD0_dq_XD2_XN3_mid1 XD0_dq XD2_XN3_mid1 1.21e-17
* device instance cc_XD0_dq_XD2_XN3_mid2 r0 *1 0,0
Ccc_XD0_dq_XD2_XN3_mid2 XD0_dq XD2_XN3_mid2 1.21e-17
* device instance cc_XD0_dq_XD2_dmodout r0 *1 0,0
Ccc_XD0_dq_XD2_dmodout XD0_dq XD2_dmodout 1.21e-17
* device instance cc_XD0_dq_XD2_dq r0 *1 0,0
Ccc_XD0_dq_XD2_dq XD0_dq XD2_dq 1.8151e-17
* device instance cc_XD0_dq_XD2_nm r0 *1 0,0
Ccc_XD0_dq_XD2_nm XD0_dq XD2_nm 1.21e-17
* device instance cc_XD0_dq_XD2_nt r0 *1 0,0
Ccc_XD0_dq_XD2_nt XD0_dq XD2_nt 1.21e-17
* device instance cc_XD0_dq_XD2_t1 r0 *1 0,0
Ccc_XD0_dq_XD2_t1 XD0_dq XD2_t1 1.21e-17
* device instance cc_XD0_dq_XD3_XDFFM_CLKB r0 *1 0,0
Ccc_XD0_dq_XD3_XDFFM_CLKB XD0_dq XD3_XDFFM_CLKB 1.8151e-17
* device instance cc_XD0_dq_XD3_XDFFM_M r0 *1 0,0
Ccc_XD0_dq_XD3_XDFFM_M XD0_dq XD3_XDFFM_M 2.4201e-17
* device instance cc_XD0_dq_XD3_XDFFM_MB r0 *1 0,0
Ccc_XD0_dq_XD3_XDFFM_MB XD0_dq XD3_XDFFM_MB 1.21e-17
* device instance cc_XD0_dq_XD3_XDFFM_S r0 *1 0,0
Ccc_XD0_dq_XD3_XDFFM_S XD0_dq XD3_XDFFM_S 1.8151e-17
* device instance cc_XD0_dq_XD3_XDFFM_SB r0 *1 0,0
Ccc_XD0_dq_XD3_XDFFM_SB XD0_dq XD3_XDFFM_SB 1.8151e-17
* device instance cc_XD0_dq_XD3_XDFFQ_CLKB r0 *1 0,0
Ccc_XD0_dq_XD3_XDFFQ_CLKB XD0_dq XD3_XDFFQ_CLKB 1.8151e-17
* device instance cc_XD0_dq_XD3_XDFFQ_M r0 *1 0,0
Ccc_XD0_dq_XD3_XDFFQ_M XD0_dq XD3_XDFFQ_M 2.4201e-17
* device instance cc_XD0_dq_XD3_XDFFQ_MB r0 *1 0,0
Ccc_XD0_dq_XD3_XDFFQ_MB XD0_dq XD3_XDFFQ_MB 1.21e-17
* device instance cc_XD0_dq_XD3_XDFFQ_S r0 *1 0,0
Ccc_XD0_dq_XD3_XDFFQ_S XD0_dq XD3_XDFFQ_S 1.8151e-17
* device instance cc_XD0_dq_XD3_XDFFQ_SB r0 *1 0,0
Ccc_XD0_dq_XD3_XDFFQ_SB XD0_dq XD3_XDFFQ_SB 1.8151e-17
* device instance cc_XD0_dq_XD3_XN2_mid1 r0 *1 0,0
Ccc_XD0_dq_XD3_XN2_mid1 XD0_dq XD3_XN2_mid1 1.21e-17
* device instance cc_XD0_dq_XD3_XN3_mid1 r0 *1 0,0
Ccc_XD0_dq_XD3_XN3_mid1 XD0_dq XD3_XN3_mid1 1.21e-17
* device instance cc_XD0_dq_XD3_XN3_mid2 r0 *1 0,0
Ccc_XD0_dq_XD3_XN3_mid2 XD0_dq XD3_XN3_mid2 1.21e-17
* device instance cc_XD0_dq_XD3_dmodout r0 *1 0,0
Ccc_XD0_dq_XD3_dmodout XD0_dq XD3_dmodout 1.21e-17
* device instance cc_XD0_dq_XD3_dq r0 *1 0,0
Ccc_XD0_dq_XD3_dq XD0_dq XD3_dq 1.8151e-17
* device instance cc_XD0_dq_XD3_nm r0 *1 0,0
Ccc_XD0_dq_XD3_nm XD0_dq XD3_nm 1.21e-17
* device instance cc_XD0_dq_XD3_nt r0 *1 0,0
Ccc_XD0_dq_XD3_nt XD0_dq XD3_nt 1.21e-17
* device instance cc_XD0_dq_XD3_t1 r0 *1 0,0
Ccc_XD0_dq_XD3_t1 XD0_dq XD3_t1 1.21e-17
* device instance cc_XD0_dq_XD4_XDFFM_CLKB r0 *1 0,0
Ccc_XD0_dq_XD4_XDFFM_CLKB XD0_dq XD4_XDFFM_CLKB 1.8151e-17
* device instance cc_XD0_dq_XD4_XDFFM_M r0 *1 0,0
Ccc_XD0_dq_XD4_XDFFM_M XD0_dq XD4_XDFFM_M 2.4201e-17
* device instance cc_XD0_dq_XD4_XDFFM_MB r0 *1 0,0
Ccc_XD0_dq_XD4_XDFFM_MB XD0_dq XD4_XDFFM_MB 1.21e-17
* device instance cc_XD0_dq_XD4_XDFFM_S r0 *1 0,0
Ccc_XD0_dq_XD4_XDFFM_S XD0_dq XD4_XDFFM_S 1.8151e-17
* device instance cc_XD0_dq_XD4_XDFFM_SB r0 *1 0,0
Ccc_XD0_dq_XD4_XDFFM_SB XD0_dq XD4_XDFFM_SB 1.8151e-17
* device instance cc_XD0_dq_XD4_XDFFQ_CLKB r0 *1 0,0
Ccc_XD0_dq_XD4_XDFFQ_CLKB XD0_dq XD4_XDFFQ_CLKB 1.8151e-17
* device instance cc_XD0_dq_XD4_XDFFQ_M r0 *1 0,0
Ccc_XD0_dq_XD4_XDFFQ_M XD0_dq XD4_XDFFQ_M 2.4201e-17
* device instance cc_XD0_dq_XD4_XDFFQ_MB r0 *1 0,0
Ccc_XD0_dq_XD4_XDFFQ_MB XD0_dq XD4_XDFFQ_MB 1.21e-17
* device instance cc_XD0_dq_XD4_XDFFQ_S r0 *1 0,0
Ccc_XD0_dq_XD4_XDFFQ_S XD0_dq XD4_XDFFQ_S 1.8151e-17
* device instance cc_XD0_dq_XD4_XDFFQ_SB r0 *1 0,0
Ccc_XD0_dq_XD4_XDFFQ_SB XD0_dq XD4_XDFFQ_SB 1.8151e-17
* device instance cc_XD0_dq_XD4_XN2_mid1 r0 *1 0,0
Ccc_XD0_dq_XD4_XN2_mid1 XD0_dq XD4_XN2_mid1 1.21e-17
* device instance cc_XD0_dq_XD4_XN3_mid1 r0 *1 0,0
Ccc_XD0_dq_XD4_XN3_mid1 XD0_dq XD4_XN3_mid1 1.21e-17
* device instance cc_XD0_dq_XD4_XN3_mid2 r0 *1 0,0
Ccc_XD0_dq_XD4_XN3_mid2 XD0_dq XD4_XN3_mid2 1.21e-17
* device instance cc_XD0_dq_XD4_dmodout r0 *1 0,0
Ccc_XD0_dq_XD4_dmodout XD0_dq XD4_dmodout 1.21e-17
* device instance cc_XD0_dq_XD4_dq r0 *1 0,0
Ccc_XD0_dq_XD4_dq XD0_dq XD4_dq 1.8151e-17
* device instance cc_XD0_dq_XD4_nm r0 *1 0,0
Ccc_XD0_dq_XD4_nm XD0_dq XD4_nm 1.21e-17
* device instance cc_XD0_dq_XD4_nt r0 *1 0,0
Ccc_XD0_dq_XD4_nt XD0_dq XD4_nt 1.21e-17
* device instance cc_XD0_dq_XD4_t1 r0 *1 0,0
Ccc_XD0_dq_XD4_t1 XD0_dq XD4_t1 1.21e-17
* device instance cc_XD0_dq_XD5_XDFFM_CLKB r0 *1 0,0
Ccc_XD0_dq_XD5_XDFFM_CLKB XD0_dq XD5_XDFFM_CLKB 1.8151e-17
* device instance cc_XD0_dq_XD5_XDFFM_M r0 *1 0,0
Ccc_XD0_dq_XD5_XDFFM_M XD0_dq XD5_XDFFM_M 2.4201e-17
* device instance cc_XD0_dq_XD5_XDFFM_MB r0 *1 0,0
Ccc_XD0_dq_XD5_XDFFM_MB XD0_dq XD5_XDFFM_MB 1.21e-17
* device instance cc_XD0_dq_XD5_XDFFM_S r0 *1 0,0
Ccc_XD0_dq_XD5_XDFFM_S XD0_dq XD5_XDFFM_S 1.8151e-17
* device instance cc_XD0_dq_XD5_XDFFM_SB r0 *1 0,0
Ccc_XD0_dq_XD5_XDFFM_SB XD0_dq XD5_XDFFM_SB 1.8151e-17
* device instance cc_XD0_dq_XD5_XDFFQ_CLKB r0 *1 0,0
Ccc_XD0_dq_XD5_XDFFQ_CLKB XD0_dq XD5_XDFFQ_CLKB 1.8151e-17
* device instance cc_XD0_dq_XD5_XDFFQ_M r0 *1 0,0
Ccc_XD0_dq_XD5_XDFFQ_M XD0_dq XD5_XDFFQ_M 2.4201e-17
* device instance cc_XD0_dq_XD5_XDFFQ_MB r0 *1 0,0
Ccc_XD0_dq_XD5_XDFFQ_MB XD0_dq XD5_XDFFQ_MB 1.21e-17
* device instance cc_XD0_dq_XD5_XDFFQ_S r0 *1 0,0
Ccc_XD0_dq_XD5_XDFFQ_S XD0_dq XD5_XDFFQ_S 1.8151e-17
* device instance cc_XD0_dq_XD5_XDFFQ_SB r0 *1 0,0
Ccc_XD0_dq_XD5_XDFFQ_SB XD0_dq XD5_XDFFQ_SB 1.8151e-17
* device instance cc_XD0_dq_XD5_XN2_mid1 r0 *1 0,0
Ccc_XD0_dq_XD5_XN2_mid1 XD0_dq XD5_XN2_mid1 1.21e-17
* device instance cc_XD0_dq_XD5_XN3_mid1 r0 *1 0,0
Ccc_XD0_dq_XD5_XN3_mid1 XD0_dq XD5_XN3_mid1 1.21e-17
* device instance cc_XD0_dq_XD5_XN3_mid2 r0 *1 0,0
Ccc_XD0_dq_XD5_XN3_mid2 XD0_dq XD5_XN3_mid2 1.21e-17
* device instance cc_XD0_dq_XD5_dmodout r0 *1 0,0
Ccc_XD0_dq_XD5_dmodout XD0_dq XD5_dmodout 1.21e-17
* device instance cc_XD0_dq_XD5_dq r0 *1 0,0
Ccc_XD0_dq_XD5_dq XD0_dq XD5_dq 1.8151e-17
* device instance cc_XD0_dq_XD5_nm r0 *1 0,0
Ccc_XD0_dq_XD5_nm XD0_dq XD5_nm 1.21e-17
* device instance cc_XD0_dq_XD5_nt r0 *1 0,0
Ccc_XD0_dq_XD5_nt XD0_dq XD5_nt 1.21e-17
* device instance cc_XD0_dq_XD5_t1 r0 *1 0,0
Ccc_XD0_dq_XD5_t1 XD0_dq XD5_t1 1.21e-17
* device instance cc_XD0_dq_XFRT_CLKB r0 *1 0,0
Ccc_XD0_dq_XFRT_CLKB XD0_dq XFRT_CLKB 1.8151e-17
* device instance cc_XD0_dq_XFRT_M r0 *1 0,0
Ccc_XD0_dq_XFRT_M XD0_dq XFRT_M 2.4201e-17
* device instance cc_XD0_dq_XFRT_MB r0 *1 0,0
Ccc_XD0_dq_XFRT_MB XD0_dq XFRT_MB 1.21e-17
* device instance cc_XD0_dq_XFRT_S r0 *1 0,0
Ccc_XD0_dq_XFRT_S XD0_dq XFRT_S 1.8151e-17
* device instance cc_XD0_dq_XFRT_SB r0 *1 0,0
Ccc_XD0_dq_XFRT_SB XD0_dq XFRT_SB 1.8151e-17
* device instance cc_XD0_dq_ck1 r0 *1 0,0
Ccc_XD0_dq_ck1 XD0_dq ck1 5.4452e-17
* device instance cc_XD0_dq_ck2 r0 *1 0,0
Ccc_XD0_dq_ck2 XD0_dq ck2 5.4452e-17
* device instance cc_XD0_dq_ck3 r0 *1 0,0
Ccc_XD0_dq_ck3 XD0_dq ck3 5.4452e-17
* device instance cc_XD0_dq_ck4 r0 *1 0,0
Ccc_XD0_dq_ck4 XD0_dq ck4 5.4452e-17
* device instance cc_XD0_dq_ck5 r0 *1 0,0
Ccc_XD0_dq_ck5 XD0_dq ck5 5.4452e-17
* device instance cc_XD0_dq_mod0 r0 *1 0,0
Ccc_XD0_dq_mod0 XD0_dq mod0 2.4201e-17
* device instance cc_XD0_dq_mod1 r0 *1 0,0
Ccc_XD0_dq_mod1 XD0_dq mod1 2.4201e-17
* device instance cc_XD0_dq_mod2 r0 *1 0,0
Ccc_XD0_dq_mod2 XD0_dq mod2 2.4201e-17
* device instance cc_XD0_dq_mod3 r0 *1 0,0
Ccc_XD0_dq_mod3 XD0_dq mod3 2.4201e-17
* device instance cc_XD0_dq_mod4 r0 *1 0,0
Ccc_XD0_dq_mod4 XD0_dq mod4 2.4201e-17
* device instance cc_XD0_dq_net1 r0 *1 0,0
Ccc_XD0_dq_net1 XD0_dq net1 1.21e-17
* device instance cc_XD0_nm_XD0_nt r0 *1 0,0
Ccc_XD0_nm_XD0_nt XD0_nm XD0_nt 2.4201e-17
* device instance cc_XD0_nm_XD0_t1 r0 *1 0,0
Ccc_XD0_nm_XD0_t1 XD0_nm XD0_t1 1.21e-17
* device instance cc_XD0_nm_XD1_XDFFM_CLKB r0 *1 0,0
Ccc_XD0_nm_XD1_XDFFM_CLKB XD0_nm XD1_XDFFM_CLKB 1.8151e-17
* device instance cc_XD0_nm_XD1_XDFFM_M r0 *1 0,0
Ccc_XD0_nm_XD1_XDFFM_M XD0_nm XD1_XDFFM_M 2.4201e-17
* device instance cc_XD0_nm_XD1_XDFFM_MB r0 *1 0,0
Ccc_XD0_nm_XD1_XDFFM_MB XD0_nm XD1_XDFFM_MB 1.21e-17
* device instance cc_XD0_nm_XD1_XDFFM_S r0 *1 0,0
Ccc_XD0_nm_XD1_XDFFM_S XD0_nm XD1_XDFFM_S 1.8151e-17
* device instance cc_XD0_nm_XD1_XDFFM_SB r0 *1 0,0
Ccc_XD0_nm_XD1_XDFFM_SB XD0_nm XD1_XDFFM_SB 1.8151e-17
* device instance cc_XD0_nm_XD1_XDFFQ_CLKB r0 *1 0,0
Ccc_XD0_nm_XD1_XDFFQ_CLKB XD0_nm XD1_XDFFQ_CLKB 1.8151e-17
* device instance cc_XD0_nm_XD1_XDFFQ_M r0 *1 0,0
Ccc_XD0_nm_XD1_XDFFQ_M XD0_nm XD1_XDFFQ_M 2.4201e-17
* device instance cc_XD0_nm_XD1_XDFFQ_MB r0 *1 0,0
Ccc_XD0_nm_XD1_XDFFQ_MB XD0_nm XD1_XDFFQ_MB 1.21e-17
* device instance cc_XD0_nm_XD1_XDFFQ_S r0 *1 0,0
Ccc_XD0_nm_XD1_XDFFQ_S XD0_nm XD1_XDFFQ_S 1.8151e-17
* device instance cc_XD0_nm_XD1_XDFFQ_SB r0 *1 0,0
Ccc_XD0_nm_XD1_XDFFQ_SB XD0_nm XD1_XDFFQ_SB 1.8151e-17
* device instance cc_XD0_nm_XD1_XN2_mid1 r0 *1 0,0
Ccc_XD0_nm_XD1_XN2_mid1 XD0_nm XD1_XN2_mid1 1.21e-17
* device instance cc_XD0_nm_XD1_XN3_mid1 r0 *1 0,0
Ccc_XD0_nm_XD1_XN3_mid1 XD0_nm XD1_XN3_mid1 1.21e-17
* device instance cc_XD0_nm_XD1_XN3_mid2 r0 *1 0,0
Ccc_XD0_nm_XD1_XN3_mid2 XD0_nm XD1_XN3_mid2 1.21e-17
* device instance cc_XD0_nm_XD1_dmodout r0 *1 0,0
Ccc_XD0_nm_XD1_dmodout XD0_nm XD1_dmodout 1.21e-17
* device instance cc_XD0_nm_XD1_dq r0 *1 0,0
Ccc_XD0_nm_XD1_dq XD0_nm XD1_dq 1.8151e-17
* device instance cc_XD0_nm_XD1_nm r0 *1 0,0
Ccc_XD0_nm_XD1_nm XD0_nm XD1_nm 1.21e-17
* device instance cc_XD0_nm_XD1_nt r0 *1 0,0
Ccc_XD0_nm_XD1_nt XD0_nm XD1_nt 1.21e-17
* device instance cc_XD0_nm_XD1_t1 r0 *1 0,0
Ccc_XD0_nm_XD1_t1 XD0_nm XD1_t1 1.21e-17
* device instance cc_XD0_nm_XD2_XDFFM_CLKB r0 *1 0,0
Ccc_XD0_nm_XD2_XDFFM_CLKB XD0_nm XD2_XDFFM_CLKB 1.8151e-17
* device instance cc_XD0_nm_XD2_XDFFM_M r0 *1 0,0
Ccc_XD0_nm_XD2_XDFFM_M XD0_nm XD2_XDFFM_M 2.4201e-17
* device instance cc_XD0_nm_XD2_XDFFM_MB r0 *1 0,0
Ccc_XD0_nm_XD2_XDFFM_MB XD0_nm XD2_XDFFM_MB 1.21e-17
* device instance cc_XD0_nm_XD2_XDFFM_S r0 *1 0,0
Ccc_XD0_nm_XD2_XDFFM_S XD0_nm XD2_XDFFM_S 1.8151e-17
* device instance cc_XD0_nm_XD2_XDFFM_SB r0 *1 0,0
Ccc_XD0_nm_XD2_XDFFM_SB XD0_nm XD2_XDFFM_SB 1.8151e-17
* device instance cc_XD0_nm_XD2_XDFFQ_CLKB r0 *1 0,0
Ccc_XD0_nm_XD2_XDFFQ_CLKB XD0_nm XD2_XDFFQ_CLKB 1.8151e-17
* device instance cc_XD0_nm_XD2_XDFFQ_M r0 *1 0,0
Ccc_XD0_nm_XD2_XDFFQ_M XD0_nm XD2_XDFFQ_M 2.4201e-17
* device instance cc_XD0_nm_XD2_XDFFQ_MB r0 *1 0,0
Ccc_XD0_nm_XD2_XDFFQ_MB XD0_nm XD2_XDFFQ_MB 1.21e-17
* device instance cc_XD0_nm_XD2_XDFFQ_S r0 *1 0,0
Ccc_XD0_nm_XD2_XDFFQ_S XD0_nm XD2_XDFFQ_S 1.8151e-17
* device instance cc_XD0_nm_XD2_XDFFQ_SB r0 *1 0,0
Ccc_XD0_nm_XD2_XDFFQ_SB XD0_nm XD2_XDFFQ_SB 1.8151e-17
* device instance cc_XD0_nm_XD2_XN2_mid1 r0 *1 0,0
Ccc_XD0_nm_XD2_XN2_mid1 XD0_nm XD2_XN2_mid1 1.21e-17
* device instance cc_XD0_nm_XD2_XN3_mid1 r0 *1 0,0
Ccc_XD0_nm_XD2_XN3_mid1 XD0_nm XD2_XN3_mid1 1.21e-17
* device instance cc_XD0_nm_XD2_XN3_mid2 r0 *1 0,0
Ccc_XD0_nm_XD2_XN3_mid2 XD0_nm XD2_XN3_mid2 1.21e-17
* device instance cc_XD0_nm_XD2_dmodout r0 *1 0,0
Ccc_XD0_nm_XD2_dmodout XD0_nm XD2_dmodout 1.21e-17
* device instance cc_XD0_nm_XD2_dq r0 *1 0,0
Ccc_XD0_nm_XD2_dq XD0_nm XD2_dq 1.8151e-17
* device instance cc_XD0_nm_XD2_nm r0 *1 0,0
Ccc_XD0_nm_XD2_nm XD0_nm XD2_nm 1.21e-17
* device instance cc_XD0_nm_XD2_nt r0 *1 0,0
Ccc_XD0_nm_XD2_nt XD0_nm XD2_nt 1.21e-17
* device instance cc_XD0_nm_XD2_t1 r0 *1 0,0
Ccc_XD0_nm_XD2_t1 XD0_nm XD2_t1 1.21e-17
* device instance cc_XD0_nm_XD3_XDFFM_CLKB r0 *1 0,0
Ccc_XD0_nm_XD3_XDFFM_CLKB XD0_nm XD3_XDFFM_CLKB 1.8151e-17
* device instance cc_XD0_nm_XD3_XDFFM_M r0 *1 0,0
Ccc_XD0_nm_XD3_XDFFM_M XD0_nm XD3_XDFFM_M 2.4201e-17
* device instance cc_XD0_nm_XD3_XDFFM_MB r0 *1 0,0
Ccc_XD0_nm_XD3_XDFFM_MB XD0_nm XD3_XDFFM_MB 1.21e-17
* device instance cc_XD0_nm_XD3_XDFFM_S r0 *1 0,0
Ccc_XD0_nm_XD3_XDFFM_S XD0_nm XD3_XDFFM_S 1.8151e-17
* device instance cc_XD0_nm_XD3_XDFFM_SB r0 *1 0,0
Ccc_XD0_nm_XD3_XDFFM_SB XD0_nm XD3_XDFFM_SB 1.8151e-17
* device instance cc_XD0_nm_XD3_XDFFQ_CLKB r0 *1 0,0
Ccc_XD0_nm_XD3_XDFFQ_CLKB XD0_nm XD3_XDFFQ_CLKB 1.8151e-17
* device instance cc_XD0_nm_XD3_XDFFQ_M r0 *1 0,0
Ccc_XD0_nm_XD3_XDFFQ_M XD0_nm XD3_XDFFQ_M 2.4201e-17
* device instance cc_XD0_nm_XD3_XDFFQ_MB r0 *1 0,0
Ccc_XD0_nm_XD3_XDFFQ_MB XD0_nm XD3_XDFFQ_MB 1.21e-17
* device instance cc_XD0_nm_XD3_XDFFQ_S r0 *1 0,0
Ccc_XD0_nm_XD3_XDFFQ_S XD0_nm XD3_XDFFQ_S 1.8151e-17
* device instance cc_XD0_nm_XD3_XDFFQ_SB r0 *1 0,0
Ccc_XD0_nm_XD3_XDFFQ_SB XD0_nm XD3_XDFFQ_SB 1.8151e-17
* device instance cc_XD0_nm_XD3_XN2_mid1 r0 *1 0,0
Ccc_XD0_nm_XD3_XN2_mid1 XD0_nm XD3_XN2_mid1 1.21e-17
* device instance cc_XD0_nm_XD3_XN3_mid1 r0 *1 0,0
Ccc_XD0_nm_XD3_XN3_mid1 XD0_nm XD3_XN3_mid1 1.21e-17
* device instance cc_XD0_nm_XD3_XN3_mid2 r0 *1 0,0
Ccc_XD0_nm_XD3_XN3_mid2 XD0_nm XD3_XN3_mid2 1.21e-17
* device instance cc_XD0_nm_XD3_dmodout r0 *1 0,0
Ccc_XD0_nm_XD3_dmodout XD0_nm XD3_dmodout 1.21e-17
* device instance cc_XD0_nm_XD3_dq r0 *1 0,0
Ccc_XD0_nm_XD3_dq XD0_nm XD3_dq 1.8151e-17
* device instance cc_XD0_nm_XD3_nm r0 *1 0,0
Ccc_XD0_nm_XD3_nm XD0_nm XD3_nm 1.21e-17
* device instance cc_XD0_nm_XD3_nt r0 *1 0,0
Ccc_XD0_nm_XD3_nt XD0_nm XD3_nt 1.21e-17
* device instance cc_XD0_nm_XD3_t1 r0 *1 0,0
Ccc_XD0_nm_XD3_t1 XD0_nm XD3_t1 1.21e-17
* device instance cc_XD0_nm_XD4_XDFFM_CLKB r0 *1 0,0
Ccc_XD0_nm_XD4_XDFFM_CLKB XD0_nm XD4_XDFFM_CLKB 1.8151e-17
* device instance cc_XD0_nm_XD4_XDFFM_M r0 *1 0,0
Ccc_XD0_nm_XD4_XDFFM_M XD0_nm XD4_XDFFM_M 2.4201e-17
* device instance cc_XD0_nm_XD4_XDFFM_MB r0 *1 0,0
Ccc_XD0_nm_XD4_XDFFM_MB XD0_nm XD4_XDFFM_MB 1.21e-17
* device instance cc_XD0_nm_XD4_XDFFM_S r0 *1 0,0
Ccc_XD0_nm_XD4_XDFFM_S XD0_nm XD4_XDFFM_S 1.8151e-17
* device instance cc_XD0_nm_XD4_XDFFM_SB r0 *1 0,0
Ccc_XD0_nm_XD4_XDFFM_SB XD0_nm XD4_XDFFM_SB 1.8151e-17
* device instance cc_XD0_nm_XD4_XDFFQ_CLKB r0 *1 0,0
Ccc_XD0_nm_XD4_XDFFQ_CLKB XD0_nm XD4_XDFFQ_CLKB 1.8151e-17
* device instance cc_XD0_nm_XD4_XDFFQ_M r0 *1 0,0
Ccc_XD0_nm_XD4_XDFFQ_M XD0_nm XD4_XDFFQ_M 2.4201e-17
* device instance cc_XD0_nm_XD4_XDFFQ_MB r0 *1 0,0
Ccc_XD0_nm_XD4_XDFFQ_MB XD0_nm XD4_XDFFQ_MB 1.21e-17
* device instance cc_XD0_nm_XD4_XDFFQ_S r0 *1 0,0
Ccc_XD0_nm_XD4_XDFFQ_S XD0_nm XD4_XDFFQ_S 1.8151e-17
* device instance cc_XD0_nm_XD4_XDFFQ_SB r0 *1 0,0
Ccc_XD0_nm_XD4_XDFFQ_SB XD0_nm XD4_XDFFQ_SB 1.8151e-17
* device instance cc_XD0_nm_XD4_XN2_mid1 r0 *1 0,0
Ccc_XD0_nm_XD4_XN2_mid1 XD0_nm XD4_XN2_mid1 1.21e-17
* device instance cc_XD0_nm_XD4_XN3_mid1 r0 *1 0,0
Ccc_XD0_nm_XD4_XN3_mid1 XD0_nm XD4_XN3_mid1 1.21e-17
* device instance cc_XD0_nm_XD4_XN3_mid2 r0 *1 0,0
Ccc_XD0_nm_XD4_XN3_mid2 XD0_nm XD4_XN3_mid2 1.21e-17
* device instance cc_XD0_nm_XD4_dmodout r0 *1 0,0
Ccc_XD0_nm_XD4_dmodout XD0_nm XD4_dmodout 1.21e-17
* device instance cc_XD0_nm_XD4_dq r0 *1 0,0
Ccc_XD0_nm_XD4_dq XD0_nm XD4_dq 1.8151e-17
* device instance cc_XD0_nm_XD4_nm r0 *1 0,0
Ccc_XD0_nm_XD4_nm XD0_nm XD4_nm 1.21e-17
* device instance cc_XD0_nm_XD4_nt r0 *1 0,0
Ccc_XD0_nm_XD4_nt XD0_nm XD4_nt 1.21e-17
* device instance cc_XD0_nm_XD4_t1 r0 *1 0,0
Ccc_XD0_nm_XD4_t1 XD0_nm XD4_t1 1.21e-17
* device instance cc_XD0_nm_XD5_XDFFM_CLKB r0 *1 0,0
Ccc_XD0_nm_XD5_XDFFM_CLKB XD0_nm XD5_XDFFM_CLKB 1.8151e-17
* device instance cc_XD0_nm_XD5_XDFFM_M r0 *1 0,0
Ccc_XD0_nm_XD5_XDFFM_M XD0_nm XD5_XDFFM_M 2.4201e-17
* device instance cc_XD0_nm_XD5_XDFFM_MB r0 *1 0,0
Ccc_XD0_nm_XD5_XDFFM_MB XD0_nm XD5_XDFFM_MB 1.21e-17
* device instance cc_XD0_nm_XD5_XDFFM_S r0 *1 0,0
Ccc_XD0_nm_XD5_XDFFM_S XD0_nm XD5_XDFFM_S 1.8151e-17
* device instance cc_XD0_nm_XD5_XDFFM_SB r0 *1 0,0
Ccc_XD0_nm_XD5_XDFFM_SB XD0_nm XD5_XDFFM_SB 1.8151e-17
* device instance cc_XD0_nm_XD5_XDFFQ_CLKB r0 *1 0,0
Ccc_XD0_nm_XD5_XDFFQ_CLKB XD0_nm XD5_XDFFQ_CLKB 1.8151e-17
* device instance cc_XD0_nm_XD5_XDFFQ_M r0 *1 0,0
Ccc_XD0_nm_XD5_XDFFQ_M XD0_nm XD5_XDFFQ_M 2.4201e-17
* device instance cc_XD0_nm_XD5_XDFFQ_MB r0 *1 0,0
Ccc_XD0_nm_XD5_XDFFQ_MB XD0_nm XD5_XDFFQ_MB 1.21e-17
* device instance cc_XD0_nm_XD5_XDFFQ_S r0 *1 0,0
Ccc_XD0_nm_XD5_XDFFQ_S XD0_nm XD5_XDFFQ_S 1.8151e-17
* device instance cc_XD0_nm_XD5_XDFFQ_SB r0 *1 0,0
Ccc_XD0_nm_XD5_XDFFQ_SB XD0_nm XD5_XDFFQ_SB 1.8151e-17
* device instance cc_XD0_nm_XD5_XN2_mid1 r0 *1 0,0
Ccc_XD0_nm_XD5_XN2_mid1 XD0_nm XD5_XN2_mid1 1.21e-17
* device instance cc_XD0_nm_XD5_XN3_mid1 r0 *1 0,0
Ccc_XD0_nm_XD5_XN3_mid1 XD0_nm XD5_XN3_mid1 1.21e-17
* device instance cc_XD0_nm_XD5_XN3_mid2 r0 *1 0,0
Ccc_XD0_nm_XD5_XN3_mid2 XD0_nm XD5_XN3_mid2 1.21e-17
* device instance cc_XD0_nm_XD5_dmodout r0 *1 0,0
Ccc_XD0_nm_XD5_dmodout XD0_nm XD5_dmodout 1.21e-17
* device instance cc_XD0_nm_XD5_dq r0 *1 0,0
Ccc_XD0_nm_XD5_dq XD0_nm XD5_dq 1.8151e-17
* device instance cc_XD0_nm_XD5_nm r0 *1 0,0
Ccc_XD0_nm_XD5_nm XD0_nm XD5_nm 1.21e-17
* device instance cc_XD0_nm_XD5_nt r0 *1 0,0
Ccc_XD0_nm_XD5_nt XD0_nm XD5_nt 1.21e-17
* device instance cc_XD0_nm_XD5_t1 r0 *1 0,0
Ccc_XD0_nm_XD5_t1 XD0_nm XD5_t1 1.21e-17
* device instance cc_XD0_nm_XFRT_CLKB r0 *1 0,0
Ccc_XD0_nm_XFRT_CLKB XD0_nm XFRT_CLKB 1.8151e-17
* device instance cc_XD0_nm_XFRT_M r0 *1 0,0
Ccc_XD0_nm_XFRT_M XD0_nm XFRT_M 2.4201e-17
* device instance cc_XD0_nm_XFRT_MB r0 *1 0,0
Ccc_XD0_nm_XFRT_MB XD0_nm XFRT_MB 1.21e-17
* device instance cc_XD0_nm_XFRT_S r0 *1 0,0
Ccc_XD0_nm_XFRT_S XD0_nm XFRT_S 1.8151e-17
* device instance cc_XD0_nm_XFRT_SB r0 *1 0,0
Ccc_XD0_nm_XFRT_SB XD0_nm XFRT_SB 1.8151e-17
* device instance cc_XD0_nm_ck1 r0 *1 0,0
Ccc_XD0_nm_ck1 XD0_nm ck1 6.0502e-17
* device instance cc_XD0_nm_ck2 r0 *1 0,0
Ccc_XD0_nm_ck2 XD0_nm ck2 5.4452e-17
* device instance cc_XD0_nm_ck3 r0 *1 0,0
Ccc_XD0_nm_ck3 XD0_nm ck3 5.4452e-17
* device instance cc_XD0_nm_ck4 r0 *1 0,0
Ccc_XD0_nm_ck4 XD0_nm ck4 5.4452e-17
* device instance cc_XD0_nm_ck5 r0 *1 0,0
Ccc_XD0_nm_ck5 XD0_nm ck5 5.4452e-17
* device instance cc_XD0_nm_mod0 r0 *1 0,0
Ccc_XD0_nm_mod0 XD0_nm mod0 2.4201e-17
* device instance cc_XD0_nm_mod1 r0 *1 0,0
Ccc_XD0_nm_mod1 XD0_nm mod1 2.4201e-17
* device instance cc_XD0_nm_mod2 r0 *1 0,0
Ccc_XD0_nm_mod2 XD0_nm mod2 2.4201e-17
* device instance cc_XD0_nm_mod3 r0 *1 0,0
Ccc_XD0_nm_mod3 XD0_nm mod3 2.4201e-17
* device instance cc_XD0_nm_mod4 r0 *1 0,0
Ccc_XD0_nm_mod4 XD0_nm mod4 2.4201e-17
* device instance cc_XD0_nm_net1 r0 *1 0,0
Ccc_XD0_nm_net1 XD0_nm net1 1.21e-17
* device instance cc_XD0_nt_XD0_t1 r0 *1 0,0
Ccc_XD0_nt_XD0_t1 XD0_nt XD0_t1 1.21e-17
* device instance cc_XD0_nt_XD1_XDFFM_CLKB r0 *1 0,0
Ccc_XD0_nt_XD1_XDFFM_CLKB XD0_nt XD1_XDFFM_CLKB 1.8151e-17
* device instance cc_XD0_nt_XD1_XDFFM_M r0 *1 0,0
Ccc_XD0_nt_XD1_XDFFM_M XD0_nt XD1_XDFFM_M 2.4201e-17
* device instance cc_XD0_nt_XD1_XDFFM_MB r0 *1 0,0
Ccc_XD0_nt_XD1_XDFFM_MB XD0_nt XD1_XDFFM_MB 1.21e-17
* device instance cc_XD0_nt_XD1_XDFFM_S r0 *1 0,0
Ccc_XD0_nt_XD1_XDFFM_S XD0_nt XD1_XDFFM_S 1.8151e-17
* device instance cc_XD0_nt_XD1_XDFFM_SB r0 *1 0,0
Ccc_XD0_nt_XD1_XDFFM_SB XD0_nt XD1_XDFFM_SB 1.8151e-17
* device instance cc_XD0_nt_XD1_XDFFQ_CLKB r0 *1 0,0
Ccc_XD0_nt_XD1_XDFFQ_CLKB XD0_nt XD1_XDFFQ_CLKB 1.8151e-17
* device instance cc_XD0_nt_XD1_XDFFQ_M r0 *1 0,0
Ccc_XD0_nt_XD1_XDFFQ_M XD0_nt XD1_XDFFQ_M 2.4201e-17
* device instance cc_XD0_nt_XD1_XDFFQ_MB r0 *1 0,0
Ccc_XD0_nt_XD1_XDFFQ_MB XD0_nt XD1_XDFFQ_MB 1.21e-17
* device instance cc_XD0_nt_XD1_XDFFQ_S r0 *1 0,0
Ccc_XD0_nt_XD1_XDFFQ_S XD0_nt XD1_XDFFQ_S 1.8151e-17
* device instance cc_XD0_nt_XD1_XDFFQ_SB r0 *1 0,0
Ccc_XD0_nt_XD1_XDFFQ_SB XD0_nt XD1_XDFFQ_SB 1.8151e-17
* device instance cc_XD0_nt_XD1_XN2_mid1 r0 *1 0,0
Ccc_XD0_nt_XD1_XN2_mid1 XD0_nt XD1_XN2_mid1 1.21e-17
* device instance cc_XD0_nt_XD1_XN3_mid1 r0 *1 0,0
Ccc_XD0_nt_XD1_XN3_mid1 XD0_nt XD1_XN3_mid1 1.21e-17
* device instance cc_XD0_nt_XD1_XN3_mid2 r0 *1 0,0
Ccc_XD0_nt_XD1_XN3_mid2 XD0_nt XD1_XN3_mid2 1.21e-17
* device instance cc_XD0_nt_XD1_dmodout r0 *1 0,0
Ccc_XD0_nt_XD1_dmodout XD0_nt XD1_dmodout 1.21e-17
* device instance cc_XD0_nt_XD1_dq r0 *1 0,0
Ccc_XD0_nt_XD1_dq XD0_nt XD1_dq 1.8151e-17
* device instance cc_XD0_nt_XD1_nm r0 *1 0,0
Ccc_XD0_nt_XD1_nm XD0_nt XD1_nm 1.21e-17
* device instance cc_XD0_nt_XD1_nt r0 *1 0,0
Ccc_XD0_nt_XD1_nt XD0_nt XD1_nt 1.21e-17
* device instance cc_XD0_nt_XD1_t1 r0 *1 0,0
Ccc_XD0_nt_XD1_t1 XD0_nt XD1_t1 1.21e-17
* device instance cc_XD0_nt_XD2_XDFFM_CLKB r0 *1 0,0
Ccc_XD0_nt_XD2_XDFFM_CLKB XD0_nt XD2_XDFFM_CLKB 1.8151e-17
* device instance cc_XD0_nt_XD2_XDFFM_M r0 *1 0,0
Ccc_XD0_nt_XD2_XDFFM_M XD0_nt XD2_XDFFM_M 2.4201e-17
* device instance cc_XD0_nt_XD2_XDFFM_MB r0 *1 0,0
Ccc_XD0_nt_XD2_XDFFM_MB XD0_nt XD2_XDFFM_MB 1.21e-17
* device instance cc_XD0_nt_XD2_XDFFM_S r0 *1 0,0
Ccc_XD0_nt_XD2_XDFFM_S XD0_nt XD2_XDFFM_S 1.8151e-17
* device instance cc_XD0_nt_XD2_XDFFM_SB r0 *1 0,0
Ccc_XD0_nt_XD2_XDFFM_SB XD0_nt XD2_XDFFM_SB 1.8151e-17
* device instance cc_XD0_nt_XD2_XDFFQ_CLKB r0 *1 0,0
Ccc_XD0_nt_XD2_XDFFQ_CLKB XD0_nt XD2_XDFFQ_CLKB 1.8151e-17
* device instance cc_XD0_nt_XD2_XDFFQ_M r0 *1 0,0
Ccc_XD0_nt_XD2_XDFFQ_M XD0_nt XD2_XDFFQ_M 2.4201e-17
* device instance cc_XD0_nt_XD2_XDFFQ_MB r0 *1 0,0
Ccc_XD0_nt_XD2_XDFFQ_MB XD0_nt XD2_XDFFQ_MB 1.21e-17
* device instance cc_XD0_nt_XD2_XDFFQ_S r0 *1 0,0
Ccc_XD0_nt_XD2_XDFFQ_S XD0_nt XD2_XDFFQ_S 1.8151e-17
* device instance cc_XD0_nt_XD2_XDFFQ_SB r0 *1 0,0
Ccc_XD0_nt_XD2_XDFFQ_SB XD0_nt XD2_XDFFQ_SB 1.8151e-17
* device instance cc_XD0_nt_XD2_XN2_mid1 r0 *1 0,0
Ccc_XD0_nt_XD2_XN2_mid1 XD0_nt XD2_XN2_mid1 1.21e-17
* device instance cc_XD0_nt_XD2_XN3_mid1 r0 *1 0,0
Ccc_XD0_nt_XD2_XN3_mid1 XD0_nt XD2_XN3_mid1 1.21e-17
* device instance cc_XD0_nt_XD2_XN3_mid2 r0 *1 0,0
Ccc_XD0_nt_XD2_XN3_mid2 XD0_nt XD2_XN3_mid2 1.21e-17
* device instance cc_XD0_nt_XD2_dmodout r0 *1 0,0
Ccc_XD0_nt_XD2_dmodout XD0_nt XD2_dmodout 1.21e-17
* device instance cc_XD0_nt_XD2_dq r0 *1 0,0
Ccc_XD0_nt_XD2_dq XD0_nt XD2_dq 1.8151e-17
* device instance cc_XD0_nt_XD2_nm r0 *1 0,0
Ccc_XD0_nt_XD2_nm XD0_nt XD2_nm 1.21e-17
* device instance cc_XD0_nt_XD2_nt r0 *1 0,0
Ccc_XD0_nt_XD2_nt XD0_nt XD2_nt 1.21e-17
* device instance cc_XD0_nt_XD2_t1 r0 *1 0,0
Ccc_XD0_nt_XD2_t1 XD0_nt XD2_t1 1.21e-17
* device instance cc_XD0_nt_XD3_XDFFM_CLKB r0 *1 0,0
Ccc_XD0_nt_XD3_XDFFM_CLKB XD0_nt XD3_XDFFM_CLKB 1.8151e-17
* device instance cc_XD0_nt_XD3_XDFFM_M r0 *1 0,0
Ccc_XD0_nt_XD3_XDFFM_M XD0_nt XD3_XDFFM_M 2.4201e-17
* device instance cc_XD0_nt_XD3_XDFFM_MB r0 *1 0,0
Ccc_XD0_nt_XD3_XDFFM_MB XD0_nt XD3_XDFFM_MB 1.21e-17
* device instance cc_XD0_nt_XD3_XDFFM_S r0 *1 0,0
Ccc_XD0_nt_XD3_XDFFM_S XD0_nt XD3_XDFFM_S 1.8151e-17
* device instance cc_XD0_nt_XD3_XDFFM_SB r0 *1 0,0
Ccc_XD0_nt_XD3_XDFFM_SB XD0_nt XD3_XDFFM_SB 1.8151e-17
* device instance cc_XD0_nt_XD3_XDFFQ_CLKB r0 *1 0,0
Ccc_XD0_nt_XD3_XDFFQ_CLKB XD0_nt XD3_XDFFQ_CLKB 1.8151e-17
* device instance cc_XD0_nt_XD3_XDFFQ_M r0 *1 0,0
Ccc_XD0_nt_XD3_XDFFQ_M XD0_nt XD3_XDFFQ_M 2.4201e-17
* device instance cc_XD0_nt_XD3_XDFFQ_MB r0 *1 0,0
Ccc_XD0_nt_XD3_XDFFQ_MB XD0_nt XD3_XDFFQ_MB 1.21e-17
* device instance cc_XD0_nt_XD3_XDFFQ_S r0 *1 0,0
Ccc_XD0_nt_XD3_XDFFQ_S XD0_nt XD3_XDFFQ_S 1.8151e-17
* device instance cc_XD0_nt_XD3_XDFFQ_SB r0 *1 0,0
Ccc_XD0_nt_XD3_XDFFQ_SB XD0_nt XD3_XDFFQ_SB 1.8151e-17
* device instance cc_XD0_nt_XD3_XN2_mid1 r0 *1 0,0
Ccc_XD0_nt_XD3_XN2_mid1 XD0_nt XD3_XN2_mid1 1.21e-17
* device instance cc_XD0_nt_XD3_XN3_mid1 r0 *1 0,0
Ccc_XD0_nt_XD3_XN3_mid1 XD0_nt XD3_XN3_mid1 1.21e-17
* device instance cc_XD0_nt_XD3_XN3_mid2 r0 *1 0,0
Ccc_XD0_nt_XD3_XN3_mid2 XD0_nt XD3_XN3_mid2 1.21e-17
* device instance cc_XD0_nt_XD3_dmodout r0 *1 0,0
Ccc_XD0_nt_XD3_dmodout XD0_nt XD3_dmodout 1.21e-17
* device instance cc_XD0_nt_XD3_dq r0 *1 0,0
Ccc_XD0_nt_XD3_dq XD0_nt XD3_dq 1.8151e-17
* device instance cc_XD0_nt_XD3_nm r0 *1 0,0
Ccc_XD0_nt_XD3_nm XD0_nt XD3_nm 1.21e-17
* device instance cc_XD0_nt_XD3_nt r0 *1 0,0
Ccc_XD0_nt_XD3_nt XD0_nt XD3_nt 1.21e-17
* device instance cc_XD0_nt_XD3_t1 r0 *1 0,0
Ccc_XD0_nt_XD3_t1 XD0_nt XD3_t1 1.21e-17
* device instance cc_XD0_nt_XD4_XDFFM_CLKB r0 *1 0,0
Ccc_XD0_nt_XD4_XDFFM_CLKB XD0_nt XD4_XDFFM_CLKB 1.8151e-17
* device instance cc_XD0_nt_XD4_XDFFM_M r0 *1 0,0
Ccc_XD0_nt_XD4_XDFFM_M XD0_nt XD4_XDFFM_M 2.4201e-17
* device instance cc_XD0_nt_XD4_XDFFM_MB r0 *1 0,0
Ccc_XD0_nt_XD4_XDFFM_MB XD0_nt XD4_XDFFM_MB 1.21e-17
* device instance cc_XD0_nt_XD4_XDFFM_S r0 *1 0,0
Ccc_XD0_nt_XD4_XDFFM_S XD0_nt XD4_XDFFM_S 1.8151e-17
* device instance cc_XD0_nt_XD4_XDFFM_SB r0 *1 0,0
Ccc_XD0_nt_XD4_XDFFM_SB XD0_nt XD4_XDFFM_SB 1.8151e-17
* device instance cc_XD0_nt_XD4_XDFFQ_CLKB r0 *1 0,0
Ccc_XD0_nt_XD4_XDFFQ_CLKB XD0_nt XD4_XDFFQ_CLKB 1.8151e-17
* device instance cc_XD0_nt_XD4_XDFFQ_M r0 *1 0,0
Ccc_XD0_nt_XD4_XDFFQ_M XD0_nt XD4_XDFFQ_M 2.4201e-17
* device instance cc_XD0_nt_XD4_XDFFQ_MB r0 *1 0,0
Ccc_XD0_nt_XD4_XDFFQ_MB XD0_nt XD4_XDFFQ_MB 1.21e-17
* device instance cc_XD0_nt_XD4_XDFFQ_S r0 *1 0,0
Ccc_XD0_nt_XD4_XDFFQ_S XD0_nt XD4_XDFFQ_S 1.8151e-17
* device instance cc_XD0_nt_XD4_XDFFQ_SB r0 *1 0,0
Ccc_XD0_nt_XD4_XDFFQ_SB XD0_nt XD4_XDFFQ_SB 1.8151e-17
* device instance cc_XD0_nt_XD4_XN2_mid1 r0 *1 0,0
Ccc_XD0_nt_XD4_XN2_mid1 XD0_nt XD4_XN2_mid1 1.21e-17
* device instance cc_XD0_nt_XD4_XN3_mid1 r0 *1 0,0
Ccc_XD0_nt_XD4_XN3_mid1 XD0_nt XD4_XN3_mid1 1.21e-17
* device instance cc_XD0_nt_XD4_XN3_mid2 r0 *1 0,0
Ccc_XD0_nt_XD4_XN3_mid2 XD0_nt XD4_XN3_mid2 1.21e-17
* device instance cc_XD0_nt_XD4_dmodout r0 *1 0,0
Ccc_XD0_nt_XD4_dmodout XD0_nt XD4_dmodout 1.21e-17
* device instance cc_XD0_nt_XD4_dq r0 *1 0,0
Ccc_XD0_nt_XD4_dq XD0_nt XD4_dq 1.8151e-17
* device instance cc_XD0_nt_XD4_nm r0 *1 0,0
Ccc_XD0_nt_XD4_nm XD0_nt XD4_nm 1.21e-17
* device instance cc_XD0_nt_XD4_nt r0 *1 0,0
Ccc_XD0_nt_XD4_nt XD0_nt XD4_nt 1.21e-17
* device instance cc_XD0_nt_XD4_t1 r0 *1 0,0
Ccc_XD0_nt_XD4_t1 XD0_nt XD4_t1 1.21e-17
* device instance cc_XD0_nt_XD5_XDFFM_CLKB r0 *1 0,0
Ccc_XD0_nt_XD5_XDFFM_CLKB XD0_nt XD5_XDFFM_CLKB 1.8151e-17
* device instance cc_XD0_nt_XD5_XDFFM_M r0 *1 0,0
Ccc_XD0_nt_XD5_XDFFM_M XD0_nt XD5_XDFFM_M 2.4201e-17
* device instance cc_XD0_nt_XD5_XDFFM_MB r0 *1 0,0
Ccc_XD0_nt_XD5_XDFFM_MB XD0_nt XD5_XDFFM_MB 1.21e-17
* device instance cc_XD0_nt_XD5_XDFFM_S r0 *1 0,0
Ccc_XD0_nt_XD5_XDFFM_S XD0_nt XD5_XDFFM_S 1.8151e-17
* device instance cc_XD0_nt_XD5_XDFFM_SB r0 *1 0,0
Ccc_XD0_nt_XD5_XDFFM_SB XD0_nt XD5_XDFFM_SB 1.8151e-17
* device instance cc_XD0_nt_XD5_XDFFQ_CLKB r0 *1 0,0
Ccc_XD0_nt_XD5_XDFFQ_CLKB XD0_nt XD5_XDFFQ_CLKB 1.8151e-17
* device instance cc_XD0_nt_XD5_XDFFQ_M r0 *1 0,0
Ccc_XD0_nt_XD5_XDFFQ_M XD0_nt XD5_XDFFQ_M 2.4201e-17
* device instance cc_XD0_nt_XD5_XDFFQ_MB r0 *1 0,0
Ccc_XD0_nt_XD5_XDFFQ_MB XD0_nt XD5_XDFFQ_MB 1.21e-17
* device instance cc_XD0_nt_XD5_XDFFQ_S r0 *1 0,0
Ccc_XD0_nt_XD5_XDFFQ_S XD0_nt XD5_XDFFQ_S 1.8151e-17
* device instance cc_XD0_nt_XD5_XDFFQ_SB r0 *1 0,0
Ccc_XD0_nt_XD5_XDFFQ_SB XD0_nt XD5_XDFFQ_SB 1.8151e-17
* device instance cc_XD0_nt_XD5_XN2_mid1 r0 *1 0,0
Ccc_XD0_nt_XD5_XN2_mid1 XD0_nt XD5_XN2_mid1 1.21e-17
* device instance cc_XD0_nt_XD5_XN3_mid1 r0 *1 0,0
Ccc_XD0_nt_XD5_XN3_mid1 XD0_nt XD5_XN3_mid1 1.21e-17
* device instance cc_XD0_nt_XD5_XN3_mid2 r0 *1 0,0
Ccc_XD0_nt_XD5_XN3_mid2 XD0_nt XD5_XN3_mid2 1.21e-17
* device instance cc_XD0_nt_XD5_dmodout r0 *1 0,0
Ccc_XD0_nt_XD5_dmodout XD0_nt XD5_dmodout 1.21e-17
* device instance cc_XD0_nt_XD5_dq r0 *1 0,0
Ccc_XD0_nt_XD5_dq XD0_nt XD5_dq 1.8151e-17
* device instance cc_XD0_nt_XD5_nm r0 *1 0,0
Ccc_XD0_nt_XD5_nm XD0_nt XD5_nm 1.21e-17
* device instance cc_XD0_nt_XD5_nt r0 *1 0,0
Ccc_XD0_nt_XD5_nt XD0_nt XD5_nt 1.21e-17
* device instance cc_XD0_nt_XD5_t1 r0 *1 0,0
Ccc_XD0_nt_XD5_t1 XD0_nt XD5_t1 1.21e-17
* device instance cc_XD0_nt_XFRT_CLKB r0 *1 0,0
Ccc_XD0_nt_XFRT_CLKB XD0_nt XFRT_CLKB 1.8151e-17
* device instance cc_XD0_nt_XFRT_M r0 *1 0,0
Ccc_XD0_nt_XFRT_M XD0_nt XFRT_M 2.4201e-17
* device instance cc_XD0_nt_XFRT_MB r0 *1 0,0
Ccc_XD0_nt_XFRT_MB XD0_nt XFRT_MB 1.21e-17
* device instance cc_XD0_nt_XFRT_S r0 *1 0,0
Ccc_XD0_nt_XFRT_S XD0_nt XFRT_S 1.8151e-17
* device instance cc_XD0_nt_XFRT_SB r0 *1 0,0
Ccc_XD0_nt_XFRT_SB XD0_nt XFRT_SB 1.8151e-17
* device instance cc_XD0_nt_ck1 r0 *1 0,0
Ccc_XD0_nt_ck1 XD0_nt ck1 5.4452e-17
* device instance cc_XD0_nt_ck2 r0 *1 0,0
Ccc_XD0_nt_ck2 XD0_nt ck2 5.4452e-17
* device instance cc_XD0_nt_ck3 r0 *1 0,0
Ccc_XD0_nt_ck3 XD0_nt ck3 5.4452e-17
* device instance cc_XD0_nt_ck4 r0 *1 0,0
Ccc_XD0_nt_ck4 XD0_nt ck4 5.4452e-17
* device instance cc_XD0_nt_ck5 r0 *1 0,0
Ccc_XD0_nt_ck5 XD0_nt ck5 5.4452e-17
* device instance cc_XD0_nt_mod0 r0 *1 0,0
Ccc_XD0_nt_mod0 XD0_nt mod0 2.4201e-17
* device instance cc_XD0_nt_mod1 r0 *1 0,0
Ccc_XD0_nt_mod1 XD0_nt mod1 2.4201e-17
* device instance cc_XD0_nt_mod2 r0 *1 0,0
Ccc_XD0_nt_mod2 XD0_nt mod2 2.4201e-17
* device instance cc_XD0_nt_mod3 r0 *1 0,0
Ccc_XD0_nt_mod3 XD0_nt mod3 2.4201e-17
* device instance cc_XD0_nt_mod4 r0 *1 0,0
Ccc_XD0_nt_mod4 XD0_nt mod4 2.4201e-17
* device instance cc_XD0_nt_net1 r0 *1 0,0
Ccc_XD0_nt_net1 XD0_nt net1 1.8151e-17
* device instance cc_XD0_t1_XD1_XDFFM_CLKB r0 *1 0,0
Ccc_XD0_t1_XD1_XDFFM_CLKB XD0_t1 XD1_XDFFM_CLKB 1.8151e-17
* device instance cc_XD0_t1_XD1_XDFFM_M r0 *1 0,0
Ccc_XD0_t1_XD1_XDFFM_M XD0_t1 XD1_XDFFM_M 2.4201e-17
* device instance cc_XD0_t1_XD1_XDFFM_MB r0 *1 0,0
Ccc_XD0_t1_XD1_XDFFM_MB XD0_t1 XD1_XDFFM_MB 1.21e-17
* device instance cc_XD0_t1_XD1_XDFFM_S r0 *1 0,0
Ccc_XD0_t1_XD1_XDFFM_S XD0_t1 XD1_XDFFM_S 1.8151e-17
* device instance cc_XD0_t1_XD1_XDFFM_SB r0 *1 0,0
Ccc_XD0_t1_XD1_XDFFM_SB XD0_t1 XD1_XDFFM_SB 1.8151e-17
* device instance cc_XD0_t1_XD1_XDFFQ_CLKB r0 *1 0,0
Ccc_XD0_t1_XD1_XDFFQ_CLKB XD0_t1 XD1_XDFFQ_CLKB 1.8151e-17
* device instance cc_XD0_t1_XD1_XDFFQ_M r0 *1 0,0
Ccc_XD0_t1_XD1_XDFFQ_M XD0_t1 XD1_XDFFQ_M 2.4201e-17
* device instance cc_XD0_t1_XD1_XDFFQ_MB r0 *1 0,0
Ccc_XD0_t1_XD1_XDFFQ_MB XD0_t1 XD1_XDFFQ_MB 1.21e-17
* device instance cc_XD0_t1_XD1_XDFFQ_S r0 *1 0,0
Ccc_XD0_t1_XD1_XDFFQ_S XD0_t1 XD1_XDFFQ_S 1.8151e-17
* device instance cc_XD0_t1_XD1_XDFFQ_SB r0 *1 0,0
Ccc_XD0_t1_XD1_XDFFQ_SB XD0_t1 XD1_XDFFQ_SB 1.8151e-17
* device instance cc_XD0_t1_XD1_XN2_mid1 r0 *1 0,0
Ccc_XD0_t1_XD1_XN2_mid1 XD0_t1 XD1_XN2_mid1 1.21e-17
* device instance cc_XD0_t1_XD1_XN3_mid1 r0 *1 0,0
Ccc_XD0_t1_XD1_XN3_mid1 XD0_t1 XD1_XN3_mid1 1.21e-17
* device instance cc_XD0_t1_XD1_XN3_mid2 r0 *1 0,0
Ccc_XD0_t1_XD1_XN3_mid2 XD0_t1 XD1_XN3_mid2 1.21e-17
* device instance cc_XD0_t1_XD1_dmodout r0 *1 0,0
Ccc_XD0_t1_XD1_dmodout XD0_t1 XD1_dmodout 1.21e-17
* device instance cc_XD0_t1_XD1_dq r0 *1 0,0
Ccc_XD0_t1_XD1_dq XD0_t1 XD1_dq 1.8151e-17
* device instance cc_XD0_t1_XD1_nm r0 *1 0,0
Ccc_XD0_t1_XD1_nm XD0_t1 XD1_nm 1.21e-17
* device instance cc_XD0_t1_XD1_nt r0 *1 0,0
Ccc_XD0_t1_XD1_nt XD0_t1 XD1_nt 1.21e-17
* device instance cc_XD0_t1_XD1_t1 r0 *1 0,0
Ccc_XD0_t1_XD1_t1 XD0_t1 XD1_t1 1.21e-17
* device instance cc_XD0_t1_XD2_XDFFM_CLKB r0 *1 0,0
Ccc_XD0_t1_XD2_XDFFM_CLKB XD0_t1 XD2_XDFFM_CLKB 1.8151e-17
* device instance cc_XD0_t1_XD2_XDFFM_M r0 *1 0,0
Ccc_XD0_t1_XD2_XDFFM_M XD0_t1 XD2_XDFFM_M 2.4201e-17
* device instance cc_XD0_t1_XD2_XDFFM_MB r0 *1 0,0
Ccc_XD0_t1_XD2_XDFFM_MB XD0_t1 XD2_XDFFM_MB 1.21e-17
* device instance cc_XD0_t1_XD2_XDFFM_S r0 *1 0,0
Ccc_XD0_t1_XD2_XDFFM_S XD0_t1 XD2_XDFFM_S 1.8151e-17
* device instance cc_XD0_t1_XD2_XDFFM_SB r0 *1 0,0
Ccc_XD0_t1_XD2_XDFFM_SB XD0_t1 XD2_XDFFM_SB 1.8151e-17
* device instance cc_XD0_t1_XD2_XDFFQ_CLKB r0 *1 0,0
Ccc_XD0_t1_XD2_XDFFQ_CLKB XD0_t1 XD2_XDFFQ_CLKB 1.8151e-17
* device instance cc_XD0_t1_XD2_XDFFQ_M r0 *1 0,0
Ccc_XD0_t1_XD2_XDFFQ_M XD0_t1 XD2_XDFFQ_M 2.4201e-17
* device instance cc_XD0_t1_XD2_XDFFQ_MB r0 *1 0,0
Ccc_XD0_t1_XD2_XDFFQ_MB XD0_t1 XD2_XDFFQ_MB 1.21e-17
* device instance cc_XD0_t1_XD2_XDFFQ_S r0 *1 0,0
Ccc_XD0_t1_XD2_XDFFQ_S XD0_t1 XD2_XDFFQ_S 1.8151e-17
* device instance cc_XD0_t1_XD2_XDFFQ_SB r0 *1 0,0
Ccc_XD0_t1_XD2_XDFFQ_SB XD0_t1 XD2_XDFFQ_SB 1.8151e-17
* device instance cc_XD0_t1_XD2_XN2_mid1 r0 *1 0,0
Ccc_XD0_t1_XD2_XN2_mid1 XD0_t1 XD2_XN2_mid1 1.21e-17
* device instance cc_XD0_t1_XD2_XN3_mid1 r0 *1 0,0
Ccc_XD0_t1_XD2_XN3_mid1 XD0_t1 XD2_XN3_mid1 1.21e-17
* device instance cc_XD0_t1_XD2_XN3_mid2 r0 *1 0,0
Ccc_XD0_t1_XD2_XN3_mid2 XD0_t1 XD2_XN3_mid2 1.21e-17
* device instance cc_XD0_t1_XD2_dmodout r0 *1 0,0
Ccc_XD0_t1_XD2_dmodout XD0_t1 XD2_dmodout 1.21e-17
* device instance cc_XD0_t1_XD2_dq r0 *1 0,0
Ccc_XD0_t1_XD2_dq XD0_t1 XD2_dq 1.8151e-17
* device instance cc_XD0_t1_XD2_nm r0 *1 0,0
Ccc_XD0_t1_XD2_nm XD0_t1 XD2_nm 1.21e-17
* device instance cc_XD0_t1_XD2_nt r0 *1 0,0
Ccc_XD0_t1_XD2_nt XD0_t1 XD2_nt 1.21e-17
* device instance cc_XD0_t1_XD2_t1 r0 *1 0,0
Ccc_XD0_t1_XD2_t1 XD0_t1 XD2_t1 1.21e-17
* device instance cc_XD0_t1_XD3_XDFFM_CLKB r0 *1 0,0
Ccc_XD0_t1_XD3_XDFFM_CLKB XD0_t1 XD3_XDFFM_CLKB 1.8151e-17
* device instance cc_XD0_t1_XD3_XDFFM_M r0 *1 0,0
Ccc_XD0_t1_XD3_XDFFM_M XD0_t1 XD3_XDFFM_M 2.4201e-17
* device instance cc_XD0_t1_XD3_XDFFM_MB r0 *1 0,0
Ccc_XD0_t1_XD3_XDFFM_MB XD0_t1 XD3_XDFFM_MB 1.21e-17
* device instance cc_XD0_t1_XD3_XDFFM_S r0 *1 0,0
Ccc_XD0_t1_XD3_XDFFM_S XD0_t1 XD3_XDFFM_S 1.8151e-17
* device instance cc_XD0_t1_XD3_XDFFM_SB r0 *1 0,0
Ccc_XD0_t1_XD3_XDFFM_SB XD0_t1 XD3_XDFFM_SB 1.8151e-17
* device instance cc_XD0_t1_XD3_XDFFQ_CLKB r0 *1 0,0
Ccc_XD0_t1_XD3_XDFFQ_CLKB XD0_t1 XD3_XDFFQ_CLKB 1.8151e-17
* device instance cc_XD0_t1_XD3_XDFFQ_M r0 *1 0,0
Ccc_XD0_t1_XD3_XDFFQ_M XD0_t1 XD3_XDFFQ_M 2.4201e-17
* device instance cc_XD0_t1_XD3_XDFFQ_MB r0 *1 0,0
Ccc_XD0_t1_XD3_XDFFQ_MB XD0_t1 XD3_XDFFQ_MB 1.21e-17
* device instance cc_XD0_t1_XD3_XDFFQ_S r0 *1 0,0
Ccc_XD0_t1_XD3_XDFFQ_S XD0_t1 XD3_XDFFQ_S 1.8151e-17
* device instance cc_XD0_t1_XD3_XDFFQ_SB r0 *1 0,0
Ccc_XD0_t1_XD3_XDFFQ_SB XD0_t1 XD3_XDFFQ_SB 1.8151e-17
* device instance cc_XD0_t1_XD3_XN2_mid1 r0 *1 0,0
Ccc_XD0_t1_XD3_XN2_mid1 XD0_t1 XD3_XN2_mid1 1.21e-17
* device instance cc_XD0_t1_XD3_XN3_mid1 r0 *1 0,0
Ccc_XD0_t1_XD3_XN3_mid1 XD0_t1 XD3_XN3_mid1 1.21e-17
* device instance cc_XD0_t1_XD3_XN3_mid2 r0 *1 0,0
Ccc_XD0_t1_XD3_XN3_mid2 XD0_t1 XD3_XN3_mid2 1.21e-17
* device instance cc_XD0_t1_XD3_dmodout r0 *1 0,0
Ccc_XD0_t1_XD3_dmodout XD0_t1 XD3_dmodout 1.21e-17
* device instance cc_XD0_t1_XD3_dq r0 *1 0,0
Ccc_XD0_t1_XD3_dq XD0_t1 XD3_dq 1.8151e-17
* device instance cc_XD0_t1_XD3_nm r0 *1 0,0
Ccc_XD0_t1_XD3_nm XD0_t1 XD3_nm 1.21e-17
* device instance cc_XD0_t1_XD3_nt r0 *1 0,0
Ccc_XD0_t1_XD3_nt XD0_t1 XD3_nt 1.21e-17
* device instance cc_XD0_t1_XD3_t1 r0 *1 0,0
Ccc_XD0_t1_XD3_t1 XD0_t1 XD3_t1 1.21e-17
* device instance cc_XD0_t1_XD4_XDFFM_CLKB r0 *1 0,0
Ccc_XD0_t1_XD4_XDFFM_CLKB XD0_t1 XD4_XDFFM_CLKB 1.8151e-17
* device instance cc_XD0_t1_XD4_XDFFM_M r0 *1 0,0
Ccc_XD0_t1_XD4_XDFFM_M XD0_t1 XD4_XDFFM_M 2.4201e-17
* device instance cc_XD0_t1_XD4_XDFFM_MB r0 *1 0,0
Ccc_XD0_t1_XD4_XDFFM_MB XD0_t1 XD4_XDFFM_MB 1.21e-17
* device instance cc_XD0_t1_XD4_XDFFM_S r0 *1 0,0
Ccc_XD0_t1_XD4_XDFFM_S XD0_t1 XD4_XDFFM_S 1.8151e-17
* device instance cc_XD0_t1_XD4_XDFFM_SB r0 *1 0,0
Ccc_XD0_t1_XD4_XDFFM_SB XD0_t1 XD4_XDFFM_SB 1.8151e-17
* device instance cc_XD0_t1_XD4_XDFFQ_CLKB r0 *1 0,0
Ccc_XD0_t1_XD4_XDFFQ_CLKB XD0_t1 XD4_XDFFQ_CLKB 1.8151e-17
* device instance cc_XD0_t1_XD4_XDFFQ_M r0 *1 0,0
Ccc_XD0_t1_XD4_XDFFQ_M XD0_t1 XD4_XDFFQ_M 2.4201e-17
* device instance cc_XD0_t1_XD4_XDFFQ_MB r0 *1 0,0
Ccc_XD0_t1_XD4_XDFFQ_MB XD0_t1 XD4_XDFFQ_MB 1.21e-17
* device instance cc_XD0_t1_XD4_XDFFQ_S r0 *1 0,0
Ccc_XD0_t1_XD4_XDFFQ_S XD0_t1 XD4_XDFFQ_S 1.8151e-17
* device instance cc_XD0_t1_XD4_XDFFQ_SB r0 *1 0,0
Ccc_XD0_t1_XD4_XDFFQ_SB XD0_t1 XD4_XDFFQ_SB 1.8151e-17
* device instance cc_XD0_t1_XD4_XN2_mid1 r0 *1 0,0
Ccc_XD0_t1_XD4_XN2_mid1 XD0_t1 XD4_XN2_mid1 1.21e-17
* device instance cc_XD0_t1_XD4_XN3_mid1 r0 *1 0,0
Ccc_XD0_t1_XD4_XN3_mid1 XD0_t1 XD4_XN3_mid1 1.21e-17
* device instance cc_XD0_t1_XD4_XN3_mid2 r0 *1 0,0
Ccc_XD0_t1_XD4_XN3_mid2 XD0_t1 XD4_XN3_mid2 1.21e-17
* device instance cc_XD0_t1_XD4_dmodout r0 *1 0,0
Ccc_XD0_t1_XD4_dmodout XD0_t1 XD4_dmodout 1.21e-17
* device instance cc_XD0_t1_XD4_dq r0 *1 0,0
Ccc_XD0_t1_XD4_dq XD0_t1 XD4_dq 1.8151e-17
* device instance cc_XD0_t1_XD4_nm r0 *1 0,0
Ccc_XD0_t1_XD4_nm XD0_t1 XD4_nm 1.21e-17
* device instance cc_XD0_t1_XD4_nt r0 *1 0,0
Ccc_XD0_t1_XD4_nt XD0_t1 XD4_nt 1.21e-17
* device instance cc_XD0_t1_XD4_t1 r0 *1 0,0
Ccc_XD0_t1_XD4_t1 XD0_t1 XD4_t1 1.21e-17
* device instance cc_XD0_t1_XD5_XDFFM_CLKB r0 *1 0,0
Ccc_XD0_t1_XD5_XDFFM_CLKB XD0_t1 XD5_XDFFM_CLKB 1.8151e-17
* device instance cc_XD0_t1_XD5_XDFFM_M r0 *1 0,0
Ccc_XD0_t1_XD5_XDFFM_M XD0_t1 XD5_XDFFM_M 2.4201e-17
* device instance cc_XD0_t1_XD5_XDFFM_MB r0 *1 0,0
Ccc_XD0_t1_XD5_XDFFM_MB XD0_t1 XD5_XDFFM_MB 1.21e-17
* device instance cc_XD0_t1_XD5_XDFFM_S r0 *1 0,0
Ccc_XD0_t1_XD5_XDFFM_S XD0_t1 XD5_XDFFM_S 1.8151e-17
* device instance cc_XD0_t1_XD5_XDFFM_SB r0 *1 0,0
Ccc_XD0_t1_XD5_XDFFM_SB XD0_t1 XD5_XDFFM_SB 1.8151e-17
* device instance cc_XD0_t1_XD5_XDFFQ_CLKB r0 *1 0,0
Ccc_XD0_t1_XD5_XDFFQ_CLKB XD0_t1 XD5_XDFFQ_CLKB 1.8151e-17
* device instance cc_XD0_t1_XD5_XDFFQ_M r0 *1 0,0
Ccc_XD0_t1_XD5_XDFFQ_M XD0_t1 XD5_XDFFQ_M 2.4201e-17
* device instance cc_XD0_t1_XD5_XDFFQ_MB r0 *1 0,0
Ccc_XD0_t1_XD5_XDFFQ_MB XD0_t1 XD5_XDFFQ_MB 1.21e-17
* device instance cc_XD0_t1_XD5_XDFFQ_S r0 *1 0,0
Ccc_XD0_t1_XD5_XDFFQ_S XD0_t1 XD5_XDFFQ_S 1.8151e-17
* device instance cc_XD0_t1_XD5_XDFFQ_SB r0 *1 0,0
Ccc_XD0_t1_XD5_XDFFQ_SB XD0_t1 XD5_XDFFQ_SB 1.8151e-17
* device instance cc_XD0_t1_XD5_XN2_mid1 r0 *1 0,0
Ccc_XD0_t1_XD5_XN2_mid1 XD0_t1 XD5_XN2_mid1 1.21e-17
* device instance cc_XD0_t1_XD5_XN3_mid1 r0 *1 0,0
Ccc_XD0_t1_XD5_XN3_mid1 XD0_t1 XD5_XN3_mid1 1.21e-17
* device instance cc_XD0_t1_XD5_XN3_mid2 r0 *1 0,0
Ccc_XD0_t1_XD5_XN3_mid2 XD0_t1 XD5_XN3_mid2 1.21e-17
* device instance cc_XD0_t1_XD5_dmodout r0 *1 0,0
Ccc_XD0_t1_XD5_dmodout XD0_t1 XD5_dmodout 1.21e-17
* device instance cc_XD0_t1_XD5_dq r0 *1 0,0
Ccc_XD0_t1_XD5_dq XD0_t1 XD5_dq 1.8151e-17
* device instance cc_XD0_t1_XD5_nm r0 *1 0,0
Ccc_XD0_t1_XD5_nm XD0_t1 XD5_nm 1.21e-17
* device instance cc_XD0_t1_XD5_nt r0 *1 0,0
Ccc_XD0_t1_XD5_nt XD0_t1 XD5_nt 1.21e-17
* device instance cc_XD0_t1_XD5_t1 r0 *1 0,0
Ccc_XD0_t1_XD5_t1 XD0_t1 XD5_t1 1.21e-17
* device instance cc_XD0_t1_XFRT_CLKB r0 *1 0,0
Ccc_XD0_t1_XFRT_CLKB XD0_t1 XFRT_CLKB 1.8151e-17
* device instance cc_XD0_t1_XFRT_M r0 *1 0,0
Ccc_XD0_t1_XFRT_M XD0_t1 XFRT_M 2.4201e-17
* device instance cc_XD0_t1_XFRT_MB r0 *1 0,0
Ccc_XD0_t1_XFRT_MB XD0_t1 XFRT_MB 1.21e-17
* device instance cc_XD0_t1_XFRT_S r0 *1 0,0
Ccc_XD0_t1_XFRT_S XD0_t1 XFRT_S 1.8151e-17
* device instance cc_XD0_t1_XFRT_SB r0 *1 0,0
Ccc_XD0_t1_XFRT_SB XD0_t1 XFRT_SB 1.8151e-17
* device instance cc_XD0_t1_ck1 r0 *1 0,0
Ccc_XD0_t1_ck1 XD0_t1 ck1 6.0502e-17
* device instance cc_XD0_t1_ck2 r0 *1 0,0
Ccc_XD0_t1_ck2 XD0_t1 ck2 5.4452e-17
* device instance cc_XD0_t1_ck3 r0 *1 0,0
Ccc_XD0_t1_ck3 XD0_t1 ck3 5.4452e-17
* device instance cc_XD0_t1_ck4 r0 *1 0,0
Ccc_XD0_t1_ck4 XD0_t1 ck4 5.4452e-17
* device instance cc_XD0_t1_ck5 r0 *1 0,0
Ccc_XD0_t1_ck5 XD0_t1 ck5 5.4452e-17
* device instance cc_XD0_t1_mod0 r0 *1 0,0
Ccc_XD0_t1_mod0 XD0_t1 mod0 2.4201e-17
* device instance cc_XD0_t1_mod1 r0 *1 0,0
Ccc_XD0_t1_mod1 XD0_t1 mod1 2.4201e-17
* device instance cc_XD0_t1_mod2 r0 *1 0,0
Ccc_XD0_t1_mod2 XD0_t1 mod2 2.4201e-17
* device instance cc_XD0_t1_mod3 r0 *1 0,0
Ccc_XD0_t1_mod3 XD0_t1 mod3 2.4201e-17
* device instance cc_XD0_t1_mod4 r0 *1 0,0
Ccc_XD0_t1_mod4 XD0_t1 mod4 2.4201e-17
* device instance cc_XD0_t1_net1 r0 *1 0,0
Ccc_XD0_t1_net1 XD0_t1 net1 1.21e-17
* device instance cc_XD1_XDFFM_CLKB_XD1_XDFFM_M r0 *1 0,0
Ccc_XD1_XDFFM_CLKB_XD1_XDFFM_M XD1_XDFFM_CLKB XD1_XDFFM_M 4.2352e-17
* device instance cc_XD1_XDFFM_CLKB_XD1_XDFFM_MB r0 *1 0,0
Ccc_XD1_XDFFM_CLKB_XD1_XDFFM_MB XD1_XDFFM_CLKB XD1_XDFFM_MB 2.4201e-17
* device instance cc_XD1_XDFFM_CLKB_XD1_XDFFM_S r0 *1 0,0
Ccc_XD1_XDFFM_CLKB_XD1_XDFFM_S XD1_XDFFM_CLKB XD1_XDFFM_S 1.8151e-17
* device instance cc_XD1_XDFFM_CLKB_XD1_XDFFM_SB r0 *1 0,0
Ccc_XD1_XDFFM_CLKB_XD1_XDFFM_SB XD1_XDFFM_CLKB XD1_XDFFM_SB 1.8151e-17
* device instance cc_XD1_XDFFM_CLKB_XD1_XDFFQ_CLKB r0 *1 0,0
Ccc_XD1_XDFFM_CLKB_XD1_XDFFQ_CLKB XD1_XDFFM_CLKB XD1_XDFFQ_CLKB 1.8151e-17
* device instance cc_XD1_XDFFM_CLKB_XD1_XDFFQ_M r0 *1 0,0
Ccc_XD1_XDFFM_CLKB_XD1_XDFFQ_M XD1_XDFFM_CLKB XD1_XDFFQ_M 2.4201e-17
* device instance cc_XD1_XDFFM_CLKB_XD1_XDFFQ_MB r0 *1 0,0
Ccc_XD1_XDFFM_CLKB_XD1_XDFFQ_MB XD1_XDFFM_CLKB XD1_XDFFQ_MB 1.21e-17
* device instance cc_XD1_XDFFM_CLKB_XD1_XDFFQ_S r0 *1 0,0
Ccc_XD1_XDFFM_CLKB_XD1_XDFFQ_S XD1_XDFFM_CLKB XD1_XDFFQ_S 1.8151e-17
* device instance cc_XD1_XDFFM_CLKB_XD1_XDFFQ_SB r0 *1 0,0
Ccc_XD1_XDFFM_CLKB_XD1_XDFFQ_SB XD1_XDFFM_CLKB XD1_XDFFQ_SB 1.8151e-17
* device instance cc_XD1_XDFFM_CLKB_XD1_XNOR_midp r0 *1 0,0
Ccc_XD1_XDFFM_CLKB_XD1_XNOR_midp XD1_XDFFM_CLKB XD1_XNOR_midp 1.21e-17
* device instance cc_XD1_XDFFM_CLKB_XD1_dmodout r0 *1 0,0
Ccc_XD1_XDFFM_CLKB_XD1_dmodout XD1_XDFFM_CLKB XD1_dmodout 1.8151e-17
* device instance cc_XD1_XDFFM_CLKB_XD1_dq r0 *1 0,0
Ccc_XD1_XDFFM_CLKB_XD1_dq XD1_XDFFM_CLKB XD1_dq 1.21e-17
* device instance cc_XD1_XDFFM_CLKB_XD1_nm r0 *1 0,0
Ccc_XD1_XDFFM_CLKB_XD1_nm XD1_XDFFM_CLKB XD1_nm 1.8151e-17
* device instance cc_XD1_XDFFM_CLKB_XD1_nt r0 *1 0,0
Ccc_XD1_XDFFM_CLKB_XD1_nt XD1_XDFFM_CLKB XD1_nt 2.4201e-17
* device instance cc_XD1_XDFFM_CLKB_XD1_t1 r0 *1 0,0
Ccc_XD1_XDFFM_CLKB_XD1_t1 XD1_XDFFM_CLKB XD1_t1 1.21e-17
* device instance cc_XD1_XDFFM_CLKB_XD2_XDFFM_CLKB r0 *1 0,0
Ccc_XD1_XDFFM_CLKB_XD2_XDFFM_CLKB XD1_XDFFM_CLKB XD2_XDFFM_CLKB 1.8151e-17
* device instance cc_XD1_XDFFM_CLKB_XD2_XDFFM_M r0 *1 0,0
Ccc_XD1_XDFFM_CLKB_XD2_XDFFM_M XD1_XDFFM_CLKB XD2_XDFFM_M 2.4201e-17
* device instance cc_XD1_XDFFM_CLKB_XD2_XDFFM_MB r0 *1 0,0
Ccc_XD1_XDFFM_CLKB_XD2_XDFFM_MB XD1_XDFFM_CLKB XD2_XDFFM_MB 1.21e-17
* device instance cc_XD1_XDFFM_CLKB_XD2_XDFFM_S r0 *1 0,0
Ccc_XD1_XDFFM_CLKB_XD2_XDFFM_S XD1_XDFFM_CLKB XD2_XDFFM_S 1.8151e-17
* device instance cc_XD1_XDFFM_CLKB_XD2_XDFFM_SB r0 *1 0,0
Ccc_XD1_XDFFM_CLKB_XD2_XDFFM_SB XD1_XDFFM_CLKB XD2_XDFFM_SB 1.8151e-17
* device instance cc_XD1_XDFFM_CLKB_XD2_XDFFQ_CLKB r0 *1 0,0
Ccc_XD1_XDFFM_CLKB_XD2_XDFFQ_CLKB XD1_XDFFM_CLKB XD2_XDFFQ_CLKB 1.8151e-17
* device instance cc_XD1_XDFFM_CLKB_XD2_XDFFQ_M r0 *1 0,0
Ccc_XD1_XDFFM_CLKB_XD2_XDFFQ_M XD1_XDFFM_CLKB XD2_XDFFQ_M 2.4201e-17
* device instance cc_XD1_XDFFM_CLKB_XD2_XDFFQ_MB r0 *1 0,0
Ccc_XD1_XDFFM_CLKB_XD2_XDFFQ_MB XD1_XDFFM_CLKB XD2_XDFFQ_MB 1.21e-17
* device instance cc_XD1_XDFFM_CLKB_XD2_XDFFQ_S r0 *1 0,0
Ccc_XD1_XDFFM_CLKB_XD2_XDFFQ_S XD1_XDFFM_CLKB XD2_XDFFQ_S 1.8151e-17
* device instance cc_XD1_XDFFM_CLKB_XD2_XDFFQ_SB r0 *1 0,0
Ccc_XD1_XDFFM_CLKB_XD2_XDFFQ_SB XD1_XDFFM_CLKB XD2_XDFFQ_SB 1.8151e-17
* device instance cc_XD1_XDFFM_CLKB_XD2_XN2_mid1 r0 *1 0,0
Ccc_XD1_XDFFM_CLKB_XD2_XN2_mid1 XD1_XDFFM_CLKB XD2_XN2_mid1 1.21e-17
* device instance cc_XD1_XDFFM_CLKB_XD2_XN3_mid1 r0 *1 0,0
Ccc_XD1_XDFFM_CLKB_XD2_XN3_mid1 XD1_XDFFM_CLKB XD2_XN3_mid1 1.21e-17
* device instance cc_XD1_XDFFM_CLKB_XD2_XN3_mid2 r0 *1 0,0
Ccc_XD1_XDFFM_CLKB_XD2_XN3_mid2 XD1_XDFFM_CLKB XD2_XN3_mid2 1.21e-17
* device instance cc_XD1_XDFFM_CLKB_XD2_dmodout r0 *1 0,0
Ccc_XD1_XDFFM_CLKB_XD2_dmodout XD1_XDFFM_CLKB XD2_dmodout 1.21e-17
* device instance cc_XD1_XDFFM_CLKB_XD2_dq r0 *1 0,0
Ccc_XD1_XDFFM_CLKB_XD2_dq XD1_XDFFM_CLKB XD2_dq 1.8151e-17
* device instance cc_XD1_XDFFM_CLKB_XD2_nm r0 *1 0,0
Ccc_XD1_XDFFM_CLKB_XD2_nm XD1_XDFFM_CLKB XD2_nm 1.21e-17
* device instance cc_XD1_XDFFM_CLKB_XD2_nt r0 *1 0,0
Ccc_XD1_XDFFM_CLKB_XD2_nt XD1_XDFFM_CLKB XD2_nt 1.21e-17
* device instance cc_XD1_XDFFM_CLKB_XD2_t1 r0 *1 0,0
Ccc_XD1_XDFFM_CLKB_XD2_t1 XD1_XDFFM_CLKB XD2_t1 1.21e-17
* device instance cc_XD1_XDFFM_CLKB_XD3_XDFFM_CLKB r0 *1 0,0
Ccc_XD1_XDFFM_CLKB_XD3_XDFFM_CLKB XD1_XDFFM_CLKB XD3_XDFFM_CLKB 1.8151e-17
* device instance cc_XD1_XDFFM_CLKB_XD3_XDFFM_M r0 *1 0,0
Ccc_XD1_XDFFM_CLKB_XD3_XDFFM_M XD1_XDFFM_CLKB XD3_XDFFM_M 2.4201e-17
* device instance cc_XD1_XDFFM_CLKB_XD3_XDFFM_MB r0 *1 0,0
Ccc_XD1_XDFFM_CLKB_XD3_XDFFM_MB XD1_XDFFM_CLKB XD3_XDFFM_MB 1.21e-17
* device instance cc_XD1_XDFFM_CLKB_XD3_XDFFM_S r0 *1 0,0
Ccc_XD1_XDFFM_CLKB_XD3_XDFFM_S XD1_XDFFM_CLKB XD3_XDFFM_S 1.8151e-17
* device instance cc_XD1_XDFFM_CLKB_XD3_XDFFM_SB r0 *1 0,0
Ccc_XD1_XDFFM_CLKB_XD3_XDFFM_SB XD1_XDFFM_CLKB XD3_XDFFM_SB 1.8151e-17
* device instance cc_XD1_XDFFM_CLKB_XD3_XDFFQ_CLKB r0 *1 0,0
Ccc_XD1_XDFFM_CLKB_XD3_XDFFQ_CLKB XD1_XDFFM_CLKB XD3_XDFFQ_CLKB 1.8151e-17
* device instance cc_XD1_XDFFM_CLKB_XD3_XDFFQ_M r0 *1 0,0
Ccc_XD1_XDFFM_CLKB_XD3_XDFFQ_M XD1_XDFFM_CLKB XD3_XDFFQ_M 2.4201e-17
* device instance cc_XD1_XDFFM_CLKB_XD3_XDFFQ_MB r0 *1 0,0
Ccc_XD1_XDFFM_CLKB_XD3_XDFFQ_MB XD1_XDFFM_CLKB XD3_XDFFQ_MB 1.21e-17
* device instance cc_XD1_XDFFM_CLKB_XD3_XDFFQ_S r0 *1 0,0
Ccc_XD1_XDFFM_CLKB_XD3_XDFFQ_S XD1_XDFFM_CLKB XD3_XDFFQ_S 1.8151e-17
* device instance cc_XD1_XDFFM_CLKB_XD3_XDFFQ_SB r0 *1 0,0
Ccc_XD1_XDFFM_CLKB_XD3_XDFFQ_SB XD1_XDFFM_CLKB XD3_XDFFQ_SB 1.8151e-17
* device instance cc_XD1_XDFFM_CLKB_XD3_XN2_mid1 r0 *1 0,0
Ccc_XD1_XDFFM_CLKB_XD3_XN2_mid1 XD1_XDFFM_CLKB XD3_XN2_mid1 1.21e-17
* device instance cc_XD1_XDFFM_CLKB_XD3_XN3_mid1 r0 *1 0,0
Ccc_XD1_XDFFM_CLKB_XD3_XN3_mid1 XD1_XDFFM_CLKB XD3_XN3_mid1 1.21e-17
* device instance cc_XD1_XDFFM_CLKB_XD3_XN3_mid2 r0 *1 0,0
Ccc_XD1_XDFFM_CLKB_XD3_XN3_mid2 XD1_XDFFM_CLKB XD3_XN3_mid2 1.21e-17
* device instance cc_XD1_XDFFM_CLKB_XD3_dmodout r0 *1 0,0
Ccc_XD1_XDFFM_CLKB_XD3_dmodout XD1_XDFFM_CLKB XD3_dmodout 1.21e-17
* device instance cc_XD1_XDFFM_CLKB_XD3_dq r0 *1 0,0
Ccc_XD1_XDFFM_CLKB_XD3_dq XD1_XDFFM_CLKB XD3_dq 1.8151e-17
* device instance cc_XD1_XDFFM_CLKB_XD3_nm r0 *1 0,0
Ccc_XD1_XDFFM_CLKB_XD3_nm XD1_XDFFM_CLKB XD3_nm 1.21e-17
* device instance cc_XD1_XDFFM_CLKB_XD3_nt r0 *1 0,0
Ccc_XD1_XDFFM_CLKB_XD3_nt XD1_XDFFM_CLKB XD3_nt 1.21e-17
* device instance cc_XD1_XDFFM_CLKB_XD3_t1 r0 *1 0,0
Ccc_XD1_XDFFM_CLKB_XD3_t1 XD1_XDFFM_CLKB XD3_t1 1.21e-17
* device instance cc_XD1_XDFFM_CLKB_XD4_XDFFM_CLKB r0 *1 0,0
Ccc_XD1_XDFFM_CLKB_XD4_XDFFM_CLKB XD1_XDFFM_CLKB XD4_XDFFM_CLKB 1.8151e-17
* device instance cc_XD1_XDFFM_CLKB_XD4_XDFFM_M r0 *1 0,0
Ccc_XD1_XDFFM_CLKB_XD4_XDFFM_M XD1_XDFFM_CLKB XD4_XDFFM_M 2.4201e-17
* device instance cc_XD1_XDFFM_CLKB_XD4_XDFFM_MB r0 *1 0,0
Ccc_XD1_XDFFM_CLKB_XD4_XDFFM_MB XD1_XDFFM_CLKB XD4_XDFFM_MB 1.21e-17
* device instance cc_XD1_XDFFM_CLKB_XD4_XDFFM_S r0 *1 0,0
Ccc_XD1_XDFFM_CLKB_XD4_XDFFM_S XD1_XDFFM_CLKB XD4_XDFFM_S 1.8151e-17
* device instance cc_XD1_XDFFM_CLKB_XD4_XDFFM_SB r0 *1 0,0
Ccc_XD1_XDFFM_CLKB_XD4_XDFFM_SB XD1_XDFFM_CLKB XD4_XDFFM_SB 1.8151e-17
* device instance cc_XD1_XDFFM_CLKB_XD4_XDFFQ_CLKB r0 *1 0,0
Ccc_XD1_XDFFM_CLKB_XD4_XDFFQ_CLKB XD1_XDFFM_CLKB XD4_XDFFQ_CLKB 1.8151e-17
* device instance cc_XD1_XDFFM_CLKB_XD4_XDFFQ_M r0 *1 0,0
Ccc_XD1_XDFFM_CLKB_XD4_XDFFQ_M XD1_XDFFM_CLKB XD4_XDFFQ_M 2.4201e-17
* device instance cc_XD1_XDFFM_CLKB_XD4_XDFFQ_MB r0 *1 0,0
Ccc_XD1_XDFFM_CLKB_XD4_XDFFQ_MB XD1_XDFFM_CLKB XD4_XDFFQ_MB 1.21e-17
* device instance cc_XD1_XDFFM_CLKB_XD4_XDFFQ_S r0 *1 0,0
Ccc_XD1_XDFFM_CLKB_XD4_XDFFQ_S XD1_XDFFM_CLKB XD4_XDFFQ_S 1.8151e-17
* device instance cc_XD1_XDFFM_CLKB_XD4_XDFFQ_SB r0 *1 0,0
Ccc_XD1_XDFFM_CLKB_XD4_XDFFQ_SB XD1_XDFFM_CLKB XD4_XDFFQ_SB 1.8151e-17
* device instance cc_XD1_XDFFM_CLKB_XD4_XN2_mid1 r0 *1 0,0
Ccc_XD1_XDFFM_CLKB_XD4_XN2_mid1 XD1_XDFFM_CLKB XD4_XN2_mid1 1.21e-17
* device instance cc_XD1_XDFFM_CLKB_XD4_XN3_mid1 r0 *1 0,0
Ccc_XD1_XDFFM_CLKB_XD4_XN3_mid1 XD1_XDFFM_CLKB XD4_XN3_mid1 1.21e-17
* device instance cc_XD1_XDFFM_CLKB_XD4_XN3_mid2 r0 *1 0,0
Ccc_XD1_XDFFM_CLKB_XD4_XN3_mid2 XD1_XDFFM_CLKB XD4_XN3_mid2 1.21e-17
* device instance cc_XD1_XDFFM_CLKB_XD4_dmodout r0 *1 0,0
Ccc_XD1_XDFFM_CLKB_XD4_dmodout XD1_XDFFM_CLKB XD4_dmodout 1.21e-17
* device instance cc_XD1_XDFFM_CLKB_XD4_dq r0 *1 0,0
Ccc_XD1_XDFFM_CLKB_XD4_dq XD1_XDFFM_CLKB XD4_dq 1.8151e-17
* device instance cc_XD1_XDFFM_CLKB_XD4_nm r0 *1 0,0
Ccc_XD1_XDFFM_CLKB_XD4_nm XD1_XDFFM_CLKB XD4_nm 1.21e-17
* device instance cc_XD1_XDFFM_CLKB_XD4_nt r0 *1 0,0
Ccc_XD1_XDFFM_CLKB_XD4_nt XD1_XDFFM_CLKB XD4_nt 1.21e-17
* device instance cc_XD1_XDFFM_CLKB_XD4_t1 r0 *1 0,0
Ccc_XD1_XDFFM_CLKB_XD4_t1 XD1_XDFFM_CLKB XD4_t1 1.21e-17
* device instance cc_XD1_XDFFM_CLKB_XD5_XDFFM_CLKB r0 *1 0,0
Ccc_XD1_XDFFM_CLKB_XD5_XDFFM_CLKB XD1_XDFFM_CLKB XD5_XDFFM_CLKB 1.8151e-17
* device instance cc_XD1_XDFFM_CLKB_XD5_XDFFM_M r0 *1 0,0
Ccc_XD1_XDFFM_CLKB_XD5_XDFFM_M XD1_XDFFM_CLKB XD5_XDFFM_M 2.4201e-17
* device instance cc_XD1_XDFFM_CLKB_XD5_XDFFM_MB r0 *1 0,0
Ccc_XD1_XDFFM_CLKB_XD5_XDFFM_MB XD1_XDFFM_CLKB XD5_XDFFM_MB 1.21e-17
* device instance cc_XD1_XDFFM_CLKB_XD5_XDFFM_S r0 *1 0,0
Ccc_XD1_XDFFM_CLKB_XD5_XDFFM_S XD1_XDFFM_CLKB XD5_XDFFM_S 1.8151e-17
* device instance cc_XD1_XDFFM_CLKB_XD5_XDFFM_SB r0 *1 0,0
Ccc_XD1_XDFFM_CLKB_XD5_XDFFM_SB XD1_XDFFM_CLKB XD5_XDFFM_SB 1.8151e-17
* device instance cc_XD1_XDFFM_CLKB_XD5_XDFFQ_CLKB r0 *1 0,0
Ccc_XD1_XDFFM_CLKB_XD5_XDFFQ_CLKB XD1_XDFFM_CLKB XD5_XDFFQ_CLKB 1.8151e-17
* device instance cc_XD1_XDFFM_CLKB_XD5_XDFFQ_M r0 *1 0,0
Ccc_XD1_XDFFM_CLKB_XD5_XDFFQ_M XD1_XDFFM_CLKB XD5_XDFFQ_M 2.4201e-17
* device instance cc_XD1_XDFFM_CLKB_XD5_XDFFQ_MB r0 *1 0,0
Ccc_XD1_XDFFM_CLKB_XD5_XDFFQ_MB XD1_XDFFM_CLKB XD5_XDFFQ_MB 1.21e-17
* device instance cc_XD1_XDFFM_CLKB_XD5_XDFFQ_S r0 *1 0,0
Ccc_XD1_XDFFM_CLKB_XD5_XDFFQ_S XD1_XDFFM_CLKB XD5_XDFFQ_S 1.8151e-17
* device instance cc_XD1_XDFFM_CLKB_XD5_XDFFQ_SB r0 *1 0,0
Ccc_XD1_XDFFM_CLKB_XD5_XDFFQ_SB XD1_XDFFM_CLKB XD5_XDFFQ_SB 1.8151e-17
* device instance cc_XD1_XDFFM_CLKB_XD5_XN2_mid1 r0 *1 0,0
Ccc_XD1_XDFFM_CLKB_XD5_XN2_mid1 XD1_XDFFM_CLKB XD5_XN2_mid1 1.21e-17
* device instance cc_XD1_XDFFM_CLKB_XD5_XN3_mid1 r0 *1 0,0
Ccc_XD1_XDFFM_CLKB_XD5_XN3_mid1 XD1_XDFFM_CLKB XD5_XN3_mid1 1.21e-17
* device instance cc_XD1_XDFFM_CLKB_XD5_XN3_mid2 r0 *1 0,0
Ccc_XD1_XDFFM_CLKB_XD5_XN3_mid2 XD1_XDFFM_CLKB XD5_XN3_mid2 1.21e-17
* device instance cc_XD1_XDFFM_CLKB_XD5_dmodout r0 *1 0,0
Ccc_XD1_XDFFM_CLKB_XD5_dmodout XD1_XDFFM_CLKB XD5_dmodout 1.21e-17
* device instance cc_XD1_XDFFM_CLKB_XD5_dq r0 *1 0,0
Ccc_XD1_XDFFM_CLKB_XD5_dq XD1_XDFFM_CLKB XD5_dq 1.8151e-17
* device instance cc_XD1_XDFFM_CLKB_XD5_nm r0 *1 0,0
Ccc_XD1_XDFFM_CLKB_XD5_nm XD1_XDFFM_CLKB XD5_nm 1.21e-17
* device instance cc_XD1_XDFFM_CLKB_XD5_nt r0 *1 0,0
Ccc_XD1_XDFFM_CLKB_XD5_nt XD1_XDFFM_CLKB XD5_nt 1.21e-17
* device instance cc_XD1_XDFFM_CLKB_XD5_t1 r0 *1 0,0
Ccc_XD1_XDFFM_CLKB_XD5_t1 XD1_XDFFM_CLKB XD5_t1 1.21e-17
* device instance cc_XD1_XDFFM_CLKB_XFRT_CLKB r0 *1 0,0
Ccc_XD1_XDFFM_CLKB_XFRT_CLKB XD1_XDFFM_CLKB XFRT_CLKB 1.8151e-17
* device instance cc_XD1_XDFFM_CLKB_XFRT_M r0 *1 0,0
Ccc_XD1_XDFFM_CLKB_XFRT_M XD1_XDFFM_CLKB XFRT_M 2.4201e-17
* device instance cc_XD1_XDFFM_CLKB_XFRT_MB r0 *1 0,0
Ccc_XD1_XDFFM_CLKB_XFRT_MB XD1_XDFFM_CLKB XFRT_MB 1.21e-17
* device instance cc_XD1_XDFFM_CLKB_XFRT_S r0 *1 0,0
Ccc_XD1_XDFFM_CLKB_XFRT_S XD1_XDFFM_CLKB XFRT_S 1.8151e-17
* device instance cc_XD1_XDFFM_CLKB_XFRT_SB r0 *1 0,0
Ccc_XD1_XDFFM_CLKB_XFRT_SB XD1_XDFFM_CLKB XFRT_SB 1.8151e-17
* device instance cc_XD1_XDFFM_CLKB_ck1 r0 *1 0,0
Ccc_XD1_XDFFM_CLKB_ck1 XD1_XDFFM_CLKB ck1 6.0502e-17
* device instance cc_XD1_XDFFM_CLKB_ck2 r0 *1 0,0
Ccc_XD1_XDFFM_CLKB_ck2 XD1_XDFFM_CLKB ck2 5.4452e-17
* device instance cc_XD1_XDFFM_CLKB_ck3 r0 *1 0,0
Ccc_XD1_XDFFM_CLKB_ck3 XD1_XDFFM_CLKB ck3 5.4452e-17
* device instance cc_XD1_XDFFM_CLKB_ck4 r0 *1 0,0
Ccc_XD1_XDFFM_CLKB_ck4 XD1_XDFFM_CLKB ck4 5.4452e-17
* device instance cc_XD1_XDFFM_CLKB_ck5 r0 *1 0,0
Ccc_XD1_XDFFM_CLKB_ck5 XD1_XDFFM_CLKB ck5 5.4452e-17
* device instance cc_XD1_XDFFM_CLKB_mod0 r0 *1 0,0
Ccc_XD1_XDFFM_CLKB_mod0 XD1_XDFFM_CLKB mod0 2.4201e-17
* device instance cc_XD1_XDFFM_CLKB_mod1 r0 *1 0,0
Ccc_XD1_XDFFM_CLKB_mod1 XD1_XDFFM_CLKB mod1 2.4201e-17
* device instance cc_XD1_XDFFM_CLKB_mod2 r0 *1 0,0
Ccc_XD1_XDFFM_CLKB_mod2 XD1_XDFFM_CLKB mod2 2.4201e-17
* device instance cc_XD1_XDFFM_CLKB_mod3 r0 *1 0,0
Ccc_XD1_XDFFM_CLKB_mod3 XD1_XDFFM_CLKB mod3 2.4201e-17
* device instance cc_XD1_XDFFM_CLKB_mod4 r0 *1 0,0
Ccc_XD1_XDFFM_CLKB_mod4 XD1_XDFFM_CLKB mod4 2.4201e-17
* device instance cc_XD1_XDFFM_CLKB_net1 r0 *1 0,0
Ccc_XD1_XDFFM_CLKB_net1 XD1_XDFFM_CLKB net1 1.21e-17
* device instance cc_XD1_XDFFM_M_XD1_XDFFM_MB r0 *1 0,0
Ccc_XD1_XDFFM_M_XD1_XDFFM_MB XD1_XDFFM_M XD1_XDFFM_MB 3.4688e-17
* device instance cc_XD1_XDFFM_M_XD1_XDFFM_S r0 *1 0,0
Ccc_XD1_XDFFM_M_XD1_XDFFM_S XD1_XDFFM_M XD1_XDFFM_S 2.8638e-17
* device instance cc_XD1_XDFFM_M_XD1_XDFFM_SB r0 *1 0,0
Ccc_XD1_XDFFM_M_XD1_XDFFM_SB XD1_XDFFM_M XD1_XDFFM_SB 1.8151e-17
* device instance cc_XD1_XDFFM_M_XD1_XDFFQ_CLKB r0 *1 0,0
Ccc_XD1_XDFFM_M_XD1_XDFFQ_CLKB XD1_XDFFM_M XD1_XDFFQ_CLKB 1.8151e-17
* device instance cc_XD1_XDFFM_M_XD1_XDFFQ_M r0 *1 0,0
Ccc_XD1_XDFFM_M_XD1_XDFFQ_M XD1_XDFFM_M XD1_XDFFQ_M 2.4201e-17
* device instance cc_XD1_XDFFM_M_XD1_XDFFQ_MB r0 *1 0,0
Ccc_XD1_XDFFM_M_XD1_XDFFQ_MB XD1_XDFFM_M XD1_XDFFQ_MB 1.21e-17
* device instance cc_XD1_XDFFM_M_XD1_XDFFQ_S r0 *1 0,0
Ccc_XD1_XDFFM_M_XD1_XDFFQ_S XD1_XDFFM_M XD1_XDFFQ_S 1.8151e-17
* device instance cc_XD1_XDFFM_M_XD1_XDFFQ_SB r0 *1 0,0
Ccc_XD1_XDFFM_M_XD1_XDFFQ_SB XD1_XDFFM_M XD1_XDFFQ_SB 1.8151e-17
* device instance cc_XD1_XDFFM_M_XD1_XNOR_midp r0 *1 0,0
Ccc_XD1_XDFFM_M_XD1_XNOR_midp XD1_XDFFM_M XD1_XNOR_midp 1.21e-17
* device instance cc_XD1_XDFFM_M_XD1_dmodout r0 *1 0,0
Ccc_XD1_XDFFM_M_XD1_dmodout XD1_XDFFM_M XD1_dmodout 2.8638e-17
* device instance cc_XD1_XDFFM_M_XD1_dq r0 *1 0,0
Ccc_XD1_XDFFM_M_XD1_dq XD1_XDFFM_M XD1_dq 1.21e-17
* device instance cc_XD1_XDFFM_M_XD1_nm r0 *1 0,0
Ccc_XD1_XDFFM_M_XD1_nm XD1_XDFFM_M XD1_nm 1.8151e-17
* device instance cc_XD1_XDFFM_M_XD1_nt r0 *1 0,0
Ccc_XD1_XDFFM_M_XD1_nt XD1_XDFFM_M XD1_nt 2.4201e-17
* device instance cc_XD1_XDFFM_M_XD1_t1 r0 *1 0,0
Ccc_XD1_XDFFM_M_XD1_t1 XD1_XDFFM_M XD1_t1 1.21e-17
* device instance cc_XD1_XDFFM_M_XD2_XDFFM_CLKB r0 *1 0,0
Ccc_XD1_XDFFM_M_XD2_XDFFM_CLKB XD1_XDFFM_M XD2_XDFFM_CLKB 1.8151e-17
* device instance cc_XD1_XDFFM_M_XD2_XDFFM_M r0 *1 0,0
Ccc_XD1_XDFFM_M_XD2_XDFFM_M XD1_XDFFM_M XD2_XDFFM_M 2.4201e-17
* device instance cc_XD1_XDFFM_M_XD2_XDFFM_MB r0 *1 0,0
Ccc_XD1_XDFFM_M_XD2_XDFFM_MB XD1_XDFFM_M XD2_XDFFM_MB 1.21e-17
* device instance cc_XD1_XDFFM_M_XD2_XDFFM_S r0 *1 0,0
Ccc_XD1_XDFFM_M_XD2_XDFFM_S XD1_XDFFM_M XD2_XDFFM_S 1.8151e-17
* device instance cc_XD1_XDFFM_M_XD2_XDFFM_SB r0 *1 0,0
Ccc_XD1_XDFFM_M_XD2_XDFFM_SB XD1_XDFFM_M XD2_XDFFM_SB 1.8151e-17
* device instance cc_XD1_XDFFM_M_XD2_XDFFQ_CLKB r0 *1 0,0
Ccc_XD1_XDFFM_M_XD2_XDFFQ_CLKB XD1_XDFFM_M XD2_XDFFQ_CLKB 1.8151e-17
* device instance cc_XD1_XDFFM_M_XD2_XDFFQ_M r0 *1 0,0
Ccc_XD1_XDFFM_M_XD2_XDFFQ_M XD1_XDFFM_M XD2_XDFFQ_M 2.4201e-17
* device instance cc_XD1_XDFFM_M_XD2_XDFFQ_MB r0 *1 0,0
Ccc_XD1_XDFFM_M_XD2_XDFFQ_MB XD1_XDFFM_M XD2_XDFFQ_MB 1.21e-17
* device instance cc_XD1_XDFFM_M_XD2_XDFFQ_S r0 *1 0,0
Ccc_XD1_XDFFM_M_XD2_XDFFQ_S XD1_XDFFM_M XD2_XDFFQ_S 1.8151e-17
* device instance cc_XD1_XDFFM_M_XD2_XDFFQ_SB r0 *1 0,0
Ccc_XD1_XDFFM_M_XD2_XDFFQ_SB XD1_XDFFM_M XD2_XDFFQ_SB 1.8151e-17
* device instance cc_XD1_XDFFM_M_XD2_XN2_mid1 r0 *1 0,0
Ccc_XD1_XDFFM_M_XD2_XN2_mid1 XD1_XDFFM_M XD2_XN2_mid1 1.21e-17
* device instance cc_XD1_XDFFM_M_XD2_XN3_mid1 r0 *1 0,0
Ccc_XD1_XDFFM_M_XD2_XN3_mid1 XD1_XDFFM_M XD2_XN3_mid1 1.21e-17
* device instance cc_XD1_XDFFM_M_XD2_XN3_mid2 r0 *1 0,0
Ccc_XD1_XDFFM_M_XD2_XN3_mid2 XD1_XDFFM_M XD2_XN3_mid2 1.21e-17
* device instance cc_XD1_XDFFM_M_XD2_dmodout r0 *1 0,0
Ccc_XD1_XDFFM_M_XD2_dmodout XD1_XDFFM_M XD2_dmodout 1.21e-17
* device instance cc_XD1_XDFFM_M_XD2_dq r0 *1 0,0
Ccc_XD1_XDFFM_M_XD2_dq XD1_XDFFM_M XD2_dq 1.8151e-17
* device instance cc_XD1_XDFFM_M_XD2_nm r0 *1 0,0
Ccc_XD1_XDFFM_M_XD2_nm XD1_XDFFM_M XD2_nm 1.21e-17
* device instance cc_XD1_XDFFM_M_XD2_nt r0 *1 0,0
Ccc_XD1_XDFFM_M_XD2_nt XD1_XDFFM_M XD2_nt 1.21e-17
* device instance cc_XD1_XDFFM_M_XD2_t1 r0 *1 0,0
Ccc_XD1_XDFFM_M_XD2_t1 XD1_XDFFM_M XD2_t1 1.21e-17
* device instance cc_XD1_XDFFM_M_XD3_XDFFM_CLKB r0 *1 0,0
Ccc_XD1_XDFFM_M_XD3_XDFFM_CLKB XD1_XDFFM_M XD3_XDFFM_CLKB 1.8151e-17
* device instance cc_XD1_XDFFM_M_XD3_XDFFM_M r0 *1 0,0
Ccc_XD1_XDFFM_M_XD3_XDFFM_M XD1_XDFFM_M XD3_XDFFM_M 2.4201e-17
* device instance cc_XD1_XDFFM_M_XD3_XDFFM_MB r0 *1 0,0
Ccc_XD1_XDFFM_M_XD3_XDFFM_MB XD1_XDFFM_M XD3_XDFFM_MB 1.21e-17
* device instance cc_XD1_XDFFM_M_XD3_XDFFM_S r0 *1 0,0
Ccc_XD1_XDFFM_M_XD3_XDFFM_S XD1_XDFFM_M XD3_XDFFM_S 1.8151e-17
* device instance cc_XD1_XDFFM_M_XD3_XDFFM_SB r0 *1 0,0
Ccc_XD1_XDFFM_M_XD3_XDFFM_SB XD1_XDFFM_M XD3_XDFFM_SB 1.8151e-17
* device instance cc_XD1_XDFFM_M_XD3_XDFFQ_CLKB r0 *1 0,0
Ccc_XD1_XDFFM_M_XD3_XDFFQ_CLKB XD1_XDFFM_M XD3_XDFFQ_CLKB 1.8151e-17
* device instance cc_XD1_XDFFM_M_XD3_XDFFQ_M r0 *1 0,0
Ccc_XD1_XDFFM_M_XD3_XDFFQ_M XD1_XDFFM_M XD3_XDFFQ_M 2.4201e-17
* device instance cc_XD1_XDFFM_M_XD3_XDFFQ_MB r0 *1 0,0
Ccc_XD1_XDFFM_M_XD3_XDFFQ_MB XD1_XDFFM_M XD3_XDFFQ_MB 1.21e-17
* device instance cc_XD1_XDFFM_M_XD3_XDFFQ_S r0 *1 0,0
Ccc_XD1_XDFFM_M_XD3_XDFFQ_S XD1_XDFFM_M XD3_XDFFQ_S 1.8151e-17
* device instance cc_XD1_XDFFM_M_XD3_XDFFQ_SB r0 *1 0,0
Ccc_XD1_XDFFM_M_XD3_XDFFQ_SB XD1_XDFFM_M XD3_XDFFQ_SB 1.8151e-17
* device instance cc_XD1_XDFFM_M_XD3_XN2_mid1 r0 *1 0,0
Ccc_XD1_XDFFM_M_XD3_XN2_mid1 XD1_XDFFM_M XD3_XN2_mid1 1.21e-17
* device instance cc_XD1_XDFFM_M_XD3_XN3_mid1 r0 *1 0,0
Ccc_XD1_XDFFM_M_XD3_XN3_mid1 XD1_XDFFM_M XD3_XN3_mid1 1.21e-17
* device instance cc_XD1_XDFFM_M_XD3_XN3_mid2 r0 *1 0,0
Ccc_XD1_XDFFM_M_XD3_XN3_mid2 XD1_XDFFM_M XD3_XN3_mid2 1.21e-17
* device instance cc_XD1_XDFFM_M_XD3_dmodout r0 *1 0,0
Ccc_XD1_XDFFM_M_XD3_dmodout XD1_XDFFM_M XD3_dmodout 1.21e-17
* device instance cc_XD1_XDFFM_M_XD3_dq r0 *1 0,0
Ccc_XD1_XDFFM_M_XD3_dq XD1_XDFFM_M XD3_dq 1.8151e-17
* device instance cc_XD1_XDFFM_M_XD3_nm r0 *1 0,0
Ccc_XD1_XDFFM_M_XD3_nm XD1_XDFFM_M XD3_nm 1.21e-17
* device instance cc_XD1_XDFFM_M_XD3_nt r0 *1 0,0
Ccc_XD1_XDFFM_M_XD3_nt XD1_XDFFM_M XD3_nt 1.21e-17
* device instance cc_XD1_XDFFM_M_XD3_t1 r0 *1 0,0
Ccc_XD1_XDFFM_M_XD3_t1 XD1_XDFFM_M XD3_t1 1.21e-17
* device instance cc_XD1_XDFFM_M_XD4_XDFFM_CLKB r0 *1 0,0
Ccc_XD1_XDFFM_M_XD4_XDFFM_CLKB XD1_XDFFM_M XD4_XDFFM_CLKB 1.8151e-17
* device instance cc_XD1_XDFFM_M_XD4_XDFFM_M r0 *1 0,0
Ccc_XD1_XDFFM_M_XD4_XDFFM_M XD1_XDFFM_M XD4_XDFFM_M 2.4201e-17
* device instance cc_XD1_XDFFM_M_XD4_XDFFM_MB r0 *1 0,0
Ccc_XD1_XDFFM_M_XD4_XDFFM_MB XD1_XDFFM_M XD4_XDFFM_MB 1.21e-17
* device instance cc_XD1_XDFFM_M_XD4_XDFFM_S r0 *1 0,0
Ccc_XD1_XDFFM_M_XD4_XDFFM_S XD1_XDFFM_M XD4_XDFFM_S 1.8151e-17
* device instance cc_XD1_XDFFM_M_XD4_XDFFM_SB r0 *1 0,0
Ccc_XD1_XDFFM_M_XD4_XDFFM_SB XD1_XDFFM_M XD4_XDFFM_SB 1.8151e-17
* device instance cc_XD1_XDFFM_M_XD4_XDFFQ_CLKB r0 *1 0,0
Ccc_XD1_XDFFM_M_XD4_XDFFQ_CLKB XD1_XDFFM_M XD4_XDFFQ_CLKB 1.8151e-17
* device instance cc_XD1_XDFFM_M_XD4_XDFFQ_M r0 *1 0,0
Ccc_XD1_XDFFM_M_XD4_XDFFQ_M XD1_XDFFM_M XD4_XDFFQ_M 2.4201e-17
* device instance cc_XD1_XDFFM_M_XD4_XDFFQ_MB r0 *1 0,0
Ccc_XD1_XDFFM_M_XD4_XDFFQ_MB XD1_XDFFM_M XD4_XDFFQ_MB 1.21e-17
* device instance cc_XD1_XDFFM_M_XD4_XDFFQ_S r0 *1 0,0
Ccc_XD1_XDFFM_M_XD4_XDFFQ_S XD1_XDFFM_M XD4_XDFFQ_S 1.8151e-17
* device instance cc_XD1_XDFFM_M_XD4_XDFFQ_SB r0 *1 0,0
Ccc_XD1_XDFFM_M_XD4_XDFFQ_SB XD1_XDFFM_M XD4_XDFFQ_SB 1.8151e-17
* device instance cc_XD1_XDFFM_M_XD4_XN2_mid1 r0 *1 0,0
Ccc_XD1_XDFFM_M_XD4_XN2_mid1 XD1_XDFFM_M XD4_XN2_mid1 1.21e-17
* device instance cc_XD1_XDFFM_M_XD4_XN3_mid1 r0 *1 0,0
Ccc_XD1_XDFFM_M_XD4_XN3_mid1 XD1_XDFFM_M XD4_XN3_mid1 1.21e-17
* device instance cc_XD1_XDFFM_M_XD4_XN3_mid2 r0 *1 0,0
Ccc_XD1_XDFFM_M_XD4_XN3_mid2 XD1_XDFFM_M XD4_XN3_mid2 1.21e-17
* device instance cc_XD1_XDFFM_M_XD4_dmodout r0 *1 0,0
Ccc_XD1_XDFFM_M_XD4_dmodout XD1_XDFFM_M XD4_dmodout 1.21e-17
* device instance cc_XD1_XDFFM_M_XD4_dq r0 *1 0,0
Ccc_XD1_XDFFM_M_XD4_dq XD1_XDFFM_M XD4_dq 1.8151e-17
* device instance cc_XD1_XDFFM_M_XD4_nm r0 *1 0,0
Ccc_XD1_XDFFM_M_XD4_nm XD1_XDFFM_M XD4_nm 1.21e-17
* device instance cc_XD1_XDFFM_M_XD4_nt r0 *1 0,0
Ccc_XD1_XDFFM_M_XD4_nt XD1_XDFFM_M XD4_nt 1.21e-17
* device instance cc_XD1_XDFFM_M_XD4_t1 r0 *1 0,0
Ccc_XD1_XDFFM_M_XD4_t1 XD1_XDFFM_M XD4_t1 1.21e-17
* device instance cc_XD1_XDFFM_M_XD5_XDFFM_CLKB r0 *1 0,0
Ccc_XD1_XDFFM_M_XD5_XDFFM_CLKB XD1_XDFFM_M XD5_XDFFM_CLKB 1.8151e-17
* device instance cc_XD1_XDFFM_M_XD5_XDFFM_M r0 *1 0,0
Ccc_XD1_XDFFM_M_XD5_XDFFM_M XD1_XDFFM_M XD5_XDFFM_M 2.4201e-17
* device instance cc_XD1_XDFFM_M_XD5_XDFFM_MB r0 *1 0,0
Ccc_XD1_XDFFM_M_XD5_XDFFM_MB XD1_XDFFM_M XD5_XDFFM_MB 1.21e-17
* device instance cc_XD1_XDFFM_M_XD5_XDFFM_S r0 *1 0,0
Ccc_XD1_XDFFM_M_XD5_XDFFM_S XD1_XDFFM_M XD5_XDFFM_S 1.8151e-17
* device instance cc_XD1_XDFFM_M_XD5_XDFFM_SB r0 *1 0,0
Ccc_XD1_XDFFM_M_XD5_XDFFM_SB XD1_XDFFM_M XD5_XDFFM_SB 1.8151e-17
* device instance cc_XD1_XDFFM_M_XD5_XDFFQ_CLKB r0 *1 0,0
Ccc_XD1_XDFFM_M_XD5_XDFFQ_CLKB XD1_XDFFM_M XD5_XDFFQ_CLKB 1.8151e-17
* device instance cc_XD1_XDFFM_M_XD5_XDFFQ_M r0 *1 0,0
Ccc_XD1_XDFFM_M_XD5_XDFFQ_M XD1_XDFFM_M XD5_XDFFQ_M 2.4201e-17
* device instance cc_XD1_XDFFM_M_XD5_XDFFQ_MB r0 *1 0,0
Ccc_XD1_XDFFM_M_XD5_XDFFQ_MB XD1_XDFFM_M XD5_XDFFQ_MB 1.21e-17
* device instance cc_XD1_XDFFM_M_XD5_XDFFQ_S r0 *1 0,0
Ccc_XD1_XDFFM_M_XD5_XDFFQ_S XD1_XDFFM_M XD5_XDFFQ_S 1.8151e-17
* device instance cc_XD1_XDFFM_M_XD5_XDFFQ_SB r0 *1 0,0
Ccc_XD1_XDFFM_M_XD5_XDFFQ_SB XD1_XDFFM_M XD5_XDFFQ_SB 1.8151e-17
* device instance cc_XD1_XDFFM_M_XD5_XN2_mid1 r0 *1 0,0
Ccc_XD1_XDFFM_M_XD5_XN2_mid1 XD1_XDFFM_M XD5_XN2_mid1 1.21e-17
* device instance cc_XD1_XDFFM_M_XD5_XN3_mid1 r0 *1 0,0
Ccc_XD1_XDFFM_M_XD5_XN3_mid1 XD1_XDFFM_M XD5_XN3_mid1 1.21e-17
* device instance cc_XD1_XDFFM_M_XD5_XN3_mid2 r0 *1 0,0
Ccc_XD1_XDFFM_M_XD5_XN3_mid2 XD1_XDFFM_M XD5_XN3_mid2 1.21e-17
* device instance cc_XD1_XDFFM_M_XD5_dmodout r0 *1 0,0
Ccc_XD1_XDFFM_M_XD5_dmodout XD1_XDFFM_M XD5_dmodout 1.21e-17
* device instance cc_XD1_XDFFM_M_XD5_dq r0 *1 0,0
Ccc_XD1_XDFFM_M_XD5_dq XD1_XDFFM_M XD5_dq 1.8151e-17
* device instance cc_XD1_XDFFM_M_XD5_nm r0 *1 0,0
Ccc_XD1_XDFFM_M_XD5_nm XD1_XDFFM_M XD5_nm 1.21e-17
* device instance cc_XD1_XDFFM_M_XD5_nt r0 *1 0,0
Ccc_XD1_XDFFM_M_XD5_nt XD1_XDFFM_M XD5_nt 1.21e-17
* device instance cc_XD1_XDFFM_M_XD5_t1 r0 *1 0,0
Ccc_XD1_XDFFM_M_XD5_t1 XD1_XDFFM_M XD5_t1 1.21e-17
* device instance cc_XD1_XDFFM_M_XFRT_CLKB r0 *1 0,0
Ccc_XD1_XDFFM_M_XFRT_CLKB XD1_XDFFM_M XFRT_CLKB 1.8151e-17
* device instance cc_XD1_XDFFM_M_XFRT_M r0 *1 0,0
Ccc_XD1_XDFFM_M_XFRT_M XD1_XDFFM_M XFRT_M 2.4201e-17
* device instance cc_XD1_XDFFM_M_XFRT_MB r0 *1 0,0
Ccc_XD1_XDFFM_M_XFRT_MB XD1_XDFFM_M XFRT_MB 1.21e-17
* device instance cc_XD1_XDFFM_M_XFRT_S r0 *1 0,0
Ccc_XD1_XDFFM_M_XFRT_S XD1_XDFFM_M XFRT_S 1.8151e-17
* device instance cc_XD1_XDFFM_M_XFRT_SB r0 *1 0,0
Ccc_XD1_XDFFM_M_XFRT_SB XD1_XDFFM_M XFRT_SB 1.8151e-17
* device instance cc_XD1_XDFFM_M_ck1 r0 *1 0,0
Ccc_XD1_XDFFM_M_ck1 XD1_XDFFM_M ck1 6.0502e-17
* device instance cc_XD1_XDFFM_M_ck2 r0 *1 0,0
Ccc_XD1_XDFFM_M_ck2 XD1_XDFFM_M ck2 5.4452e-17
* device instance cc_XD1_XDFFM_M_ck3 r0 *1 0,0
Ccc_XD1_XDFFM_M_ck3 XD1_XDFFM_M ck3 5.4452e-17
* device instance cc_XD1_XDFFM_M_ck4 r0 *1 0,0
Ccc_XD1_XDFFM_M_ck4 XD1_XDFFM_M ck4 5.4452e-17
* device instance cc_XD1_XDFFM_M_ck5 r0 *1 0,0
Ccc_XD1_XDFFM_M_ck5 XD1_XDFFM_M ck5 5.4452e-17
* device instance cc_XD1_XDFFM_M_mod0 r0 *1 0,0
Ccc_XD1_XDFFM_M_mod0 XD1_XDFFM_M mod0 2.4201e-17
* device instance cc_XD1_XDFFM_M_mod1 r0 *1 0,0
Ccc_XD1_XDFFM_M_mod1 XD1_XDFFM_M mod1 2.4201e-17
* device instance cc_XD1_XDFFM_M_mod2 r0 *1 0,0
Ccc_XD1_XDFFM_M_mod2 XD1_XDFFM_M mod2 2.4201e-17
* device instance cc_XD1_XDFFM_M_mod3 r0 *1 0,0
Ccc_XD1_XDFFM_M_mod3 XD1_XDFFM_M mod3 2.4201e-17
* device instance cc_XD1_XDFFM_M_mod4 r0 *1 0,0
Ccc_XD1_XDFFM_M_mod4 XD1_XDFFM_M mod4 2.4201e-17
* device instance cc_XD1_XDFFM_M_net1 r0 *1 0,0
Ccc_XD1_XDFFM_M_net1 XD1_XDFFM_M net1 1.21e-17
* device instance cc_XD1_XDFFM_MB_XD1_XDFFM_S r0 *1 0,0
Ccc_XD1_XDFFM_MB_XD1_XDFFM_S XD1_XDFFM_MB XD1_XDFFM_S 1.8151e-17
* device instance cc_XD1_XDFFM_MB_XD1_XDFFM_SB r0 *1 0,0
Ccc_XD1_XDFFM_MB_XD1_XDFFM_SB XD1_XDFFM_MB XD1_XDFFM_SB 1.8151e-17
* device instance cc_XD1_XDFFM_MB_XD1_XDFFQ_CLKB r0 *1 0,0
Ccc_XD1_XDFFM_MB_XD1_XDFFQ_CLKB XD1_XDFFM_MB XD1_XDFFQ_CLKB 1.8151e-17
* device instance cc_XD1_XDFFM_MB_XD1_XDFFQ_M r0 *1 0,0
Ccc_XD1_XDFFM_MB_XD1_XDFFQ_M XD1_XDFFM_MB XD1_XDFFQ_M 2.4201e-17
* device instance cc_XD1_XDFFM_MB_XD1_XDFFQ_MB r0 *1 0,0
Ccc_XD1_XDFFM_MB_XD1_XDFFQ_MB XD1_XDFFM_MB XD1_XDFFQ_MB 1.21e-17
* device instance cc_XD1_XDFFM_MB_XD1_XDFFQ_S r0 *1 0,0
Ccc_XD1_XDFFM_MB_XD1_XDFFQ_S XD1_XDFFM_MB XD1_XDFFQ_S 1.8151e-17
* device instance cc_XD1_XDFFM_MB_XD1_XDFFQ_SB r0 *1 0,0
Ccc_XD1_XDFFM_MB_XD1_XDFFQ_SB XD1_XDFFM_MB XD1_XDFFQ_SB 1.8151e-17
* device instance cc_XD1_XDFFM_MB_XD1_XNOR_midp r0 *1 0,0
Ccc_XD1_XDFFM_MB_XD1_XNOR_midp XD1_XDFFM_MB XD1_XNOR_midp 1.21e-17
* device instance cc_XD1_XDFFM_MB_XD1_dmodout r0 *1 0,0
Ccc_XD1_XDFFM_MB_XD1_dmodout XD1_XDFFM_MB XD1_dmodout 1.21e-17
* device instance cc_XD1_XDFFM_MB_XD1_dq r0 *1 0,0
Ccc_XD1_XDFFM_MB_XD1_dq XD1_XDFFM_MB XD1_dq 1.21e-17
* device instance cc_XD1_XDFFM_MB_XD1_nm r0 *1 0,0
Ccc_XD1_XDFFM_MB_XD1_nm XD1_XDFFM_MB XD1_nm 1.8151e-17
* device instance cc_XD1_XDFFM_MB_XD1_nt r0 *1 0,0
Ccc_XD1_XDFFM_MB_XD1_nt XD1_XDFFM_MB XD1_nt 2.4201e-17
* device instance cc_XD1_XDFFM_MB_XD1_t1 r0 *1 0,0
Ccc_XD1_XDFFM_MB_XD1_t1 XD1_XDFFM_MB XD1_t1 1.21e-17
* device instance cc_XD1_XDFFM_MB_XD2_XDFFM_CLKB r0 *1 0,0
Ccc_XD1_XDFFM_MB_XD2_XDFFM_CLKB XD1_XDFFM_MB XD2_XDFFM_CLKB 1.8151e-17
* device instance cc_XD1_XDFFM_MB_XD2_XDFFM_M r0 *1 0,0
Ccc_XD1_XDFFM_MB_XD2_XDFFM_M XD1_XDFFM_MB XD2_XDFFM_M 2.4201e-17
* device instance cc_XD1_XDFFM_MB_XD2_XDFFM_MB r0 *1 0,0
Ccc_XD1_XDFFM_MB_XD2_XDFFM_MB XD1_XDFFM_MB XD2_XDFFM_MB 1.21e-17
* device instance cc_XD1_XDFFM_MB_XD2_XDFFM_S r0 *1 0,0
Ccc_XD1_XDFFM_MB_XD2_XDFFM_S XD1_XDFFM_MB XD2_XDFFM_S 1.8151e-17
* device instance cc_XD1_XDFFM_MB_XD2_XDFFM_SB r0 *1 0,0
Ccc_XD1_XDFFM_MB_XD2_XDFFM_SB XD1_XDFFM_MB XD2_XDFFM_SB 1.8151e-17
* device instance cc_XD1_XDFFM_MB_XD2_XDFFQ_CLKB r0 *1 0,0
Ccc_XD1_XDFFM_MB_XD2_XDFFQ_CLKB XD1_XDFFM_MB XD2_XDFFQ_CLKB 1.8151e-17
* device instance cc_XD1_XDFFM_MB_XD2_XDFFQ_M r0 *1 0,0
Ccc_XD1_XDFFM_MB_XD2_XDFFQ_M XD1_XDFFM_MB XD2_XDFFQ_M 2.4201e-17
* device instance cc_XD1_XDFFM_MB_XD2_XDFFQ_MB r0 *1 0,0
Ccc_XD1_XDFFM_MB_XD2_XDFFQ_MB XD1_XDFFM_MB XD2_XDFFQ_MB 1.21e-17
* device instance cc_XD1_XDFFM_MB_XD2_XDFFQ_S r0 *1 0,0
Ccc_XD1_XDFFM_MB_XD2_XDFFQ_S XD1_XDFFM_MB XD2_XDFFQ_S 1.8151e-17
* device instance cc_XD1_XDFFM_MB_XD2_XDFFQ_SB r0 *1 0,0
Ccc_XD1_XDFFM_MB_XD2_XDFFQ_SB XD1_XDFFM_MB XD2_XDFFQ_SB 1.8151e-17
* device instance cc_XD1_XDFFM_MB_XD2_XN2_mid1 r0 *1 0,0
Ccc_XD1_XDFFM_MB_XD2_XN2_mid1 XD1_XDFFM_MB XD2_XN2_mid1 1.21e-17
* device instance cc_XD1_XDFFM_MB_XD2_XN3_mid1 r0 *1 0,0
Ccc_XD1_XDFFM_MB_XD2_XN3_mid1 XD1_XDFFM_MB XD2_XN3_mid1 1.21e-17
* device instance cc_XD1_XDFFM_MB_XD2_XN3_mid2 r0 *1 0,0
Ccc_XD1_XDFFM_MB_XD2_XN3_mid2 XD1_XDFFM_MB XD2_XN3_mid2 1.21e-17
* device instance cc_XD1_XDFFM_MB_XD2_dmodout r0 *1 0,0
Ccc_XD1_XDFFM_MB_XD2_dmodout XD1_XDFFM_MB XD2_dmodout 1.21e-17
* device instance cc_XD1_XDFFM_MB_XD2_dq r0 *1 0,0
Ccc_XD1_XDFFM_MB_XD2_dq XD1_XDFFM_MB XD2_dq 1.8151e-17
* device instance cc_XD1_XDFFM_MB_XD2_nm r0 *1 0,0
Ccc_XD1_XDFFM_MB_XD2_nm XD1_XDFFM_MB XD2_nm 1.21e-17
* device instance cc_XD1_XDFFM_MB_XD2_nt r0 *1 0,0
Ccc_XD1_XDFFM_MB_XD2_nt XD1_XDFFM_MB XD2_nt 1.21e-17
* device instance cc_XD1_XDFFM_MB_XD2_t1 r0 *1 0,0
Ccc_XD1_XDFFM_MB_XD2_t1 XD1_XDFFM_MB XD2_t1 1.21e-17
* device instance cc_XD1_XDFFM_MB_XD3_XDFFM_CLKB r0 *1 0,0
Ccc_XD1_XDFFM_MB_XD3_XDFFM_CLKB XD1_XDFFM_MB XD3_XDFFM_CLKB 1.8151e-17
* device instance cc_XD1_XDFFM_MB_XD3_XDFFM_M r0 *1 0,0
Ccc_XD1_XDFFM_MB_XD3_XDFFM_M XD1_XDFFM_MB XD3_XDFFM_M 2.4201e-17
* device instance cc_XD1_XDFFM_MB_XD3_XDFFM_MB r0 *1 0,0
Ccc_XD1_XDFFM_MB_XD3_XDFFM_MB XD1_XDFFM_MB XD3_XDFFM_MB 1.21e-17
* device instance cc_XD1_XDFFM_MB_XD3_XDFFM_S r0 *1 0,0
Ccc_XD1_XDFFM_MB_XD3_XDFFM_S XD1_XDFFM_MB XD3_XDFFM_S 1.8151e-17
* device instance cc_XD1_XDFFM_MB_XD3_XDFFM_SB r0 *1 0,0
Ccc_XD1_XDFFM_MB_XD3_XDFFM_SB XD1_XDFFM_MB XD3_XDFFM_SB 1.8151e-17
* device instance cc_XD1_XDFFM_MB_XD3_XDFFQ_CLKB r0 *1 0,0
Ccc_XD1_XDFFM_MB_XD3_XDFFQ_CLKB XD1_XDFFM_MB XD3_XDFFQ_CLKB 1.8151e-17
* device instance cc_XD1_XDFFM_MB_XD3_XDFFQ_M r0 *1 0,0
Ccc_XD1_XDFFM_MB_XD3_XDFFQ_M XD1_XDFFM_MB XD3_XDFFQ_M 2.4201e-17
* device instance cc_XD1_XDFFM_MB_XD3_XDFFQ_MB r0 *1 0,0
Ccc_XD1_XDFFM_MB_XD3_XDFFQ_MB XD1_XDFFM_MB XD3_XDFFQ_MB 1.21e-17
* device instance cc_XD1_XDFFM_MB_XD3_XDFFQ_S r0 *1 0,0
Ccc_XD1_XDFFM_MB_XD3_XDFFQ_S XD1_XDFFM_MB XD3_XDFFQ_S 1.8151e-17
* device instance cc_XD1_XDFFM_MB_XD3_XDFFQ_SB r0 *1 0,0
Ccc_XD1_XDFFM_MB_XD3_XDFFQ_SB XD1_XDFFM_MB XD3_XDFFQ_SB 1.8151e-17
* device instance cc_XD1_XDFFM_MB_XD3_XN2_mid1 r0 *1 0,0
Ccc_XD1_XDFFM_MB_XD3_XN2_mid1 XD1_XDFFM_MB XD3_XN2_mid1 1.21e-17
* device instance cc_XD1_XDFFM_MB_XD3_XN3_mid1 r0 *1 0,0
Ccc_XD1_XDFFM_MB_XD3_XN3_mid1 XD1_XDFFM_MB XD3_XN3_mid1 1.21e-17
* device instance cc_XD1_XDFFM_MB_XD3_XN3_mid2 r0 *1 0,0
Ccc_XD1_XDFFM_MB_XD3_XN3_mid2 XD1_XDFFM_MB XD3_XN3_mid2 1.21e-17
* device instance cc_XD1_XDFFM_MB_XD3_dmodout r0 *1 0,0
Ccc_XD1_XDFFM_MB_XD3_dmodout XD1_XDFFM_MB XD3_dmodout 1.21e-17
* device instance cc_XD1_XDFFM_MB_XD3_dq r0 *1 0,0
Ccc_XD1_XDFFM_MB_XD3_dq XD1_XDFFM_MB XD3_dq 1.8151e-17
* device instance cc_XD1_XDFFM_MB_XD3_nm r0 *1 0,0
Ccc_XD1_XDFFM_MB_XD3_nm XD1_XDFFM_MB XD3_nm 1.21e-17
* device instance cc_XD1_XDFFM_MB_XD3_nt r0 *1 0,0
Ccc_XD1_XDFFM_MB_XD3_nt XD1_XDFFM_MB XD3_nt 1.21e-17
* device instance cc_XD1_XDFFM_MB_XD3_t1 r0 *1 0,0
Ccc_XD1_XDFFM_MB_XD3_t1 XD1_XDFFM_MB XD3_t1 1.21e-17
* device instance cc_XD1_XDFFM_MB_XD4_XDFFM_CLKB r0 *1 0,0
Ccc_XD1_XDFFM_MB_XD4_XDFFM_CLKB XD1_XDFFM_MB XD4_XDFFM_CLKB 1.8151e-17
* device instance cc_XD1_XDFFM_MB_XD4_XDFFM_M r0 *1 0,0
Ccc_XD1_XDFFM_MB_XD4_XDFFM_M XD1_XDFFM_MB XD4_XDFFM_M 2.4201e-17
* device instance cc_XD1_XDFFM_MB_XD4_XDFFM_MB r0 *1 0,0
Ccc_XD1_XDFFM_MB_XD4_XDFFM_MB XD1_XDFFM_MB XD4_XDFFM_MB 1.21e-17
* device instance cc_XD1_XDFFM_MB_XD4_XDFFM_S r0 *1 0,0
Ccc_XD1_XDFFM_MB_XD4_XDFFM_S XD1_XDFFM_MB XD4_XDFFM_S 1.8151e-17
* device instance cc_XD1_XDFFM_MB_XD4_XDFFM_SB r0 *1 0,0
Ccc_XD1_XDFFM_MB_XD4_XDFFM_SB XD1_XDFFM_MB XD4_XDFFM_SB 1.8151e-17
* device instance cc_XD1_XDFFM_MB_XD4_XDFFQ_CLKB r0 *1 0,0
Ccc_XD1_XDFFM_MB_XD4_XDFFQ_CLKB XD1_XDFFM_MB XD4_XDFFQ_CLKB 1.8151e-17
* device instance cc_XD1_XDFFM_MB_XD4_XDFFQ_M r0 *1 0,0
Ccc_XD1_XDFFM_MB_XD4_XDFFQ_M XD1_XDFFM_MB XD4_XDFFQ_M 2.4201e-17
* device instance cc_XD1_XDFFM_MB_XD4_XDFFQ_MB r0 *1 0,0
Ccc_XD1_XDFFM_MB_XD4_XDFFQ_MB XD1_XDFFM_MB XD4_XDFFQ_MB 1.21e-17
* device instance cc_XD1_XDFFM_MB_XD4_XDFFQ_S r0 *1 0,0
Ccc_XD1_XDFFM_MB_XD4_XDFFQ_S XD1_XDFFM_MB XD4_XDFFQ_S 1.8151e-17
* device instance cc_XD1_XDFFM_MB_XD4_XDFFQ_SB r0 *1 0,0
Ccc_XD1_XDFFM_MB_XD4_XDFFQ_SB XD1_XDFFM_MB XD4_XDFFQ_SB 1.8151e-17
* device instance cc_XD1_XDFFM_MB_XD4_XN2_mid1 r0 *1 0,0
Ccc_XD1_XDFFM_MB_XD4_XN2_mid1 XD1_XDFFM_MB XD4_XN2_mid1 1.21e-17
* device instance cc_XD1_XDFFM_MB_XD4_XN3_mid1 r0 *1 0,0
Ccc_XD1_XDFFM_MB_XD4_XN3_mid1 XD1_XDFFM_MB XD4_XN3_mid1 1.21e-17
* device instance cc_XD1_XDFFM_MB_XD4_XN3_mid2 r0 *1 0,0
Ccc_XD1_XDFFM_MB_XD4_XN3_mid2 XD1_XDFFM_MB XD4_XN3_mid2 1.21e-17
* device instance cc_XD1_XDFFM_MB_XD4_dmodout r0 *1 0,0
Ccc_XD1_XDFFM_MB_XD4_dmodout XD1_XDFFM_MB XD4_dmodout 1.21e-17
* device instance cc_XD1_XDFFM_MB_XD4_dq r0 *1 0,0
Ccc_XD1_XDFFM_MB_XD4_dq XD1_XDFFM_MB XD4_dq 1.8151e-17
* device instance cc_XD1_XDFFM_MB_XD4_nm r0 *1 0,0
Ccc_XD1_XDFFM_MB_XD4_nm XD1_XDFFM_MB XD4_nm 1.21e-17
* device instance cc_XD1_XDFFM_MB_XD4_nt r0 *1 0,0
Ccc_XD1_XDFFM_MB_XD4_nt XD1_XDFFM_MB XD4_nt 1.21e-17
* device instance cc_XD1_XDFFM_MB_XD4_t1 r0 *1 0,0
Ccc_XD1_XDFFM_MB_XD4_t1 XD1_XDFFM_MB XD4_t1 1.21e-17
* device instance cc_XD1_XDFFM_MB_XD5_XDFFM_CLKB r0 *1 0,0
Ccc_XD1_XDFFM_MB_XD5_XDFFM_CLKB XD1_XDFFM_MB XD5_XDFFM_CLKB 1.8151e-17
* device instance cc_XD1_XDFFM_MB_XD5_XDFFM_M r0 *1 0,0
Ccc_XD1_XDFFM_MB_XD5_XDFFM_M XD1_XDFFM_MB XD5_XDFFM_M 2.4201e-17
* device instance cc_XD1_XDFFM_MB_XD5_XDFFM_MB r0 *1 0,0
Ccc_XD1_XDFFM_MB_XD5_XDFFM_MB XD1_XDFFM_MB XD5_XDFFM_MB 1.21e-17
* device instance cc_XD1_XDFFM_MB_XD5_XDFFM_S r0 *1 0,0
Ccc_XD1_XDFFM_MB_XD5_XDFFM_S XD1_XDFFM_MB XD5_XDFFM_S 1.8151e-17
* device instance cc_XD1_XDFFM_MB_XD5_XDFFM_SB r0 *1 0,0
Ccc_XD1_XDFFM_MB_XD5_XDFFM_SB XD1_XDFFM_MB XD5_XDFFM_SB 1.8151e-17
* device instance cc_XD1_XDFFM_MB_XD5_XDFFQ_CLKB r0 *1 0,0
Ccc_XD1_XDFFM_MB_XD5_XDFFQ_CLKB XD1_XDFFM_MB XD5_XDFFQ_CLKB 1.8151e-17
* device instance cc_XD1_XDFFM_MB_XD5_XDFFQ_M r0 *1 0,0
Ccc_XD1_XDFFM_MB_XD5_XDFFQ_M XD1_XDFFM_MB XD5_XDFFQ_M 2.4201e-17
* device instance cc_XD1_XDFFM_MB_XD5_XDFFQ_MB r0 *1 0,0
Ccc_XD1_XDFFM_MB_XD5_XDFFQ_MB XD1_XDFFM_MB XD5_XDFFQ_MB 1.21e-17
* device instance cc_XD1_XDFFM_MB_XD5_XDFFQ_S r0 *1 0,0
Ccc_XD1_XDFFM_MB_XD5_XDFFQ_S XD1_XDFFM_MB XD5_XDFFQ_S 1.8151e-17
* device instance cc_XD1_XDFFM_MB_XD5_XDFFQ_SB r0 *1 0,0
Ccc_XD1_XDFFM_MB_XD5_XDFFQ_SB XD1_XDFFM_MB XD5_XDFFQ_SB 1.8151e-17
* device instance cc_XD1_XDFFM_MB_XD5_XN2_mid1 r0 *1 0,0
Ccc_XD1_XDFFM_MB_XD5_XN2_mid1 XD1_XDFFM_MB XD5_XN2_mid1 1.21e-17
* device instance cc_XD1_XDFFM_MB_XD5_XN3_mid1 r0 *1 0,0
Ccc_XD1_XDFFM_MB_XD5_XN3_mid1 XD1_XDFFM_MB XD5_XN3_mid1 1.21e-17
* device instance cc_XD1_XDFFM_MB_XD5_XN3_mid2 r0 *1 0,0
Ccc_XD1_XDFFM_MB_XD5_XN3_mid2 XD1_XDFFM_MB XD5_XN3_mid2 1.21e-17
* device instance cc_XD1_XDFFM_MB_XD5_dmodout r0 *1 0,0
Ccc_XD1_XDFFM_MB_XD5_dmodout XD1_XDFFM_MB XD5_dmodout 1.21e-17
* device instance cc_XD1_XDFFM_MB_XD5_dq r0 *1 0,0
Ccc_XD1_XDFFM_MB_XD5_dq XD1_XDFFM_MB XD5_dq 1.8151e-17
* device instance cc_XD1_XDFFM_MB_XD5_nm r0 *1 0,0
Ccc_XD1_XDFFM_MB_XD5_nm XD1_XDFFM_MB XD5_nm 1.21e-17
* device instance cc_XD1_XDFFM_MB_XD5_nt r0 *1 0,0
Ccc_XD1_XDFFM_MB_XD5_nt XD1_XDFFM_MB XD5_nt 1.21e-17
* device instance cc_XD1_XDFFM_MB_XD5_t1 r0 *1 0,0
Ccc_XD1_XDFFM_MB_XD5_t1 XD1_XDFFM_MB XD5_t1 1.21e-17
* device instance cc_XD1_XDFFM_MB_XFRT_CLKB r0 *1 0,0
Ccc_XD1_XDFFM_MB_XFRT_CLKB XD1_XDFFM_MB XFRT_CLKB 1.8151e-17
* device instance cc_XD1_XDFFM_MB_XFRT_M r0 *1 0,0
Ccc_XD1_XDFFM_MB_XFRT_M XD1_XDFFM_MB XFRT_M 2.4201e-17
* device instance cc_XD1_XDFFM_MB_XFRT_MB r0 *1 0,0
Ccc_XD1_XDFFM_MB_XFRT_MB XD1_XDFFM_MB XFRT_MB 1.21e-17
* device instance cc_XD1_XDFFM_MB_XFRT_S r0 *1 0,0
Ccc_XD1_XDFFM_MB_XFRT_S XD1_XDFFM_MB XFRT_S 1.8151e-17
* device instance cc_XD1_XDFFM_MB_XFRT_SB r0 *1 0,0
Ccc_XD1_XDFFM_MB_XFRT_SB XD1_XDFFM_MB XFRT_SB 1.8151e-17
* device instance cc_XD1_XDFFM_MB_ck1 r0 *1 0,0
Ccc_XD1_XDFFM_MB_ck1 XD1_XDFFM_MB ck1 6.0502e-17
* device instance cc_XD1_XDFFM_MB_ck2 r0 *1 0,0
Ccc_XD1_XDFFM_MB_ck2 XD1_XDFFM_MB ck2 5.4452e-17
* device instance cc_XD1_XDFFM_MB_ck3 r0 *1 0,0
Ccc_XD1_XDFFM_MB_ck3 XD1_XDFFM_MB ck3 5.4452e-17
* device instance cc_XD1_XDFFM_MB_ck4 r0 *1 0,0
Ccc_XD1_XDFFM_MB_ck4 XD1_XDFFM_MB ck4 5.4452e-17
* device instance cc_XD1_XDFFM_MB_ck5 r0 *1 0,0
Ccc_XD1_XDFFM_MB_ck5 XD1_XDFFM_MB ck5 5.4452e-17
* device instance cc_XD1_XDFFM_MB_mod0 r0 *1 0,0
Ccc_XD1_XDFFM_MB_mod0 XD1_XDFFM_MB mod0 2.4201e-17
* device instance cc_XD1_XDFFM_MB_mod1 r0 *1 0,0
Ccc_XD1_XDFFM_MB_mod1 XD1_XDFFM_MB mod1 2.4201e-17
* device instance cc_XD1_XDFFM_MB_mod2 r0 *1 0,0
Ccc_XD1_XDFFM_MB_mod2 XD1_XDFFM_MB mod2 2.4201e-17
* device instance cc_XD1_XDFFM_MB_mod3 r0 *1 0,0
Ccc_XD1_XDFFM_MB_mod3 XD1_XDFFM_MB mod3 2.4201e-17
* device instance cc_XD1_XDFFM_MB_mod4 r0 *1 0,0
Ccc_XD1_XDFFM_MB_mod4 XD1_XDFFM_MB mod4 2.4201e-17
* device instance cc_XD1_XDFFM_MB_net1 r0 *1 0,0
Ccc_XD1_XDFFM_MB_net1 XD1_XDFFM_MB net1 1.21e-17
* device instance cc_XD1_XDFFM_S_XD1_XDFFM_SB r0 *1 0,0
Ccc_XD1_XDFFM_S_XD1_XDFFM_SB XD1_XDFFM_S XD1_XDFFM_SB 4.0738e-17
* device instance cc_XD1_XDFFM_S_XD1_XDFFQ_CLKB r0 *1 0,0
Ccc_XD1_XDFFM_S_XD1_XDFFQ_CLKB XD1_XDFFM_S XD1_XDFFQ_CLKB 1.8151e-17
* device instance cc_XD1_XDFFM_S_XD1_XDFFQ_M r0 *1 0,0
Ccc_XD1_XDFFM_S_XD1_XDFFQ_M XD1_XDFFM_S XD1_XDFFQ_M 2.4201e-17
* device instance cc_XD1_XDFFM_S_XD1_XDFFQ_MB r0 *1 0,0
Ccc_XD1_XDFFM_S_XD1_XDFFQ_MB XD1_XDFFM_S XD1_XDFFQ_MB 1.21e-17
* device instance cc_XD1_XDFFM_S_XD1_XDFFQ_S r0 *1 0,0
Ccc_XD1_XDFFM_S_XD1_XDFFQ_S XD1_XDFFM_S XD1_XDFFQ_S 1.8151e-17
* device instance cc_XD1_XDFFM_S_XD1_XDFFQ_SB r0 *1 0,0
Ccc_XD1_XDFFM_S_XD1_XDFFQ_SB XD1_XDFFM_S XD1_XDFFQ_SB 1.8151e-17
* device instance cc_XD1_XDFFM_S_XD1_XNOR_midp r0 *1 0,0
Ccc_XD1_XDFFM_S_XD1_XNOR_midp XD1_XDFFM_S XD1_XNOR_midp 1.21e-17
* device instance cc_XD1_XDFFM_S_XD1_dmodout r0 *1 0,0
Ccc_XD1_XDFFM_S_XD1_dmodout XD1_XDFFM_S XD1_dmodout 1.21e-17
* device instance cc_XD1_XDFFM_S_XD1_dq r0 *1 0,0
Ccc_XD1_XDFFM_S_XD1_dq XD1_XDFFM_S XD1_dq 1.21e-17
* device instance cc_XD1_XDFFM_S_XD1_nm r0 *1 0,0
Ccc_XD1_XDFFM_S_XD1_nm XD1_XDFFM_S XD1_nm 1.8151e-17
* device instance cc_XD1_XDFFM_S_XD1_nt r0 *1 0,0
Ccc_XD1_XDFFM_S_XD1_nt XD1_XDFFM_S XD1_nt 2.4201e-17
* device instance cc_XD1_XDFFM_S_XD1_t1 r0 *1 0,0
Ccc_XD1_XDFFM_S_XD1_t1 XD1_XDFFM_S XD1_t1 1.21e-17
* device instance cc_XD1_XDFFM_S_XD2_XDFFM_CLKB r0 *1 0,0
Ccc_XD1_XDFFM_S_XD2_XDFFM_CLKB XD1_XDFFM_S XD2_XDFFM_CLKB 1.8151e-17
* device instance cc_XD1_XDFFM_S_XD2_XDFFM_M r0 *1 0,0
Ccc_XD1_XDFFM_S_XD2_XDFFM_M XD1_XDFFM_S XD2_XDFFM_M 2.4201e-17
* device instance cc_XD1_XDFFM_S_XD2_XDFFM_MB r0 *1 0,0
Ccc_XD1_XDFFM_S_XD2_XDFFM_MB XD1_XDFFM_S XD2_XDFFM_MB 1.21e-17
* device instance cc_XD1_XDFFM_S_XD2_XDFFM_S r0 *1 0,0
Ccc_XD1_XDFFM_S_XD2_XDFFM_S XD1_XDFFM_S XD2_XDFFM_S 1.8151e-17
* device instance cc_XD1_XDFFM_S_XD2_XDFFM_SB r0 *1 0,0
Ccc_XD1_XDFFM_S_XD2_XDFFM_SB XD1_XDFFM_S XD2_XDFFM_SB 1.8151e-17
* device instance cc_XD1_XDFFM_S_XD2_XDFFQ_CLKB r0 *1 0,0
Ccc_XD1_XDFFM_S_XD2_XDFFQ_CLKB XD1_XDFFM_S XD2_XDFFQ_CLKB 1.8151e-17
* device instance cc_XD1_XDFFM_S_XD2_XDFFQ_M r0 *1 0,0
Ccc_XD1_XDFFM_S_XD2_XDFFQ_M XD1_XDFFM_S XD2_XDFFQ_M 2.4201e-17
* device instance cc_XD1_XDFFM_S_XD2_XDFFQ_MB r0 *1 0,0
Ccc_XD1_XDFFM_S_XD2_XDFFQ_MB XD1_XDFFM_S XD2_XDFFQ_MB 1.21e-17
* device instance cc_XD1_XDFFM_S_XD2_XDFFQ_S r0 *1 0,0
Ccc_XD1_XDFFM_S_XD2_XDFFQ_S XD1_XDFFM_S XD2_XDFFQ_S 1.8151e-17
* device instance cc_XD1_XDFFM_S_XD2_XDFFQ_SB r0 *1 0,0
Ccc_XD1_XDFFM_S_XD2_XDFFQ_SB XD1_XDFFM_S XD2_XDFFQ_SB 1.8151e-17
* device instance cc_XD1_XDFFM_S_XD2_XN2_mid1 r0 *1 0,0
Ccc_XD1_XDFFM_S_XD2_XN2_mid1 XD1_XDFFM_S XD2_XN2_mid1 1.21e-17
* device instance cc_XD1_XDFFM_S_XD2_XN3_mid1 r0 *1 0,0
Ccc_XD1_XDFFM_S_XD2_XN3_mid1 XD1_XDFFM_S XD2_XN3_mid1 1.21e-17
* device instance cc_XD1_XDFFM_S_XD2_XN3_mid2 r0 *1 0,0
Ccc_XD1_XDFFM_S_XD2_XN3_mid2 XD1_XDFFM_S XD2_XN3_mid2 1.21e-17
* device instance cc_XD1_XDFFM_S_XD2_dmodout r0 *1 0,0
Ccc_XD1_XDFFM_S_XD2_dmodout XD1_XDFFM_S XD2_dmodout 1.21e-17
* device instance cc_XD1_XDFFM_S_XD2_dq r0 *1 0,0
Ccc_XD1_XDFFM_S_XD2_dq XD1_XDFFM_S XD2_dq 1.8151e-17
* device instance cc_XD1_XDFFM_S_XD2_nm r0 *1 0,0
Ccc_XD1_XDFFM_S_XD2_nm XD1_XDFFM_S XD2_nm 1.21e-17
* device instance cc_XD1_XDFFM_S_XD2_nt r0 *1 0,0
Ccc_XD1_XDFFM_S_XD2_nt XD1_XDFFM_S XD2_nt 1.21e-17
* device instance cc_XD1_XDFFM_S_XD2_t1 r0 *1 0,0
Ccc_XD1_XDFFM_S_XD2_t1 XD1_XDFFM_S XD2_t1 1.21e-17
* device instance cc_XD1_XDFFM_S_XD3_XDFFM_CLKB r0 *1 0,0
Ccc_XD1_XDFFM_S_XD3_XDFFM_CLKB XD1_XDFFM_S XD3_XDFFM_CLKB 1.8151e-17
* device instance cc_XD1_XDFFM_S_XD3_XDFFM_M r0 *1 0,0
Ccc_XD1_XDFFM_S_XD3_XDFFM_M XD1_XDFFM_S XD3_XDFFM_M 2.4201e-17
* device instance cc_XD1_XDFFM_S_XD3_XDFFM_MB r0 *1 0,0
Ccc_XD1_XDFFM_S_XD3_XDFFM_MB XD1_XDFFM_S XD3_XDFFM_MB 1.21e-17
* device instance cc_XD1_XDFFM_S_XD3_XDFFM_S r0 *1 0,0
Ccc_XD1_XDFFM_S_XD3_XDFFM_S XD1_XDFFM_S XD3_XDFFM_S 1.8151e-17
* device instance cc_XD1_XDFFM_S_XD3_XDFFM_SB r0 *1 0,0
Ccc_XD1_XDFFM_S_XD3_XDFFM_SB XD1_XDFFM_S XD3_XDFFM_SB 1.8151e-17
* device instance cc_XD1_XDFFM_S_XD3_XDFFQ_CLKB r0 *1 0,0
Ccc_XD1_XDFFM_S_XD3_XDFFQ_CLKB XD1_XDFFM_S XD3_XDFFQ_CLKB 1.8151e-17
* device instance cc_XD1_XDFFM_S_XD3_XDFFQ_M r0 *1 0,0
Ccc_XD1_XDFFM_S_XD3_XDFFQ_M XD1_XDFFM_S XD3_XDFFQ_M 2.4201e-17
* device instance cc_XD1_XDFFM_S_XD3_XDFFQ_MB r0 *1 0,0
Ccc_XD1_XDFFM_S_XD3_XDFFQ_MB XD1_XDFFM_S XD3_XDFFQ_MB 1.21e-17
* device instance cc_XD1_XDFFM_S_XD3_XDFFQ_S r0 *1 0,0
Ccc_XD1_XDFFM_S_XD3_XDFFQ_S XD1_XDFFM_S XD3_XDFFQ_S 1.8151e-17
* device instance cc_XD1_XDFFM_S_XD3_XDFFQ_SB r0 *1 0,0
Ccc_XD1_XDFFM_S_XD3_XDFFQ_SB XD1_XDFFM_S XD3_XDFFQ_SB 1.8151e-17
* device instance cc_XD1_XDFFM_S_XD3_XN2_mid1 r0 *1 0,0
Ccc_XD1_XDFFM_S_XD3_XN2_mid1 XD1_XDFFM_S XD3_XN2_mid1 1.21e-17
* device instance cc_XD1_XDFFM_S_XD3_XN3_mid1 r0 *1 0,0
Ccc_XD1_XDFFM_S_XD3_XN3_mid1 XD1_XDFFM_S XD3_XN3_mid1 1.21e-17
* device instance cc_XD1_XDFFM_S_XD3_XN3_mid2 r0 *1 0,0
Ccc_XD1_XDFFM_S_XD3_XN3_mid2 XD1_XDFFM_S XD3_XN3_mid2 1.21e-17
* device instance cc_XD1_XDFFM_S_XD3_dmodout r0 *1 0,0
Ccc_XD1_XDFFM_S_XD3_dmodout XD1_XDFFM_S XD3_dmodout 1.21e-17
* device instance cc_XD1_XDFFM_S_XD3_dq r0 *1 0,0
Ccc_XD1_XDFFM_S_XD3_dq XD1_XDFFM_S XD3_dq 1.8151e-17
* device instance cc_XD1_XDFFM_S_XD3_nm r0 *1 0,0
Ccc_XD1_XDFFM_S_XD3_nm XD1_XDFFM_S XD3_nm 1.21e-17
* device instance cc_XD1_XDFFM_S_XD3_nt r0 *1 0,0
Ccc_XD1_XDFFM_S_XD3_nt XD1_XDFFM_S XD3_nt 1.21e-17
* device instance cc_XD1_XDFFM_S_XD3_t1 r0 *1 0,0
Ccc_XD1_XDFFM_S_XD3_t1 XD1_XDFFM_S XD3_t1 1.21e-17
* device instance cc_XD1_XDFFM_S_XD4_XDFFM_CLKB r0 *1 0,0
Ccc_XD1_XDFFM_S_XD4_XDFFM_CLKB XD1_XDFFM_S XD4_XDFFM_CLKB 1.8151e-17
* device instance cc_XD1_XDFFM_S_XD4_XDFFM_M r0 *1 0,0
Ccc_XD1_XDFFM_S_XD4_XDFFM_M XD1_XDFFM_S XD4_XDFFM_M 2.4201e-17
* device instance cc_XD1_XDFFM_S_XD4_XDFFM_MB r0 *1 0,0
Ccc_XD1_XDFFM_S_XD4_XDFFM_MB XD1_XDFFM_S XD4_XDFFM_MB 1.21e-17
* device instance cc_XD1_XDFFM_S_XD4_XDFFM_S r0 *1 0,0
Ccc_XD1_XDFFM_S_XD4_XDFFM_S XD1_XDFFM_S XD4_XDFFM_S 1.8151e-17
* device instance cc_XD1_XDFFM_S_XD4_XDFFM_SB r0 *1 0,0
Ccc_XD1_XDFFM_S_XD4_XDFFM_SB XD1_XDFFM_S XD4_XDFFM_SB 1.8151e-17
* device instance cc_XD1_XDFFM_S_XD4_XDFFQ_CLKB r0 *1 0,0
Ccc_XD1_XDFFM_S_XD4_XDFFQ_CLKB XD1_XDFFM_S XD4_XDFFQ_CLKB 1.8151e-17
* device instance cc_XD1_XDFFM_S_XD4_XDFFQ_M r0 *1 0,0
Ccc_XD1_XDFFM_S_XD4_XDFFQ_M XD1_XDFFM_S XD4_XDFFQ_M 2.4201e-17
* device instance cc_XD1_XDFFM_S_XD4_XDFFQ_MB r0 *1 0,0
Ccc_XD1_XDFFM_S_XD4_XDFFQ_MB XD1_XDFFM_S XD4_XDFFQ_MB 1.21e-17
* device instance cc_XD1_XDFFM_S_XD4_XDFFQ_S r0 *1 0,0
Ccc_XD1_XDFFM_S_XD4_XDFFQ_S XD1_XDFFM_S XD4_XDFFQ_S 1.8151e-17
* device instance cc_XD1_XDFFM_S_XD4_XDFFQ_SB r0 *1 0,0
Ccc_XD1_XDFFM_S_XD4_XDFFQ_SB XD1_XDFFM_S XD4_XDFFQ_SB 1.8151e-17
* device instance cc_XD1_XDFFM_S_XD4_XN2_mid1 r0 *1 0,0
Ccc_XD1_XDFFM_S_XD4_XN2_mid1 XD1_XDFFM_S XD4_XN2_mid1 1.21e-17
* device instance cc_XD1_XDFFM_S_XD4_XN3_mid1 r0 *1 0,0
Ccc_XD1_XDFFM_S_XD4_XN3_mid1 XD1_XDFFM_S XD4_XN3_mid1 1.21e-17
* device instance cc_XD1_XDFFM_S_XD4_XN3_mid2 r0 *1 0,0
Ccc_XD1_XDFFM_S_XD4_XN3_mid2 XD1_XDFFM_S XD4_XN3_mid2 1.21e-17
* device instance cc_XD1_XDFFM_S_XD4_dmodout r0 *1 0,0
Ccc_XD1_XDFFM_S_XD4_dmodout XD1_XDFFM_S XD4_dmodout 1.21e-17
* device instance cc_XD1_XDFFM_S_XD4_dq r0 *1 0,0
Ccc_XD1_XDFFM_S_XD4_dq XD1_XDFFM_S XD4_dq 1.8151e-17
* device instance cc_XD1_XDFFM_S_XD4_nm r0 *1 0,0
Ccc_XD1_XDFFM_S_XD4_nm XD1_XDFFM_S XD4_nm 1.21e-17
* device instance cc_XD1_XDFFM_S_XD4_nt r0 *1 0,0
Ccc_XD1_XDFFM_S_XD4_nt XD1_XDFFM_S XD4_nt 1.21e-17
* device instance cc_XD1_XDFFM_S_XD4_t1 r0 *1 0,0
Ccc_XD1_XDFFM_S_XD4_t1 XD1_XDFFM_S XD4_t1 1.21e-17
* device instance cc_XD1_XDFFM_S_XD5_XDFFM_CLKB r0 *1 0,0
Ccc_XD1_XDFFM_S_XD5_XDFFM_CLKB XD1_XDFFM_S XD5_XDFFM_CLKB 1.8151e-17
* device instance cc_XD1_XDFFM_S_XD5_XDFFM_M r0 *1 0,0
Ccc_XD1_XDFFM_S_XD5_XDFFM_M XD1_XDFFM_S XD5_XDFFM_M 2.4201e-17
* device instance cc_XD1_XDFFM_S_XD5_XDFFM_MB r0 *1 0,0
Ccc_XD1_XDFFM_S_XD5_XDFFM_MB XD1_XDFFM_S XD5_XDFFM_MB 1.21e-17
* device instance cc_XD1_XDFFM_S_XD5_XDFFM_S r0 *1 0,0
Ccc_XD1_XDFFM_S_XD5_XDFFM_S XD1_XDFFM_S XD5_XDFFM_S 1.8151e-17
* device instance cc_XD1_XDFFM_S_XD5_XDFFM_SB r0 *1 0,0
Ccc_XD1_XDFFM_S_XD5_XDFFM_SB XD1_XDFFM_S XD5_XDFFM_SB 1.8151e-17
* device instance cc_XD1_XDFFM_S_XD5_XDFFQ_CLKB r0 *1 0,0
Ccc_XD1_XDFFM_S_XD5_XDFFQ_CLKB XD1_XDFFM_S XD5_XDFFQ_CLKB 1.8151e-17
* device instance cc_XD1_XDFFM_S_XD5_XDFFQ_M r0 *1 0,0
Ccc_XD1_XDFFM_S_XD5_XDFFQ_M XD1_XDFFM_S XD5_XDFFQ_M 2.4201e-17
* device instance cc_XD1_XDFFM_S_XD5_XDFFQ_MB r0 *1 0,0
Ccc_XD1_XDFFM_S_XD5_XDFFQ_MB XD1_XDFFM_S XD5_XDFFQ_MB 1.21e-17
* device instance cc_XD1_XDFFM_S_XD5_XDFFQ_S r0 *1 0,0
Ccc_XD1_XDFFM_S_XD5_XDFFQ_S XD1_XDFFM_S XD5_XDFFQ_S 1.8151e-17
* device instance cc_XD1_XDFFM_S_XD5_XDFFQ_SB r0 *1 0,0
Ccc_XD1_XDFFM_S_XD5_XDFFQ_SB XD1_XDFFM_S XD5_XDFFQ_SB 1.8151e-17
* device instance cc_XD1_XDFFM_S_XD5_XN2_mid1 r0 *1 0,0
Ccc_XD1_XDFFM_S_XD5_XN2_mid1 XD1_XDFFM_S XD5_XN2_mid1 1.21e-17
* device instance cc_XD1_XDFFM_S_XD5_XN3_mid1 r0 *1 0,0
Ccc_XD1_XDFFM_S_XD5_XN3_mid1 XD1_XDFFM_S XD5_XN3_mid1 1.21e-17
* device instance cc_XD1_XDFFM_S_XD5_XN3_mid2 r0 *1 0,0
Ccc_XD1_XDFFM_S_XD5_XN3_mid2 XD1_XDFFM_S XD5_XN3_mid2 1.21e-17
* device instance cc_XD1_XDFFM_S_XD5_dmodout r0 *1 0,0
Ccc_XD1_XDFFM_S_XD5_dmodout XD1_XDFFM_S XD5_dmodout 1.21e-17
* device instance cc_XD1_XDFFM_S_XD5_dq r0 *1 0,0
Ccc_XD1_XDFFM_S_XD5_dq XD1_XDFFM_S XD5_dq 1.8151e-17
* device instance cc_XD1_XDFFM_S_XD5_nm r0 *1 0,0
Ccc_XD1_XDFFM_S_XD5_nm XD1_XDFFM_S XD5_nm 1.21e-17
* device instance cc_XD1_XDFFM_S_XD5_nt r0 *1 0,0
Ccc_XD1_XDFFM_S_XD5_nt XD1_XDFFM_S XD5_nt 1.21e-17
* device instance cc_XD1_XDFFM_S_XD5_t1 r0 *1 0,0
Ccc_XD1_XDFFM_S_XD5_t1 XD1_XDFFM_S XD5_t1 1.21e-17
* device instance cc_XD1_XDFFM_S_XFRT_CLKB r0 *1 0,0
Ccc_XD1_XDFFM_S_XFRT_CLKB XD1_XDFFM_S XFRT_CLKB 1.8151e-17
* device instance cc_XD1_XDFFM_S_XFRT_M r0 *1 0,0
Ccc_XD1_XDFFM_S_XFRT_M XD1_XDFFM_S XFRT_M 2.4201e-17
* device instance cc_XD1_XDFFM_S_XFRT_MB r0 *1 0,0
Ccc_XD1_XDFFM_S_XFRT_MB XD1_XDFFM_S XFRT_MB 1.21e-17
* device instance cc_XD1_XDFFM_S_XFRT_S r0 *1 0,0
Ccc_XD1_XDFFM_S_XFRT_S XD1_XDFFM_S XFRT_S 1.8151e-17
* device instance cc_XD1_XDFFM_S_XFRT_SB r0 *1 0,0
Ccc_XD1_XDFFM_S_XFRT_SB XD1_XDFFM_S XFRT_SB 1.8151e-17
* device instance cc_XD1_XDFFM_S_ck1 r0 *1 0,0
Ccc_XD1_XDFFM_S_ck1 XD1_XDFFM_S ck1 5.4452e-17
* device instance cc_XD1_XDFFM_S_ck2 r0 *1 0,0
Ccc_XD1_XDFFM_S_ck2 XD1_XDFFM_S ck2 5.4452e-17
* device instance cc_XD1_XDFFM_S_ck3 r0 *1 0,0
Ccc_XD1_XDFFM_S_ck3 XD1_XDFFM_S ck3 5.4452e-17
* device instance cc_XD1_XDFFM_S_ck4 r0 *1 0,0
Ccc_XD1_XDFFM_S_ck4 XD1_XDFFM_S ck4 5.4452e-17
* device instance cc_XD1_XDFFM_S_ck5 r0 *1 0,0
Ccc_XD1_XDFFM_S_ck5 XD1_XDFFM_S ck5 5.4452e-17
* device instance cc_XD1_XDFFM_S_mod0 r0 *1 0,0
Ccc_XD1_XDFFM_S_mod0 XD1_XDFFM_S mod0 2.4201e-17
* device instance cc_XD1_XDFFM_S_mod1 r0 *1 0,0
Ccc_XD1_XDFFM_S_mod1 XD1_XDFFM_S mod1 2.4201e-17
* device instance cc_XD1_XDFFM_S_mod2 r0 *1 0,0
Ccc_XD1_XDFFM_S_mod2 XD1_XDFFM_S mod2 2.4201e-17
* device instance cc_XD1_XDFFM_S_mod3 r0 *1 0,0
Ccc_XD1_XDFFM_S_mod3 XD1_XDFFM_S mod3 2.4201e-17
* device instance cc_XD1_XDFFM_S_mod4 r0 *1 0,0
Ccc_XD1_XDFFM_S_mod4 XD1_XDFFM_S mod4 2.4201e-17
* device instance cc_XD1_XDFFM_S_net1 r0 *1 0,0
Ccc_XD1_XDFFM_S_net1 XD1_XDFFM_S net1 1.21e-17
* device instance cc_XD1_XDFFM_SB_XD1_XDFFQ_CLKB r0 *1 0,0
Ccc_XD1_XDFFM_SB_XD1_XDFFQ_CLKB XD1_XDFFM_SB XD1_XDFFQ_CLKB 1.8151e-17
* device instance cc_XD1_XDFFM_SB_XD1_XDFFQ_M r0 *1 0,0
Ccc_XD1_XDFFM_SB_XD1_XDFFQ_M XD1_XDFFM_SB XD1_XDFFQ_M 2.4201e-17
* device instance cc_XD1_XDFFM_SB_XD1_XDFFQ_MB r0 *1 0,0
Ccc_XD1_XDFFM_SB_XD1_XDFFQ_MB XD1_XDFFM_SB XD1_XDFFQ_MB 1.21e-17
* device instance cc_XD1_XDFFM_SB_XD1_XDFFQ_S r0 *1 0,0
Ccc_XD1_XDFFM_SB_XD1_XDFFQ_S XD1_XDFFM_SB XD1_XDFFQ_S 1.8151e-17
* device instance cc_XD1_XDFFM_SB_XD1_XDFFQ_SB r0 *1 0,0
Ccc_XD1_XDFFM_SB_XD1_XDFFQ_SB XD1_XDFFM_SB XD1_XDFFQ_SB 1.8151e-17
* device instance cc_XD1_XDFFM_SB_XD1_XNOR_midp r0 *1 0,0
Ccc_XD1_XDFFM_SB_XD1_XNOR_midp XD1_XDFFM_SB XD1_XNOR_midp 1.21e-17
* device instance cc_XD1_XDFFM_SB_XD1_dmodout r0 *1 0,0
Ccc_XD1_XDFFM_SB_XD1_dmodout XD1_XDFFM_SB XD1_dmodout 1.21e-17
* device instance cc_XD1_XDFFM_SB_XD1_dq r0 *1 0,0
Ccc_XD1_XDFFM_SB_XD1_dq XD1_XDFFM_SB XD1_dq 1.21e-17
* device instance cc_XD1_XDFFM_SB_XD1_nm r0 *1 0,0
Ccc_XD1_XDFFM_SB_XD1_nm XD1_XDFFM_SB XD1_nm 1.8151e-17
* device instance cc_XD1_XDFFM_SB_XD1_nt r0 *1 0,0
Ccc_XD1_XDFFM_SB_XD1_nt XD1_XDFFM_SB XD1_nt 2.4201e-17
* device instance cc_XD1_XDFFM_SB_XD1_t1 r0 *1 0,0
Ccc_XD1_XDFFM_SB_XD1_t1 XD1_XDFFM_SB XD1_t1 1.21e-17
* device instance cc_XD1_XDFFM_SB_XD2_XDFFM_CLKB r0 *1 0,0
Ccc_XD1_XDFFM_SB_XD2_XDFFM_CLKB XD1_XDFFM_SB XD2_XDFFM_CLKB 1.8151e-17
* device instance cc_XD1_XDFFM_SB_XD2_XDFFM_M r0 *1 0,0
Ccc_XD1_XDFFM_SB_XD2_XDFFM_M XD1_XDFFM_SB XD2_XDFFM_M 2.4201e-17
* device instance cc_XD1_XDFFM_SB_XD2_XDFFM_MB r0 *1 0,0
Ccc_XD1_XDFFM_SB_XD2_XDFFM_MB XD1_XDFFM_SB XD2_XDFFM_MB 1.21e-17
* device instance cc_XD1_XDFFM_SB_XD2_XDFFM_S r0 *1 0,0
Ccc_XD1_XDFFM_SB_XD2_XDFFM_S XD1_XDFFM_SB XD2_XDFFM_S 1.8151e-17
* device instance cc_XD1_XDFFM_SB_XD2_XDFFM_SB r0 *1 0,0
Ccc_XD1_XDFFM_SB_XD2_XDFFM_SB XD1_XDFFM_SB XD2_XDFFM_SB 1.8151e-17
* device instance cc_XD1_XDFFM_SB_XD2_XDFFQ_CLKB r0 *1 0,0
Ccc_XD1_XDFFM_SB_XD2_XDFFQ_CLKB XD1_XDFFM_SB XD2_XDFFQ_CLKB 1.8151e-17
* device instance cc_XD1_XDFFM_SB_XD2_XDFFQ_M r0 *1 0,0
Ccc_XD1_XDFFM_SB_XD2_XDFFQ_M XD1_XDFFM_SB XD2_XDFFQ_M 2.4201e-17
* device instance cc_XD1_XDFFM_SB_XD2_XDFFQ_MB r0 *1 0,0
Ccc_XD1_XDFFM_SB_XD2_XDFFQ_MB XD1_XDFFM_SB XD2_XDFFQ_MB 1.21e-17
* device instance cc_XD1_XDFFM_SB_XD2_XDFFQ_S r0 *1 0,0
Ccc_XD1_XDFFM_SB_XD2_XDFFQ_S XD1_XDFFM_SB XD2_XDFFQ_S 1.8151e-17
* device instance cc_XD1_XDFFM_SB_XD2_XDFFQ_SB r0 *1 0,0
Ccc_XD1_XDFFM_SB_XD2_XDFFQ_SB XD1_XDFFM_SB XD2_XDFFQ_SB 1.8151e-17
* device instance cc_XD1_XDFFM_SB_XD2_XN2_mid1 r0 *1 0,0
Ccc_XD1_XDFFM_SB_XD2_XN2_mid1 XD1_XDFFM_SB XD2_XN2_mid1 1.21e-17
* device instance cc_XD1_XDFFM_SB_XD2_XN3_mid1 r0 *1 0,0
Ccc_XD1_XDFFM_SB_XD2_XN3_mid1 XD1_XDFFM_SB XD2_XN3_mid1 1.21e-17
* device instance cc_XD1_XDFFM_SB_XD2_XN3_mid2 r0 *1 0,0
Ccc_XD1_XDFFM_SB_XD2_XN3_mid2 XD1_XDFFM_SB XD2_XN3_mid2 1.21e-17
* device instance cc_XD1_XDFFM_SB_XD2_dmodout r0 *1 0,0
Ccc_XD1_XDFFM_SB_XD2_dmodout XD1_XDFFM_SB XD2_dmodout 1.21e-17
* device instance cc_XD1_XDFFM_SB_XD2_dq r0 *1 0,0
Ccc_XD1_XDFFM_SB_XD2_dq XD1_XDFFM_SB XD2_dq 1.8151e-17
* device instance cc_XD1_XDFFM_SB_XD2_nm r0 *1 0,0
Ccc_XD1_XDFFM_SB_XD2_nm XD1_XDFFM_SB XD2_nm 1.21e-17
* device instance cc_XD1_XDFFM_SB_XD2_nt r0 *1 0,0
Ccc_XD1_XDFFM_SB_XD2_nt XD1_XDFFM_SB XD2_nt 1.21e-17
* device instance cc_XD1_XDFFM_SB_XD2_t1 r0 *1 0,0
Ccc_XD1_XDFFM_SB_XD2_t1 XD1_XDFFM_SB XD2_t1 1.21e-17
* device instance cc_XD1_XDFFM_SB_XD3_XDFFM_CLKB r0 *1 0,0
Ccc_XD1_XDFFM_SB_XD3_XDFFM_CLKB XD1_XDFFM_SB XD3_XDFFM_CLKB 1.8151e-17
* device instance cc_XD1_XDFFM_SB_XD3_XDFFM_M r0 *1 0,0
Ccc_XD1_XDFFM_SB_XD3_XDFFM_M XD1_XDFFM_SB XD3_XDFFM_M 2.4201e-17
* device instance cc_XD1_XDFFM_SB_XD3_XDFFM_MB r0 *1 0,0
Ccc_XD1_XDFFM_SB_XD3_XDFFM_MB XD1_XDFFM_SB XD3_XDFFM_MB 1.21e-17
* device instance cc_XD1_XDFFM_SB_XD3_XDFFM_S r0 *1 0,0
Ccc_XD1_XDFFM_SB_XD3_XDFFM_S XD1_XDFFM_SB XD3_XDFFM_S 1.8151e-17
* device instance cc_XD1_XDFFM_SB_XD3_XDFFM_SB r0 *1 0,0
Ccc_XD1_XDFFM_SB_XD3_XDFFM_SB XD1_XDFFM_SB XD3_XDFFM_SB 1.8151e-17
* device instance cc_XD1_XDFFM_SB_XD3_XDFFQ_CLKB r0 *1 0,0
Ccc_XD1_XDFFM_SB_XD3_XDFFQ_CLKB XD1_XDFFM_SB XD3_XDFFQ_CLKB 1.8151e-17
* device instance cc_XD1_XDFFM_SB_XD3_XDFFQ_M r0 *1 0,0
Ccc_XD1_XDFFM_SB_XD3_XDFFQ_M XD1_XDFFM_SB XD3_XDFFQ_M 2.4201e-17
* device instance cc_XD1_XDFFM_SB_XD3_XDFFQ_MB r0 *1 0,0
Ccc_XD1_XDFFM_SB_XD3_XDFFQ_MB XD1_XDFFM_SB XD3_XDFFQ_MB 1.21e-17
* device instance cc_XD1_XDFFM_SB_XD3_XDFFQ_S r0 *1 0,0
Ccc_XD1_XDFFM_SB_XD3_XDFFQ_S XD1_XDFFM_SB XD3_XDFFQ_S 1.8151e-17
* device instance cc_XD1_XDFFM_SB_XD3_XDFFQ_SB r0 *1 0,0
Ccc_XD1_XDFFM_SB_XD3_XDFFQ_SB XD1_XDFFM_SB XD3_XDFFQ_SB 1.8151e-17
* device instance cc_XD1_XDFFM_SB_XD3_XN2_mid1 r0 *1 0,0
Ccc_XD1_XDFFM_SB_XD3_XN2_mid1 XD1_XDFFM_SB XD3_XN2_mid1 1.21e-17
* device instance cc_XD1_XDFFM_SB_XD3_XN3_mid1 r0 *1 0,0
Ccc_XD1_XDFFM_SB_XD3_XN3_mid1 XD1_XDFFM_SB XD3_XN3_mid1 1.21e-17
* device instance cc_XD1_XDFFM_SB_XD3_XN3_mid2 r0 *1 0,0
Ccc_XD1_XDFFM_SB_XD3_XN3_mid2 XD1_XDFFM_SB XD3_XN3_mid2 1.21e-17
* device instance cc_XD1_XDFFM_SB_XD3_dmodout r0 *1 0,0
Ccc_XD1_XDFFM_SB_XD3_dmodout XD1_XDFFM_SB XD3_dmodout 1.21e-17
* device instance cc_XD1_XDFFM_SB_XD3_dq r0 *1 0,0
Ccc_XD1_XDFFM_SB_XD3_dq XD1_XDFFM_SB XD3_dq 1.8151e-17
* device instance cc_XD1_XDFFM_SB_XD3_nm r0 *1 0,0
Ccc_XD1_XDFFM_SB_XD3_nm XD1_XDFFM_SB XD3_nm 1.21e-17
* device instance cc_XD1_XDFFM_SB_XD3_nt r0 *1 0,0
Ccc_XD1_XDFFM_SB_XD3_nt XD1_XDFFM_SB XD3_nt 1.21e-17
* device instance cc_XD1_XDFFM_SB_XD3_t1 r0 *1 0,0
Ccc_XD1_XDFFM_SB_XD3_t1 XD1_XDFFM_SB XD3_t1 1.21e-17
* device instance cc_XD1_XDFFM_SB_XD4_XDFFM_CLKB r0 *1 0,0
Ccc_XD1_XDFFM_SB_XD4_XDFFM_CLKB XD1_XDFFM_SB XD4_XDFFM_CLKB 1.8151e-17
* device instance cc_XD1_XDFFM_SB_XD4_XDFFM_M r0 *1 0,0
Ccc_XD1_XDFFM_SB_XD4_XDFFM_M XD1_XDFFM_SB XD4_XDFFM_M 2.4201e-17
* device instance cc_XD1_XDFFM_SB_XD4_XDFFM_MB r0 *1 0,0
Ccc_XD1_XDFFM_SB_XD4_XDFFM_MB XD1_XDFFM_SB XD4_XDFFM_MB 1.21e-17
* device instance cc_XD1_XDFFM_SB_XD4_XDFFM_S r0 *1 0,0
Ccc_XD1_XDFFM_SB_XD4_XDFFM_S XD1_XDFFM_SB XD4_XDFFM_S 1.8151e-17
* device instance cc_XD1_XDFFM_SB_XD4_XDFFM_SB r0 *1 0,0
Ccc_XD1_XDFFM_SB_XD4_XDFFM_SB XD1_XDFFM_SB XD4_XDFFM_SB 1.8151e-17
* device instance cc_XD1_XDFFM_SB_XD4_XDFFQ_CLKB r0 *1 0,0
Ccc_XD1_XDFFM_SB_XD4_XDFFQ_CLKB XD1_XDFFM_SB XD4_XDFFQ_CLKB 1.8151e-17
* device instance cc_XD1_XDFFM_SB_XD4_XDFFQ_M r0 *1 0,0
Ccc_XD1_XDFFM_SB_XD4_XDFFQ_M XD1_XDFFM_SB XD4_XDFFQ_M 2.4201e-17
* device instance cc_XD1_XDFFM_SB_XD4_XDFFQ_MB r0 *1 0,0
Ccc_XD1_XDFFM_SB_XD4_XDFFQ_MB XD1_XDFFM_SB XD4_XDFFQ_MB 1.21e-17
* device instance cc_XD1_XDFFM_SB_XD4_XDFFQ_S r0 *1 0,0
Ccc_XD1_XDFFM_SB_XD4_XDFFQ_S XD1_XDFFM_SB XD4_XDFFQ_S 1.8151e-17
* device instance cc_XD1_XDFFM_SB_XD4_XDFFQ_SB r0 *1 0,0
Ccc_XD1_XDFFM_SB_XD4_XDFFQ_SB XD1_XDFFM_SB XD4_XDFFQ_SB 1.8151e-17
* device instance cc_XD1_XDFFM_SB_XD4_XN2_mid1 r0 *1 0,0
Ccc_XD1_XDFFM_SB_XD4_XN2_mid1 XD1_XDFFM_SB XD4_XN2_mid1 1.21e-17
* device instance cc_XD1_XDFFM_SB_XD4_XN3_mid1 r0 *1 0,0
Ccc_XD1_XDFFM_SB_XD4_XN3_mid1 XD1_XDFFM_SB XD4_XN3_mid1 1.21e-17
* device instance cc_XD1_XDFFM_SB_XD4_XN3_mid2 r0 *1 0,0
Ccc_XD1_XDFFM_SB_XD4_XN3_mid2 XD1_XDFFM_SB XD4_XN3_mid2 1.21e-17
* device instance cc_XD1_XDFFM_SB_XD4_dmodout r0 *1 0,0
Ccc_XD1_XDFFM_SB_XD4_dmodout XD1_XDFFM_SB XD4_dmodout 1.21e-17
* device instance cc_XD1_XDFFM_SB_XD4_dq r0 *1 0,0
Ccc_XD1_XDFFM_SB_XD4_dq XD1_XDFFM_SB XD4_dq 1.8151e-17
* device instance cc_XD1_XDFFM_SB_XD4_nm r0 *1 0,0
Ccc_XD1_XDFFM_SB_XD4_nm XD1_XDFFM_SB XD4_nm 1.21e-17
* device instance cc_XD1_XDFFM_SB_XD4_nt r0 *1 0,0
Ccc_XD1_XDFFM_SB_XD4_nt XD1_XDFFM_SB XD4_nt 1.21e-17
* device instance cc_XD1_XDFFM_SB_XD4_t1 r0 *1 0,0
Ccc_XD1_XDFFM_SB_XD4_t1 XD1_XDFFM_SB XD4_t1 1.21e-17
* device instance cc_XD1_XDFFM_SB_XD5_XDFFM_CLKB r0 *1 0,0
Ccc_XD1_XDFFM_SB_XD5_XDFFM_CLKB XD1_XDFFM_SB XD5_XDFFM_CLKB 1.8151e-17
* device instance cc_XD1_XDFFM_SB_XD5_XDFFM_M r0 *1 0,0
Ccc_XD1_XDFFM_SB_XD5_XDFFM_M XD1_XDFFM_SB XD5_XDFFM_M 2.4201e-17
* device instance cc_XD1_XDFFM_SB_XD5_XDFFM_MB r0 *1 0,0
Ccc_XD1_XDFFM_SB_XD5_XDFFM_MB XD1_XDFFM_SB XD5_XDFFM_MB 1.21e-17
* device instance cc_XD1_XDFFM_SB_XD5_XDFFM_S r0 *1 0,0
Ccc_XD1_XDFFM_SB_XD5_XDFFM_S XD1_XDFFM_SB XD5_XDFFM_S 1.8151e-17
* device instance cc_XD1_XDFFM_SB_XD5_XDFFM_SB r0 *1 0,0
Ccc_XD1_XDFFM_SB_XD5_XDFFM_SB XD1_XDFFM_SB XD5_XDFFM_SB 1.8151e-17
* device instance cc_XD1_XDFFM_SB_XD5_XDFFQ_CLKB r0 *1 0,0
Ccc_XD1_XDFFM_SB_XD5_XDFFQ_CLKB XD1_XDFFM_SB XD5_XDFFQ_CLKB 1.8151e-17
* device instance cc_XD1_XDFFM_SB_XD5_XDFFQ_M r0 *1 0,0
Ccc_XD1_XDFFM_SB_XD5_XDFFQ_M XD1_XDFFM_SB XD5_XDFFQ_M 2.4201e-17
* device instance cc_XD1_XDFFM_SB_XD5_XDFFQ_MB r0 *1 0,0
Ccc_XD1_XDFFM_SB_XD5_XDFFQ_MB XD1_XDFFM_SB XD5_XDFFQ_MB 1.21e-17
* device instance cc_XD1_XDFFM_SB_XD5_XDFFQ_S r0 *1 0,0
Ccc_XD1_XDFFM_SB_XD5_XDFFQ_S XD1_XDFFM_SB XD5_XDFFQ_S 1.8151e-17
* device instance cc_XD1_XDFFM_SB_XD5_XDFFQ_SB r0 *1 0,0
Ccc_XD1_XDFFM_SB_XD5_XDFFQ_SB XD1_XDFFM_SB XD5_XDFFQ_SB 1.8151e-17
* device instance cc_XD1_XDFFM_SB_XD5_XN2_mid1 r0 *1 0,0
Ccc_XD1_XDFFM_SB_XD5_XN2_mid1 XD1_XDFFM_SB XD5_XN2_mid1 1.21e-17
* device instance cc_XD1_XDFFM_SB_XD5_XN3_mid1 r0 *1 0,0
Ccc_XD1_XDFFM_SB_XD5_XN3_mid1 XD1_XDFFM_SB XD5_XN3_mid1 1.21e-17
* device instance cc_XD1_XDFFM_SB_XD5_XN3_mid2 r0 *1 0,0
Ccc_XD1_XDFFM_SB_XD5_XN3_mid2 XD1_XDFFM_SB XD5_XN3_mid2 1.21e-17
* device instance cc_XD1_XDFFM_SB_XD5_dmodout r0 *1 0,0
Ccc_XD1_XDFFM_SB_XD5_dmodout XD1_XDFFM_SB XD5_dmodout 1.21e-17
* device instance cc_XD1_XDFFM_SB_XD5_dq r0 *1 0,0
Ccc_XD1_XDFFM_SB_XD5_dq XD1_XDFFM_SB XD5_dq 1.8151e-17
* device instance cc_XD1_XDFFM_SB_XD5_nm r0 *1 0,0
Ccc_XD1_XDFFM_SB_XD5_nm XD1_XDFFM_SB XD5_nm 1.21e-17
* device instance cc_XD1_XDFFM_SB_XD5_nt r0 *1 0,0
Ccc_XD1_XDFFM_SB_XD5_nt XD1_XDFFM_SB XD5_nt 1.21e-17
* device instance cc_XD1_XDFFM_SB_XD5_t1 r0 *1 0,0
Ccc_XD1_XDFFM_SB_XD5_t1 XD1_XDFFM_SB XD5_t1 1.21e-17
* device instance cc_XD1_XDFFM_SB_XFRT_CLKB r0 *1 0,0
Ccc_XD1_XDFFM_SB_XFRT_CLKB XD1_XDFFM_SB XFRT_CLKB 1.8151e-17
* device instance cc_XD1_XDFFM_SB_XFRT_M r0 *1 0,0
Ccc_XD1_XDFFM_SB_XFRT_M XD1_XDFFM_SB XFRT_M 2.4201e-17
* device instance cc_XD1_XDFFM_SB_XFRT_MB r0 *1 0,0
Ccc_XD1_XDFFM_SB_XFRT_MB XD1_XDFFM_SB XFRT_MB 1.21e-17
* device instance cc_XD1_XDFFM_SB_XFRT_S r0 *1 0,0
Ccc_XD1_XDFFM_SB_XFRT_S XD1_XDFFM_SB XFRT_S 1.8151e-17
* device instance cc_XD1_XDFFM_SB_XFRT_SB r0 *1 0,0
Ccc_XD1_XDFFM_SB_XFRT_SB XD1_XDFFM_SB XFRT_SB 1.8151e-17
* device instance cc_XD1_XDFFM_SB_ck1 r0 *1 0,0
Ccc_XD1_XDFFM_SB_ck1 XD1_XDFFM_SB ck1 5.4452e-17
* device instance cc_XD1_XDFFM_SB_ck2 r0 *1 0,0
Ccc_XD1_XDFFM_SB_ck2 XD1_XDFFM_SB ck2 5.4452e-17
* device instance cc_XD1_XDFFM_SB_ck3 r0 *1 0,0
Ccc_XD1_XDFFM_SB_ck3 XD1_XDFFM_SB ck3 5.4452e-17
* device instance cc_XD1_XDFFM_SB_ck4 r0 *1 0,0
Ccc_XD1_XDFFM_SB_ck4 XD1_XDFFM_SB ck4 5.4452e-17
* device instance cc_XD1_XDFFM_SB_ck5 r0 *1 0,0
Ccc_XD1_XDFFM_SB_ck5 XD1_XDFFM_SB ck5 5.4452e-17
* device instance cc_XD1_XDFFM_SB_mod0 r0 *1 0,0
Ccc_XD1_XDFFM_SB_mod0 XD1_XDFFM_SB mod0 2.4201e-17
* device instance cc_XD1_XDFFM_SB_mod1 r0 *1 0,0
Ccc_XD1_XDFFM_SB_mod1 XD1_XDFFM_SB mod1 2.4201e-17
* device instance cc_XD1_XDFFM_SB_mod2 r0 *1 0,0
Ccc_XD1_XDFFM_SB_mod2 XD1_XDFFM_SB mod2 2.4201e-17
* device instance cc_XD1_XDFFM_SB_mod3 r0 *1 0,0
Ccc_XD1_XDFFM_SB_mod3 XD1_XDFFM_SB mod3 2.4201e-17
* device instance cc_XD1_XDFFM_SB_mod4 r0 *1 0,0
Ccc_XD1_XDFFM_SB_mod4 XD1_XDFFM_SB mod4 2.4201e-17
* device instance cc_XD1_XDFFM_SB_net1 r0 *1 0,0
Ccc_XD1_XDFFM_SB_net1 XD1_XDFFM_SB net1 1.21e-17
* device instance cc_XD1_XDFFQ_CLKB_XD1_XDFFQ_M r0 *1 0,0
Ccc_XD1_XDFFQ_CLKB_XD1_XDFFQ_M XD1_XDFFQ_CLKB XD1_XDFFQ_M 4.2352e-17
* device instance cc_XD1_XDFFQ_CLKB_XD1_XDFFQ_MB r0 *1 0,0
Ccc_XD1_XDFFQ_CLKB_XD1_XDFFQ_MB XD1_XDFFQ_CLKB XD1_XDFFQ_MB 2.4201e-17
* device instance cc_XD1_XDFFQ_CLKB_XD1_XDFFQ_S r0 *1 0,0
Ccc_XD1_XDFFQ_CLKB_XD1_XDFFQ_S XD1_XDFFQ_CLKB XD1_XDFFQ_S 1.8151e-17
* device instance cc_XD1_XDFFQ_CLKB_XD1_XDFFQ_SB r0 *1 0,0
Ccc_XD1_XDFFQ_CLKB_XD1_XDFFQ_SB XD1_XDFFQ_CLKB XD1_XDFFQ_SB 1.8151e-17
* device instance cc_XD1_XDFFQ_CLKB_XD1_XN2_mid1 r0 *1 0,0
Ccc_XD1_XDFFQ_CLKB_XD1_XN2_mid1 XD1_XDFFQ_CLKB XD1_XN2_mid1 1.21e-17
* device instance cc_XD1_XDFFQ_CLKB_XD1_XNOR_midp r0 *1 0,0
Ccc_XD1_XDFFQ_CLKB_XD1_XNOR_midp XD1_XDFFQ_CLKB XD1_XNOR_midp 1.21e-17
* device instance cc_XD1_XDFFQ_CLKB_XD1_dmodout r0 *1 0,0
Ccc_XD1_XDFFQ_CLKB_XD1_dmodout XD1_XDFFQ_CLKB XD1_dmodout 1.21e-17
* device instance cc_XD1_XDFFQ_CLKB_XD1_dq r0 *1 0,0
Ccc_XD1_XDFFQ_CLKB_XD1_dq XD1_XDFFQ_CLKB XD1_dq 1.8151e-17
* device instance cc_XD1_XDFFQ_CLKB_XD1_nm r0 *1 0,0
Ccc_XD1_XDFFQ_CLKB_XD1_nm XD1_XDFFQ_CLKB XD1_nm 1.21e-17
* device instance cc_XD1_XDFFQ_CLKB_XD1_nt r0 *1 0,0
Ccc_XD1_XDFFQ_CLKB_XD1_nt XD1_XDFFQ_CLKB XD1_nt 2.4201e-17
* device instance cc_XD1_XDFFQ_CLKB_XD1_t1 r0 *1 0,0
Ccc_XD1_XDFFQ_CLKB_XD1_t1 XD1_XDFFQ_CLKB XD1_t1 1.21e-17
* device instance cc_XD1_XDFFQ_CLKB_XD2_XDFFM_CLKB r0 *1 0,0
Ccc_XD1_XDFFQ_CLKB_XD2_XDFFM_CLKB XD1_XDFFQ_CLKB XD2_XDFFM_CLKB 1.8151e-17
* device instance cc_XD1_XDFFQ_CLKB_XD2_XDFFM_M r0 *1 0,0
Ccc_XD1_XDFFQ_CLKB_XD2_XDFFM_M XD1_XDFFQ_CLKB XD2_XDFFM_M 2.4201e-17
* device instance cc_XD1_XDFFQ_CLKB_XD2_XDFFM_MB r0 *1 0,0
Ccc_XD1_XDFFQ_CLKB_XD2_XDFFM_MB XD1_XDFFQ_CLKB XD2_XDFFM_MB 1.21e-17
* device instance cc_XD1_XDFFQ_CLKB_XD2_XDFFM_S r0 *1 0,0
Ccc_XD1_XDFFQ_CLKB_XD2_XDFFM_S XD1_XDFFQ_CLKB XD2_XDFFM_S 1.8151e-17
* device instance cc_XD1_XDFFQ_CLKB_XD2_XDFFM_SB r0 *1 0,0
Ccc_XD1_XDFFQ_CLKB_XD2_XDFFM_SB XD1_XDFFQ_CLKB XD2_XDFFM_SB 1.8151e-17
* device instance cc_XD1_XDFFQ_CLKB_XD2_XDFFQ_CLKB r0 *1 0,0
Ccc_XD1_XDFFQ_CLKB_XD2_XDFFQ_CLKB XD1_XDFFQ_CLKB XD2_XDFFQ_CLKB 1.8151e-17
* device instance cc_XD1_XDFFQ_CLKB_XD2_XDFFQ_M r0 *1 0,0
Ccc_XD1_XDFFQ_CLKB_XD2_XDFFQ_M XD1_XDFFQ_CLKB XD2_XDFFQ_M 2.4201e-17
* device instance cc_XD1_XDFFQ_CLKB_XD2_XDFFQ_MB r0 *1 0,0
Ccc_XD1_XDFFQ_CLKB_XD2_XDFFQ_MB XD1_XDFFQ_CLKB XD2_XDFFQ_MB 1.21e-17
* device instance cc_XD1_XDFFQ_CLKB_XD2_XDFFQ_S r0 *1 0,0
Ccc_XD1_XDFFQ_CLKB_XD2_XDFFQ_S XD1_XDFFQ_CLKB XD2_XDFFQ_S 1.8151e-17
* device instance cc_XD1_XDFFQ_CLKB_XD2_XDFFQ_SB r0 *1 0,0
Ccc_XD1_XDFFQ_CLKB_XD2_XDFFQ_SB XD1_XDFFQ_CLKB XD2_XDFFQ_SB 1.8151e-17
* device instance cc_XD1_XDFFQ_CLKB_XD2_XN2_mid1 r0 *1 0,0
Ccc_XD1_XDFFQ_CLKB_XD2_XN2_mid1 XD1_XDFFQ_CLKB XD2_XN2_mid1 1.21e-17
* device instance cc_XD1_XDFFQ_CLKB_XD2_XN3_mid1 r0 *1 0,0
Ccc_XD1_XDFFQ_CLKB_XD2_XN3_mid1 XD1_XDFFQ_CLKB XD2_XN3_mid1 1.21e-17
* device instance cc_XD1_XDFFQ_CLKB_XD2_XN3_mid2 r0 *1 0,0
Ccc_XD1_XDFFQ_CLKB_XD2_XN3_mid2 XD1_XDFFQ_CLKB XD2_XN3_mid2 1.21e-17
* device instance cc_XD1_XDFFQ_CLKB_XD2_dmodout r0 *1 0,0
Ccc_XD1_XDFFQ_CLKB_XD2_dmodout XD1_XDFFQ_CLKB XD2_dmodout 1.21e-17
* device instance cc_XD1_XDFFQ_CLKB_XD2_dq r0 *1 0,0
Ccc_XD1_XDFFQ_CLKB_XD2_dq XD1_XDFFQ_CLKB XD2_dq 1.8151e-17
* device instance cc_XD1_XDFFQ_CLKB_XD2_nm r0 *1 0,0
Ccc_XD1_XDFFQ_CLKB_XD2_nm XD1_XDFFQ_CLKB XD2_nm 1.21e-17
* device instance cc_XD1_XDFFQ_CLKB_XD2_nt r0 *1 0,0
Ccc_XD1_XDFFQ_CLKB_XD2_nt XD1_XDFFQ_CLKB XD2_nt 1.21e-17
* device instance cc_XD1_XDFFQ_CLKB_XD2_t1 r0 *1 0,0
Ccc_XD1_XDFFQ_CLKB_XD2_t1 XD1_XDFFQ_CLKB XD2_t1 1.21e-17
* device instance cc_XD1_XDFFQ_CLKB_XD3_XDFFM_CLKB r0 *1 0,0
Ccc_XD1_XDFFQ_CLKB_XD3_XDFFM_CLKB XD1_XDFFQ_CLKB XD3_XDFFM_CLKB 1.8151e-17
* device instance cc_XD1_XDFFQ_CLKB_XD3_XDFFM_M r0 *1 0,0
Ccc_XD1_XDFFQ_CLKB_XD3_XDFFM_M XD1_XDFFQ_CLKB XD3_XDFFM_M 2.4201e-17
* device instance cc_XD1_XDFFQ_CLKB_XD3_XDFFM_MB r0 *1 0,0
Ccc_XD1_XDFFQ_CLKB_XD3_XDFFM_MB XD1_XDFFQ_CLKB XD3_XDFFM_MB 1.21e-17
* device instance cc_XD1_XDFFQ_CLKB_XD3_XDFFM_S r0 *1 0,0
Ccc_XD1_XDFFQ_CLKB_XD3_XDFFM_S XD1_XDFFQ_CLKB XD3_XDFFM_S 1.8151e-17
* device instance cc_XD1_XDFFQ_CLKB_XD3_XDFFM_SB r0 *1 0,0
Ccc_XD1_XDFFQ_CLKB_XD3_XDFFM_SB XD1_XDFFQ_CLKB XD3_XDFFM_SB 1.8151e-17
* device instance cc_XD1_XDFFQ_CLKB_XD3_XDFFQ_CLKB r0 *1 0,0
Ccc_XD1_XDFFQ_CLKB_XD3_XDFFQ_CLKB XD1_XDFFQ_CLKB XD3_XDFFQ_CLKB 1.8151e-17
* device instance cc_XD1_XDFFQ_CLKB_XD3_XDFFQ_M r0 *1 0,0
Ccc_XD1_XDFFQ_CLKB_XD3_XDFFQ_M XD1_XDFFQ_CLKB XD3_XDFFQ_M 2.4201e-17
* device instance cc_XD1_XDFFQ_CLKB_XD3_XDFFQ_MB r0 *1 0,0
Ccc_XD1_XDFFQ_CLKB_XD3_XDFFQ_MB XD1_XDFFQ_CLKB XD3_XDFFQ_MB 1.21e-17
* device instance cc_XD1_XDFFQ_CLKB_XD3_XDFFQ_S r0 *1 0,0
Ccc_XD1_XDFFQ_CLKB_XD3_XDFFQ_S XD1_XDFFQ_CLKB XD3_XDFFQ_S 1.8151e-17
* device instance cc_XD1_XDFFQ_CLKB_XD3_XDFFQ_SB r0 *1 0,0
Ccc_XD1_XDFFQ_CLKB_XD3_XDFFQ_SB XD1_XDFFQ_CLKB XD3_XDFFQ_SB 1.8151e-17
* device instance cc_XD1_XDFFQ_CLKB_XD3_XN2_mid1 r0 *1 0,0
Ccc_XD1_XDFFQ_CLKB_XD3_XN2_mid1 XD1_XDFFQ_CLKB XD3_XN2_mid1 1.21e-17
* device instance cc_XD1_XDFFQ_CLKB_XD3_XN3_mid1 r0 *1 0,0
Ccc_XD1_XDFFQ_CLKB_XD3_XN3_mid1 XD1_XDFFQ_CLKB XD3_XN3_mid1 1.21e-17
* device instance cc_XD1_XDFFQ_CLKB_XD3_XN3_mid2 r0 *1 0,0
Ccc_XD1_XDFFQ_CLKB_XD3_XN3_mid2 XD1_XDFFQ_CLKB XD3_XN3_mid2 1.21e-17
* device instance cc_XD1_XDFFQ_CLKB_XD3_dmodout r0 *1 0,0
Ccc_XD1_XDFFQ_CLKB_XD3_dmodout XD1_XDFFQ_CLKB XD3_dmodout 1.21e-17
* device instance cc_XD1_XDFFQ_CLKB_XD3_dq r0 *1 0,0
Ccc_XD1_XDFFQ_CLKB_XD3_dq XD1_XDFFQ_CLKB XD3_dq 1.8151e-17
* device instance cc_XD1_XDFFQ_CLKB_XD3_nm r0 *1 0,0
Ccc_XD1_XDFFQ_CLKB_XD3_nm XD1_XDFFQ_CLKB XD3_nm 1.21e-17
* device instance cc_XD1_XDFFQ_CLKB_XD3_nt r0 *1 0,0
Ccc_XD1_XDFFQ_CLKB_XD3_nt XD1_XDFFQ_CLKB XD3_nt 1.21e-17
* device instance cc_XD1_XDFFQ_CLKB_XD3_t1 r0 *1 0,0
Ccc_XD1_XDFFQ_CLKB_XD3_t1 XD1_XDFFQ_CLKB XD3_t1 1.21e-17
* device instance cc_XD1_XDFFQ_CLKB_XD4_XDFFM_CLKB r0 *1 0,0
Ccc_XD1_XDFFQ_CLKB_XD4_XDFFM_CLKB XD1_XDFFQ_CLKB XD4_XDFFM_CLKB 1.8151e-17
* device instance cc_XD1_XDFFQ_CLKB_XD4_XDFFM_M r0 *1 0,0
Ccc_XD1_XDFFQ_CLKB_XD4_XDFFM_M XD1_XDFFQ_CLKB XD4_XDFFM_M 2.4201e-17
* device instance cc_XD1_XDFFQ_CLKB_XD4_XDFFM_MB r0 *1 0,0
Ccc_XD1_XDFFQ_CLKB_XD4_XDFFM_MB XD1_XDFFQ_CLKB XD4_XDFFM_MB 1.21e-17
* device instance cc_XD1_XDFFQ_CLKB_XD4_XDFFM_S r0 *1 0,0
Ccc_XD1_XDFFQ_CLKB_XD4_XDFFM_S XD1_XDFFQ_CLKB XD4_XDFFM_S 1.8151e-17
* device instance cc_XD1_XDFFQ_CLKB_XD4_XDFFM_SB r0 *1 0,0
Ccc_XD1_XDFFQ_CLKB_XD4_XDFFM_SB XD1_XDFFQ_CLKB XD4_XDFFM_SB 1.8151e-17
* device instance cc_XD1_XDFFQ_CLKB_XD4_XDFFQ_CLKB r0 *1 0,0
Ccc_XD1_XDFFQ_CLKB_XD4_XDFFQ_CLKB XD1_XDFFQ_CLKB XD4_XDFFQ_CLKB 1.8151e-17
* device instance cc_XD1_XDFFQ_CLKB_XD4_XDFFQ_M r0 *1 0,0
Ccc_XD1_XDFFQ_CLKB_XD4_XDFFQ_M XD1_XDFFQ_CLKB XD4_XDFFQ_M 2.4201e-17
* device instance cc_XD1_XDFFQ_CLKB_XD4_XDFFQ_MB r0 *1 0,0
Ccc_XD1_XDFFQ_CLKB_XD4_XDFFQ_MB XD1_XDFFQ_CLKB XD4_XDFFQ_MB 1.21e-17
* device instance cc_XD1_XDFFQ_CLKB_XD4_XDFFQ_S r0 *1 0,0
Ccc_XD1_XDFFQ_CLKB_XD4_XDFFQ_S XD1_XDFFQ_CLKB XD4_XDFFQ_S 1.8151e-17
* device instance cc_XD1_XDFFQ_CLKB_XD4_XDFFQ_SB r0 *1 0,0
Ccc_XD1_XDFFQ_CLKB_XD4_XDFFQ_SB XD1_XDFFQ_CLKB XD4_XDFFQ_SB 1.8151e-17
* device instance cc_XD1_XDFFQ_CLKB_XD4_XN2_mid1 r0 *1 0,0
Ccc_XD1_XDFFQ_CLKB_XD4_XN2_mid1 XD1_XDFFQ_CLKB XD4_XN2_mid1 1.21e-17
* device instance cc_XD1_XDFFQ_CLKB_XD4_XN3_mid1 r0 *1 0,0
Ccc_XD1_XDFFQ_CLKB_XD4_XN3_mid1 XD1_XDFFQ_CLKB XD4_XN3_mid1 1.21e-17
* device instance cc_XD1_XDFFQ_CLKB_XD4_XN3_mid2 r0 *1 0,0
Ccc_XD1_XDFFQ_CLKB_XD4_XN3_mid2 XD1_XDFFQ_CLKB XD4_XN3_mid2 1.21e-17
* device instance cc_XD1_XDFFQ_CLKB_XD4_dmodout r0 *1 0,0
Ccc_XD1_XDFFQ_CLKB_XD4_dmodout XD1_XDFFQ_CLKB XD4_dmodout 1.21e-17
* device instance cc_XD1_XDFFQ_CLKB_XD4_dq r0 *1 0,0
Ccc_XD1_XDFFQ_CLKB_XD4_dq XD1_XDFFQ_CLKB XD4_dq 1.8151e-17
* device instance cc_XD1_XDFFQ_CLKB_XD4_nm r0 *1 0,0
Ccc_XD1_XDFFQ_CLKB_XD4_nm XD1_XDFFQ_CLKB XD4_nm 1.21e-17
* device instance cc_XD1_XDFFQ_CLKB_XD4_nt r0 *1 0,0
Ccc_XD1_XDFFQ_CLKB_XD4_nt XD1_XDFFQ_CLKB XD4_nt 1.21e-17
* device instance cc_XD1_XDFFQ_CLKB_XD4_t1 r0 *1 0,0
Ccc_XD1_XDFFQ_CLKB_XD4_t1 XD1_XDFFQ_CLKB XD4_t1 1.21e-17
* device instance cc_XD1_XDFFQ_CLKB_XD5_XDFFM_CLKB r0 *1 0,0
Ccc_XD1_XDFFQ_CLKB_XD5_XDFFM_CLKB XD1_XDFFQ_CLKB XD5_XDFFM_CLKB 1.8151e-17
* device instance cc_XD1_XDFFQ_CLKB_XD5_XDFFM_M r0 *1 0,0
Ccc_XD1_XDFFQ_CLKB_XD5_XDFFM_M XD1_XDFFQ_CLKB XD5_XDFFM_M 2.4201e-17
* device instance cc_XD1_XDFFQ_CLKB_XD5_XDFFM_MB r0 *1 0,0
Ccc_XD1_XDFFQ_CLKB_XD5_XDFFM_MB XD1_XDFFQ_CLKB XD5_XDFFM_MB 1.21e-17
* device instance cc_XD1_XDFFQ_CLKB_XD5_XDFFM_S r0 *1 0,0
Ccc_XD1_XDFFQ_CLKB_XD5_XDFFM_S XD1_XDFFQ_CLKB XD5_XDFFM_S 1.8151e-17
* device instance cc_XD1_XDFFQ_CLKB_XD5_XDFFM_SB r0 *1 0,0
Ccc_XD1_XDFFQ_CLKB_XD5_XDFFM_SB XD1_XDFFQ_CLKB XD5_XDFFM_SB 1.8151e-17
* device instance cc_XD1_XDFFQ_CLKB_XD5_XDFFQ_CLKB r0 *1 0,0
Ccc_XD1_XDFFQ_CLKB_XD5_XDFFQ_CLKB XD1_XDFFQ_CLKB XD5_XDFFQ_CLKB 1.8151e-17
* device instance cc_XD1_XDFFQ_CLKB_XD5_XDFFQ_M r0 *1 0,0
Ccc_XD1_XDFFQ_CLKB_XD5_XDFFQ_M XD1_XDFFQ_CLKB XD5_XDFFQ_M 2.4201e-17
* device instance cc_XD1_XDFFQ_CLKB_XD5_XDFFQ_MB r0 *1 0,0
Ccc_XD1_XDFFQ_CLKB_XD5_XDFFQ_MB XD1_XDFFQ_CLKB XD5_XDFFQ_MB 1.21e-17
* device instance cc_XD1_XDFFQ_CLKB_XD5_XDFFQ_S r0 *1 0,0
Ccc_XD1_XDFFQ_CLKB_XD5_XDFFQ_S XD1_XDFFQ_CLKB XD5_XDFFQ_S 1.8151e-17
* device instance cc_XD1_XDFFQ_CLKB_XD5_XDFFQ_SB r0 *1 0,0
Ccc_XD1_XDFFQ_CLKB_XD5_XDFFQ_SB XD1_XDFFQ_CLKB XD5_XDFFQ_SB 1.8151e-17
* device instance cc_XD1_XDFFQ_CLKB_XD5_XN2_mid1 r0 *1 0,0
Ccc_XD1_XDFFQ_CLKB_XD5_XN2_mid1 XD1_XDFFQ_CLKB XD5_XN2_mid1 1.21e-17
* device instance cc_XD1_XDFFQ_CLKB_XD5_XN3_mid1 r0 *1 0,0
Ccc_XD1_XDFFQ_CLKB_XD5_XN3_mid1 XD1_XDFFQ_CLKB XD5_XN3_mid1 1.21e-17
* device instance cc_XD1_XDFFQ_CLKB_XD5_XN3_mid2 r0 *1 0,0
Ccc_XD1_XDFFQ_CLKB_XD5_XN3_mid2 XD1_XDFFQ_CLKB XD5_XN3_mid2 1.21e-17
* device instance cc_XD1_XDFFQ_CLKB_XD5_dmodout r0 *1 0,0
Ccc_XD1_XDFFQ_CLKB_XD5_dmodout XD1_XDFFQ_CLKB XD5_dmodout 1.21e-17
* device instance cc_XD1_XDFFQ_CLKB_XD5_dq r0 *1 0,0
Ccc_XD1_XDFFQ_CLKB_XD5_dq XD1_XDFFQ_CLKB XD5_dq 1.8151e-17
* device instance cc_XD1_XDFFQ_CLKB_XD5_nm r0 *1 0,0
Ccc_XD1_XDFFQ_CLKB_XD5_nm XD1_XDFFQ_CLKB XD5_nm 1.21e-17
* device instance cc_XD1_XDFFQ_CLKB_XD5_nt r0 *1 0,0
Ccc_XD1_XDFFQ_CLKB_XD5_nt XD1_XDFFQ_CLKB XD5_nt 1.21e-17
* device instance cc_XD1_XDFFQ_CLKB_XD5_t1 r0 *1 0,0
Ccc_XD1_XDFFQ_CLKB_XD5_t1 XD1_XDFFQ_CLKB XD5_t1 1.21e-17
* device instance cc_XD1_XDFFQ_CLKB_XFRT_CLKB r0 *1 0,0
Ccc_XD1_XDFFQ_CLKB_XFRT_CLKB XD1_XDFFQ_CLKB XFRT_CLKB 1.8151e-17
* device instance cc_XD1_XDFFQ_CLKB_XFRT_M r0 *1 0,0
Ccc_XD1_XDFFQ_CLKB_XFRT_M XD1_XDFFQ_CLKB XFRT_M 2.4201e-17
* device instance cc_XD1_XDFFQ_CLKB_XFRT_MB r0 *1 0,0
Ccc_XD1_XDFFQ_CLKB_XFRT_MB XD1_XDFFQ_CLKB XFRT_MB 1.21e-17
* device instance cc_XD1_XDFFQ_CLKB_XFRT_S r0 *1 0,0
Ccc_XD1_XDFFQ_CLKB_XFRT_S XD1_XDFFQ_CLKB XFRT_S 1.8151e-17
* device instance cc_XD1_XDFFQ_CLKB_XFRT_SB r0 *1 0,0
Ccc_XD1_XDFFQ_CLKB_XFRT_SB XD1_XDFFQ_CLKB XFRT_SB 1.8151e-17
* device instance cc_XD1_XDFFQ_CLKB_ck1 r0 *1 0,0
Ccc_XD1_XDFFQ_CLKB_ck1 XD1_XDFFQ_CLKB ck1 6.0502e-17
* device instance cc_XD1_XDFFQ_CLKB_ck2 r0 *1 0,0
Ccc_XD1_XDFFQ_CLKB_ck2 XD1_XDFFQ_CLKB ck2 5.4452e-17
* device instance cc_XD1_XDFFQ_CLKB_ck3 r0 *1 0,0
Ccc_XD1_XDFFQ_CLKB_ck3 XD1_XDFFQ_CLKB ck3 5.4452e-17
* device instance cc_XD1_XDFFQ_CLKB_ck4 r0 *1 0,0
Ccc_XD1_XDFFQ_CLKB_ck4 XD1_XDFFQ_CLKB ck4 5.4452e-17
* device instance cc_XD1_XDFFQ_CLKB_ck5 r0 *1 0,0
Ccc_XD1_XDFFQ_CLKB_ck5 XD1_XDFFQ_CLKB ck5 5.4452e-17
* device instance cc_XD1_XDFFQ_CLKB_mod0 r0 *1 0,0
Ccc_XD1_XDFFQ_CLKB_mod0 XD1_XDFFQ_CLKB mod0 2.4201e-17
* device instance cc_XD1_XDFFQ_CLKB_mod1 r0 *1 0,0
Ccc_XD1_XDFFQ_CLKB_mod1 XD1_XDFFQ_CLKB mod1 2.4201e-17
* device instance cc_XD1_XDFFQ_CLKB_mod2 r0 *1 0,0
Ccc_XD1_XDFFQ_CLKB_mod2 XD1_XDFFQ_CLKB mod2 2.4201e-17
* device instance cc_XD1_XDFFQ_CLKB_mod3 r0 *1 0,0
Ccc_XD1_XDFFQ_CLKB_mod3 XD1_XDFFQ_CLKB mod3 2.4201e-17
* device instance cc_XD1_XDFFQ_CLKB_mod4 r0 *1 0,0
Ccc_XD1_XDFFQ_CLKB_mod4 XD1_XDFFQ_CLKB mod4 2.4201e-17
* device instance cc_XD1_XDFFQ_CLKB_net1 r0 *1 0,0
Ccc_XD1_XDFFQ_CLKB_net1 XD1_XDFFQ_CLKB net1 1.21e-17
* device instance cc_XD1_XDFFQ_M_XD1_XDFFQ_MB r0 *1 0,0
Ccc_XD1_XDFFQ_M_XD1_XDFFQ_MB XD1_XDFFQ_M XD1_XDFFQ_MB 3.4688e-17
* device instance cc_XD1_XDFFQ_M_XD1_XDFFQ_S r0 *1 0,0
Ccc_XD1_XDFFQ_M_XD1_XDFFQ_S XD1_XDFFQ_M XD1_XDFFQ_S 2.8638e-17
* device instance cc_XD1_XDFFQ_M_XD1_XDFFQ_SB r0 *1 0,0
Ccc_XD1_XDFFQ_M_XD1_XDFFQ_SB XD1_XDFFQ_M XD1_XDFFQ_SB 1.8151e-17
* device instance cc_XD1_XDFFQ_M_XD1_XN2_mid1 r0 *1 0,0
Ccc_XD1_XDFFQ_M_XD1_XN2_mid1 XD1_XDFFQ_M XD1_XN2_mid1 1.21e-17
* device instance cc_XD1_XDFFQ_M_XD1_XNOR_midp r0 *1 0,0
Ccc_XD1_XDFFQ_M_XD1_XNOR_midp XD1_XDFFQ_M XD1_XNOR_midp 1.21e-17
* device instance cc_XD1_XDFFQ_M_XD1_dmodout r0 *1 0,0
Ccc_XD1_XDFFQ_M_XD1_dmodout XD1_XDFFQ_M XD1_dmodout 1.21e-17
* device instance cc_XD1_XDFFQ_M_XD1_dq r0 *1 0,0
Ccc_XD1_XDFFQ_M_XD1_dq XD1_XDFFQ_M XD1_dq 2.8638e-17
* device instance cc_XD1_XDFFQ_M_XD1_nm r0 *1 0,0
Ccc_XD1_XDFFQ_M_XD1_nm XD1_XDFFQ_M XD1_nm 1.21e-17
* device instance cc_XD1_XDFFQ_M_XD1_nt r0 *1 0,0
Ccc_XD1_XDFFQ_M_XD1_nt XD1_XDFFQ_M XD1_nt 2.4201e-17
* device instance cc_XD1_XDFFQ_M_XD1_t1 r0 *1 0,0
Ccc_XD1_XDFFQ_M_XD1_t1 XD1_XDFFQ_M XD1_t1 1.21e-17
* device instance cc_XD1_XDFFQ_M_XD2_XDFFM_CLKB r0 *1 0,0
Ccc_XD1_XDFFQ_M_XD2_XDFFM_CLKB XD1_XDFFQ_M XD2_XDFFM_CLKB 1.8151e-17
* device instance cc_XD1_XDFFQ_M_XD2_XDFFM_M r0 *1 0,0
Ccc_XD1_XDFFQ_M_XD2_XDFFM_M XD1_XDFFQ_M XD2_XDFFM_M 2.4201e-17
* device instance cc_XD1_XDFFQ_M_XD2_XDFFM_MB r0 *1 0,0
Ccc_XD1_XDFFQ_M_XD2_XDFFM_MB XD1_XDFFQ_M XD2_XDFFM_MB 1.21e-17
* device instance cc_XD1_XDFFQ_M_XD2_XDFFM_S r0 *1 0,0
Ccc_XD1_XDFFQ_M_XD2_XDFFM_S XD1_XDFFQ_M XD2_XDFFM_S 1.8151e-17
* device instance cc_XD1_XDFFQ_M_XD2_XDFFM_SB r0 *1 0,0
Ccc_XD1_XDFFQ_M_XD2_XDFFM_SB XD1_XDFFQ_M XD2_XDFFM_SB 1.8151e-17
* device instance cc_XD1_XDFFQ_M_XD2_XDFFQ_CLKB r0 *1 0,0
Ccc_XD1_XDFFQ_M_XD2_XDFFQ_CLKB XD1_XDFFQ_M XD2_XDFFQ_CLKB 1.8151e-17
* device instance cc_XD1_XDFFQ_M_XD2_XDFFQ_M r0 *1 0,0
Ccc_XD1_XDFFQ_M_XD2_XDFFQ_M XD1_XDFFQ_M XD2_XDFFQ_M 2.4201e-17
* device instance cc_XD1_XDFFQ_M_XD2_XDFFQ_MB r0 *1 0,0
Ccc_XD1_XDFFQ_M_XD2_XDFFQ_MB XD1_XDFFQ_M XD2_XDFFQ_MB 1.21e-17
* device instance cc_XD1_XDFFQ_M_XD2_XDFFQ_S r0 *1 0,0
Ccc_XD1_XDFFQ_M_XD2_XDFFQ_S XD1_XDFFQ_M XD2_XDFFQ_S 1.8151e-17
* device instance cc_XD1_XDFFQ_M_XD2_XDFFQ_SB r0 *1 0,0
Ccc_XD1_XDFFQ_M_XD2_XDFFQ_SB XD1_XDFFQ_M XD2_XDFFQ_SB 1.8151e-17
* device instance cc_XD1_XDFFQ_M_XD2_XN2_mid1 r0 *1 0,0
Ccc_XD1_XDFFQ_M_XD2_XN2_mid1 XD1_XDFFQ_M XD2_XN2_mid1 1.21e-17
* device instance cc_XD1_XDFFQ_M_XD2_XN3_mid1 r0 *1 0,0
Ccc_XD1_XDFFQ_M_XD2_XN3_mid1 XD1_XDFFQ_M XD2_XN3_mid1 1.21e-17
* device instance cc_XD1_XDFFQ_M_XD2_XN3_mid2 r0 *1 0,0
Ccc_XD1_XDFFQ_M_XD2_XN3_mid2 XD1_XDFFQ_M XD2_XN3_mid2 1.21e-17
* device instance cc_XD1_XDFFQ_M_XD2_dmodout r0 *1 0,0
Ccc_XD1_XDFFQ_M_XD2_dmodout XD1_XDFFQ_M XD2_dmodout 1.21e-17
* device instance cc_XD1_XDFFQ_M_XD2_dq r0 *1 0,0
Ccc_XD1_XDFFQ_M_XD2_dq XD1_XDFFQ_M XD2_dq 1.8151e-17
* device instance cc_XD1_XDFFQ_M_XD2_nm r0 *1 0,0
Ccc_XD1_XDFFQ_M_XD2_nm XD1_XDFFQ_M XD2_nm 1.21e-17
* device instance cc_XD1_XDFFQ_M_XD2_nt r0 *1 0,0
Ccc_XD1_XDFFQ_M_XD2_nt XD1_XDFFQ_M XD2_nt 1.21e-17
* device instance cc_XD1_XDFFQ_M_XD2_t1 r0 *1 0,0
Ccc_XD1_XDFFQ_M_XD2_t1 XD1_XDFFQ_M XD2_t1 1.21e-17
* device instance cc_XD1_XDFFQ_M_XD3_XDFFM_CLKB r0 *1 0,0
Ccc_XD1_XDFFQ_M_XD3_XDFFM_CLKB XD1_XDFFQ_M XD3_XDFFM_CLKB 1.8151e-17
* device instance cc_XD1_XDFFQ_M_XD3_XDFFM_M r0 *1 0,0
Ccc_XD1_XDFFQ_M_XD3_XDFFM_M XD1_XDFFQ_M XD3_XDFFM_M 2.4201e-17
* device instance cc_XD1_XDFFQ_M_XD3_XDFFM_MB r0 *1 0,0
Ccc_XD1_XDFFQ_M_XD3_XDFFM_MB XD1_XDFFQ_M XD3_XDFFM_MB 1.21e-17
* device instance cc_XD1_XDFFQ_M_XD3_XDFFM_S r0 *1 0,0
Ccc_XD1_XDFFQ_M_XD3_XDFFM_S XD1_XDFFQ_M XD3_XDFFM_S 1.8151e-17
* device instance cc_XD1_XDFFQ_M_XD3_XDFFM_SB r0 *1 0,0
Ccc_XD1_XDFFQ_M_XD3_XDFFM_SB XD1_XDFFQ_M XD3_XDFFM_SB 1.8151e-17
* device instance cc_XD1_XDFFQ_M_XD3_XDFFQ_CLKB r0 *1 0,0
Ccc_XD1_XDFFQ_M_XD3_XDFFQ_CLKB XD1_XDFFQ_M XD3_XDFFQ_CLKB 1.8151e-17
* device instance cc_XD1_XDFFQ_M_XD3_XDFFQ_M r0 *1 0,0
Ccc_XD1_XDFFQ_M_XD3_XDFFQ_M XD1_XDFFQ_M XD3_XDFFQ_M 2.4201e-17
* device instance cc_XD1_XDFFQ_M_XD3_XDFFQ_MB r0 *1 0,0
Ccc_XD1_XDFFQ_M_XD3_XDFFQ_MB XD1_XDFFQ_M XD3_XDFFQ_MB 1.21e-17
* device instance cc_XD1_XDFFQ_M_XD3_XDFFQ_S r0 *1 0,0
Ccc_XD1_XDFFQ_M_XD3_XDFFQ_S XD1_XDFFQ_M XD3_XDFFQ_S 1.8151e-17
* device instance cc_XD1_XDFFQ_M_XD3_XDFFQ_SB r0 *1 0,0
Ccc_XD1_XDFFQ_M_XD3_XDFFQ_SB XD1_XDFFQ_M XD3_XDFFQ_SB 1.8151e-17
* device instance cc_XD1_XDFFQ_M_XD3_XN2_mid1 r0 *1 0,0
Ccc_XD1_XDFFQ_M_XD3_XN2_mid1 XD1_XDFFQ_M XD3_XN2_mid1 1.21e-17
* device instance cc_XD1_XDFFQ_M_XD3_XN3_mid1 r0 *1 0,0
Ccc_XD1_XDFFQ_M_XD3_XN3_mid1 XD1_XDFFQ_M XD3_XN3_mid1 1.21e-17
* device instance cc_XD1_XDFFQ_M_XD3_XN3_mid2 r0 *1 0,0
Ccc_XD1_XDFFQ_M_XD3_XN3_mid2 XD1_XDFFQ_M XD3_XN3_mid2 1.21e-17
* device instance cc_XD1_XDFFQ_M_XD3_dmodout r0 *1 0,0
Ccc_XD1_XDFFQ_M_XD3_dmodout XD1_XDFFQ_M XD3_dmodout 1.21e-17
* device instance cc_XD1_XDFFQ_M_XD3_dq r0 *1 0,0
Ccc_XD1_XDFFQ_M_XD3_dq XD1_XDFFQ_M XD3_dq 1.8151e-17
* device instance cc_XD1_XDFFQ_M_XD3_nm r0 *1 0,0
Ccc_XD1_XDFFQ_M_XD3_nm XD1_XDFFQ_M XD3_nm 1.21e-17
* device instance cc_XD1_XDFFQ_M_XD3_nt r0 *1 0,0
Ccc_XD1_XDFFQ_M_XD3_nt XD1_XDFFQ_M XD3_nt 1.21e-17
* device instance cc_XD1_XDFFQ_M_XD3_t1 r0 *1 0,0
Ccc_XD1_XDFFQ_M_XD3_t1 XD1_XDFFQ_M XD3_t1 1.21e-17
* device instance cc_XD1_XDFFQ_M_XD4_XDFFM_CLKB r0 *1 0,0
Ccc_XD1_XDFFQ_M_XD4_XDFFM_CLKB XD1_XDFFQ_M XD4_XDFFM_CLKB 1.8151e-17
* device instance cc_XD1_XDFFQ_M_XD4_XDFFM_M r0 *1 0,0
Ccc_XD1_XDFFQ_M_XD4_XDFFM_M XD1_XDFFQ_M XD4_XDFFM_M 2.4201e-17
* device instance cc_XD1_XDFFQ_M_XD4_XDFFM_MB r0 *1 0,0
Ccc_XD1_XDFFQ_M_XD4_XDFFM_MB XD1_XDFFQ_M XD4_XDFFM_MB 1.21e-17
* device instance cc_XD1_XDFFQ_M_XD4_XDFFM_S r0 *1 0,0
Ccc_XD1_XDFFQ_M_XD4_XDFFM_S XD1_XDFFQ_M XD4_XDFFM_S 1.8151e-17
* device instance cc_XD1_XDFFQ_M_XD4_XDFFM_SB r0 *1 0,0
Ccc_XD1_XDFFQ_M_XD4_XDFFM_SB XD1_XDFFQ_M XD4_XDFFM_SB 1.8151e-17
* device instance cc_XD1_XDFFQ_M_XD4_XDFFQ_CLKB r0 *1 0,0
Ccc_XD1_XDFFQ_M_XD4_XDFFQ_CLKB XD1_XDFFQ_M XD4_XDFFQ_CLKB 1.8151e-17
* device instance cc_XD1_XDFFQ_M_XD4_XDFFQ_M r0 *1 0,0
Ccc_XD1_XDFFQ_M_XD4_XDFFQ_M XD1_XDFFQ_M XD4_XDFFQ_M 2.4201e-17
* device instance cc_XD1_XDFFQ_M_XD4_XDFFQ_MB r0 *1 0,0
Ccc_XD1_XDFFQ_M_XD4_XDFFQ_MB XD1_XDFFQ_M XD4_XDFFQ_MB 1.21e-17
* device instance cc_XD1_XDFFQ_M_XD4_XDFFQ_S r0 *1 0,0
Ccc_XD1_XDFFQ_M_XD4_XDFFQ_S XD1_XDFFQ_M XD4_XDFFQ_S 1.8151e-17
* device instance cc_XD1_XDFFQ_M_XD4_XDFFQ_SB r0 *1 0,0
Ccc_XD1_XDFFQ_M_XD4_XDFFQ_SB XD1_XDFFQ_M XD4_XDFFQ_SB 1.8151e-17
* device instance cc_XD1_XDFFQ_M_XD4_XN2_mid1 r0 *1 0,0
Ccc_XD1_XDFFQ_M_XD4_XN2_mid1 XD1_XDFFQ_M XD4_XN2_mid1 1.21e-17
* device instance cc_XD1_XDFFQ_M_XD4_XN3_mid1 r0 *1 0,0
Ccc_XD1_XDFFQ_M_XD4_XN3_mid1 XD1_XDFFQ_M XD4_XN3_mid1 1.21e-17
* device instance cc_XD1_XDFFQ_M_XD4_XN3_mid2 r0 *1 0,0
Ccc_XD1_XDFFQ_M_XD4_XN3_mid2 XD1_XDFFQ_M XD4_XN3_mid2 1.21e-17
* device instance cc_XD1_XDFFQ_M_XD4_dmodout r0 *1 0,0
Ccc_XD1_XDFFQ_M_XD4_dmodout XD1_XDFFQ_M XD4_dmodout 1.21e-17
* device instance cc_XD1_XDFFQ_M_XD4_dq r0 *1 0,0
Ccc_XD1_XDFFQ_M_XD4_dq XD1_XDFFQ_M XD4_dq 1.8151e-17
* device instance cc_XD1_XDFFQ_M_XD4_nm r0 *1 0,0
Ccc_XD1_XDFFQ_M_XD4_nm XD1_XDFFQ_M XD4_nm 1.21e-17
* device instance cc_XD1_XDFFQ_M_XD4_nt r0 *1 0,0
Ccc_XD1_XDFFQ_M_XD4_nt XD1_XDFFQ_M XD4_nt 1.21e-17
* device instance cc_XD1_XDFFQ_M_XD4_t1 r0 *1 0,0
Ccc_XD1_XDFFQ_M_XD4_t1 XD1_XDFFQ_M XD4_t1 1.21e-17
* device instance cc_XD1_XDFFQ_M_XD5_XDFFM_CLKB r0 *1 0,0
Ccc_XD1_XDFFQ_M_XD5_XDFFM_CLKB XD1_XDFFQ_M XD5_XDFFM_CLKB 1.8151e-17
* device instance cc_XD1_XDFFQ_M_XD5_XDFFM_M r0 *1 0,0
Ccc_XD1_XDFFQ_M_XD5_XDFFM_M XD1_XDFFQ_M XD5_XDFFM_M 2.4201e-17
* device instance cc_XD1_XDFFQ_M_XD5_XDFFM_MB r0 *1 0,0
Ccc_XD1_XDFFQ_M_XD5_XDFFM_MB XD1_XDFFQ_M XD5_XDFFM_MB 1.21e-17
* device instance cc_XD1_XDFFQ_M_XD5_XDFFM_S r0 *1 0,0
Ccc_XD1_XDFFQ_M_XD5_XDFFM_S XD1_XDFFQ_M XD5_XDFFM_S 1.8151e-17
* device instance cc_XD1_XDFFQ_M_XD5_XDFFM_SB r0 *1 0,0
Ccc_XD1_XDFFQ_M_XD5_XDFFM_SB XD1_XDFFQ_M XD5_XDFFM_SB 1.8151e-17
* device instance cc_XD1_XDFFQ_M_XD5_XDFFQ_CLKB r0 *1 0,0
Ccc_XD1_XDFFQ_M_XD5_XDFFQ_CLKB XD1_XDFFQ_M XD5_XDFFQ_CLKB 1.8151e-17
* device instance cc_XD1_XDFFQ_M_XD5_XDFFQ_M r0 *1 0,0
Ccc_XD1_XDFFQ_M_XD5_XDFFQ_M XD1_XDFFQ_M XD5_XDFFQ_M 2.4201e-17
* device instance cc_XD1_XDFFQ_M_XD5_XDFFQ_MB r0 *1 0,0
Ccc_XD1_XDFFQ_M_XD5_XDFFQ_MB XD1_XDFFQ_M XD5_XDFFQ_MB 1.21e-17
* device instance cc_XD1_XDFFQ_M_XD5_XDFFQ_S r0 *1 0,0
Ccc_XD1_XDFFQ_M_XD5_XDFFQ_S XD1_XDFFQ_M XD5_XDFFQ_S 1.8151e-17
* device instance cc_XD1_XDFFQ_M_XD5_XDFFQ_SB r0 *1 0,0
Ccc_XD1_XDFFQ_M_XD5_XDFFQ_SB XD1_XDFFQ_M XD5_XDFFQ_SB 1.8151e-17
* device instance cc_XD1_XDFFQ_M_XD5_XN2_mid1 r0 *1 0,0
Ccc_XD1_XDFFQ_M_XD5_XN2_mid1 XD1_XDFFQ_M XD5_XN2_mid1 1.21e-17
* device instance cc_XD1_XDFFQ_M_XD5_XN3_mid1 r0 *1 0,0
Ccc_XD1_XDFFQ_M_XD5_XN3_mid1 XD1_XDFFQ_M XD5_XN3_mid1 1.21e-17
* device instance cc_XD1_XDFFQ_M_XD5_XN3_mid2 r0 *1 0,0
Ccc_XD1_XDFFQ_M_XD5_XN3_mid2 XD1_XDFFQ_M XD5_XN3_mid2 1.21e-17
* device instance cc_XD1_XDFFQ_M_XD5_dmodout r0 *1 0,0
Ccc_XD1_XDFFQ_M_XD5_dmodout XD1_XDFFQ_M XD5_dmodout 1.21e-17
* device instance cc_XD1_XDFFQ_M_XD5_dq r0 *1 0,0
Ccc_XD1_XDFFQ_M_XD5_dq XD1_XDFFQ_M XD5_dq 1.8151e-17
* device instance cc_XD1_XDFFQ_M_XD5_nm r0 *1 0,0
Ccc_XD1_XDFFQ_M_XD5_nm XD1_XDFFQ_M XD5_nm 1.21e-17
* device instance cc_XD1_XDFFQ_M_XD5_nt r0 *1 0,0
Ccc_XD1_XDFFQ_M_XD5_nt XD1_XDFFQ_M XD5_nt 1.21e-17
* device instance cc_XD1_XDFFQ_M_XD5_t1 r0 *1 0,0
Ccc_XD1_XDFFQ_M_XD5_t1 XD1_XDFFQ_M XD5_t1 1.21e-17
* device instance cc_XD1_XDFFQ_M_XFRT_CLKB r0 *1 0,0
Ccc_XD1_XDFFQ_M_XFRT_CLKB XD1_XDFFQ_M XFRT_CLKB 1.8151e-17
* device instance cc_XD1_XDFFQ_M_XFRT_M r0 *1 0,0
Ccc_XD1_XDFFQ_M_XFRT_M XD1_XDFFQ_M XFRT_M 2.4201e-17
* device instance cc_XD1_XDFFQ_M_XFRT_MB r0 *1 0,0
Ccc_XD1_XDFFQ_M_XFRT_MB XD1_XDFFQ_M XFRT_MB 1.21e-17
* device instance cc_XD1_XDFFQ_M_XFRT_S r0 *1 0,0
Ccc_XD1_XDFFQ_M_XFRT_S XD1_XDFFQ_M XFRT_S 1.8151e-17
* device instance cc_XD1_XDFFQ_M_XFRT_SB r0 *1 0,0
Ccc_XD1_XDFFQ_M_XFRT_SB XD1_XDFFQ_M XFRT_SB 1.8151e-17
* device instance cc_XD1_XDFFQ_M_ck1 r0 *1 0,0
Ccc_XD1_XDFFQ_M_ck1 XD1_XDFFQ_M ck1 6.0502e-17
* device instance cc_XD1_XDFFQ_M_ck2 r0 *1 0,0
Ccc_XD1_XDFFQ_M_ck2 XD1_XDFFQ_M ck2 5.4452e-17
* device instance cc_XD1_XDFFQ_M_ck3 r0 *1 0,0
Ccc_XD1_XDFFQ_M_ck3 XD1_XDFFQ_M ck3 5.4452e-17
* device instance cc_XD1_XDFFQ_M_ck4 r0 *1 0,0
Ccc_XD1_XDFFQ_M_ck4 XD1_XDFFQ_M ck4 5.4452e-17
* device instance cc_XD1_XDFFQ_M_ck5 r0 *1 0,0
Ccc_XD1_XDFFQ_M_ck5 XD1_XDFFQ_M ck5 5.4452e-17
* device instance cc_XD1_XDFFQ_M_mod0 r0 *1 0,0
Ccc_XD1_XDFFQ_M_mod0 XD1_XDFFQ_M mod0 2.4201e-17
* device instance cc_XD1_XDFFQ_M_mod1 r0 *1 0,0
Ccc_XD1_XDFFQ_M_mod1 XD1_XDFFQ_M mod1 2.4201e-17
* device instance cc_XD1_XDFFQ_M_mod2 r0 *1 0,0
Ccc_XD1_XDFFQ_M_mod2 XD1_XDFFQ_M mod2 2.4201e-17
* device instance cc_XD1_XDFFQ_M_mod3 r0 *1 0,0
Ccc_XD1_XDFFQ_M_mod3 XD1_XDFFQ_M mod3 2.4201e-17
* device instance cc_XD1_XDFFQ_M_mod4 r0 *1 0,0
Ccc_XD1_XDFFQ_M_mod4 XD1_XDFFQ_M mod4 2.4201e-17
* device instance cc_XD1_XDFFQ_M_net1 r0 *1 0,0
Ccc_XD1_XDFFQ_M_net1 XD1_XDFFQ_M net1 1.21e-17
* device instance cc_XD1_XDFFQ_MB_XD1_XDFFQ_S r0 *1 0,0
Ccc_XD1_XDFFQ_MB_XD1_XDFFQ_S XD1_XDFFQ_MB XD1_XDFFQ_S 1.8151e-17
* device instance cc_XD1_XDFFQ_MB_XD1_XDFFQ_SB r0 *1 0,0
Ccc_XD1_XDFFQ_MB_XD1_XDFFQ_SB XD1_XDFFQ_MB XD1_XDFFQ_SB 1.8151e-17
* device instance cc_XD1_XDFFQ_MB_XD1_XN2_mid1 r0 *1 0,0
Ccc_XD1_XDFFQ_MB_XD1_XN2_mid1 XD1_XDFFQ_MB XD1_XN2_mid1 1.21e-17
* device instance cc_XD1_XDFFQ_MB_XD1_XNOR_midp r0 *1 0,0
Ccc_XD1_XDFFQ_MB_XD1_XNOR_midp XD1_XDFFQ_MB XD1_XNOR_midp 1.21e-17
* device instance cc_XD1_XDFFQ_MB_XD1_dmodout r0 *1 0,0
Ccc_XD1_XDFFQ_MB_XD1_dmodout XD1_XDFFQ_MB XD1_dmodout 1.21e-17
* device instance cc_XD1_XDFFQ_MB_XD1_dq r0 *1 0,0
Ccc_XD1_XDFFQ_MB_XD1_dq XD1_XDFFQ_MB XD1_dq 1.21e-17
* device instance cc_XD1_XDFFQ_MB_XD1_nm r0 *1 0,0
Ccc_XD1_XDFFQ_MB_XD1_nm XD1_XDFFQ_MB XD1_nm 1.21e-17
* device instance cc_XD1_XDFFQ_MB_XD1_nt r0 *1 0,0
Ccc_XD1_XDFFQ_MB_XD1_nt XD1_XDFFQ_MB XD1_nt 2.4201e-17
* device instance cc_XD1_XDFFQ_MB_XD1_t1 r0 *1 0,0
Ccc_XD1_XDFFQ_MB_XD1_t1 XD1_XDFFQ_MB XD1_t1 1.21e-17
* device instance cc_XD1_XDFFQ_MB_XD2_XDFFM_CLKB r0 *1 0,0
Ccc_XD1_XDFFQ_MB_XD2_XDFFM_CLKB XD1_XDFFQ_MB XD2_XDFFM_CLKB 1.8151e-17
* device instance cc_XD1_XDFFQ_MB_XD2_XDFFM_M r0 *1 0,0
Ccc_XD1_XDFFQ_MB_XD2_XDFFM_M XD1_XDFFQ_MB XD2_XDFFM_M 2.4201e-17
* device instance cc_XD1_XDFFQ_MB_XD2_XDFFM_MB r0 *1 0,0
Ccc_XD1_XDFFQ_MB_XD2_XDFFM_MB XD1_XDFFQ_MB XD2_XDFFM_MB 1.21e-17
* device instance cc_XD1_XDFFQ_MB_XD2_XDFFM_S r0 *1 0,0
Ccc_XD1_XDFFQ_MB_XD2_XDFFM_S XD1_XDFFQ_MB XD2_XDFFM_S 1.8151e-17
* device instance cc_XD1_XDFFQ_MB_XD2_XDFFM_SB r0 *1 0,0
Ccc_XD1_XDFFQ_MB_XD2_XDFFM_SB XD1_XDFFQ_MB XD2_XDFFM_SB 1.8151e-17
* device instance cc_XD1_XDFFQ_MB_XD2_XDFFQ_CLKB r0 *1 0,0
Ccc_XD1_XDFFQ_MB_XD2_XDFFQ_CLKB XD1_XDFFQ_MB XD2_XDFFQ_CLKB 1.8151e-17
* device instance cc_XD1_XDFFQ_MB_XD2_XDFFQ_M r0 *1 0,0
Ccc_XD1_XDFFQ_MB_XD2_XDFFQ_M XD1_XDFFQ_MB XD2_XDFFQ_M 2.4201e-17
* device instance cc_XD1_XDFFQ_MB_XD2_XDFFQ_MB r0 *1 0,0
Ccc_XD1_XDFFQ_MB_XD2_XDFFQ_MB XD1_XDFFQ_MB XD2_XDFFQ_MB 1.21e-17
* device instance cc_XD1_XDFFQ_MB_XD2_XDFFQ_S r0 *1 0,0
Ccc_XD1_XDFFQ_MB_XD2_XDFFQ_S XD1_XDFFQ_MB XD2_XDFFQ_S 1.8151e-17
* device instance cc_XD1_XDFFQ_MB_XD2_XDFFQ_SB r0 *1 0,0
Ccc_XD1_XDFFQ_MB_XD2_XDFFQ_SB XD1_XDFFQ_MB XD2_XDFFQ_SB 1.8151e-17
* device instance cc_XD1_XDFFQ_MB_XD2_XN2_mid1 r0 *1 0,0
Ccc_XD1_XDFFQ_MB_XD2_XN2_mid1 XD1_XDFFQ_MB XD2_XN2_mid1 1.21e-17
* device instance cc_XD1_XDFFQ_MB_XD2_XN3_mid1 r0 *1 0,0
Ccc_XD1_XDFFQ_MB_XD2_XN3_mid1 XD1_XDFFQ_MB XD2_XN3_mid1 1.21e-17
* device instance cc_XD1_XDFFQ_MB_XD2_XN3_mid2 r0 *1 0,0
Ccc_XD1_XDFFQ_MB_XD2_XN3_mid2 XD1_XDFFQ_MB XD2_XN3_mid2 1.21e-17
* device instance cc_XD1_XDFFQ_MB_XD2_dmodout r0 *1 0,0
Ccc_XD1_XDFFQ_MB_XD2_dmodout XD1_XDFFQ_MB XD2_dmodout 1.21e-17
* device instance cc_XD1_XDFFQ_MB_XD2_dq r0 *1 0,0
Ccc_XD1_XDFFQ_MB_XD2_dq XD1_XDFFQ_MB XD2_dq 1.8151e-17
* device instance cc_XD1_XDFFQ_MB_XD2_nm r0 *1 0,0
Ccc_XD1_XDFFQ_MB_XD2_nm XD1_XDFFQ_MB XD2_nm 1.21e-17
* device instance cc_XD1_XDFFQ_MB_XD2_nt r0 *1 0,0
Ccc_XD1_XDFFQ_MB_XD2_nt XD1_XDFFQ_MB XD2_nt 1.21e-17
* device instance cc_XD1_XDFFQ_MB_XD2_t1 r0 *1 0,0
Ccc_XD1_XDFFQ_MB_XD2_t1 XD1_XDFFQ_MB XD2_t1 1.21e-17
* device instance cc_XD1_XDFFQ_MB_XD3_XDFFM_CLKB r0 *1 0,0
Ccc_XD1_XDFFQ_MB_XD3_XDFFM_CLKB XD1_XDFFQ_MB XD3_XDFFM_CLKB 1.8151e-17
* device instance cc_XD1_XDFFQ_MB_XD3_XDFFM_M r0 *1 0,0
Ccc_XD1_XDFFQ_MB_XD3_XDFFM_M XD1_XDFFQ_MB XD3_XDFFM_M 2.4201e-17
* device instance cc_XD1_XDFFQ_MB_XD3_XDFFM_MB r0 *1 0,0
Ccc_XD1_XDFFQ_MB_XD3_XDFFM_MB XD1_XDFFQ_MB XD3_XDFFM_MB 1.21e-17
* device instance cc_XD1_XDFFQ_MB_XD3_XDFFM_S r0 *1 0,0
Ccc_XD1_XDFFQ_MB_XD3_XDFFM_S XD1_XDFFQ_MB XD3_XDFFM_S 1.8151e-17
* device instance cc_XD1_XDFFQ_MB_XD3_XDFFM_SB r0 *1 0,0
Ccc_XD1_XDFFQ_MB_XD3_XDFFM_SB XD1_XDFFQ_MB XD3_XDFFM_SB 1.8151e-17
* device instance cc_XD1_XDFFQ_MB_XD3_XDFFQ_CLKB r0 *1 0,0
Ccc_XD1_XDFFQ_MB_XD3_XDFFQ_CLKB XD1_XDFFQ_MB XD3_XDFFQ_CLKB 1.8151e-17
* device instance cc_XD1_XDFFQ_MB_XD3_XDFFQ_M r0 *1 0,0
Ccc_XD1_XDFFQ_MB_XD3_XDFFQ_M XD1_XDFFQ_MB XD3_XDFFQ_M 2.4201e-17
* device instance cc_XD1_XDFFQ_MB_XD3_XDFFQ_MB r0 *1 0,0
Ccc_XD1_XDFFQ_MB_XD3_XDFFQ_MB XD1_XDFFQ_MB XD3_XDFFQ_MB 1.21e-17
* device instance cc_XD1_XDFFQ_MB_XD3_XDFFQ_S r0 *1 0,0
Ccc_XD1_XDFFQ_MB_XD3_XDFFQ_S XD1_XDFFQ_MB XD3_XDFFQ_S 1.8151e-17
* device instance cc_XD1_XDFFQ_MB_XD3_XDFFQ_SB r0 *1 0,0
Ccc_XD1_XDFFQ_MB_XD3_XDFFQ_SB XD1_XDFFQ_MB XD3_XDFFQ_SB 1.8151e-17
* device instance cc_XD1_XDFFQ_MB_XD3_XN2_mid1 r0 *1 0,0
Ccc_XD1_XDFFQ_MB_XD3_XN2_mid1 XD1_XDFFQ_MB XD3_XN2_mid1 1.21e-17
* device instance cc_XD1_XDFFQ_MB_XD3_XN3_mid1 r0 *1 0,0
Ccc_XD1_XDFFQ_MB_XD3_XN3_mid1 XD1_XDFFQ_MB XD3_XN3_mid1 1.21e-17
* device instance cc_XD1_XDFFQ_MB_XD3_XN3_mid2 r0 *1 0,0
Ccc_XD1_XDFFQ_MB_XD3_XN3_mid2 XD1_XDFFQ_MB XD3_XN3_mid2 1.21e-17
* device instance cc_XD1_XDFFQ_MB_XD3_dmodout r0 *1 0,0
Ccc_XD1_XDFFQ_MB_XD3_dmodout XD1_XDFFQ_MB XD3_dmodout 1.21e-17
* device instance cc_XD1_XDFFQ_MB_XD3_dq r0 *1 0,0
Ccc_XD1_XDFFQ_MB_XD3_dq XD1_XDFFQ_MB XD3_dq 1.8151e-17
* device instance cc_XD1_XDFFQ_MB_XD3_nm r0 *1 0,0
Ccc_XD1_XDFFQ_MB_XD3_nm XD1_XDFFQ_MB XD3_nm 1.21e-17
* device instance cc_XD1_XDFFQ_MB_XD3_nt r0 *1 0,0
Ccc_XD1_XDFFQ_MB_XD3_nt XD1_XDFFQ_MB XD3_nt 1.21e-17
* device instance cc_XD1_XDFFQ_MB_XD3_t1 r0 *1 0,0
Ccc_XD1_XDFFQ_MB_XD3_t1 XD1_XDFFQ_MB XD3_t1 1.21e-17
* device instance cc_XD1_XDFFQ_MB_XD4_XDFFM_CLKB r0 *1 0,0
Ccc_XD1_XDFFQ_MB_XD4_XDFFM_CLKB XD1_XDFFQ_MB XD4_XDFFM_CLKB 1.8151e-17
* device instance cc_XD1_XDFFQ_MB_XD4_XDFFM_M r0 *1 0,0
Ccc_XD1_XDFFQ_MB_XD4_XDFFM_M XD1_XDFFQ_MB XD4_XDFFM_M 2.4201e-17
* device instance cc_XD1_XDFFQ_MB_XD4_XDFFM_MB r0 *1 0,0
Ccc_XD1_XDFFQ_MB_XD4_XDFFM_MB XD1_XDFFQ_MB XD4_XDFFM_MB 1.21e-17
* device instance cc_XD1_XDFFQ_MB_XD4_XDFFM_S r0 *1 0,0
Ccc_XD1_XDFFQ_MB_XD4_XDFFM_S XD1_XDFFQ_MB XD4_XDFFM_S 1.8151e-17
* device instance cc_XD1_XDFFQ_MB_XD4_XDFFM_SB r0 *1 0,0
Ccc_XD1_XDFFQ_MB_XD4_XDFFM_SB XD1_XDFFQ_MB XD4_XDFFM_SB 1.8151e-17
* device instance cc_XD1_XDFFQ_MB_XD4_XDFFQ_CLKB r0 *1 0,0
Ccc_XD1_XDFFQ_MB_XD4_XDFFQ_CLKB XD1_XDFFQ_MB XD4_XDFFQ_CLKB 1.8151e-17
* device instance cc_XD1_XDFFQ_MB_XD4_XDFFQ_M r0 *1 0,0
Ccc_XD1_XDFFQ_MB_XD4_XDFFQ_M XD1_XDFFQ_MB XD4_XDFFQ_M 2.4201e-17
* device instance cc_XD1_XDFFQ_MB_XD4_XDFFQ_MB r0 *1 0,0
Ccc_XD1_XDFFQ_MB_XD4_XDFFQ_MB XD1_XDFFQ_MB XD4_XDFFQ_MB 1.21e-17
* device instance cc_XD1_XDFFQ_MB_XD4_XDFFQ_S r0 *1 0,0
Ccc_XD1_XDFFQ_MB_XD4_XDFFQ_S XD1_XDFFQ_MB XD4_XDFFQ_S 1.8151e-17
* device instance cc_XD1_XDFFQ_MB_XD4_XDFFQ_SB r0 *1 0,0
Ccc_XD1_XDFFQ_MB_XD4_XDFFQ_SB XD1_XDFFQ_MB XD4_XDFFQ_SB 1.8151e-17
* device instance cc_XD1_XDFFQ_MB_XD4_XN2_mid1 r0 *1 0,0
Ccc_XD1_XDFFQ_MB_XD4_XN2_mid1 XD1_XDFFQ_MB XD4_XN2_mid1 1.21e-17
* device instance cc_XD1_XDFFQ_MB_XD4_XN3_mid1 r0 *1 0,0
Ccc_XD1_XDFFQ_MB_XD4_XN3_mid1 XD1_XDFFQ_MB XD4_XN3_mid1 1.21e-17
* device instance cc_XD1_XDFFQ_MB_XD4_XN3_mid2 r0 *1 0,0
Ccc_XD1_XDFFQ_MB_XD4_XN3_mid2 XD1_XDFFQ_MB XD4_XN3_mid2 1.21e-17
* device instance cc_XD1_XDFFQ_MB_XD4_dmodout r0 *1 0,0
Ccc_XD1_XDFFQ_MB_XD4_dmodout XD1_XDFFQ_MB XD4_dmodout 1.21e-17
* device instance cc_XD1_XDFFQ_MB_XD4_dq r0 *1 0,0
Ccc_XD1_XDFFQ_MB_XD4_dq XD1_XDFFQ_MB XD4_dq 1.8151e-17
* device instance cc_XD1_XDFFQ_MB_XD4_nm r0 *1 0,0
Ccc_XD1_XDFFQ_MB_XD4_nm XD1_XDFFQ_MB XD4_nm 1.21e-17
* device instance cc_XD1_XDFFQ_MB_XD4_nt r0 *1 0,0
Ccc_XD1_XDFFQ_MB_XD4_nt XD1_XDFFQ_MB XD4_nt 1.21e-17
* device instance cc_XD1_XDFFQ_MB_XD4_t1 r0 *1 0,0
Ccc_XD1_XDFFQ_MB_XD4_t1 XD1_XDFFQ_MB XD4_t1 1.21e-17
* device instance cc_XD1_XDFFQ_MB_XD5_XDFFM_CLKB r0 *1 0,0
Ccc_XD1_XDFFQ_MB_XD5_XDFFM_CLKB XD1_XDFFQ_MB XD5_XDFFM_CLKB 1.8151e-17
* device instance cc_XD1_XDFFQ_MB_XD5_XDFFM_M r0 *1 0,0
Ccc_XD1_XDFFQ_MB_XD5_XDFFM_M XD1_XDFFQ_MB XD5_XDFFM_M 2.4201e-17
* device instance cc_XD1_XDFFQ_MB_XD5_XDFFM_MB r0 *1 0,0
Ccc_XD1_XDFFQ_MB_XD5_XDFFM_MB XD1_XDFFQ_MB XD5_XDFFM_MB 1.21e-17
* device instance cc_XD1_XDFFQ_MB_XD5_XDFFM_S r0 *1 0,0
Ccc_XD1_XDFFQ_MB_XD5_XDFFM_S XD1_XDFFQ_MB XD5_XDFFM_S 1.8151e-17
* device instance cc_XD1_XDFFQ_MB_XD5_XDFFM_SB r0 *1 0,0
Ccc_XD1_XDFFQ_MB_XD5_XDFFM_SB XD1_XDFFQ_MB XD5_XDFFM_SB 1.8151e-17
* device instance cc_XD1_XDFFQ_MB_XD5_XDFFQ_CLKB r0 *1 0,0
Ccc_XD1_XDFFQ_MB_XD5_XDFFQ_CLKB XD1_XDFFQ_MB XD5_XDFFQ_CLKB 1.8151e-17
* device instance cc_XD1_XDFFQ_MB_XD5_XDFFQ_M r0 *1 0,0
Ccc_XD1_XDFFQ_MB_XD5_XDFFQ_M XD1_XDFFQ_MB XD5_XDFFQ_M 2.4201e-17
* device instance cc_XD1_XDFFQ_MB_XD5_XDFFQ_MB r0 *1 0,0
Ccc_XD1_XDFFQ_MB_XD5_XDFFQ_MB XD1_XDFFQ_MB XD5_XDFFQ_MB 1.21e-17
* device instance cc_XD1_XDFFQ_MB_XD5_XDFFQ_S r0 *1 0,0
Ccc_XD1_XDFFQ_MB_XD5_XDFFQ_S XD1_XDFFQ_MB XD5_XDFFQ_S 1.8151e-17
* device instance cc_XD1_XDFFQ_MB_XD5_XDFFQ_SB r0 *1 0,0
Ccc_XD1_XDFFQ_MB_XD5_XDFFQ_SB XD1_XDFFQ_MB XD5_XDFFQ_SB 1.8151e-17
* device instance cc_XD1_XDFFQ_MB_XD5_XN2_mid1 r0 *1 0,0
Ccc_XD1_XDFFQ_MB_XD5_XN2_mid1 XD1_XDFFQ_MB XD5_XN2_mid1 1.21e-17
* device instance cc_XD1_XDFFQ_MB_XD5_XN3_mid1 r0 *1 0,0
Ccc_XD1_XDFFQ_MB_XD5_XN3_mid1 XD1_XDFFQ_MB XD5_XN3_mid1 1.21e-17
* device instance cc_XD1_XDFFQ_MB_XD5_XN3_mid2 r0 *1 0,0
Ccc_XD1_XDFFQ_MB_XD5_XN3_mid2 XD1_XDFFQ_MB XD5_XN3_mid2 1.21e-17
* device instance cc_XD1_XDFFQ_MB_XD5_dmodout r0 *1 0,0
Ccc_XD1_XDFFQ_MB_XD5_dmodout XD1_XDFFQ_MB XD5_dmodout 1.21e-17
* device instance cc_XD1_XDFFQ_MB_XD5_dq r0 *1 0,0
Ccc_XD1_XDFFQ_MB_XD5_dq XD1_XDFFQ_MB XD5_dq 1.8151e-17
* device instance cc_XD1_XDFFQ_MB_XD5_nm r0 *1 0,0
Ccc_XD1_XDFFQ_MB_XD5_nm XD1_XDFFQ_MB XD5_nm 1.21e-17
* device instance cc_XD1_XDFFQ_MB_XD5_nt r0 *1 0,0
Ccc_XD1_XDFFQ_MB_XD5_nt XD1_XDFFQ_MB XD5_nt 1.21e-17
* device instance cc_XD1_XDFFQ_MB_XD5_t1 r0 *1 0,0
Ccc_XD1_XDFFQ_MB_XD5_t1 XD1_XDFFQ_MB XD5_t1 1.21e-17
* device instance cc_XD1_XDFFQ_MB_XFRT_CLKB r0 *1 0,0
Ccc_XD1_XDFFQ_MB_XFRT_CLKB XD1_XDFFQ_MB XFRT_CLKB 1.8151e-17
* device instance cc_XD1_XDFFQ_MB_XFRT_M r0 *1 0,0
Ccc_XD1_XDFFQ_MB_XFRT_M XD1_XDFFQ_MB XFRT_M 2.4201e-17
* device instance cc_XD1_XDFFQ_MB_XFRT_MB r0 *1 0,0
Ccc_XD1_XDFFQ_MB_XFRT_MB XD1_XDFFQ_MB XFRT_MB 1.21e-17
* device instance cc_XD1_XDFFQ_MB_XFRT_S r0 *1 0,0
Ccc_XD1_XDFFQ_MB_XFRT_S XD1_XDFFQ_MB XFRT_S 1.8151e-17
* device instance cc_XD1_XDFFQ_MB_XFRT_SB r0 *1 0,0
Ccc_XD1_XDFFQ_MB_XFRT_SB XD1_XDFFQ_MB XFRT_SB 1.8151e-17
* device instance cc_XD1_XDFFQ_MB_ck1 r0 *1 0,0
Ccc_XD1_XDFFQ_MB_ck1 XD1_XDFFQ_MB ck1 6.0502e-17
* device instance cc_XD1_XDFFQ_MB_ck2 r0 *1 0,0
Ccc_XD1_XDFFQ_MB_ck2 XD1_XDFFQ_MB ck2 5.4452e-17
* device instance cc_XD1_XDFFQ_MB_ck3 r0 *1 0,0
Ccc_XD1_XDFFQ_MB_ck3 XD1_XDFFQ_MB ck3 5.4452e-17
* device instance cc_XD1_XDFFQ_MB_ck4 r0 *1 0,0
Ccc_XD1_XDFFQ_MB_ck4 XD1_XDFFQ_MB ck4 5.4452e-17
* device instance cc_XD1_XDFFQ_MB_ck5 r0 *1 0,0
Ccc_XD1_XDFFQ_MB_ck5 XD1_XDFFQ_MB ck5 5.4452e-17
* device instance cc_XD1_XDFFQ_MB_mod0 r0 *1 0,0
Ccc_XD1_XDFFQ_MB_mod0 XD1_XDFFQ_MB mod0 2.4201e-17
* device instance cc_XD1_XDFFQ_MB_mod1 r0 *1 0,0
Ccc_XD1_XDFFQ_MB_mod1 XD1_XDFFQ_MB mod1 2.4201e-17
* device instance cc_XD1_XDFFQ_MB_mod2 r0 *1 0,0
Ccc_XD1_XDFFQ_MB_mod2 XD1_XDFFQ_MB mod2 2.4201e-17
* device instance cc_XD1_XDFFQ_MB_mod3 r0 *1 0,0
Ccc_XD1_XDFFQ_MB_mod3 XD1_XDFFQ_MB mod3 2.4201e-17
* device instance cc_XD1_XDFFQ_MB_mod4 r0 *1 0,0
Ccc_XD1_XDFFQ_MB_mod4 XD1_XDFFQ_MB mod4 2.4201e-17
* device instance cc_XD1_XDFFQ_MB_net1 r0 *1 0,0
Ccc_XD1_XDFFQ_MB_net1 XD1_XDFFQ_MB net1 1.21e-17
* device instance cc_XD1_XDFFQ_S_XD1_XDFFQ_SB r0 *1 0,0
Ccc_XD1_XDFFQ_S_XD1_XDFFQ_SB XD1_XDFFQ_S XD1_XDFFQ_SB 4.0738e-17
* device instance cc_XD1_XDFFQ_S_XD1_XN2_mid1 r0 *1 0,0
Ccc_XD1_XDFFQ_S_XD1_XN2_mid1 XD1_XDFFQ_S XD1_XN2_mid1 1.21e-17
* device instance cc_XD1_XDFFQ_S_XD1_XNOR_midp r0 *1 0,0
Ccc_XD1_XDFFQ_S_XD1_XNOR_midp XD1_XDFFQ_S XD1_XNOR_midp 1.21e-17
* device instance cc_XD1_XDFFQ_S_XD1_dmodout r0 *1 0,0
Ccc_XD1_XDFFQ_S_XD1_dmodout XD1_XDFFQ_S XD1_dmodout 1.21e-17
* device instance cc_XD1_XDFFQ_S_XD1_dq r0 *1 0,0
Ccc_XD1_XDFFQ_S_XD1_dq XD1_XDFFQ_S XD1_dq 1.21e-17
* device instance cc_XD1_XDFFQ_S_XD1_nm r0 *1 0,0
Ccc_XD1_XDFFQ_S_XD1_nm XD1_XDFFQ_S XD1_nm 1.21e-17
* device instance cc_XD1_XDFFQ_S_XD1_nt r0 *1 0,0
Ccc_XD1_XDFFQ_S_XD1_nt XD1_XDFFQ_S XD1_nt 2.4201e-17
* device instance cc_XD1_XDFFQ_S_XD1_t1 r0 *1 0,0
Ccc_XD1_XDFFQ_S_XD1_t1 XD1_XDFFQ_S XD1_t1 1.21e-17
* device instance cc_XD1_XDFFQ_S_XD2_XDFFM_CLKB r0 *1 0,0
Ccc_XD1_XDFFQ_S_XD2_XDFFM_CLKB XD1_XDFFQ_S XD2_XDFFM_CLKB 1.8151e-17
* device instance cc_XD1_XDFFQ_S_XD2_XDFFM_M r0 *1 0,0
Ccc_XD1_XDFFQ_S_XD2_XDFFM_M XD1_XDFFQ_S XD2_XDFFM_M 2.4201e-17
* device instance cc_XD1_XDFFQ_S_XD2_XDFFM_MB r0 *1 0,0
Ccc_XD1_XDFFQ_S_XD2_XDFFM_MB XD1_XDFFQ_S XD2_XDFFM_MB 1.21e-17
* device instance cc_XD1_XDFFQ_S_XD2_XDFFM_S r0 *1 0,0
Ccc_XD1_XDFFQ_S_XD2_XDFFM_S XD1_XDFFQ_S XD2_XDFFM_S 1.8151e-17
* device instance cc_XD1_XDFFQ_S_XD2_XDFFM_SB r0 *1 0,0
Ccc_XD1_XDFFQ_S_XD2_XDFFM_SB XD1_XDFFQ_S XD2_XDFFM_SB 1.8151e-17
* device instance cc_XD1_XDFFQ_S_XD2_XDFFQ_CLKB r0 *1 0,0
Ccc_XD1_XDFFQ_S_XD2_XDFFQ_CLKB XD1_XDFFQ_S XD2_XDFFQ_CLKB 1.8151e-17
* device instance cc_XD1_XDFFQ_S_XD2_XDFFQ_M r0 *1 0,0
Ccc_XD1_XDFFQ_S_XD2_XDFFQ_M XD1_XDFFQ_S XD2_XDFFQ_M 2.4201e-17
* device instance cc_XD1_XDFFQ_S_XD2_XDFFQ_MB r0 *1 0,0
Ccc_XD1_XDFFQ_S_XD2_XDFFQ_MB XD1_XDFFQ_S XD2_XDFFQ_MB 1.21e-17
* device instance cc_XD1_XDFFQ_S_XD2_XDFFQ_S r0 *1 0,0
Ccc_XD1_XDFFQ_S_XD2_XDFFQ_S XD1_XDFFQ_S XD2_XDFFQ_S 1.8151e-17
* device instance cc_XD1_XDFFQ_S_XD2_XDFFQ_SB r0 *1 0,0
Ccc_XD1_XDFFQ_S_XD2_XDFFQ_SB XD1_XDFFQ_S XD2_XDFFQ_SB 1.8151e-17
* device instance cc_XD1_XDFFQ_S_XD2_XN2_mid1 r0 *1 0,0
Ccc_XD1_XDFFQ_S_XD2_XN2_mid1 XD1_XDFFQ_S XD2_XN2_mid1 1.21e-17
* device instance cc_XD1_XDFFQ_S_XD2_XN3_mid1 r0 *1 0,0
Ccc_XD1_XDFFQ_S_XD2_XN3_mid1 XD1_XDFFQ_S XD2_XN3_mid1 1.21e-17
* device instance cc_XD1_XDFFQ_S_XD2_XN3_mid2 r0 *1 0,0
Ccc_XD1_XDFFQ_S_XD2_XN3_mid2 XD1_XDFFQ_S XD2_XN3_mid2 1.21e-17
* device instance cc_XD1_XDFFQ_S_XD2_dmodout r0 *1 0,0
Ccc_XD1_XDFFQ_S_XD2_dmodout XD1_XDFFQ_S XD2_dmodout 1.21e-17
* device instance cc_XD1_XDFFQ_S_XD2_dq r0 *1 0,0
Ccc_XD1_XDFFQ_S_XD2_dq XD1_XDFFQ_S XD2_dq 1.8151e-17
* device instance cc_XD1_XDFFQ_S_XD2_nm r0 *1 0,0
Ccc_XD1_XDFFQ_S_XD2_nm XD1_XDFFQ_S XD2_nm 1.21e-17
* device instance cc_XD1_XDFFQ_S_XD2_nt r0 *1 0,0
Ccc_XD1_XDFFQ_S_XD2_nt XD1_XDFFQ_S XD2_nt 1.21e-17
* device instance cc_XD1_XDFFQ_S_XD2_t1 r0 *1 0,0
Ccc_XD1_XDFFQ_S_XD2_t1 XD1_XDFFQ_S XD2_t1 1.21e-17
* device instance cc_XD1_XDFFQ_S_XD3_XDFFM_CLKB r0 *1 0,0
Ccc_XD1_XDFFQ_S_XD3_XDFFM_CLKB XD1_XDFFQ_S XD3_XDFFM_CLKB 1.8151e-17
* device instance cc_XD1_XDFFQ_S_XD3_XDFFM_M r0 *1 0,0
Ccc_XD1_XDFFQ_S_XD3_XDFFM_M XD1_XDFFQ_S XD3_XDFFM_M 2.4201e-17
* device instance cc_XD1_XDFFQ_S_XD3_XDFFM_MB r0 *1 0,0
Ccc_XD1_XDFFQ_S_XD3_XDFFM_MB XD1_XDFFQ_S XD3_XDFFM_MB 1.21e-17
* device instance cc_XD1_XDFFQ_S_XD3_XDFFM_S r0 *1 0,0
Ccc_XD1_XDFFQ_S_XD3_XDFFM_S XD1_XDFFQ_S XD3_XDFFM_S 1.8151e-17
* device instance cc_XD1_XDFFQ_S_XD3_XDFFM_SB r0 *1 0,0
Ccc_XD1_XDFFQ_S_XD3_XDFFM_SB XD1_XDFFQ_S XD3_XDFFM_SB 1.8151e-17
* device instance cc_XD1_XDFFQ_S_XD3_XDFFQ_CLKB r0 *1 0,0
Ccc_XD1_XDFFQ_S_XD3_XDFFQ_CLKB XD1_XDFFQ_S XD3_XDFFQ_CLKB 1.8151e-17
* device instance cc_XD1_XDFFQ_S_XD3_XDFFQ_M r0 *1 0,0
Ccc_XD1_XDFFQ_S_XD3_XDFFQ_M XD1_XDFFQ_S XD3_XDFFQ_M 2.4201e-17
* device instance cc_XD1_XDFFQ_S_XD3_XDFFQ_MB r0 *1 0,0
Ccc_XD1_XDFFQ_S_XD3_XDFFQ_MB XD1_XDFFQ_S XD3_XDFFQ_MB 1.21e-17
* device instance cc_XD1_XDFFQ_S_XD3_XDFFQ_S r0 *1 0,0
Ccc_XD1_XDFFQ_S_XD3_XDFFQ_S XD1_XDFFQ_S XD3_XDFFQ_S 1.8151e-17
* device instance cc_XD1_XDFFQ_S_XD3_XDFFQ_SB r0 *1 0,0
Ccc_XD1_XDFFQ_S_XD3_XDFFQ_SB XD1_XDFFQ_S XD3_XDFFQ_SB 1.8151e-17
* device instance cc_XD1_XDFFQ_S_XD3_XN2_mid1 r0 *1 0,0
Ccc_XD1_XDFFQ_S_XD3_XN2_mid1 XD1_XDFFQ_S XD3_XN2_mid1 1.21e-17
* device instance cc_XD1_XDFFQ_S_XD3_XN3_mid1 r0 *1 0,0
Ccc_XD1_XDFFQ_S_XD3_XN3_mid1 XD1_XDFFQ_S XD3_XN3_mid1 1.21e-17
* device instance cc_XD1_XDFFQ_S_XD3_XN3_mid2 r0 *1 0,0
Ccc_XD1_XDFFQ_S_XD3_XN3_mid2 XD1_XDFFQ_S XD3_XN3_mid2 1.21e-17
* device instance cc_XD1_XDFFQ_S_XD3_dmodout r0 *1 0,0
Ccc_XD1_XDFFQ_S_XD3_dmodout XD1_XDFFQ_S XD3_dmodout 1.21e-17
* device instance cc_XD1_XDFFQ_S_XD3_dq r0 *1 0,0
Ccc_XD1_XDFFQ_S_XD3_dq XD1_XDFFQ_S XD3_dq 1.8151e-17
* device instance cc_XD1_XDFFQ_S_XD3_nm r0 *1 0,0
Ccc_XD1_XDFFQ_S_XD3_nm XD1_XDFFQ_S XD3_nm 1.21e-17
* device instance cc_XD1_XDFFQ_S_XD3_nt r0 *1 0,0
Ccc_XD1_XDFFQ_S_XD3_nt XD1_XDFFQ_S XD3_nt 1.21e-17
* device instance cc_XD1_XDFFQ_S_XD3_t1 r0 *1 0,0
Ccc_XD1_XDFFQ_S_XD3_t1 XD1_XDFFQ_S XD3_t1 1.21e-17
* device instance cc_XD1_XDFFQ_S_XD4_XDFFM_CLKB r0 *1 0,0
Ccc_XD1_XDFFQ_S_XD4_XDFFM_CLKB XD1_XDFFQ_S XD4_XDFFM_CLKB 1.8151e-17
* device instance cc_XD1_XDFFQ_S_XD4_XDFFM_M r0 *1 0,0
Ccc_XD1_XDFFQ_S_XD4_XDFFM_M XD1_XDFFQ_S XD4_XDFFM_M 2.4201e-17
* device instance cc_XD1_XDFFQ_S_XD4_XDFFM_MB r0 *1 0,0
Ccc_XD1_XDFFQ_S_XD4_XDFFM_MB XD1_XDFFQ_S XD4_XDFFM_MB 1.21e-17
* device instance cc_XD1_XDFFQ_S_XD4_XDFFM_S r0 *1 0,0
Ccc_XD1_XDFFQ_S_XD4_XDFFM_S XD1_XDFFQ_S XD4_XDFFM_S 1.8151e-17
* device instance cc_XD1_XDFFQ_S_XD4_XDFFM_SB r0 *1 0,0
Ccc_XD1_XDFFQ_S_XD4_XDFFM_SB XD1_XDFFQ_S XD4_XDFFM_SB 1.8151e-17
* device instance cc_XD1_XDFFQ_S_XD4_XDFFQ_CLKB r0 *1 0,0
Ccc_XD1_XDFFQ_S_XD4_XDFFQ_CLKB XD1_XDFFQ_S XD4_XDFFQ_CLKB 1.8151e-17
* device instance cc_XD1_XDFFQ_S_XD4_XDFFQ_M r0 *1 0,0
Ccc_XD1_XDFFQ_S_XD4_XDFFQ_M XD1_XDFFQ_S XD4_XDFFQ_M 2.4201e-17
* device instance cc_XD1_XDFFQ_S_XD4_XDFFQ_MB r0 *1 0,0
Ccc_XD1_XDFFQ_S_XD4_XDFFQ_MB XD1_XDFFQ_S XD4_XDFFQ_MB 1.21e-17
* device instance cc_XD1_XDFFQ_S_XD4_XDFFQ_S r0 *1 0,0
Ccc_XD1_XDFFQ_S_XD4_XDFFQ_S XD1_XDFFQ_S XD4_XDFFQ_S 1.8151e-17
* device instance cc_XD1_XDFFQ_S_XD4_XDFFQ_SB r0 *1 0,0
Ccc_XD1_XDFFQ_S_XD4_XDFFQ_SB XD1_XDFFQ_S XD4_XDFFQ_SB 1.8151e-17
* device instance cc_XD1_XDFFQ_S_XD4_XN2_mid1 r0 *1 0,0
Ccc_XD1_XDFFQ_S_XD4_XN2_mid1 XD1_XDFFQ_S XD4_XN2_mid1 1.21e-17
* device instance cc_XD1_XDFFQ_S_XD4_XN3_mid1 r0 *1 0,0
Ccc_XD1_XDFFQ_S_XD4_XN3_mid1 XD1_XDFFQ_S XD4_XN3_mid1 1.21e-17
* device instance cc_XD1_XDFFQ_S_XD4_XN3_mid2 r0 *1 0,0
Ccc_XD1_XDFFQ_S_XD4_XN3_mid2 XD1_XDFFQ_S XD4_XN3_mid2 1.21e-17
* device instance cc_XD1_XDFFQ_S_XD4_dmodout r0 *1 0,0
Ccc_XD1_XDFFQ_S_XD4_dmodout XD1_XDFFQ_S XD4_dmodout 1.21e-17
* device instance cc_XD1_XDFFQ_S_XD4_dq r0 *1 0,0
Ccc_XD1_XDFFQ_S_XD4_dq XD1_XDFFQ_S XD4_dq 1.8151e-17
* device instance cc_XD1_XDFFQ_S_XD4_nm r0 *1 0,0
Ccc_XD1_XDFFQ_S_XD4_nm XD1_XDFFQ_S XD4_nm 1.21e-17
* device instance cc_XD1_XDFFQ_S_XD4_nt r0 *1 0,0
Ccc_XD1_XDFFQ_S_XD4_nt XD1_XDFFQ_S XD4_nt 1.21e-17
* device instance cc_XD1_XDFFQ_S_XD4_t1 r0 *1 0,0
Ccc_XD1_XDFFQ_S_XD4_t1 XD1_XDFFQ_S XD4_t1 1.21e-17
* device instance cc_XD1_XDFFQ_S_XD5_XDFFM_CLKB r0 *1 0,0
Ccc_XD1_XDFFQ_S_XD5_XDFFM_CLKB XD1_XDFFQ_S XD5_XDFFM_CLKB 1.8151e-17
* device instance cc_XD1_XDFFQ_S_XD5_XDFFM_M r0 *1 0,0
Ccc_XD1_XDFFQ_S_XD5_XDFFM_M XD1_XDFFQ_S XD5_XDFFM_M 2.4201e-17
* device instance cc_XD1_XDFFQ_S_XD5_XDFFM_MB r0 *1 0,0
Ccc_XD1_XDFFQ_S_XD5_XDFFM_MB XD1_XDFFQ_S XD5_XDFFM_MB 1.21e-17
* device instance cc_XD1_XDFFQ_S_XD5_XDFFM_S r0 *1 0,0
Ccc_XD1_XDFFQ_S_XD5_XDFFM_S XD1_XDFFQ_S XD5_XDFFM_S 1.8151e-17
* device instance cc_XD1_XDFFQ_S_XD5_XDFFM_SB r0 *1 0,0
Ccc_XD1_XDFFQ_S_XD5_XDFFM_SB XD1_XDFFQ_S XD5_XDFFM_SB 1.8151e-17
* device instance cc_XD1_XDFFQ_S_XD5_XDFFQ_CLKB r0 *1 0,0
Ccc_XD1_XDFFQ_S_XD5_XDFFQ_CLKB XD1_XDFFQ_S XD5_XDFFQ_CLKB 1.8151e-17
* device instance cc_XD1_XDFFQ_S_XD5_XDFFQ_M r0 *1 0,0
Ccc_XD1_XDFFQ_S_XD5_XDFFQ_M XD1_XDFFQ_S XD5_XDFFQ_M 2.4201e-17
* device instance cc_XD1_XDFFQ_S_XD5_XDFFQ_MB r0 *1 0,0
Ccc_XD1_XDFFQ_S_XD5_XDFFQ_MB XD1_XDFFQ_S XD5_XDFFQ_MB 1.21e-17
* device instance cc_XD1_XDFFQ_S_XD5_XDFFQ_S r0 *1 0,0
Ccc_XD1_XDFFQ_S_XD5_XDFFQ_S XD1_XDFFQ_S XD5_XDFFQ_S 1.8151e-17
* device instance cc_XD1_XDFFQ_S_XD5_XDFFQ_SB r0 *1 0,0
Ccc_XD1_XDFFQ_S_XD5_XDFFQ_SB XD1_XDFFQ_S XD5_XDFFQ_SB 1.8151e-17
* device instance cc_XD1_XDFFQ_S_XD5_XN2_mid1 r0 *1 0,0
Ccc_XD1_XDFFQ_S_XD5_XN2_mid1 XD1_XDFFQ_S XD5_XN2_mid1 1.21e-17
* device instance cc_XD1_XDFFQ_S_XD5_XN3_mid1 r0 *1 0,0
Ccc_XD1_XDFFQ_S_XD5_XN3_mid1 XD1_XDFFQ_S XD5_XN3_mid1 1.21e-17
* device instance cc_XD1_XDFFQ_S_XD5_XN3_mid2 r0 *1 0,0
Ccc_XD1_XDFFQ_S_XD5_XN3_mid2 XD1_XDFFQ_S XD5_XN3_mid2 1.21e-17
* device instance cc_XD1_XDFFQ_S_XD5_dmodout r0 *1 0,0
Ccc_XD1_XDFFQ_S_XD5_dmodout XD1_XDFFQ_S XD5_dmodout 1.21e-17
* device instance cc_XD1_XDFFQ_S_XD5_dq r0 *1 0,0
Ccc_XD1_XDFFQ_S_XD5_dq XD1_XDFFQ_S XD5_dq 1.8151e-17
* device instance cc_XD1_XDFFQ_S_XD5_nm r0 *1 0,0
Ccc_XD1_XDFFQ_S_XD5_nm XD1_XDFFQ_S XD5_nm 1.21e-17
* device instance cc_XD1_XDFFQ_S_XD5_nt r0 *1 0,0
Ccc_XD1_XDFFQ_S_XD5_nt XD1_XDFFQ_S XD5_nt 1.21e-17
* device instance cc_XD1_XDFFQ_S_XD5_t1 r0 *1 0,0
Ccc_XD1_XDFFQ_S_XD5_t1 XD1_XDFFQ_S XD5_t1 1.21e-17
* device instance cc_XD1_XDFFQ_S_XFRT_CLKB r0 *1 0,0
Ccc_XD1_XDFFQ_S_XFRT_CLKB XD1_XDFFQ_S XFRT_CLKB 1.8151e-17
* device instance cc_XD1_XDFFQ_S_XFRT_M r0 *1 0,0
Ccc_XD1_XDFFQ_S_XFRT_M XD1_XDFFQ_S XFRT_M 2.4201e-17
* device instance cc_XD1_XDFFQ_S_XFRT_MB r0 *1 0,0
Ccc_XD1_XDFFQ_S_XFRT_MB XD1_XDFFQ_S XFRT_MB 1.21e-17
* device instance cc_XD1_XDFFQ_S_XFRT_S r0 *1 0,0
Ccc_XD1_XDFFQ_S_XFRT_S XD1_XDFFQ_S XFRT_S 1.8151e-17
* device instance cc_XD1_XDFFQ_S_XFRT_SB r0 *1 0,0
Ccc_XD1_XDFFQ_S_XFRT_SB XD1_XDFFQ_S XFRT_SB 1.8151e-17
* device instance cc_XD1_XDFFQ_S_ck1 r0 *1 0,0
Ccc_XD1_XDFFQ_S_ck1 XD1_XDFFQ_S ck1 5.4452e-17
* device instance cc_XD1_XDFFQ_S_ck2 r0 *1 0,0
Ccc_XD1_XDFFQ_S_ck2 XD1_XDFFQ_S ck2 5.4452e-17
* device instance cc_XD1_XDFFQ_S_ck3 r0 *1 0,0
Ccc_XD1_XDFFQ_S_ck3 XD1_XDFFQ_S ck3 5.4452e-17
* device instance cc_XD1_XDFFQ_S_ck4 r0 *1 0,0
Ccc_XD1_XDFFQ_S_ck4 XD1_XDFFQ_S ck4 5.4452e-17
* device instance cc_XD1_XDFFQ_S_ck5 r0 *1 0,0
Ccc_XD1_XDFFQ_S_ck5 XD1_XDFFQ_S ck5 5.4452e-17
* device instance cc_XD1_XDFFQ_S_mod0 r0 *1 0,0
Ccc_XD1_XDFFQ_S_mod0 XD1_XDFFQ_S mod0 2.4201e-17
* device instance cc_XD1_XDFFQ_S_mod1 r0 *1 0,0
Ccc_XD1_XDFFQ_S_mod1 XD1_XDFFQ_S mod1 2.4201e-17
* device instance cc_XD1_XDFFQ_S_mod2 r0 *1 0,0
Ccc_XD1_XDFFQ_S_mod2 XD1_XDFFQ_S mod2 2.4201e-17
* device instance cc_XD1_XDFFQ_S_mod3 r0 *1 0,0
Ccc_XD1_XDFFQ_S_mod3 XD1_XDFFQ_S mod3 2.4201e-17
* device instance cc_XD1_XDFFQ_S_mod4 r0 *1 0,0
Ccc_XD1_XDFFQ_S_mod4 XD1_XDFFQ_S mod4 2.4201e-17
* device instance cc_XD1_XDFFQ_S_net1 r0 *1 0,0
Ccc_XD1_XDFFQ_S_net1 XD1_XDFFQ_S net1 1.21e-17
* device instance cc_XD1_XDFFQ_SB_XD1_XN2_mid1 r0 *1 0,0
Ccc_XD1_XDFFQ_SB_XD1_XN2_mid1 XD1_XDFFQ_SB XD1_XN2_mid1 1.21e-17
* device instance cc_XD1_XDFFQ_SB_XD1_XNOR_midp r0 *1 0,0
Ccc_XD1_XDFFQ_SB_XD1_XNOR_midp XD1_XDFFQ_SB XD1_XNOR_midp 1.21e-17
* device instance cc_XD1_XDFFQ_SB_XD1_dmodout r0 *1 0,0
Ccc_XD1_XDFFQ_SB_XD1_dmodout XD1_XDFFQ_SB XD1_dmodout 1.21e-17
* device instance cc_XD1_XDFFQ_SB_XD1_dq r0 *1 0,0
Ccc_XD1_XDFFQ_SB_XD1_dq XD1_XDFFQ_SB XD1_dq 1.21e-17
* device instance cc_XD1_XDFFQ_SB_XD1_nm r0 *1 0,0
Ccc_XD1_XDFFQ_SB_XD1_nm XD1_XDFFQ_SB XD1_nm 1.21e-17
* device instance cc_XD1_XDFFQ_SB_XD1_nt r0 *1 0,0
Ccc_XD1_XDFFQ_SB_XD1_nt XD1_XDFFQ_SB XD1_nt 2.4201e-17
* device instance cc_XD1_XDFFQ_SB_XD1_t1 r0 *1 0,0
Ccc_XD1_XDFFQ_SB_XD1_t1 XD1_XDFFQ_SB XD1_t1 1.21e-17
* device instance cc_XD1_XDFFQ_SB_XD2_XDFFM_CLKB r0 *1 0,0
Ccc_XD1_XDFFQ_SB_XD2_XDFFM_CLKB XD1_XDFFQ_SB XD2_XDFFM_CLKB 1.8151e-17
* device instance cc_XD1_XDFFQ_SB_XD2_XDFFM_M r0 *1 0,0
Ccc_XD1_XDFFQ_SB_XD2_XDFFM_M XD1_XDFFQ_SB XD2_XDFFM_M 2.4201e-17
* device instance cc_XD1_XDFFQ_SB_XD2_XDFFM_MB r0 *1 0,0
Ccc_XD1_XDFFQ_SB_XD2_XDFFM_MB XD1_XDFFQ_SB XD2_XDFFM_MB 1.21e-17
* device instance cc_XD1_XDFFQ_SB_XD2_XDFFM_S r0 *1 0,0
Ccc_XD1_XDFFQ_SB_XD2_XDFFM_S XD1_XDFFQ_SB XD2_XDFFM_S 1.8151e-17
* device instance cc_XD1_XDFFQ_SB_XD2_XDFFM_SB r0 *1 0,0
Ccc_XD1_XDFFQ_SB_XD2_XDFFM_SB XD1_XDFFQ_SB XD2_XDFFM_SB 1.8151e-17
* device instance cc_XD1_XDFFQ_SB_XD2_XDFFQ_CLKB r0 *1 0,0
Ccc_XD1_XDFFQ_SB_XD2_XDFFQ_CLKB XD1_XDFFQ_SB XD2_XDFFQ_CLKB 1.8151e-17
* device instance cc_XD1_XDFFQ_SB_XD2_XDFFQ_M r0 *1 0,0
Ccc_XD1_XDFFQ_SB_XD2_XDFFQ_M XD1_XDFFQ_SB XD2_XDFFQ_M 2.4201e-17
* device instance cc_XD1_XDFFQ_SB_XD2_XDFFQ_MB r0 *1 0,0
Ccc_XD1_XDFFQ_SB_XD2_XDFFQ_MB XD1_XDFFQ_SB XD2_XDFFQ_MB 1.21e-17
* device instance cc_XD1_XDFFQ_SB_XD2_XDFFQ_S r0 *1 0,0
Ccc_XD1_XDFFQ_SB_XD2_XDFFQ_S XD1_XDFFQ_SB XD2_XDFFQ_S 1.8151e-17
* device instance cc_XD1_XDFFQ_SB_XD2_XDFFQ_SB r0 *1 0,0
Ccc_XD1_XDFFQ_SB_XD2_XDFFQ_SB XD1_XDFFQ_SB XD2_XDFFQ_SB 1.8151e-17
* device instance cc_XD1_XDFFQ_SB_XD2_XN2_mid1 r0 *1 0,0
Ccc_XD1_XDFFQ_SB_XD2_XN2_mid1 XD1_XDFFQ_SB XD2_XN2_mid1 1.21e-17
* device instance cc_XD1_XDFFQ_SB_XD2_XN3_mid1 r0 *1 0,0
Ccc_XD1_XDFFQ_SB_XD2_XN3_mid1 XD1_XDFFQ_SB XD2_XN3_mid1 1.21e-17
* device instance cc_XD1_XDFFQ_SB_XD2_XN3_mid2 r0 *1 0,0
Ccc_XD1_XDFFQ_SB_XD2_XN3_mid2 XD1_XDFFQ_SB XD2_XN3_mid2 1.21e-17
* device instance cc_XD1_XDFFQ_SB_XD2_dmodout r0 *1 0,0
Ccc_XD1_XDFFQ_SB_XD2_dmodout XD1_XDFFQ_SB XD2_dmodout 1.21e-17
* device instance cc_XD1_XDFFQ_SB_XD2_dq r0 *1 0,0
Ccc_XD1_XDFFQ_SB_XD2_dq XD1_XDFFQ_SB XD2_dq 1.8151e-17
* device instance cc_XD1_XDFFQ_SB_XD2_nm r0 *1 0,0
Ccc_XD1_XDFFQ_SB_XD2_nm XD1_XDFFQ_SB XD2_nm 1.21e-17
* device instance cc_XD1_XDFFQ_SB_XD2_nt r0 *1 0,0
Ccc_XD1_XDFFQ_SB_XD2_nt XD1_XDFFQ_SB XD2_nt 1.21e-17
* device instance cc_XD1_XDFFQ_SB_XD2_t1 r0 *1 0,0
Ccc_XD1_XDFFQ_SB_XD2_t1 XD1_XDFFQ_SB XD2_t1 1.21e-17
* device instance cc_XD1_XDFFQ_SB_XD3_XDFFM_CLKB r0 *1 0,0
Ccc_XD1_XDFFQ_SB_XD3_XDFFM_CLKB XD1_XDFFQ_SB XD3_XDFFM_CLKB 1.8151e-17
* device instance cc_XD1_XDFFQ_SB_XD3_XDFFM_M r0 *1 0,0
Ccc_XD1_XDFFQ_SB_XD3_XDFFM_M XD1_XDFFQ_SB XD3_XDFFM_M 2.4201e-17
* device instance cc_XD1_XDFFQ_SB_XD3_XDFFM_MB r0 *1 0,0
Ccc_XD1_XDFFQ_SB_XD3_XDFFM_MB XD1_XDFFQ_SB XD3_XDFFM_MB 1.21e-17
* device instance cc_XD1_XDFFQ_SB_XD3_XDFFM_S r0 *1 0,0
Ccc_XD1_XDFFQ_SB_XD3_XDFFM_S XD1_XDFFQ_SB XD3_XDFFM_S 1.8151e-17
* device instance cc_XD1_XDFFQ_SB_XD3_XDFFM_SB r0 *1 0,0
Ccc_XD1_XDFFQ_SB_XD3_XDFFM_SB XD1_XDFFQ_SB XD3_XDFFM_SB 1.8151e-17
* device instance cc_XD1_XDFFQ_SB_XD3_XDFFQ_CLKB r0 *1 0,0
Ccc_XD1_XDFFQ_SB_XD3_XDFFQ_CLKB XD1_XDFFQ_SB XD3_XDFFQ_CLKB 1.8151e-17
* device instance cc_XD1_XDFFQ_SB_XD3_XDFFQ_M r0 *1 0,0
Ccc_XD1_XDFFQ_SB_XD3_XDFFQ_M XD1_XDFFQ_SB XD3_XDFFQ_M 2.4201e-17
* device instance cc_XD1_XDFFQ_SB_XD3_XDFFQ_MB r0 *1 0,0
Ccc_XD1_XDFFQ_SB_XD3_XDFFQ_MB XD1_XDFFQ_SB XD3_XDFFQ_MB 1.21e-17
* device instance cc_XD1_XDFFQ_SB_XD3_XDFFQ_S r0 *1 0,0
Ccc_XD1_XDFFQ_SB_XD3_XDFFQ_S XD1_XDFFQ_SB XD3_XDFFQ_S 1.8151e-17
* device instance cc_XD1_XDFFQ_SB_XD3_XDFFQ_SB r0 *1 0,0
Ccc_XD1_XDFFQ_SB_XD3_XDFFQ_SB XD1_XDFFQ_SB XD3_XDFFQ_SB 1.8151e-17
* device instance cc_XD1_XDFFQ_SB_XD3_XN2_mid1 r0 *1 0,0
Ccc_XD1_XDFFQ_SB_XD3_XN2_mid1 XD1_XDFFQ_SB XD3_XN2_mid1 1.21e-17
* device instance cc_XD1_XDFFQ_SB_XD3_XN3_mid1 r0 *1 0,0
Ccc_XD1_XDFFQ_SB_XD3_XN3_mid1 XD1_XDFFQ_SB XD3_XN3_mid1 1.21e-17
* device instance cc_XD1_XDFFQ_SB_XD3_XN3_mid2 r0 *1 0,0
Ccc_XD1_XDFFQ_SB_XD3_XN3_mid2 XD1_XDFFQ_SB XD3_XN3_mid2 1.21e-17
* device instance cc_XD1_XDFFQ_SB_XD3_dmodout r0 *1 0,0
Ccc_XD1_XDFFQ_SB_XD3_dmodout XD1_XDFFQ_SB XD3_dmodout 1.21e-17
* device instance cc_XD1_XDFFQ_SB_XD3_dq r0 *1 0,0
Ccc_XD1_XDFFQ_SB_XD3_dq XD1_XDFFQ_SB XD3_dq 1.8151e-17
* device instance cc_XD1_XDFFQ_SB_XD3_nm r0 *1 0,0
Ccc_XD1_XDFFQ_SB_XD3_nm XD1_XDFFQ_SB XD3_nm 1.21e-17
* device instance cc_XD1_XDFFQ_SB_XD3_nt r0 *1 0,0
Ccc_XD1_XDFFQ_SB_XD3_nt XD1_XDFFQ_SB XD3_nt 1.21e-17
* device instance cc_XD1_XDFFQ_SB_XD3_t1 r0 *1 0,0
Ccc_XD1_XDFFQ_SB_XD3_t1 XD1_XDFFQ_SB XD3_t1 1.21e-17
* device instance cc_XD1_XDFFQ_SB_XD4_XDFFM_CLKB r0 *1 0,0
Ccc_XD1_XDFFQ_SB_XD4_XDFFM_CLKB XD1_XDFFQ_SB XD4_XDFFM_CLKB 1.8151e-17
* device instance cc_XD1_XDFFQ_SB_XD4_XDFFM_M r0 *1 0,0
Ccc_XD1_XDFFQ_SB_XD4_XDFFM_M XD1_XDFFQ_SB XD4_XDFFM_M 2.4201e-17
* device instance cc_XD1_XDFFQ_SB_XD4_XDFFM_MB r0 *1 0,0
Ccc_XD1_XDFFQ_SB_XD4_XDFFM_MB XD1_XDFFQ_SB XD4_XDFFM_MB 1.21e-17
* device instance cc_XD1_XDFFQ_SB_XD4_XDFFM_S r0 *1 0,0
Ccc_XD1_XDFFQ_SB_XD4_XDFFM_S XD1_XDFFQ_SB XD4_XDFFM_S 1.8151e-17
* device instance cc_XD1_XDFFQ_SB_XD4_XDFFM_SB r0 *1 0,0
Ccc_XD1_XDFFQ_SB_XD4_XDFFM_SB XD1_XDFFQ_SB XD4_XDFFM_SB 1.8151e-17
* device instance cc_XD1_XDFFQ_SB_XD4_XDFFQ_CLKB r0 *1 0,0
Ccc_XD1_XDFFQ_SB_XD4_XDFFQ_CLKB XD1_XDFFQ_SB XD4_XDFFQ_CLKB 1.8151e-17
* device instance cc_XD1_XDFFQ_SB_XD4_XDFFQ_M r0 *1 0,0
Ccc_XD1_XDFFQ_SB_XD4_XDFFQ_M XD1_XDFFQ_SB XD4_XDFFQ_M 2.4201e-17
* device instance cc_XD1_XDFFQ_SB_XD4_XDFFQ_MB r0 *1 0,0
Ccc_XD1_XDFFQ_SB_XD4_XDFFQ_MB XD1_XDFFQ_SB XD4_XDFFQ_MB 1.21e-17
* device instance cc_XD1_XDFFQ_SB_XD4_XDFFQ_S r0 *1 0,0
Ccc_XD1_XDFFQ_SB_XD4_XDFFQ_S XD1_XDFFQ_SB XD4_XDFFQ_S 1.8151e-17
* device instance cc_XD1_XDFFQ_SB_XD4_XDFFQ_SB r0 *1 0,0
Ccc_XD1_XDFFQ_SB_XD4_XDFFQ_SB XD1_XDFFQ_SB XD4_XDFFQ_SB 1.8151e-17
* device instance cc_XD1_XDFFQ_SB_XD4_XN2_mid1 r0 *1 0,0
Ccc_XD1_XDFFQ_SB_XD4_XN2_mid1 XD1_XDFFQ_SB XD4_XN2_mid1 1.21e-17
* device instance cc_XD1_XDFFQ_SB_XD4_XN3_mid1 r0 *1 0,0
Ccc_XD1_XDFFQ_SB_XD4_XN3_mid1 XD1_XDFFQ_SB XD4_XN3_mid1 1.21e-17
* device instance cc_XD1_XDFFQ_SB_XD4_XN3_mid2 r0 *1 0,0
Ccc_XD1_XDFFQ_SB_XD4_XN3_mid2 XD1_XDFFQ_SB XD4_XN3_mid2 1.21e-17
* device instance cc_XD1_XDFFQ_SB_XD4_dmodout r0 *1 0,0
Ccc_XD1_XDFFQ_SB_XD4_dmodout XD1_XDFFQ_SB XD4_dmodout 1.21e-17
* device instance cc_XD1_XDFFQ_SB_XD4_dq r0 *1 0,0
Ccc_XD1_XDFFQ_SB_XD4_dq XD1_XDFFQ_SB XD4_dq 1.8151e-17
* device instance cc_XD1_XDFFQ_SB_XD4_nm r0 *1 0,0
Ccc_XD1_XDFFQ_SB_XD4_nm XD1_XDFFQ_SB XD4_nm 1.21e-17
* device instance cc_XD1_XDFFQ_SB_XD4_nt r0 *1 0,0
Ccc_XD1_XDFFQ_SB_XD4_nt XD1_XDFFQ_SB XD4_nt 1.21e-17
* device instance cc_XD1_XDFFQ_SB_XD4_t1 r0 *1 0,0
Ccc_XD1_XDFFQ_SB_XD4_t1 XD1_XDFFQ_SB XD4_t1 1.21e-17
* device instance cc_XD1_XDFFQ_SB_XD5_XDFFM_CLKB r0 *1 0,0
Ccc_XD1_XDFFQ_SB_XD5_XDFFM_CLKB XD1_XDFFQ_SB XD5_XDFFM_CLKB 1.8151e-17
* device instance cc_XD1_XDFFQ_SB_XD5_XDFFM_M r0 *1 0,0
Ccc_XD1_XDFFQ_SB_XD5_XDFFM_M XD1_XDFFQ_SB XD5_XDFFM_M 2.4201e-17
* device instance cc_XD1_XDFFQ_SB_XD5_XDFFM_MB r0 *1 0,0
Ccc_XD1_XDFFQ_SB_XD5_XDFFM_MB XD1_XDFFQ_SB XD5_XDFFM_MB 1.21e-17
* device instance cc_XD1_XDFFQ_SB_XD5_XDFFM_S r0 *1 0,0
Ccc_XD1_XDFFQ_SB_XD5_XDFFM_S XD1_XDFFQ_SB XD5_XDFFM_S 1.8151e-17
* device instance cc_XD1_XDFFQ_SB_XD5_XDFFM_SB r0 *1 0,0
Ccc_XD1_XDFFQ_SB_XD5_XDFFM_SB XD1_XDFFQ_SB XD5_XDFFM_SB 1.8151e-17
* device instance cc_XD1_XDFFQ_SB_XD5_XDFFQ_CLKB r0 *1 0,0
Ccc_XD1_XDFFQ_SB_XD5_XDFFQ_CLKB XD1_XDFFQ_SB XD5_XDFFQ_CLKB 1.8151e-17
* device instance cc_XD1_XDFFQ_SB_XD5_XDFFQ_M r0 *1 0,0
Ccc_XD1_XDFFQ_SB_XD5_XDFFQ_M XD1_XDFFQ_SB XD5_XDFFQ_M 2.4201e-17
* device instance cc_XD1_XDFFQ_SB_XD5_XDFFQ_MB r0 *1 0,0
Ccc_XD1_XDFFQ_SB_XD5_XDFFQ_MB XD1_XDFFQ_SB XD5_XDFFQ_MB 1.21e-17
* device instance cc_XD1_XDFFQ_SB_XD5_XDFFQ_S r0 *1 0,0
Ccc_XD1_XDFFQ_SB_XD5_XDFFQ_S XD1_XDFFQ_SB XD5_XDFFQ_S 1.8151e-17
* device instance cc_XD1_XDFFQ_SB_XD5_XDFFQ_SB r0 *1 0,0
Ccc_XD1_XDFFQ_SB_XD5_XDFFQ_SB XD1_XDFFQ_SB XD5_XDFFQ_SB 1.8151e-17
* device instance cc_XD1_XDFFQ_SB_XD5_XN2_mid1 r0 *1 0,0
Ccc_XD1_XDFFQ_SB_XD5_XN2_mid1 XD1_XDFFQ_SB XD5_XN2_mid1 1.21e-17
* device instance cc_XD1_XDFFQ_SB_XD5_XN3_mid1 r0 *1 0,0
Ccc_XD1_XDFFQ_SB_XD5_XN3_mid1 XD1_XDFFQ_SB XD5_XN3_mid1 1.21e-17
* device instance cc_XD1_XDFFQ_SB_XD5_XN3_mid2 r0 *1 0,0
Ccc_XD1_XDFFQ_SB_XD5_XN3_mid2 XD1_XDFFQ_SB XD5_XN3_mid2 1.21e-17
* device instance cc_XD1_XDFFQ_SB_XD5_dmodout r0 *1 0,0
Ccc_XD1_XDFFQ_SB_XD5_dmodout XD1_XDFFQ_SB XD5_dmodout 1.21e-17
* device instance cc_XD1_XDFFQ_SB_XD5_dq r0 *1 0,0
Ccc_XD1_XDFFQ_SB_XD5_dq XD1_XDFFQ_SB XD5_dq 1.8151e-17
* device instance cc_XD1_XDFFQ_SB_XD5_nm r0 *1 0,0
Ccc_XD1_XDFFQ_SB_XD5_nm XD1_XDFFQ_SB XD5_nm 1.21e-17
* device instance cc_XD1_XDFFQ_SB_XD5_nt r0 *1 0,0
Ccc_XD1_XDFFQ_SB_XD5_nt XD1_XDFFQ_SB XD5_nt 1.21e-17
* device instance cc_XD1_XDFFQ_SB_XD5_t1 r0 *1 0,0
Ccc_XD1_XDFFQ_SB_XD5_t1 XD1_XDFFQ_SB XD5_t1 1.21e-17
* device instance cc_XD1_XDFFQ_SB_XFRT_CLKB r0 *1 0,0
Ccc_XD1_XDFFQ_SB_XFRT_CLKB XD1_XDFFQ_SB XFRT_CLKB 1.8151e-17
* device instance cc_XD1_XDFFQ_SB_XFRT_M r0 *1 0,0
Ccc_XD1_XDFFQ_SB_XFRT_M XD1_XDFFQ_SB XFRT_M 2.4201e-17
* device instance cc_XD1_XDFFQ_SB_XFRT_MB r0 *1 0,0
Ccc_XD1_XDFFQ_SB_XFRT_MB XD1_XDFFQ_SB XFRT_MB 1.21e-17
* device instance cc_XD1_XDFFQ_SB_XFRT_S r0 *1 0,0
Ccc_XD1_XDFFQ_SB_XFRT_S XD1_XDFFQ_SB XFRT_S 1.8151e-17
* device instance cc_XD1_XDFFQ_SB_XFRT_SB r0 *1 0,0
Ccc_XD1_XDFFQ_SB_XFRT_SB XD1_XDFFQ_SB XFRT_SB 1.8151e-17
* device instance cc_XD1_XDFFQ_SB_ck1 r0 *1 0,0
Ccc_XD1_XDFFQ_SB_ck1 XD1_XDFFQ_SB ck1 5.4452e-17
* device instance cc_XD1_XDFFQ_SB_ck2 r0 *1 0,0
Ccc_XD1_XDFFQ_SB_ck2 XD1_XDFFQ_SB ck2 5.4452e-17
* device instance cc_XD1_XDFFQ_SB_ck3 r0 *1 0,0
Ccc_XD1_XDFFQ_SB_ck3 XD1_XDFFQ_SB ck3 5.4452e-17
* device instance cc_XD1_XDFFQ_SB_ck4 r0 *1 0,0
Ccc_XD1_XDFFQ_SB_ck4 XD1_XDFFQ_SB ck4 5.4452e-17
* device instance cc_XD1_XDFFQ_SB_ck5 r0 *1 0,0
Ccc_XD1_XDFFQ_SB_ck5 XD1_XDFFQ_SB ck5 5.4452e-17
* device instance cc_XD1_XDFFQ_SB_mod0 r0 *1 0,0
Ccc_XD1_XDFFQ_SB_mod0 XD1_XDFFQ_SB mod0 2.4201e-17
* device instance cc_XD1_XDFFQ_SB_mod1 r0 *1 0,0
Ccc_XD1_XDFFQ_SB_mod1 XD1_XDFFQ_SB mod1 2.4201e-17
* device instance cc_XD1_XDFFQ_SB_mod2 r0 *1 0,0
Ccc_XD1_XDFFQ_SB_mod2 XD1_XDFFQ_SB mod2 2.4201e-17
* device instance cc_XD1_XDFFQ_SB_mod3 r0 *1 0,0
Ccc_XD1_XDFFQ_SB_mod3 XD1_XDFFQ_SB mod3 2.4201e-17
* device instance cc_XD1_XDFFQ_SB_mod4 r0 *1 0,0
Ccc_XD1_XDFFQ_SB_mod4 XD1_XDFFQ_SB mod4 2.4201e-17
* device instance cc_XD1_XDFFQ_SB_net1 r0 *1 0,0
Ccc_XD1_XDFFQ_SB_net1 XD1_XDFFQ_SB net1 1.21e-17
* device instance cc_XD1_XN2_mid1_XD1_nm r0 *1 0,0
Ccc_XD1_XN2_mid1_XD1_nm XD1_XN2_mid1 XD1_nm 1.1294e-17
* device instance cc_XD1_XN2_mid1_ck2 r0 *1 0,0
Ccc_XD1_XN2_mid1_ck2 XD1_XN2_mid1 ck2 6.05e-18
* device instance cc_XD1_XN3_mid1_XD1_XN3_mid2 r0 *1 0,0
Ccc_XD1_XN3_mid1_XD1_XN3_mid2 XD1_XN3_mid1 XD1_XN3_mid2 1.1294e-17
* device instance cc_XD1_XN3_mid1_XD1_nt r0 *1 0,0
Ccc_XD1_XN3_mid1_XD1_nt XD1_XN3_mid1 XD1_nt 1.1294e-17
* device instance cc_XD1_XN3_mid2_mod0 r0 *1 0,0
Ccc_XD1_XN3_mid2_mod0 XD1_XN3_mid2 mod0 6.05e-18
* device instance cc_XD1_XNOR_midp_XD1_dq r0 *1 0,0
Ccc_XD1_XNOR_midp_XD1_dq XD1_XNOR_midp XD1_dq 5.244e-18
* device instance cc_XD1_XNOR_midp_XD1_t1 r0 *1 0,0
Ccc_XD1_XNOR_midp_XD1_t1 XD1_XNOR_midp XD1_t1 6.05e-18
* device instance cc_XD1_dmodout_XD1_dq r0 *1 0,0
Ccc_XD1_dmodout_XD1_dq XD1_dmodout XD1_dq 1.21e-17
* device instance cc_XD1_dmodout_XD1_nm r0 *1 0,0
Ccc_XD1_dmodout_XD1_nm XD1_dmodout XD1_nm 1.8151e-17
* device instance cc_XD1_dmodout_XD1_nt r0 *1 0,0
Ccc_XD1_dmodout_XD1_nt XD1_dmodout XD1_nt 2.4201e-17
* device instance cc_XD1_dmodout_XD1_t1 r0 *1 0,0
Ccc_XD1_dmodout_XD1_t1 XD1_dmodout XD1_t1 1.21e-17
* device instance cc_XD1_dmodout_XD2_XDFFM_CLKB r0 *1 0,0
Ccc_XD1_dmodout_XD2_XDFFM_CLKB XD1_dmodout XD2_XDFFM_CLKB 1.8151e-17
* device instance cc_XD1_dmodout_XD2_XDFFM_M r0 *1 0,0
Ccc_XD1_dmodout_XD2_XDFFM_M XD1_dmodout XD2_XDFFM_M 2.4201e-17
* device instance cc_XD1_dmodout_XD2_XDFFM_MB r0 *1 0,0
Ccc_XD1_dmodout_XD2_XDFFM_MB XD1_dmodout XD2_XDFFM_MB 1.21e-17
* device instance cc_XD1_dmodout_XD2_XDFFM_S r0 *1 0,0
Ccc_XD1_dmodout_XD2_XDFFM_S XD1_dmodout XD2_XDFFM_S 1.8151e-17
* device instance cc_XD1_dmodout_XD2_XDFFM_SB r0 *1 0,0
Ccc_XD1_dmodout_XD2_XDFFM_SB XD1_dmodout XD2_XDFFM_SB 1.8151e-17
* device instance cc_XD1_dmodout_XD2_XDFFQ_CLKB r0 *1 0,0
Ccc_XD1_dmodout_XD2_XDFFQ_CLKB XD1_dmodout XD2_XDFFQ_CLKB 1.8151e-17
* device instance cc_XD1_dmodout_XD2_XDFFQ_M r0 *1 0,0
Ccc_XD1_dmodout_XD2_XDFFQ_M XD1_dmodout XD2_XDFFQ_M 2.4201e-17
* device instance cc_XD1_dmodout_XD2_XDFFQ_MB r0 *1 0,0
Ccc_XD1_dmodout_XD2_XDFFQ_MB XD1_dmodout XD2_XDFFQ_MB 1.21e-17
* device instance cc_XD1_dmodout_XD2_XDFFQ_S r0 *1 0,0
Ccc_XD1_dmodout_XD2_XDFFQ_S XD1_dmodout XD2_XDFFQ_S 1.8151e-17
* device instance cc_XD1_dmodout_XD2_XDFFQ_SB r0 *1 0,0
Ccc_XD1_dmodout_XD2_XDFFQ_SB XD1_dmodout XD2_XDFFQ_SB 1.8151e-17
* device instance cc_XD1_dmodout_XD2_XN2_mid1 r0 *1 0,0
Ccc_XD1_dmodout_XD2_XN2_mid1 XD1_dmodout XD2_XN2_mid1 1.21e-17
* device instance cc_XD1_dmodout_XD2_XN3_mid1 r0 *1 0,0
Ccc_XD1_dmodout_XD2_XN3_mid1 XD1_dmodout XD2_XN3_mid1 1.21e-17
* device instance cc_XD1_dmodout_XD2_XN3_mid2 r0 *1 0,0
Ccc_XD1_dmodout_XD2_XN3_mid2 XD1_dmodout XD2_XN3_mid2 1.21e-17
* device instance cc_XD1_dmodout_XD2_dmodout r0 *1 0,0
Ccc_XD1_dmodout_XD2_dmodout XD1_dmodout XD2_dmodout 1.21e-17
* device instance cc_XD1_dmodout_XD2_dq r0 *1 0,0
Ccc_XD1_dmodout_XD2_dq XD1_dmodout XD2_dq 1.8151e-17
* device instance cc_XD1_dmodout_XD2_nm r0 *1 0,0
Ccc_XD1_dmodout_XD2_nm XD1_dmodout XD2_nm 1.21e-17
* device instance cc_XD1_dmodout_XD2_nt r0 *1 0,0
Ccc_XD1_dmodout_XD2_nt XD1_dmodout XD2_nt 1.21e-17
* device instance cc_XD1_dmodout_XD2_t1 r0 *1 0,0
Ccc_XD1_dmodout_XD2_t1 XD1_dmodout XD2_t1 1.21e-17
* device instance cc_XD1_dmodout_XD3_XDFFM_CLKB r0 *1 0,0
Ccc_XD1_dmodout_XD3_XDFFM_CLKB XD1_dmodout XD3_XDFFM_CLKB 1.8151e-17
* device instance cc_XD1_dmodout_XD3_XDFFM_M r0 *1 0,0
Ccc_XD1_dmodout_XD3_XDFFM_M XD1_dmodout XD3_XDFFM_M 2.4201e-17
* device instance cc_XD1_dmodout_XD3_XDFFM_MB r0 *1 0,0
Ccc_XD1_dmodout_XD3_XDFFM_MB XD1_dmodout XD3_XDFFM_MB 1.21e-17
* device instance cc_XD1_dmodout_XD3_XDFFM_S r0 *1 0,0
Ccc_XD1_dmodout_XD3_XDFFM_S XD1_dmodout XD3_XDFFM_S 1.8151e-17
* device instance cc_XD1_dmodout_XD3_XDFFM_SB r0 *1 0,0
Ccc_XD1_dmodout_XD3_XDFFM_SB XD1_dmodout XD3_XDFFM_SB 1.8151e-17
* device instance cc_XD1_dmodout_XD3_XDFFQ_CLKB r0 *1 0,0
Ccc_XD1_dmodout_XD3_XDFFQ_CLKB XD1_dmodout XD3_XDFFQ_CLKB 1.8151e-17
* device instance cc_XD1_dmodout_XD3_XDFFQ_M r0 *1 0,0
Ccc_XD1_dmodout_XD3_XDFFQ_M XD1_dmodout XD3_XDFFQ_M 2.4201e-17
* device instance cc_XD1_dmodout_XD3_XDFFQ_MB r0 *1 0,0
Ccc_XD1_dmodout_XD3_XDFFQ_MB XD1_dmodout XD3_XDFFQ_MB 1.21e-17
* device instance cc_XD1_dmodout_XD3_XDFFQ_S r0 *1 0,0
Ccc_XD1_dmodout_XD3_XDFFQ_S XD1_dmodout XD3_XDFFQ_S 1.8151e-17
* device instance cc_XD1_dmodout_XD3_XDFFQ_SB r0 *1 0,0
Ccc_XD1_dmodout_XD3_XDFFQ_SB XD1_dmodout XD3_XDFFQ_SB 1.8151e-17
* device instance cc_XD1_dmodout_XD3_XN2_mid1 r0 *1 0,0
Ccc_XD1_dmodout_XD3_XN2_mid1 XD1_dmodout XD3_XN2_mid1 1.21e-17
* device instance cc_XD1_dmodout_XD3_XN3_mid1 r0 *1 0,0
Ccc_XD1_dmodout_XD3_XN3_mid1 XD1_dmodout XD3_XN3_mid1 1.21e-17
* device instance cc_XD1_dmodout_XD3_XN3_mid2 r0 *1 0,0
Ccc_XD1_dmodout_XD3_XN3_mid2 XD1_dmodout XD3_XN3_mid2 1.21e-17
* device instance cc_XD1_dmodout_XD3_dmodout r0 *1 0,0
Ccc_XD1_dmodout_XD3_dmodout XD1_dmodout XD3_dmodout 1.21e-17
* device instance cc_XD1_dmodout_XD3_dq r0 *1 0,0
Ccc_XD1_dmodout_XD3_dq XD1_dmodout XD3_dq 1.8151e-17
* device instance cc_XD1_dmodout_XD3_nm r0 *1 0,0
Ccc_XD1_dmodout_XD3_nm XD1_dmodout XD3_nm 1.21e-17
* device instance cc_XD1_dmodout_XD3_nt r0 *1 0,0
Ccc_XD1_dmodout_XD3_nt XD1_dmodout XD3_nt 1.21e-17
* device instance cc_XD1_dmodout_XD3_t1 r0 *1 0,0
Ccc_XD1_dmodout_XD3_t1 XD1_dmodout XD3_t1 1.21e-17
* device instance cc_XD1_dmodout_XD4_XDFFM_CLKB r0 *1 0,0
Ccc_XD1_dmodout_XD4_XDFFM_CLKB XD1_dmodout XD4_XDFFM_CLKB 1.8151e-17
* device instance cc_XD1_dmodout_XD4_XDFFM_M r0 *1 0,0
Ccc_XD1_dmodout_XD4_XDFFM_M XD1_dmodout XD4_XDFFM_M 2.4201e-17
* device instance cc_XD1_dmodout_XD4_XDFFM_MB r0 *1 0,0
Ccc_XD1_dmodout_XD4_XDFFM_MB XD1_dmodout XD4_XDFFM_MB 1.21e-17
* device instance cc_XD1_dmodout_XD4_XDFFM_S r0 *1 0,0
Ccc_XD1_dmodout_XD4_XDFFM_S XD1_dmodout XD4_XDFFM_S 1.8151e-17
* device instance cc_XD1_dmodout_XD4_XDFFM_SB r0 *1 0,0
Ccc_XD1_dmodout_XD4_XDFFM_SB XD1_dmodout XD4_XDFFM_SB 1.8151e-17
* device instance cc_XD1_dmodout_XD4_XDFFQ_CLKB r0 *1 0,0
Ccc_XD1_dmodout_XD4_XDFFQ_CLKB XD1_dmodout XD4_XDFFQ_CLKB 1.8151e-17
* device instance cc_XD1_dmodout_XD4_XDFFQ_M r0 *1 0,0
Ccc_XD1_dmodout_XD4_XDFFQ_M XD1_dmodout XD4_XDFFQ_M 2.4201e-17
* device instance cc_XD1_dmodout_XD4_XDFFQ_MB r0 *1 0,0
Ccc_XD1_dmodout_XD4_XDFFQ_MB XD1_dmodout XD4_XDFFQ_MB 1.21e-17
* device instance cc_XD1_dmodout_XD4_XDFFQ_S r0 *1 0,0
Ccc_XD1_dmodout_XD4_XDFFQ_S XD1_dmodout XD4_XDFFQ_S 1.8151e-17
* device instance cc_XD1_dmodout_XD4_XDFFQ_SB r0 *1 0,0
Ccc_XD1_dmodout_XD4_XDFFQ_SB XD1_dmodout XD4_XDFFQ_SB 1.8151e-17
* device instance cc_XD1_dmodout_XD4_XN2_mid1 r0 *1 0,0
Ccc_XD1_dmodout_XD4_XN2_mid1 XD1_dmodout XD4_XN2_mid1 1.21e-17
* device instance cc_XD1_dmodout_XD4_XN3_mid1 r0 *1 0,0
Ccc_XD1_dmodout_XD4_XN3_mid1 XD1_dmodout XD4_XN3_mid1 1.21e-17
* device instance cc_XD1_dmodout_XD4_XN3_mid2 r0 *1 0,0
Ccc_XD1_dmodout_XD4_XN3_mid2 XD1_dmodout XD4_XN3_mid2 1.21e-17
* device instance cc_XD1_dmodout_XD4_dmodout r0 *1 0,0
Ccc_XD1_dmodout_XD4_dmodout XD1_dmodout XD4_dmodout 1.21e-17
* device instance cc_XD1_dmodout_XD4_dq r0 *1 0,0
Ccc_XD1_dmodout_XD4_dq XD1_dmodout XD4_dq 1.8151e-17
* device instance cc_XD1_dmodout_XD4_nm r0 *1 0,0
Ccc_XD1_dmodout_XD4_nm XD1_dmodout XD4_nm 1.21e-17
* device instance cc_XD1_dmodout_XD4_nt r0 *1 0,0
Ccc_XD1_dmodout_XD4_nt XD1_dmodout XD4_nt 1.21e-17
* device instance cc_XD1_dmodout_XD4_t1 r0 *1 0,0
Ccc_XD1_dmodout_XD4_t1 XD1_dmodout XD4_t1 1.21e-17
* device instance cc_XD1_dmodout_XD5_XDFFM_CLKB r0 *1 0,0
Ccc_XD1_dmodout_XD5_XDFFM_CLKB XD1_dmodout XD5_XDFFM_CLKB 1.8151e-17
* device instance cc_XD1_dmodout_XD5_XDFFM_M r0 *1 0,0
Ccc_XD1_dmodout_XD5_XDFFM_M XD1_dmodout XD5_XDFFM_M 2.4201e-17
* device instance cc_XD1_dmodout_XD5_XDFFM_MB r0 *1 0,0
Ccc_XD1_dmodout_XD5_XDFFM_MB XD1_dmodout XD5_XDFFM_MB 1.21e-17
* device instance cc_XD1_dmodout_XD5_XDFFM_S r0 *1 0,0
Ccc_XD1_dmodout_XD5_XDFFM_S XD1_dmodout XD5_XDFFM_S 1.8151e-17
* device instance cc_XD1_dmodout_XD5_XDFFM_SB r0 *1 0,0
Ccc_XD1_dmodout_XD5_XDFFM_SB XD1_dmodout XD5_XDFFM_SB 1.8151e-17
* device instance cc_XD1_dmodout_XD5_XDFFQ_CLKB r0 *1 0,0
Ccc_XD1_dmodout_XD5_XDFFQ_CLKB XD1_dmodout XD5_XDFFQ_CLKB 1.8151e-17
* device instance cc_XD1_dmodout_XD5_XDFFQ_M r0 *1 0,0
Ccc_XD1_dmodout_XD5_XDFFQ_M XD1_dmodout XD5_XDFFQ_M 2.4201e-17
* device instance cc_XD1_dmodout_XD5_XDFFQ_MB r0 *1 0,0
Ccc_XD1_dmodout_XD5_XDFFQ_MB XD1_dmodout XD5_XDFFQ_MB 1.21e-17
* device instance cc_XD1_dmodout_XD5_XDFFQ_S r0 *1 0,0
Ccc_XD1_dmodout_XD5_XDFFQ_S XD1_dmodout XD5_XDFFQ_S 1.8151e-17
* device instance cc_XD1_dmodout_XD5_XDFFQ_SB r0 *1 0,0
Ccc_XD1_dmodout_XD5_XDFFQ_SB XD1_dmodout XD5_XDFFQ_SB 1.8151e-17
* device instance cc_XD1_dmodout_XD5_XN2_mid1 r0 *1 0,0
Ccc_XD1_dmodout_XD5_XN2_mid1 XD1_dmodout XD5_XN2_mid1 1.21e-17
* device instance cc_XD1_dmodout_XD5_XN3_mid1 r0 *1 0,0
Ccc_XD1_dmodout_XD5_XN3_mid1 XD1_dmodout XD5_XN3_mid1 1.21e-17
* device instance cc_XD1_dmodout_XD5_XN3_mid2 r0 *1 0,0
Ccc_XD1_dmodout_XD5_XN3_mid2 XD1_dmodout XD5_XN3_mid2 1.21e-17
* device instance cc_XD1_dmodout_XD5_dmodout r0 *1 0,0
Ccc_XD1_dmodout_XD5_dmodout XD1_dmodout XD5_dmodout 1.21e-17
* device instance cc_XD1_dmodout_XD5_dq r0 *1 0,0
Ccc_XD1_dmodout_XD5_dq XD1_dmodout XD5_dq 1.8151e-17
* device instance cc_XD1_dmodout_XD5_nm r0 *1 0,0
Ccc_XD1_dmodout_XD5_nm XD1_dmodout XD5_nm 1.21e-17
* device instance cc_XD1_dmodout_XD5_nt r0 *1 0,0
Ccc_XD1_dmodout_XD5_nt XD1_dmodout XD5_nt 1.21e-17
* device instance cc_XD1_dmodout_XD5_t1 r0 *1 0,0
Ccc_XD1_dmodout_XD5_t1 XD1_dmodout XD5_t1 1.21e-17
* device instance cc_XD1_dmodout_XFRT_CLKB r0 *1 0,0
Ccc_XD1_dmodout_XFRT_CLKB XD1_dmodout XFRT_CLKB 1.8151e-17
* device instance cc_XD1_dmodout_XFRT_M r0 *1 0,0
Ccc_XD1_dmodout_XFRT_M XD1_dmodout XFRT_M 2.4201e-17
* device instance cc_XD1_dmodout_XFRT_MB r0 *1 0,0
Ccc_XD1_dmodout_XFRT_MB XD1_dmodout XFRT_MB 1.21e-17
* device instance cc_XD1_dmodout_XFRT_S r0 *1 0,0
Ccc_XD1_dmodout_XFRT_S XD1_dmodout XFRT_S 1.8151e-17
* device instance cc_XD1_dmodout_XFRT_SB r0 *1 0,0
Ccc_XD1_dmodout_XFRT_SB XD1_dmodout XFRT_SB 1.8151e-17
* device instance cc_XD1_dmodout_ck1 r0 *1 0,0
Ccc_XD1_dmodout_ck1 XD1_dmodout ck1 6.6553e-17
* device instance cc_XD1_dmodout_ck2 r0 *1 0,0
Ccc_XD1_dmodout_ck2 XD1_dmodout ck2 5.4452e-17
* device instance cc_XD1_dmodout_ck3 r0 *1 0,0
Ccc_XD1_dmodout_ck3 XD1_dmodout ck3 5.4452e-17
* device instance cc_XD1_dmodout_ck4 r0 *1 0,0
Ccc_XD1_dmodout_ck4 XD1_dmodout ck4 5.4452e-17
* device instance cc_XD1_dmodout_ck5 r0 *1 0,0
Ccc_XD1_dmodout_ck5 XD1_dmodout ck5 5.4452e-17
* device instance cc_XD1_dmodout_mod0 r0 *1 0,0
Ccc_XD1_dmodout_mod0 XD1_dmodout mod0 2.4201e-17
* device instance cc_XD1_dmodout_mod1 r0 *1 0,0
Ccc_XD1_dmodout_mod1 XD1_dmodout mod1 2.4201e-17
* device instance cc_XD1_dmodout_mod2 r0 *1 0,0
Ccc_XD1_dmodout_mod2 XD1_dmodout mod2 2.4201e-17
* device instance cc_XD1_dmodout_mod3 r0 *1 0,0
Ccc_XD1_dmodout_mod3 XD1_dmodout mod3 2.4201e-17
* device instance cc_XD1_dmodout_mod4 r0 *1 0,0
Ccc_XD1_dmodout_mod4 XD1_dmodout mod4 2.4201e-17
* device instance cc_XD1_dmodout_net1 r0 *1 0,0
Ccc_XD1_dmodout_net1 XD1_dmodout net1 1.21e-17
* device instance cc_XD1_dq_XD1_nm r0 *1 0,0
Ccc_XD1_dq_XD1_nm XD1_dq XD1_nm 1.21e-17
* device instance cc_XD1_dq_XD1_nt r0 *1 0,0
Ccc_XD1_dq_XD1_nt XD1_dq XD1_nt 2.4201e-17
* device instance cc_XD1_dq_XD1_t1 r0 *1 0,0
Ccc_XD1_dq_XD1_t1 XD1_dq XD1_t1 1.8151e-17
* device instance cc_XD1_dq_XD2_XDFFM_CLKB r0 *1 0,0
Ccc_XD1_dq_XD2_XDFFM_CLKB XD1_dq XD2_XDFFM_CLKB 1.8151e-17
* device instance cc_XD1_dq_XD2_XDFFM_M r0 *1 0,0
Ccc_XD1_dq_XD2_XDFFM_M XD1_dq XD2_XDFFM_M 2.4201e-17
* device instance cc_XD1_dq_XD2_XDFFM_MB r0 *1 0,0
Ccc_XD1_dq_XD2_XDFFM_MB XD1_dq XD2_XDFFM_MB 1.21e-17
* device instance cc_XD1_dq_XD2_XDFFM_S r0 *1 0,0
Ccc_XD1_dq_XD2_XDFFM_S XD1_dq XD2_XDFFM_S 1.8151e-17
* device instance cc_XD1_dq_XD2_XDFFM_SB r0 *1 0,0
Ccc_XD1_dq_XD2_XDFFM_SB XD1_dq XD2_XDFFM_SB 1.8151e-17
* device instance cc_XD1_dq_XD2_XDFFQ_CLKB r0 *1 0,0
Ccc_XD1_dq_XD2_XDFFQ_CLKB XD1_dq XD2_XDFFQ_CLKB 1.8151e-17
* device instance cc_XD1_dq_XD2_XDFFQ_M r0 *1 0,0
Ccc_XD1_dq_XD2_XDFFQ_M XD1_dq XD2_XDFFQ_M 2.4201e-17
* device instance cc_XD1_dq_XD2_XDFFQ_MB r0 *1 0,0
Ccc_XD1_dq_XD2_XDFFQ_MB XD1_dq XD2_XDFFQ_MB 1.21e-17
* device instance cc_XD1_dq_XD2_XDFFQ_S r0 *1 0,0
Ccc_XD1_dq_XD2_XDFFQ_S XD1_dq XD2_XDFFQ_S 1.8151e-17
* device instance cc_XD1_dq_XD2_XDFFQ_SB r0 *1 0,0
Ccc_XD1_dq_XD2_XDFFQ_SB XD1_dq XD2_XDFFQ_SB 1.8151e-17
* device instance cc_XD1_dq_XD2_XN2_mid1 r0 *1 0,0
Ccc_XD1_dq_XD2_XN2_mid1 XD1_dq XD2_XN2_mid1 1.21e-17
* device instance cc_XD1_dq_XD2_XN3_mid1 r0 *1 0,0
Ccc_XD1_dq_XD2_XN3_mid1 XD1_dq XD2_XN3_mid1 1.21e-17
* device instance cc_XD1_dq_XD2_XN3_mid2 r0 *1 0,0
Ccc_XD1_dq_XD2_XN3_mid2 XD1_dq XD2_XN3_mid2 1.21e-17
* device instance cc_XD1_dq_XD2_dmodout r0 *1 0,0
Ccc_XD1_dq_XD2_dmodout XD1_dq XD2_dmodout 1.21e-17
* device instance cc_XD1_dq_XD2_dq r0 *1 0,0
Ccc_XD1_dq_XD2_dq XD1_dq XD2_dq 1.8151e-17
* device instance cc_XD1_dq_XD2_nm r0 *1 0,0
Ccc_XD1_dq_XD2_nm XD1_dq XD2_nm 1.21e-17
* device instance cc_XD1_dq_XD2_nt r0 *1 0,0
Ccc_XD1_dq_XD2_nt XD1_dq XD2_nt 1.21e-17
* device instance cc_XD1_dq_XD2_t1 r0 *1 0,0
Ccc_XD1_dq_XD2_t1 XD1_dq XD2_t1 1.21e-17
* device instance cc_XD1_dq_XD3_XDFFM_CLKB r0 *1 0,0
Ccc_XD1_dq_XD3_XDFFM_CLKB XD1_dq XD3_XDFFM_CLKB 1.8151e-17
* device instance cc_XD1_dq_XD3_XDFFM_M r0 *1 0,0
Ccc_XD1_dq_XD3_XDFFM_M XD1_dq XD3_XDFFM_M 2.4201e-17
* device instance cc_XD1_dq_XD3_XDFFM_MB r0 *1 0,0
Ccc_XD1_dq_XD3_XDFFM_MB XD1_dq XD3_XDFFM_MB 1.21e-17
* device instance cc_XD1_dq_XD3_XDFFM_S r0 *1 0,0
Ccc_XD1_dq_XD3_XDFFM_S XD1_dq XD3_XDFFM_S 1.8151e-17
* device instance cc_XD1_dq_XD3_XDFFM_SB r0 *1 0,0
Ccc_XD1_dq_XD3_XDFFM_SB XD1_dq XD3_XDFFM_SB 1.8151e-17
* device instance cc_XD1_dq_XD3_XDFFQ_CLKB r0 *1 0,0
Ccc_XD1_dq_XD3_XDFFQ_CLKB XD1_dq XD3_XDFFQ_CLKB 1.8151e-17
* device instance cc_XD1_dq_XD3_XDFFQ_M r0 *1 0,0
Ccc_XD1_dq_XD3_XDFFQ_M XD1_dq XD3_XDFFQ_M 2.4201e-17
* device instance cc_XD1_dq_XD3_XDFFQ_MB r0 *1 0,0
Ccc_XD1_dq_XD3_XDFFQ_MB XD1_dq XD3_XDFFQ_MB 1.21e-17
* device instance cc_XD1_dq_XD3_XDFFQ_S r0 *1 0,0
Ccc_XD1_dq_XD3_XDFFQ_S XD1_dq XD3_XDFFQ_S 1.8151e-17
* device instance cc_XD1_dq_XD3_XDFFQ_SB r0 *1 0,0
Ccc_XD1_dq_XD3_XDFFQ_SB XD1_dq XD3_XDFFQ_SB 1.8151e-17
* device instance cc_XD1_dq_XD3_XN2_mid1 r0 *1 0,0
Ccc_XD1_dq_XD3_XN2_mid1 XD1_dq XD3_XN2_mid1 1.21e-17
* device instance cc_XD1_dq_XD3_XN3_mid1 r0 *1 0,0
Ccc_XD1_dq_XD3_XN3_mid1 XD1_dq XD3_XN3_mid1 1.21e-17
* device instance cc_XD1_dq_XD3_XN3_mid2 r0 *1 0,0
Ccc_XD1_dq_XD3_XN3_mid2 XD1_dq XD3_XN3_mid2 1.21e-17
* device instance cc_XD1_dq_XD3_dmodout r0 *1 0,0
Ccc_XD1_dq_XD3_dmodout XD1_dq XD3_dmodout 1.21e-17
* device instance cc_XD1_dq_XD3_dq r0 *1 0,0
Ccc_XD1_dq_XD3_dq XD1_dq XD3_dq 1.8151e-17
* device instance cc_XD1_dq_XD3_nm r0 *1 0,0
Ccc_XD1_dq_XD3_nm XD1_dq XD3_nm 1.21e-17
* device instance cc_XD1_dq_XD3_nt r0 *1 0,0
Ccc_XD1_dq_XD3_nt XD1_dq XD3_nt 1.21e-17
* device instance cc_XD1_dq_XD3_t1 r0 *1 0,0
Ccc_XD1_dq_XD3_t1 XD1_dq XD3_t1 1.21e-17
* device instance cc_XD1_dq_XD4_XDFFM_CLKB r0 *1 0,0
Ccc_XD1_dq_XD4_XDFFM_CLKB XD1_dq XD4_XDFFM_CLKB 1.8151e-17
* device instance cc_XD1_dq_XD4_XDFFM_M r0 *1 0,0
Ccc_XD1_dq_XD4_XDFFM_M XD1_dq XD4_XDFFM_M 2.4201e-17
* device instance cc_XD1_dq_XD4_XDFFM_MB r0 *1 0,0
Ccc_XD1_dq_XD4_XDFFM_MB XD1_dq XD4_XDFFM_MB 1.21e-17
* device instance cc_XD1_dq_XD4_XDFFM_S r0 *1 0,0
Ccc_XD1_dq_XD4_XDFFM_S XD1_dq XD4_XDFFM_S 1.8151e-17
* device instance cc_XD1_dq_XD4_XDFFM_SB r0 *1 0,0
Ccc_XD1_dq_XD4_XDFFM_SB XD1_dq XD4_XDFFM_SB 1.8151e-17
* device instance cc_XD1_dq_XD4_XDFFQ_CLKB r0 *1 0,0
Ccc_XD1_dq_XD4_XDFFQ_CLKB XD1_dq XD4_XDFFQ_CLKB 1.8151e-17
* device instance cc_XD1_dq_XD4_XDFFQ_M r0 *1 0,0
Ccc_XD1_dq_XD4_XDFFQ_M XD1_dq XD4_XDFFQ_M 2.4201e-17
* device instance cc_XD1_dq_XD4_XDFFQ_MB r0 *1 0,0
Ccc_XD1_dq_XD4_XDFFQ_MB XD1_dq XD4_XDFFQ_MB 1.21e-17
* device instance cc_XD1_dq_XD4_XDFFQ_S r0 *1 0,0
Ccc_XD1_dq_XD4_XDFFQ_S XD1_dq XD4_XDFFQ_S 1.8151e-17
* device instance cc_XD1_dq_XD4_XDFFQ_SB r0 *1 0,0
Ccc_XD1_dq_XD4_XDFFQ_SB XD1_dq XD4_XDFFQ_SB 1.8151e-17
* device instance cc_XD1_dq_XD4_XN2_mid1 r0 *1 0,0
Ccc_XD1_dq_XD4_XN2_mid1 XD1_dq XD4_XN2_mid1 1.21e-17
* device instance cc_XD1_dq_XD4_XN3_mid1 r0 *1 0,0
Ccc_XD1_dq_XD4_XN3_mid1 XD1_dq XD4_XN3_mid1 1.21e-17
* device instance cc_XD1_dq_XD4_XN3_mid2 r0 *1 0,0
Ccc_XD1_dq_XD4_XN3_mid2 XD1_dq XD4_XN3_mid2 1.21e-17
* device instance cc_XD1_dq_XD4_dmodout r0 *1 0,0
Ccc_XD1_dq_XD4_dmodout XD1_dq XD4_dmodout 1.21e-17
* device instance cc_XD1_dq_XD4_dq r0 *1 0,0
Ccc_XD1_dq_XD4_dq XD1_dq XD4_dq 1.8151e-17
* device instance cc_XD1_dq_XD4_nm r0 *1 0,0
Ccc_XD1_dq_XD4_nm XD1_dq XD4_nm 1.21e-17
* device instance cc_XD1_dq_XD4_nt r0 *1 0,0
Ccc_XD1_dq_XD4_nt XD1_dq XD4_nt 1.21e-17
* device instance cc_XD1_dq_XD4_t1 r0 *1 0,0
Ccc_XD1_dq_XD4_t1 XD1_dq XD4_t1 1.21e-17
* device instance cc_XD1_dq_XD5_XDFFM_CLKB r0 *1 0,0
Ccc_XD1_dq_XD5_XDFFM_CLKB XD1_dq XD5_XDFFM_CLKB 1.8151e-17
* device instance cc_XD1_dq_XD5_XDFFM_M r0 *1 0,0
Ccc_XD1_dq_XD5_XDFFM_M XD1_dq XD5_XDFFM_M 2.4201e-17
* device instance cc_XD1_dq_XD5_XDFFM_MB r0 *1 0,0
Ccc_XD1_dq_XD5_XDFFM_MB XD1_dq XD5_XDFFM_MB 1.21e-17
* device instance cc_XD1_dq_XD5_XDFFM_S r0 *1 0,0
Ccc_XD1_dq_XD5_XDFFM_S XD1_dq XD5_XDFFM_S 1.8151e-17
* device instance cc_XD1_dq_XD5_XDFFM_SB r0 *1 0,0
Ccc_XD1_dq_XD5_XDFFM_SB XD1_dq XD5_XDFFM_SB 1.8151e-17
* device instance cc_XD1_dq_XD5_XDFFQ_CLKB r0 *1 0,0
Ccc_XD1_dq_XD5_XDFFQ_CLKB XD1_dq XD5_XDFFQ_CLKB 1.8151e-17
* device instance cc_XD1_dq_XD5_XDFFQ_M r0 *1 0,0
Ccc_XD1_dq_XD5_XDFFQ_M XD1_dq XD5_XDFFQ_M 2.4201e-17
* device instance cc_XD1_dq_XD5_XDFFQ_MB r0 *1 0,0
Ccc_XD1_dq_XD5_XDFFQ_MB XD1_dq XD5_XDFFQ_MB 1.21e-17
* device instance cc_XD1_dq_XD5_XDFFQ_S r0 *1 0,0
Ccc_XD1_dq_XD5_XDFFQ_S XD1_dq XD5_XDFFQ_S 1.8151e-17
* device instance cc_XD1_dq_XD5_XDFFQ_SB r0 *1 0,0
Ccc_XD1_dq_XD5_XDFFQ_SB XD1_dq XD5_XDFFQ_SB 1.8151e-17
* device instance cc_XD1_dq_XD5_XN2_mid1 r0 *1 0,0
Ccc_XD1_dq_XD5_XN2_mid1 XD1_dq XD5_XN2_mid1 1.21e-17
* device instance cc_XD1_dq_XD5_XN3_mid1 r0 *1 0,0
Ccc_XD1_dq_XD5_XN3_mid1 XD1_dq XD5_XN3_mid1 1.21e-17
* device instance cc_XD1_dq_XD5_XN3_mid2 r0 *1 0,0
Ccc_XD1_dq_XD5_XN3_mid2 XD1_dq XD5_XN3_mid2 1.21e-17
* device instance cc_XD1_dq_XD5_dmodout r0 *1 0,0
Ccc_XD1_dq_XD5_dmodout XD1_dq XD5_dmodout 1.21e-17
* device instance cc_XD1_dq_XD5_dq r0 *1 0,0
Ccc_XD1_dq_XD5_dq XD1_dq XD5_dq 1.8151e-17
* device instance cc_XD1_dq_XD5_nm r0 *1 0,0
Ccc_XD1_dq_XD5_nm XD1_dq XD5_nm 1.21e-17
* device instance cc_XD1_dq_XD5_nt r0 *1 0,0
Ccc_XD1_dq_XD5_nt XD1_dq XD5_nt 1.21e-17
* device instance cc_XD1_dq_XD5_t1 r0 *1 0,0
Ccc_XD1_dq_XD5_t1 XD1_dq XD5_t1 1.21e-17
* device instance cc_XD1_dq_XFRT_CLKB r0 *1 0,0
Ccc_XD1_dq_XFRT_CLKB XD1_dq XFRT_CLKB 1.8151e-17
* device instance cc_XD1_dq_XFRT_M r0 *1 0,0
Ccc_XD1_dq_XFRT_M XD1_dq XFRT_M 2.4201e-17
* device instance cc_XD1_dq_XFRT_MB r0 *1 0,0
Ccc_XD1_dq_XFRT_MB XD1_dq XFRT_MB 1.21e-17
* device instance cc_XD1_dq_XFRT_S r0 *1 0,0
Ccc_XD1_dq_XFRT_S XD1_dq XFRT_S 1.8151e-17
* device instance cc_XD1_dq_XFRT_SB r0 *1 0,0
Ccc_XD1_dq_XFRT_SB XD1_dq XFRT_SB 1.8151e-17
* device instance cc_XD1_dq_ck1 r0 *1 0,0
Ccc_XD1_dq_ck1 XD1_dq ck1 6.6553e-17
* device instance cc_XD1_dq_ck2 r0 *1 0,0
Ccc_XD1_dq_ck2 XD1_dq ck2 5.4452e-17
* device instance cc_XD1_dq_ck3 r0 *1 0,0
Ccc_XD1_dq_ck3 XD1_dq ck3 5.4452e-17
* device instance cc_XD1_dq_ck4 r0 *1 0,0
Ccc_XD1_dq_ck4 XD1_dq ck4 5.4452e-17
* device instance cc_XD1_dq_ck5 r0 *1 0,0
Ccc_XD1_dq_ck5 XD1_dq ck5 5.4452e-17
* device instance cc_XD1_dq_mod0 r0 *1 0,0
Ccc_XD1_dq_mod0 XD1_dq mod0 2.4201e-17
* device instance cc_XD1_dq_mod1 r0 *1 0,0
Ccc_XD1_dq_mod1 XD1_dq mod1 2.4201e-17
* device instance cc_XD1_dq_mod2 r0 *1 0,0
Ccc_XD1_dq_mod2 XD1_dq mod2 2.4201e-17
* device instance cc_XD1_dq_mod3 r0 *1 0,0
Ccc_XD1_dq_mod3 XD1_dq mod3 2.4201e-17
* device instance cc_XD1_dq_mod4 r0 *1 0,0
Ccc_XD1_dq_mod4 XD1_dq mod4 2.4201e-17
* device instance cc_XD1_dq_net1 r0 *1 0,0
Ccc_XD1_dq_net1 XD1_dq net1 1.21e-17
* device instance cc_XD1_nm_XD1_nt r0 *1 0,0
Ccc_XD1_nm_XD1_nt XD1_nm XD1_nt 2.4201e-17
* device instance cc_XD1_nm_XD1_t1 r0 *1 0,0
Ccc_XD1_nm_XD1_t1 XD1_nm XD1_t1 1.21e-17
* device instance cc_XD1_nm_XD2_XDFFM_CLKB r0 *1 0,0
Ccc_XD1_nm_XD2_XDFFM_CLKB XD1_nm XD2_XDFFM_CLKB 1.8151e-17
* device instance cc_XD1_nm_XD2_XDFFM_M r0 *1 0,0
Ccc_XD1_nm_XD2_XDFFM_M XD1_nm XD2_XDFFM_M 2.4201e-17
* device instance cc_XD1_nm_XD2_XDFFM_MB r0 *1 0,0
Ccc_XD1_nm_XD2_XDFFM_MB XD1_nm XD2_XDFFM_MB 1.21e-17
* device instance cc_XD1_nm_XD2_XDFFM_S r0 *1 0,0
Ccc_XD1_nm_XD2_XDFFM_S XD1_nm XD2_XDFFM_S 1.8151e-17
* device instance cc_XD1_nm_XD2_XDFFM_SB r0 *1 0,0
Ccc_XD1_nm_XD2_XDFFM_SB XD1_nm XD2_XDFFM_SB 1.8151e-17
* device instance cc_XD1_nm_XD2_XDFFQ_CLKB r0 *1 0,0
Ccc_XD1_nm_XD2_XDFFQ_CLKB XD1_nm XD2_XDFFQ_CLKB 1.8151e-17
* device instance cc_XD1_nm_XD2_XDFFQ_M r0 *1 0,0
Ccc_XD1_nm_XD2_XDFFQ_M XD1_nm XD2_XDFFQ_M 2.4201e-17
* device instance cc_XD1_nm_XD2_XDFFQ_MB r0 *1 0,0
Ccc_XD1_nm_XD2_XDFFQ_MB XD1_nm XD2_XDFFQ_MB 1.21e-17
* device instance cc_XD1_nm_XD2_XDFFQ_S r0 *1 0,0
Ccc_XD1_nm_XD2_XDFFQ_S XD1_nm XD2_XDFFQ_S 1.8151e-17
* device instance cc_XD1_nm_XD2_XDFFQ_SB r0 *1 0,0
Ccc_XD1_nm_XD2_XDFFQ_SB XD1_nm XD2_XDFFQ_SB 1.8151e-17
* device instance cc_XD1_nm_XD2_XN2_mid1 r0 *1 0,0
Ccc_XD1_nm_XD2_XN2_mid1 XD1_nm XD2_XN2_mid1 1.21e-17
* device instance cc_XD1_nm_XD2_XN3_mid1 r0 *1 0,0
Ccc_XD1_nm_XD2_XN3_mid1 XD1_nm XD2_XN3_mid1 1.21e-17
* device instance cc_XD1_nm_XD2_XN3_mid2 r0 *1 0,0
Ccc_XD1_nm_XD2_XN3_mid2 XD1_nm XD2_XN3_mid2 1.21e-17
* device instance cc_XD1_nm_XD2_dmodout r0 *1 0,0
Ccc_XD1_nm_XD2_dmodout XD1_nm XD2_dmodout 1.21e-17
* device instance cc_XD1_nm_XD2_dq r0 *1 0,0
Ccc_XD1_nm_XD2_dq XD1_nm XD2_dq 1.8151e-17
* device instance cc_XD1_nm_XD2_nm r0 *1 0,0
Ccc_XD1_nm_XD2_nm XD1_nm XD2_nm 1.21e-17
* device instance cc_XD1_nm_XD2_nt r0 *1 0,0
Ccc_XD1_nm_XD2_nt XD1_nm XD2_nt 1.21e-17
* device instance cc_XD1_nm_XD2_t1 r0 *1 0,0
Ccc_XD1_nm_XD2_t1 XD1_nm XD2_t1 1.21e-17
* device instance cc_XD1_nm_XD3_XDFFM_CLKB r0 *1 0,0
Ccc_XD1_nm_XD3_XDFFM_CLKB XD1_nm XD3_XDFFM_CLKB 1.8151e-17
* device instance cc_XD1_nm_XD3_XDFFM_M r0 *1 0,0
Ccc_XD1_nm_XD3_XDFFM_M XD1_nm XD3_XDFFM_M 2.4201e-17
* device instance cc_XD1_nm_XD3_XDFFM_MB r0 *1 0,0
Ccc_XD1_nm_XD3_XDFFM_MB XD1_nm XD3_XDFFM_MB 1.21e-17
* device instance cc_XD1_nm_XD3_XDFFM_S r0 *1 0,0
Ccc_XD1_nm_XD3_XDFFM_S XD1_nm XD3_XDFFM_S 1.8151e-17
* device instance cc_XD1_nm_XD3_XDFFM_SB r0 *1 0,0
Ccc_XD1_nm_XD3_XDFFM_SB XD1_nm XD3_XDFFM_SB 1.8151e-17
* device instance cc_XD1_nm_XD3_XDFFQ_CLKB r0 *1 0,0
Ccc_XD1_nm_XD3_XDFFQ_CLKB XD1_nm XD3_XDFFQ_CLKB 1.8151e-17
* device instance cc_XD1_nm_XD3_XDFFQ_M r0 *1 0,0
Ccc_XD1_nm_XD3_XDFFQ_M XD1_nm XD3_XDFFQ_M 2.4201e-17
* device instance cc_XD1_nm_XD3_XDFFQ_MB r0 *1 0,0
Ccc_XD1_nm_XD3_XDFFQ_MB XD1_nm XD3_XDFFQ_MB 1.21e-17
* device instance cc_XD1_nm_XD3_XDFFQ_S r0 *1 0,0
Ccc_XD1_nm_XD3_XDFFQ_S XD1_nm XD3_XDFFQ_S 1.8151e-17
* device instance cc_XD1_nm_XD3_XDFFQ_SB r0 *1 0,0
Ccc_XD1_nm_XD3_XDFFQ_SB XD1_nm XD3_XDFFQ_SB 1.8151e-17
* device instance cc_XD1_nm_XD3_XN2_mid1 r0 *1 0,0
Ccc_XD1_nm_XD3_XN2_mid1 XD1_nm XD3_XN2_mid1 1.21e-17
* device instance cc_XD1_nm_XD3_XN3_mid1 r0 *1 0,0
Ccc_XD1_nm_XD3_XN3_mid1 XD1_nm XD3_XN3_mid1 1.21e-17
* device instance cc_XD1_nm_XD3_XN3_mid2 r0 *1 0,0
Ccc_XD1_nm_XD3_XN3_mid2 XD1_nm XD3_XN3_mid2 1.21e-17
* device instance cc_XD1_nm_XD3_dmodout r0 *1 0,0
Ccc_XD1_nm_XD3_dmodout XD1_nm XD3_dmodout 1.21e-17
* device instance cc_XD1_nm_XD3_dq r0 *1 0,0
Ccc_XD1_nm_XD3_dq XD1_nm XD3_dq 1.8151e-17
* device instance cc_XD1_nm_XD3_nm r0 *1 0,0
Ccc_XD1_nm_XD3_nm XD1_nm XD3_nm 1.21e-17
* device instance cc_XD1_nm_XD3_nt r0 *1 0,0
Ccc_XD1_nm_XD3_nt XD1_nm XD3_nt 1.21e-17
* device instance cc_XD1_nm_XD3_t1 r0 *1 0,0
Ccc_XD1_nm_XD3_t1 XD1_nm XD3_t1 1.21e-17
* device instance cc_XD1_nm_XD4_XDFFM_CLKB r0 *1 0,0
Ccc_XD1_nm_XD4_XDFFM_CLKB XD1_nm XD4_XDFFM_CLKB 1.8151e-17
* device instance cc_XD1_nm_XD4_XDFFM_M r0 *1 0,0
Ccc_XD1_nm_XD4_XDFFM_M XD1_nm XD4_XDFFM_M 2.4201e-17
* device instance cc_XD1_nm_XD4_XDFFM_MB r0 *1 0,0
Ccc_XD1_nm_XD4_XDFFM_MB XD1_nm XD4_XDFFM_MB 1.21e-17
* device instance cc_XD1_nm_XD4_XDFFM_S r0 *1 0,0
Ccc_XD1_nm_XD4_XDFFM_S XD1_nm XD4_XDFFM_S 1.8151e-17
* device instance cc_XD1_nm_XD4_XDFFM_SB r0 *1 0,0
Ccc_XD1_nm_XD4_XDFFM_SB XD1_nm XD4_XDFFM_SB 1.8151e-17
* device instance cc_XD1_nm_XD4_XDFFQ_CLKB r0 *1 0,0
Ccc_XD1_nm_XD4_XDFFQ_CLKB XD1_nm XD4_XDFFQ_CLKB 1.8151e-17
* device instance cc_XD1_nm_XD4_XDFFQ_M r0 *1 0,0
Ccc_XD1_nm_XD4_XDFFQ_M XD1_nm XD4_XDFFQ_M 2.4201e-17
* device instance cc_XD1_nm_XD4_XDFFQ_MB r0 *1 0,0
Ccc_XD1_nm_XD4_XDFFQ_MB XD1_nm XD4_XDFFQ_MB 1.21e-17
* device instance cc_XD1_nm_XD4_XDFFQ_S r0 *1 0,0
Ccc_XD1_nm_XD4_XDFFQ_S XD1_nm XD4_XDFFQ_S 1.8151e-17
* device instance cc_XD1_nm_XD4_XDFFQ_SB r0 *1 0,0
Ccc_XD1_nm_XD4_XDFFQ_SB XD1_nm XD4_XDFFQ_SB 1.8151e-17
* device instance cc_XD1_nm_XD4_XN2_mid1 r0 *1 0,0
Ccc_XD1_nm_XD4_XN2_mid1 XD1_nm XD4_XN2_mid1 1.21e-17
* device instance cc_XD1_nm_XD4_XN3_mid1 r0 *1 0,0
Ccc_XD1_nm_XD4_XN3_mid1 XD1_nm XD4_XN3_mid1 1.21e-17
* device instance cc_XD1_nm_XD4_XN3_mid2 r0 *1 0,0
Ccc_XD1_nm_XD4_XN3_mid2 XD1_nm XD4_XN3_mid2 1.21e-17
* device instance cc_XD1_nm_XD4_dmodout r0 *1 0,0
Ccc_XD1_nm_XD4_dmodout XD1_nm XD4_dmodout 1.21e-17
* device instance cc_XD1_nm_XD4_dq r0 *1 0,0
Ccc_XD1_nm_XD4_dq XD1_nm XD4_dq 1.8151e-17
* device instance cc_XD1_nm_XD4_nm r0 *1 0,0
Ccc_XD1_nm_XD4_nm XD1_nm XD4_nm 1.21e-17
* device instance cc_XD1_nm_XD4_nt r0 *1 0,0
Ccc_XD1_nm_XD4_nt XD1_nm XD4_nt 1.21e-17
* device instance cc_XD1_nm_XD4_t1 r0 *1 0,0
Ccc_XD1_nm_XD4_t1 XD1_nm XD4_t1 1.21e-17
* device instance cc_XD1_nm_XD5_XDFFM_CLKB r0 *1 0,0
Ccc_XD1_nm_XD5_XDFFM_CLKB XD1_nm XD5_XDFFM_CLKB 1.8151e-17
* device instance cc_XD1_nm_XD5_XDFFM_M r0 *1 0,0
Ccc_XD1_nm_XD5_XDFFM_M XD1_nm XD5_XDFFM_M 2.4201e-17
* device instance cc_XD1_nm_XD5_XDFFM_MB r0 *1 0,0
Ccc_XD1_nm_XD5_XDFFM_MB XD1_nm XD5_XDFFM_MB 1.21e-17
* device instance cc_XD1_nm_XD5_XDFFM_S r0 *1 0,0
Ccc_XD1_nm_XD5_XDFFM_S XD1_nm XD5_XDFFM_S 1.8151e-17
* device instance cc_XD1_nm_XD5_XDFFM_SB r0 *1 0,0
Ccc_XD1_nm_XD5_XDFFM_SB XD1_nm XD5_XDFFM_SB 1.8151e-17
* device instance cc_XD1_nm_XD5_XDFFQ_CLKB r0 *1 0,0
Ccc_XD1_nm_XD5_XDFFQ_CLKB XD1_nm XD5_XDFFQ_CLKB 1.8151e-17
* device instance cc_XD1_nm_XD5_XDFFQ_M r0 *1 0,0
Ccc_XD1_nm_XD5_XDFFQ_M XD1_nm XD5_XDFFQ_M 2.4201e-17
* device instance cc_XD1_nm_XD5_XDFFQ_MB r0 *1 0,0
Ccc_XD1_nm_XD5_XDFFQ_MB XD1_nm XD5_XDFFQ_MB 1.21e-17
* device instance cc_XD1_nm_XD5_XDFFQ_S r0 *1 0,0
Ccc_XD1_nm_XD5_XDFFQ_S XD1_nm XD5_XDFFQ_S 1.8151e-17
* device instance cc_XD1_nm_XD5_XDFFQ_SB r0 *1 0,0
Ccc_XD1_nm_XD5_XDFFQ_SB XD1_nm XD5_XDFFQ_SB 1.8151e-17
* device instance cc_XD1_nm_XD5_XN2_mid1 r0 *1 0,0
Ccc_XD1_nm_XD5_XN2_mid1 XD1_nm XD5_XN2_mid1 1.21e-17
* device instance cc_XD1_nm_XD5_XN3_mid1 r0 *1 0,0
Ccc_XD1_nm_XD5_XN3_mid1 XD1_nm XD5_XN3_mid1 1.21e-17
* device instance cc_XD1_nm_XD5_XN3_mid2 r0 *1 0,0
Ccc_XD1_nm_XD5_XN3_mid2 XD1_nm XD5_XN3_mid2 1.21e-17
* device instance cc_XD1_nm_XD5_dmodout r0 *1 0,0
Ccc_XD1_nm_XD5_dmodout XD1_nm XD5_dmodout 1.21e-17
* device instance cc_XD1_nm_XD5_dq r0 *1 0,0
Ccc_XD1_nm_XD5_dq XD1_nm XD5_dq 1.8151e-17
* device instance cc_XD1_nm_XD5_nm r0 *1 0,0
Ccc_XD1_nm_XD5_nm XD1_nm XD5_nm 1.21e-17
* device instance cc_XD1_nm_XD5_nt r0 *1 0,0
Ccc_XD1_nm_XD5_nt XD1_nm XD5_nt 1.21e-17
* device instance cc_XD1_nm_XD5_t1 r0 *1 0,0
Ccc_XD1_nm_XD5_t1 XD1_nm XD5_t1 1.21e-17
* device instance cc_XD1_nm_XFRT_CLKB r0 *1 0,0
Ccc_XD1_nm_XFRT_CLKB XD1_nm XFRT_CLKB 1.8151e-17
* device instance cc_XD1_nm_XFRT_M r0 *1 0,0
Ccc_XD1_nm_XFRT_M XD1_nm XFRT_M 2.4201e-17
* device instance cc_XD1_nm_XFRT_MB r0 *1 0,0
Ccc_XD1_nm_XFRT_MB XD1_nm XFRT_MB 1.21e-17
* device instance cc_XD1_nm_XFRT_S r0 *1 0,0
Ccc_XD1_nm_XFRT_S XD1_nm XFRT_S 1.8151e-17
* device instance cc_XD1_nm_XFRT_SB r0 *1 0,0
Ccc_XD1_nm_XFRT_SB XD1_nm XFRT_SB 1.8151e-17
* device instance cc_XD1_nm_ck1 r0 *1 0,0
Ccc_XD1_nm_ck1 XD1_nm ck1 5.4452e-17
* device instance cc_XD1_nm_ck2 r0 *1 0,0
Ccc_XD1_nm_ck2 XD1_nm ck2 6.0502e-17
* device instance cc_XD1_nm_ck3 r0 *1 0,0
Ccc_XD1_nm_ck3 XD1_nm ck3 5.4452e-17
* device instance cc_XD1_nm_ck4 r0 *1 0,0
Ccc_XD1_nm_ck4 XD1_nm ck4 5.4452e-17
* device instance cc_XD1_nm_ck5 r0 *1 0,0
Ccc_XD1_nm_ck5 XD1_nm ck5 5.4452e-17
* device instance cc_XD1_nm_mod0 r0 *1 0,0
Ccc_XD1_nm_mod0 XD1_nm mod0 2.4201e-17
* device instance cc_XD1_nm_mod1 r0 *1 0,0
Ccc_XD1_nm_mod1 XD1_nm mod1 2.4201e-17
* device instance cc_XD1_nm_mod2 r0 *1 0,0
Ccc_XD1_nm_mod2 XD1_nm mod2 2.4201e-17
* device instance cc_XD1_nm_mod3 r0 *1 0,0
Ccc_XD1_nm_mod3 XD1_nm mod3 2.4201e-17
* device instance cc_XD1_nm_mod4 r0 *1 0,0
Ccc_XD1_nm_mod4 XD1_nm mod4 2.4201e-17
* device instance cc_XD1_nm_net1 r0 *1 0,0
Ccc_XD1_nm_net1 XD1_nm net1 1.21e-17
* device instance cc_XD1_nt_XD1_t1 r0 *1 0,0
Ccc_XD1_nt_XD1_t1 XD1_nt XD1_t1 1.21e-17
* device instance cc_XD1_nt_XD2_XDFFM_CLKB r0 *1 0,0
Ccc_XD1_nt_XD2_XDFFM_CLKB XD1_nt XD2_XDFFM_CLKB 1.8151e-17
* device instance cc_XD1_nt_XD2_XDFFM_M r0 *1 0,0
Ccc_XD1_nt_XD2_XDFFM_M XD1_nt XD2_XDFFM_M 2.4201e-17
* device instance cc_XD1_nt_XD2_XDFFM_MB r0 *1 0,0
Ccc_XD1_nt_XD2_XDFFM_MB XD1_nt XD2_XDFFM_MB 1.21e-17
* device instance cc_XD1_nt_XD2_XDFFM_S r0 *1 0,0
Ccc_XD1_nt_XD2_XDFFM_S XD1_nt XD2_XDFFM_S 1.8151e-17
* device instance cc_XD1_nt_XD2_XDFFM_SB r0 *1 0,0
Ccc_XD1_nt_XD2_XDFFM_SB XD1_nt XD2_XDFFM_SB 1.8151e-17
* device instance cc_XD1_nt_XD2_XDFFQ_CLKB r0 *1 0,0
Ccc_XD1_nt_XD2_XDFFQ_CLKB XD1_nt XD2_XDFFQ_CLKB 1.8151e-17
* device instance cc_XD1_nt_XD2_XDFFQ_M r0 *1 0,0
Ccc_XD1_nt_XD2_XDFFQ_M XD1_nt XD2_XDFFQ_M 2.4201e-17
* device instance cc_XD1_nt_XD2_XDFFQ_MB r0 *1 0,0
Ccc_XD1_nt_XD2_XDFFQ_MB XD1_nt XD2_XDFFQ_MB 1.21e-17
* device instance cc_XD1_nt_XD2_XDFFQ_S r0 *1 0,0
Ccc_XD1_nt_XD2_XDFFQ_S XD1_nt XD2_XDFFQ_S 1.8151e-17
* device instance cc_XD1_nt_XD2_XDFFQ_SB r0 *1 0,0
Ccc_XD1_nt_XD2_XDFFQ_SB XD1_nt XD2_XDFFQ_SB 1.8151e-17
* device instance cc_XD1_nt_XD2_XN2_mid1 r0 *1 0,0
Ccc_XD1_nt_XD2_XN2_mid1 XD1_nt XD2_XN2_mid1 1.21e-17
* device instance cc_XD1_nt_XD2_XN3_mid1 r0 *1 0,0
Ccc_XD1_nt_XD2_XN3_mid1 XD1_nt XD2_XN3_mid1 1.21e-17
* device instance cc_XD1_nt_XD2_XN3_mid2 r0 *1 0,0
Ccc_XD1_nt_XD2_XN3_mid2 XD1_nt XD2_XN3_mid2 1.21e-17
* device instance cc_XD1_nt_XD2_dmodout r0 *1 0,0
Ccc_XD1_nt_XD2_dmodout XD1_nt XD2_dmodout 1.21e-17
* device instance cc_XD1_nt_XD2_dq r0 *1 0,0
Ccc_XD1_nt_XD2_dq XD1_nt XD2_dq 1.8151e-17
* device instance cc_XD1_nt_XD2_nm r0 *1 0,0
Ccc_XD1_nt_XD2_nm XD1_nt XD2_nm 1.21e-17
* device instance cc_XD1_nt_XD2_nt r0 *1 0,0
Ccc_XD1_nt_XD2_nt XD1_nt XD2_nt 1.21e-17
* device instance cc_XD1_nt_XD2_t1 r0 *1 0,0
Ccc_XD1_nt_XD2_t1 XD1_nt XD2_t1 1.21e-17
* device instance cc_XD1_nt_XD3_XDFFM_CLKB r0 *1 0,0
Ccc_XD1_nt_XD3_XDFFM_CLKB XD1_nt XD3_XDFFM_CLKB 1.8151e-17
* device instance cc_XD1_nt_XD3_XDFFM_M r0 *1 0,0
Ccc_XD1_nt_XD3_XDFFM_M XD1_nt XD3_XDFFM_M 2.4201e-17
* device instance cc_XD1_nt_XD3_XDFFM_MB r0 *1 0,0
Ccc_XD1_nt_XD3_XDFFM_MB XD1_nt XD3_XDFFM_MB 1.21e-17
* device instance cc_XD1_nt_XD3_XDFFM_S r0 *1 0,0
Ccc_XD1_nt_XD3_XDFFM_S XD1_nt XD3_XDFFM_S 1.8151e-17
* device instance cc_XD1_nt_XD3_XDFFM_SB r0 *1 0,0
Ccc_XD1_nt_XD3_XDFFM_SB XD1_nt XD3_XDFFM_SB 1.8151e-17
* device instance cc_XD1_nt_XD3_XDFFQ_CLKB r0 *1 0,0
Ccc_XD1_nt_XD3_XDFFQ_CLKB XD1_nt XD3_XDFFQ_CLKB 1.8151e-17
* device instance cc_XD1_nt_XD3_XDFFQ_M r0 *1 0,0
Ccc_XD1_nt_XD3_XDFFQ_M XD1_nt XD3_XDFFQ_M 2.4201e-17
* device instance cc_XD1_nt_XD3_XDFFQ_MB r0 *1 0,0
Ccc_XD1_nt_XD3_XDFFQ_MB XD1_nt XD3_XDFFQ_MB 1.21e-17
* device instance cc_XD1_nt_XD3_XDFFQ_S r0 *1 0,0
Ccc_XD1_nt_XD3_XDFFQ_S XD1_nt XD3_XDFFQ_S 1.8151e-17
* device instance cc_XD1_nt_XD3_XDFFQ_SB r0 *1 0,0
Ccc_XD1_nt_XD3_XDFFQ_SB XD1_nt XD3_XDFFQ_SB 1.8151e-17
* device instance cc_XD1_nt_XD3_XN2_mid1 r0 *1 0,0
Ccc_XD1_nt_XD3_XN2_mid1 XD1_nt XD3_XN2_mid1 1.21e-17
* device instance cc_XD1_nt_XD3_XN3_mid1 r0 *1 0,0
Ccc_XD1_nt_XD3_XN3_mid1 XD1_nt XD3_XN3_mid1 1.21e-17
* device instance cc_XD1_nt_XD3_XN3_mid2 r0 *1 0,0
Ccc_XD1_nt_XD3_XN3_mid2 XD1_nt XD3_XN3_mid2 1.21e-17
* device instance cc_XD1_nt_XD3_dmodout r0 *1 0,0
Ccc_XD1_nt_XD3_dmodout XD1_nt XD3_dmodout 1.21e-17
* device instance cc_XD1_nt_XD3_dq r0 *1 0,0
Ccc_XD1_nt_XD3_dq XD1_nt XD3_dq 1.8151e-17
* device instance cc_XD1_nt_XD3_nm r0 *1 0,0
Ccc_XD1_nt_XD3_nm XD1_nt XD3_nm 1.21e-17
* device instance cc_XD1_nt_XD3_nt r0 *1 0,0
Ccc_XD1_nt_XD3_nt XD1_nt XD3_nt 1.21e-17
* device instance cc_XD1_nt_XD3_t1 r0 *1 0,0
Ccc_XD1_nt_XD3_t1 XD1_nt XD3_t1 1.21e-17
* device instance cc_XD1_nt_XD4_XDFFM_CLKB r0 *1 0,0
Ccc_XD1_nt_XD4_XDFFM_CLKB XD1_nt XD4_XDFFM_CLKB 1.8151e-17
* device instance cc_XD1_nt_XD4_XDFFM_M r0 *1 0,0
Ccc_XD1_nt_XD4_XDFFM_M XD1_nt XD4_XDFFM_M 2.4201e-17
* device instance cc_XD1_nt_XD4_XDFFM_MB r0 *1 0,0
Ccc_XD1_nt_XD4_XDFFM_MB XD1_nt XD4_XDFFM_MB 1.21e-17
* device instance cc_XD1_nt_XD4_XDFFM_S r0 *1 0,0
Ccc_XD1_nt_XD4_XDFFM_S XD1_nt XD4_XDFFM_S 1.8151e-17
* device instance cc_XD1_nt_XD4_XDFFM_SB r0 *1 0,0
Ccc_XD1_nt_XD4_XDFFM_SB XD1_nt XD4_XDFFM_SB 1.8151e-17
* device instance cc_XD1_nt_XD4_XDFFQ_CLKB r0 *1 0,0
Ccc_XD1_nt_XD4_XDFFQ_CLKB XD1_nt XD4_XDFFQ_CLKB 1.8151e-17
* device instance cc_XD1_nt_XD4_XDFFQ_M r0 *1 0,0
Ccc_XD1_nt_XD4_XDFFQ_M XD1_nt XD4_XDFFQ_M 2.4201e-17
* device instance cc_XD1_nt_XD4_XDFFQ_MB r0 *1 0,0
Ccc_XD1_nt_XD4_XDFFQ_MB XD1_nt XD4_XDFFQ_MB 1.21e-17
* device instance cc_XD1_nt_XD4_XDFFQ_S r0 *1 0,0
Ccc_XD1_nt_XD4_XDFFQ_S XD1_nt XD4_XDFFQ_S 1.8151e-17
* device instance cc_XD1_nt_XD4_XDFFQ_SB r0 *1 0,0
Ccc_XD1_nt_XD4_XDFFQ_SB XD1_nt XD4_XDFFQ_SB 1.8151e-17
* device instance cc_XD1_nt_XD4_XN2_mid1 r0 *1 0,0
Ccc_XD1_nt_XD4_XN2_mid1 XD1_nt XD4_XN2_mid1 1.21e-17
* device instance cc_XD1_nt_XD4_XN3_mid1 r0 *1 0,0
Ccc_XD1_nt_XD4_XN3_mid1 XD1_nt XD4_XN3_mid1 1.21e-17
* device instance cc_XD1_nt_XD4_XN3_mid2 r0 *1 0,0
Ccc_XD1_nt_XD4_XN3_mid2 XD1_nt XD4_XN3_mid2 1.21e-17
* device instance cc_XD1_nt_XD4_dmodout r0 *1 0,0
Ccc_XD1_nt_XD4_dmodout XD1_nt XD4_dmodout 1.21e-17
* device instance cc_XD1_nt_XD4_dq r0 *1 0,0
Ccc_XD1_nt_XD4_dq XD1_nt XD4_dq 1.8151e-17
* device instance cc_XD1_nt_XD4_nm r0 *1 0,0
Ccc_XD1_nt_XD4_nm XD1_nt XD4_nm 1.21e-17
* device instance cc_XD1_nt_XD4_nt r0 *1 0,0
Ccc_XD1_nt_XD4_nt XD1_nt XD4_nt 1.21e-17
* device instance cc_XD1_nt_XD4_t1 r0 *1 0,0
Ccc_XD1_nt_XD4_t1 XD1_nt XD4_t1 1.21e-17
* device instance cc_XD1_nt_XD5_XDFFM_CLKB r0 *1 0,0
Ccc_XD1_nt_XD5_XDFFM_CLKB XD1_nt XD5_XDFFM_CLKB 1.8151e-17
* device instance cc_XD1_nt_XD5_XDFFM_M r0 *1 0,0
Ccc_XD1_nt_XD5_XDFFM_M XD1_nt XD5_XDFFM_M 2.4201e-17
* device instance cc_XD1_nt_XD5_XDFFM_MB r0 *1 0,0
Ccc_XD1_nt_XD5_XDFFM_MB XD1_nt XD5_XDFFM_MB 1.21e-17
* device instance cc_XD1_nt_XD5_XDFFM_S r0 *1 0,0
Ccc_XD1_nt_XD5_XDFFM_S XD1_nt XD5_XDFFM_S 1.8151e-17
* device instance cc_XD1_nt_XD5_XDFFM_SB r0 *1 0,0
Ccc_XD1_nt_XD5_XDFFM_SB XD1_nt XD5_XDFFM_SB 1.8151e-17
* device instance cc_XD1_nt_XD5_XDFFQ_CLKB r0 *1 0,0
Ccc_XD1_nt_XD5_XDFFQ_CLKB XD1_nt XD5_XDFFQ_CLKB 1.8151e-17
* device instance cc_XD1_nt_XD5_XDFFQ_M r0 *1 0,0
Ccc_XD1_nt_XD5_XDFFQ_M XD1_nt XD5_XDFFQ_M 2.4201e-17
* device instance cc_XD1_nt_XD5_XDFFQ_MB r0 *1 0,0
Ccc_XD1_nt_XD5_XDFFQ_MB XD1_nt XD5_XDFFQ_MB 1.21e-17
* device instance cc_XD1_nt_XD5_XDFFQ_S r0 *1 0,0
Ccc_XD1_nt_XD5_XDFFQ_S XD1_nt XD5_XDFFQ_S 1.8151e-17
* device instance cc_XD1_nt_XD5_XDFFQ_SB r0 *1 0,0
Ccc_XD1_nt_XD5_XDFFQ_SB XD1_nt XD5_XDFFQ_SB 1.8151e-17
* device instance cc_XD1_nt_XD5_XN2_mid1 r0 *1 0,0
Ccc_XD1_nt_XD5_XN2_mid1 XD1_nt XD5_XN2_mid1 1.21e-17
* device instance cc_XD1_nt_XD5_XN3_mid1 r0 *1 0,0
Ccc_XD1_nt_XD5_XN3_mid1 XD1_nt XD5_XN3_mid1 1.21e-17
* device instance cc_XD1_nt_XD5_XN3_mid2 r0 *1 0,0
Ccc_XD1_nt_XD5_XN3_mid2 XD1_nt XD5_XN3_mid2 1.21e-17
* device instance cc_XD1_nt_XD5_dmodout r0 *1 0,0
Ccc_XD1_nt_XD5_dmodout XD1_nt XD5_dmodout 1.21e-17
* device instance cc_XD1_nt_XD5_dq r0 *1 0,0
Ccc_XD1_nt_XD5_dq XD1_nt XD5_dq 1.8151e-17
* device instance cc_XD1_nt_XD5_nm r0 *1 0,0
Ccc_XD1_nt_XD5_nm XD1_nt XD5_nm 1.21e-17
* device instance cc_XD1_nt_XD5_nt r0 *1 0,0
Ccc_XD1_nt_XD5_nt XD1_nt XD5_nt 1.21e-17
* device instance cc_XD1_nt_XD5_t1 r0 *1 0,0
Ccc_XD1_nt_XD5_t1 XD1_nt XD5_t1 1.21e-17
* device instance cc_XD1_nt_XFRT_CLKB r0 *1 0,0
Ccc_XD1_nt_XFRT_CLKB XD1_nt XFRT_CLKB 1.8151e-17
* device instance cc_XD1_nt_XFRT_M r0 *1 0,0
Ccc_XD1_nt_XFRT_M XD1_nt XFRT_M 2.4201e-17
* device instance cc_XD1_nt_XFRT_MB r0 *1 0,0
Ccc_XD1_nt_XFRT_MB XD1_nt XFRT_MB 1.21e-17
* device instance cc_XD1_nt_XFRT_S r0 *1 0,0
Ccc_XD1_nt_XFRT_S XD1_nt XFRT_S 1.8151e-17
* device instance cc_XD1_nt_XFRT_SB r0 *1 0,0
Ccc_XD1_nt_XFRT_SB XD1_nt XFRT_SB 1.8151e-17
* device instance cc_XD1_nt_ck1 r0 *1 0,0
Ccc_XD1_nt_ck1 XD1_nt ck1 5.4452e-17
* device instance cc_XD1_nt_ck2 r0 *1 0,0
Ccc_XD1_nt_ck2 XD1_nt ck2 5.4452e-17
* device instance cc_XD1_nt_ck3 r0 *1 0,0
Ccc_XD1_nt_ck3 XD1_nt ck3 5.4452e-17
* device instance cc_XD1_nt_ck4 r0 *1 0,0
Ccc_XD1_nt_ck4 XD1_nt ck4 5.4452e-17
* device instance cc_XD1_nt_ck5 r0 *1 0,0
Ccc_XD1_nt_ck5 XD1_nt ck5 5.4452e-17
* device instance cc_XD1_nt_mod0 r0 *1 0,0
Ccc_XD1_nt_mod0 XD1_nt mod0 3.0251e-17
* device instance cc_XD1_nt_mod1 r0 *1 0,0
Ccc_XD1_nt_mod1 XD1_nt mod1 2.4201e-17
* device instance cc_XD1_nt_mod2 r0 *1 0,0
Ccc_XD1_nt_mod2 XD1_nt mod2 2.4201e-17
* device instance cc_XD1_nt_mod3 r0 *1 0,0
Ccc_XD1_nt_mod3 XD1_nt mod3 2.4201e-17
* device instance cc_XD1_nt_mod4 r0 *1 0,0
Ccc_XD1_nt_mod4 XD1_nt mod4 2.4201e-17
* device instance cc_XD1_nt_net1 r0 *1 0,0
Ccc_XD1_nt_net1 XD1_nt net1 1.21e-17
* device instance cc_XD1_t1_XD2_XDFFM_CLKB r0 *1 0,0
Ccc_XD1_t1_XD2_XDFFM_CLKB XD1_t1 XD2_XDFFM_CLKB 1.8151e-17
* device instance cc_XD1_t1_XD2_XDFFM_M r0 *1 0,0
Ccc_XD1_t1_XD2_XDFFM_M XD1_t1 XD2_XDFFM_M 2.4201e-17
* device instance cc_XD1_t1_XD2_XDFFM_MB r0 *1 0,0
Ccc_XD1_t1_XD2_XDFFM_MB XD1_t1 XD2_XDFFM_MB 1.21e-17
* device instance cc_XD1_t1_XD2_XDFFM_S r0 *1 0,0
Ccc_XD1_t1_XD2_XDFFM_S XD1_t1 XD2_XDFFM_S 1.8151e-17
* device instance cc_XD1_t1_XD2_XDFFM_SB r0 *1 0,0
Ccc_XD1_t1_XD2_XDFFM_SB XD1_t1 XD2_XDFFM_SB 1.8151e-17
* device instance cc_XD1_t1_XD2_XDFFQ_CLKB r0 *1 0,0
Ccc_XD1_t1_XD2_XDFFQ_CLKB XD1_t1 XD2_XDFFQ_CLKB 1.8151e-17
* device instance cc_XD1_t1_XD2_XDFFQ_M r0 *1 0,0
Ccc_XD1_t1_XD2_XDFFQ_M XD1_t1 XD2_XDFFQ_M 2.4201e-17
* device instance cc_XD1_t1_XD2_XDFFQ_MB r0 *1 0,0
Ccc_XD1_t1_XD2_XDFFQ_MB XD1_t1 XD2_XDFFQ_MB 1.21e-17
* device instance cc_XD1_t1_XD2_XDFFQ_S r0 *1 0,0
Ccc_XD1_t1_XD2_XDFFQ_S XD1_t1 XD2_XDFFQ_S 1.8151e-17
* device instance cc_XD1_t1_XD2_XDFFQ_SB r0 *1 0,0
Ccc_XD1_t1_XD2_XDFFQ_SB XD1_t1 XD2_XDFFQ_SB 1.8151e-17
* device instance cc_XD1_t1_XD2_XN2_mid1 r0 *1 0,0
Ccc_XD1_t1_XD2_XN2_mid1 XD1_t1 XD2_XN2_mid1 1.21e-17
* device instance cc_XD1_t1_XD2_XN3_mid1 r0 *1 0,0
Ccc_XD1_t1_XD2_XN3_mid1 XD1_t1 XD2_XN3_mid1 1.21e-17
* device instance cc_XD1_t1_XD2_XN3_mid2 r0 *1 0,0
Ccc_XD1_t1_XD2_XN3_mid2 XD1_t1 XD2_XN3_mid2 1.21e-17
* device instance cc_XD1_t1_XD2_dmodout r0 *1 0,0
Ccc_XD1_t1_XD2_dmodout XD1_t1 XD2_dmodout 1.21e-17
* device instance cc_XD1_t1_XD2_dq r0 *1 0,0
Ccc_XD1_t1_XD2_dq XD1_t1 XD2_dq 1.8151e-17
* device instance cc_XD1_t1_XD2_nm r0 *1 0,0
Ccc_XD1_t1_XD2_nm XD1_t1 XD2_nm 1.21e-17
* device instance cc_XD1_t1_XD2_nt r0 *1 0,0
Ccc_XD1_t1_XD2_nt XD1_t1 XD2_nt 1.21e-17
* device instance cc_XD1_t1_XD2_t1 r0 *1 0,0
Ccc_XD1_t1_XD2_t1 XD1_t1 XD2_t1 1.21e-17
* device instance cc_XD1_t1_XD3_XDFFM_CLKB r0 *1 0,0
Ccc_XD1_t1_XD3_XDFFM_CLKB XD1_t1 XD3_XDFFM_CLKB 1.8151e-17
* device instance cc_XD1_t1_XD3_XDFFM_M r0 *1 0,0
Ccc_XD1_t1_XD3_XDFFM_M XD1_t1 XD3_XDFFM_M 2.4201e-17
* device instance cc_XD1_t1_XD3_XDFFM_MB r0 *1 0,0
Ccc_XD1_t1_XD3_XDFFM_MB XD1_t1 XD3_XDFFM_MB 1.21e-17
* device instance cc_XD1_t1_XD3_XDFFM_S r0 *1 0,0
Ccc_XD1_t1_XD3_XDFFM_S XD1_t1 XD3_XDFFM_S 1.8151e-17
* device instance cc_XD1_t1_XD3_XDFFM_SB r0 *1 0,0
Ccc_XD1_t1_XD3_XDFFM_SB XD1_t1 XD3_XDFFM_SB 1.8151e-17
* device instance cc_XD1_t1_XD3_XDFFQ_CLKB r0 *1 0,0
Ccc_XD1_t1_XD3_XDFFQ_CLKB XD1_t1 XD3_XDFFQ_CLKB 1.8151e-17
* device instance cc_XD1_t1_XD3_XDFFQ_M r0 *1 0,0
Ccc_XD1_t1_XD3_XDFFQ_M XD1_t1 XD3_XDFFQ_M 2.4201e-17
* device instance cc_XD1_t1_XD3_XDFFQ_MB r0 *1 0,0
Ccc_XD1_t1_XD3_XDFFQ_MB XD1_t1 XD3_XDFFQ_MB 1.21e-17
* device instance cc_XD1_t1_XD3_XDFFQ_S r0 *1 0,0
Ccc_XD1_t1_XD3_XDFFQ_S XD1_t1 XD3_XDFFQ_S 1.8151e-17
* device instance cc_XD1_t1_XD3_XDFFQ_SB r0 *1 0,0
Ccc_XD1_t1_XD3_XDFFQ_SB XD1_t1 XD3_XDFFQ_SB 1.8151e-17
* device instance cc_XD1_t1_XD3_XN2_mid1 r0 *1 0,0
Ccc_XD1_t1_XD3_XN2_mid1 XD1_t1 XD3_XN2_mid1 1.21e-17
* device instance cc_XD1_t1_XD3_XN3_mid1 r0 *1 0,0
Ccc_XD1_t1_XD3_XN3_mid1 XD1_t1 XD3_XN3_mid1 1.21e-17
* device instance cc_XD1_t1_XD3_XN3_mid2 r0 *1 0,0
Ccc_XD1_t1_XD3_XN3_mid2 XD1_t1 XD3_XN3_mid2 1.21e-17
* device instance cc_XD1_t1_XD3_dmodout r0 *1 0,0
Ccc_XD1_t1_XD3_dmodout XD1_t1 XD3_dmodout 1.21e-17
* device instance cc_XD1_t1_XD3_dq r0 *1 0,0
Ccc_XD1_t1_XD3_dq XD1_t1 XD3_dq 1.8151e-17
* device instance cc_XD1_t1_XD3_nm r0 *1 0,0
Ccc_XD1_t1_XD3_nm XD1_t1 XD3_nm 1.21e-17
* device instance cc_XD1_t1_XD3_nt r0 *1 0,0
Ccc_XD1_t1_XD3_nt XD1_t1 XD3_nt 1.21e-17
* device instance cc_XD1_t1_XD3_t1 r0 *1 0,0
Ccc_XD1_t1_XD3_t1 XD1_t1 XD3_t1 1.21e-17
* device instance cc_XD1_t1_XD4_XDFFM_CLKB r0 *1 0,0
Ccc_XD1_t1_XD4_XDFFM_CLKB XD1_t1 XD4_XDFFM_CLKB 1.8151e-17
* device instance cc_XD1_t1_XD4_XDFFM_M r0 *1 0,0
Ccc_XD1_t1_XD4_XDFFM_M XD1_t1 XD4_XDFFM_M 2.4201e-17
* device instance cc_XD1_t1_XD4_XDFFM_MB r0 *1 0,0
Ccc_XD1_t1_XD4_XDFFM_MB XD1_t1 XD4_XDFFM_MB 1.21e-17
* device instance cc_XD1_t1_XD4_XDFFM_S r0 *1 0,0
Ccc_XD1_t1_XD4_XDFFM_S XD1_t1 XD4_XDFFM_S 1.8151e-17
* device instance cc_XD1_t1_XD4_XDFFM_SB r0 *1 0,0
Ccc_XD1_t1_XD4_XDFFM_SB XD1_t1 XD4_XDFFM_SB 1.8151e-17
* device instance cc_XD1_t1_XD4_XDFFQ_CLKB r0 *1 0,0
Ccc_XD1_t1_XD4_XDFFQ_CLKB XD1_t1 XD4_XDFFQ_CLKB 1.8151e-17
* device instance cc_XD1_t1_XD4_XDFFQ_M r0 *1 0,0
Ccc_XD1_t1_XD4_XDFFQ_M XD1_t1 XD4_XDFFQ_M 2.4201e-17
* device instance cc_XD1_t1_XD4_XDFFQ_MB r0 *1 0,0
Ccc_XD1_t1_XD4_XDFFQ_MB XD1_t1 XD4_XDFFQ_MB 1.21e-17
* device instance cc_XD1_t1_XD4_XDFFQ_S r0 *1 0,0
Ccc_XD1_t1_XD4_XDFFQ_S XD1_t1 XD4_XDFFQ_S 1.8151e-17
* device instance cc_XD1_t1_XD4_XDFFQ_SB r0 *1 0,0
Ccc_XD1_t1_XD4_XDFFQ_SB XD1_t1 XD4_XDFFQ_SB 1.8151e-17
* device instance cc_XD1_t1_XD4_XN2_mid1 r0 *1 0,0
Ccc_XD1_t1_XD4_XN2_mid1 XD1_t1 XD4_XN2_mid1 1.21e-17
* device instance cc_XD1_t1_XD4_XN3_mid1 r0 *1 0,0
Ccc_XD1_t1_XD4_XN3_mid1 XD1_t1 XD4_XN3_mid1 1.21e-17
* device instance cc_XD1_t1_XD4_XN3_mid2 r0 *1 0,0
Ccc_XD1_t1_XD4_XN3_mid2 XD1_t1 XD4_XN3_mid2 1.21e-17
* device instance cc_XD1_t1_XD4_dmodout r0 *1 0,0
Ccc_XD1_t1_XD4_dmodout XD1_t1 XD4_dmodout 1.21e-17
* device instance cc_XD1_t1_XD4_dq r0 *1 0,0
Ccc_XD1_t1_XD4_dq XD1_t1 XD4_dq 1.8151e-17
* device instance cc_XD1_t1_XD4_nm r0 *1 0,0
Ccc_XD1_t1_XD4_nm XD1_t1 XD4_nm 1.21e-17
* device instance cc_XD1_t1_XD4_nt r0 *1 0,0
Ccc_XD1_t1_XD4_nt XD1_t1 XD4_nt 1.21e-17
* device instance cc_XD1_t1_XD4_t1 r0 *1 0,0
Ccc_XD1_t1_XD4_t1 XD1_t1 XD4_t1 1.21e-17
* device instance cc_XD1_t1_XD5_XDFFM_CLKB r0 *1 0,0
Ccc_XD1_t1_XD5_XDFFM_CLKB XD1_t1 XD5_XDFFM_CLKB 1.8151e-17
* device instance cc_XD1_t1_XD5_XDFFM_M r0 *1 0,0
Ccc_XD1_t1_XD5_XDFFM_M XD1_t1 XD5_XDFFM_M 2.4201e-17
* device instance cc_XD1_t1_XD5_XDFFM_MB r0 *1 0,0
Ccc_XD1_t1_XD5_XDFFM_MB XD1_t1 XD5_XDFFM_MB 1.21e-17
* device instance cc_XD1_t1_XD5_XDFFM_S r0 *1 0,0
Ccc_XD1_t1_XD5_XDFFM_S XD1_t1 XD5_XDFFM_S 1.8151e-17
* device instance cc_XD1_t1_XD5_XDFFM_SB r0 *1 0,0
Ccc_XD1_t1_XD5_XDFFM_SB XD1_t1 XD5_XDFFM_SB 1.8151e-17
* device instance cc_XD1_t1_XD5_XDFFQ_CLKB r0 *1 0,0
Ccc_XD1_t1_XD5_XDFFQ_CLKB XD1_t1 XD5_XDFFQ_CLKB 1.8151e-17
* device instance cc_XD1_t1_XD5_XDFFQ_M r0 *1 0,0
Ccc_XD1_t1_XD5_XDFFQ_M XD1_t1 XD5_XDFFQ_M 2.4201e-17
* device instance cc_XD1_t1_XD5_XDFFQ_MB r0 *1 0,0
Ccc_XD1_t1_XD5_XDFFQ_MB XD1_t1 XD5_XDFFQ_MB 1.21e-17
* device instance cc_XD1_t1_XD5_XDFFQ_S r0 *1 0,0
Ccc_XD1_t1_XD5_XDFFQ_S XD1_t1 XD5_XDFFQ_S 1.8151e-17
* device instance cc_XD1_t1_XD5_XDFFQ_SB r0 *1 0,0
Ccc_XD1_t1_XD5_XDFFQ_SB XD1_t1 XD5_XDFFQ_SB 1.8151e-17
* device instance cc_XD1_t1_XD5_XN2_mid1 r0 *1 0,0
Ccc_XD1_t1_XD5_XN2_mid1 XD1_t1 XD5_XN2_mid1 1.21e-17
* device instance cc_XD1_t1_XD5_XN3_mid1 r0 *1 0,0
Ccc_XD1_t1_XD5_XN3_mid1 XD1_t1 XD5_XN3_mid1 1.21e-17
* device instance cc_XD1_t1_XD5_XN3_mid2 r0 *1 0,0
Ccc_XD1_t1_XD5_XN3_mid2 XD1_t1 XD5_XN3_mid2 1.21e-17
* device instance cc_XD1_t1_XD5_dmodout r0 *1 0,0
Ccc_XD1_t1_XD5_dmodout XD1_t1 XD5_dmodout 1.21e-17
* device instance cc_XD1_t1_XD5_dq r0 *1 0,0
Ccc_XD1_t1_XD5_dq XD1_t1 XD5_dq 1.8151e-17
* device instance cc_XD1_t1_XD5_nm r0 *1 0,0
Ccc_XD1_t1_XD5_nm XD1_t1 XD5_nm 1.21e-17
* device instance cc_XD1_t1_XD5_nt r0 *1 0,0
Ccc_XD1_t1_XD5_nt XD1_t1 XD5_nt 1.21e-17
* device instance cc_XD1_t1_XD5_t1 r0 *1 0,0
Ccc_XD1_t1_XD5_t1 XD1_t1 XD5_t1 1.21e-17
* device instance cc_XD1_t1_XFRT_CLKB r0 *1 0,0
Ccc_XD1_t1_XFRT_CLKB XD1_t1 XFRT_CLKB 1.8151e-17
* device instance cc_XD1_t1_XFRT_M r0 *1 0,0
Ccc_XD1_t1_XFRT_M XD1_t1 XFRT_M 2.4201e-17
* device instance cc_XD1_t1_XFRT_MB r0 *1 0,0
Ccc_XD1_t1_XFRT_MB XD1_t1 XFRT_MB 1.21e-17
* device instance cc_XD1_t1_XFRT_S r0 *1 0,0
Ccc_XD1_t1_XFRT_S XD1_t1 XFRT_S 1.8151e-17
* device instance cc_XD1_t1_XFRT_SB r0 *1 0,0
Ccc_XD1_t1_XFRT_SB XD1_t1 XFRT_SB 1.8151e-17
* device instance cc_XD1_t1_ck1 r0 *1 0,0
Ccc_XD1_t1_ck1 XD1_t1 ck1 5.4452e-17
* device instance cc_XD1_t1_ck2 r0 *1 0,0
Ccc_XD1_t1_ck2 XD1_t1 ck2 6.0502e-17
* device instance cc_XD1_t1_ck3 r0 *1 0,0
Ccc_XD1_t1_ck3 XD1_t1 ck3 5.4452e-17
* device instance cc_XD1_t1_ck4 r0 *1 0,0
Ccc_XD1_t1_ck4 XD1_t1 ck4 5.4452e-17
* device instance cc_XD1_t1_ck5 r0 *1 0,0
Ccc_XD1_t1_ck5 XD1_t1 ck5 5.4452e-17
* device instance cc_XD1_t1_mod0 r0 *1 0,0
Ccc_XD1_t1_mod0 XD1_t1 mod0 2.4201e-17
* device instance cc_XD1_t1_mod1 r0 *1 0,0
Ccc_XD1_t1_mod1 XD1_t1 mod1 2.4201e-17
* device instance cc_XD1_t1_mod2 r0 *1 0,0
Ccc_XD1_t1_mod2 XD1_t1 mod2 2.4201e-17
* device instance cc_XD1_t1_mod3 r0 *1 0,0
Ccc_XD1_t1_mod3 XD1_t1 mod3 2.4201e-17
* device instance cc_XD1_t1_mod4 r0 *1 0,0
Ccc_XD1_t1_mod4 XD1_t1 mod4 2.4201e-17
* device instance cc_XD1_t1_net1 r0 *1 0,0
Ccc_XD1_t1_net1 XD1_t1 net1 1.21e-17
* device instance cc_XD2_XDFFM_CLKB_XD2_XDFFM_M r0 *1 0,0
Ccc_XD2_XDFFM_CLKB_XD2_XDFFM_M XD2_XDFFM_CLKB XD2_XDFFM_M 4.2352e-17
* device instance cc_XD2_XDFFM_CLKB_XD2_XDFFM_MB r0 *1 0,0
Ccc_XD2_XDFFM_CLKB_XD2_XDFFM_MB XD2_XDFFM_CLKB XD2_XDFFM_MB 2.4201e-17
* device instance cc_XD2_XDFFM_CLKB_XD2_XDFFM_S r0 *1 0,0
Ccc_XD2_XDFFM_CLKB_XD2_XDFFM_S XD2_XDFFM_CLKB XD2_XDFFM_S 1.8151e-17
* device instance cc_XD2_XDFFM_CLKB_XD2_XDFFM_SB r0 *1 0,0
Ccc_XD2_XDFFM_CLKB_XD2_XDFFM_SB XD2_XDFFM_CLKB XD2_XDFFM_SB 1.8151e-17
* device instance cc_XD2_XDFFM_CLKB_XD2_XDFFQ_CLKB r0 *1 0,0
Ccc_XD2_XDFFM_CLKB_XD2_XDFFQ_CLKB XD2_XDFFM_CLKB XD2_XDFFQ_CLKB 1.8151e-17
* device instance cc_XD2_XDFFM_CLKB_XD2_XDFFQ_M r0 *1 0,0
Ccc_XD2_XDFFM_CLKB_XD2_XDFFQ_M XD2_XDFFM_CLKB XD2_XDFFQ_M 2.4201e-17
* device instance cc_XD2_XDFFM_CLKB_XD2_XDFFQ_MB r0 *1 0,0
Ccc_XD2_XDFFM_CLKB_XD2_XDFFQ_MB XD2_XDFFM_CLKB XD2_XDFFQ_MB 1.21e-17
* device instance cc_XD2_XDFFM_CLKB_XD2_XDFFQ_S r0 *1 0,0
Ccc_XD2_XDFFM_CLKB_XD2_XDFFQ_S XD2_XDFFM_CLKB XD2_XDFFQ_S 1.8151e-17
* device instance cc_XD2_XDFFM_CLKB_XD2_XDFFQ_SB r0 *1 0,0
Ccc_XD2_XDFFM_CLKB_XD2_XDFFQ_SB XD2_XDFFM_CLKB XD2_XDFFQ_SB 1.8151e-17
* device instance cc_XD2_XDFFM_CLKB_XD2_XNOR_midp r0 *1 0,0
Ccc_XD2_XDFFM_CLKB_XD2_XNOR_midp XD2_XDFFM_CLKB XD2_XNOR_midp 1.21e-17
* device instance cc_XD2_XDFFM_CLKB_XD2_dmodout r0 *1 0,0
Ccc_XD2_XDFFM_CLKB_XD2_dmodout XD2_XDFFM_CLKB XD2_dmodout 1.8151e-17
* device instance cc_XD2_XDFFM_CLKB_XD2_dq r0 *1 0,0
Ccc_XD2_XDFFM_CLKB_XD2_dq XD2_XDFFM_CLKB XD2_dq 1.21e-17
* device instance cc_XD2_XDFFM_CLKB_XD2_nm r0 *1 0,0
Ccc_XD2_XDFFM_CLKB_XD2_nm XD2_XDFFM_CLKB XD2_nm 1.8151e-17
* device instance cc_XD2_XDFFM_CLKB_XD2_nt r0 *1 0,0
Ccc_XD2_XDFFM_CLKB_XD2_nt XD2_XDFFM_CLKB XD2_nt 2.4201e-17
* device instance cc_XD2_XDFFM_CLKB_XD2_t1 r0 *1 0,0
Ccc_XD2_XDFFM_CLKB_XD2_t1 XD2_XDFFM_CLKB XD2_t1 1.21e-17
* device instance cc_XD2_XDFFM_CLKB_XD3_XDFFM_CLKB r0 *1 0,0
Ccc_XD2_XDFFM_CLKB_XD3_XDFFM_CLKB XD2_XDFFM_CLKB XD3_XDFFM_CLKB 1.8151e-17
* device instance cc_XD2_XDFFM_CLKB_XD3_XDFFM_M r0 *1 0,0
Ccc_XD2_XDFFM_CLKB_XD3_XDFFM_M XD2_XDFFM_CLKB XD3_XDFFM_M 2.4201e-17
* device instance cc_XD2_XDFFM_CLKB_XD3_XDFFM_MB r0 *1 0,0
Ccc_XD2_XDFFM_CLKB_XD3_XDFFM_MB XD2_XDFFM_CLKB XD3_XDFFM_MB 1.21e-17
* device instance cc_XD2_XDFFM_CLKB_XD3_XDFFM_S r0 *1 0,0
Ccc_XD2_XDFFM_CLKB_XD3_XDFFM_S XD2_XDFFM_CLKB XD3_XDFFM_S 1.8151e-17
* device instance cc_XD2_XDFFM_CLKB_XD3_XDFFM_SB r0 *1 0,0
Ccc_XD2_XDFFM_CLKB_XD3_XDFFM_SB XD2_XDFFM_CLKB XD3_XDFFM_SB 1.8151e-17
* device instance cc_XD2_XDFFM_CLKB_XD3_XDFFQ_CLKB r0 *1 0,0
Ccc_XD2_XDFFM_CLKB_XD3_XDFFQ_CLKB XD2_XDFFM_CLKB XD3_XDFFQ_CLKB 1.8151e-17
* device instance cc_XD2_XDFFM_CLKB_XD3_XDFFQ_M r0 *1 0,0
Ccc_XD2_XDFFM_CLKB_XD3_XDFFQ_M XD2_XDFFM_CLKB XD3_XDFFQ_M 2.4201e-17
* device instance cc_XD2_XDFFM_CLKB_XD3_XDFFQ_MB r0 *1 0,0
Ccc_XD2_XDFFM_CLKB_XD3_XDFFQ_MB XD2_XDFFM_CLKB XD3_XDFFQ_MB 1.21e-17
* device instance cc_XD2_XDFFM_CLKB_XD3_XDFFQ_S r0 *1 0,0
Ccc_XD2_XDFFM_CLKB_XD3_XDFFQ_S XD2_XDFFM_CLKB XD3_XDFFQ_S 1.8151e-17
* device instance cc_XD2_XDFFM_CLKB_XD3_XDFFQ_SB r0 *1 0,0
Ccc_XD2_XDFFM_CLKB_XD3_XDFFQ_SB XD2_XDFFM_CLKB XD3_XDFFQ_SB 1.8151e-17
* device instance cc_XD2_XDFFM_CLKB_XD3_XN2_mid1 r0 *1 0,0
Ccc_XD2_XDFFM_CLKB_XD3_XN2_mid1 XD2_XDFFM_CLKB XD3_XN2_mid1 1.21e-17
* device instance cc_XD2_XDFFM_CLKB_XD3_XN3_mid1 r0 *1 0,0
Ccc_XD2_XDFFM_CLKB_XD3_XN3_mid1 XD2_XDFFM_CLKB XD3_XN3_mid1 1.21e-17
* device instance cc_XD2_XDFFM_CLKB_XD3_XN3_mid2 r0 *1 0,0
Ccc_XD2_XDFFM_CLKB_XD3_XN3_mid2 XD2_XDFFM_CLKB XD3_XN3_mid2 1.21e-17
* device instance cc_XD2_XDFFM_CLKB_XD3_dmodout r0 *1 0,0
Ccc_XD2_XDFFM_CLKB_XD3_dmodout XD2_XDFFM_CLKB XD3_dmodout 1.21e-17
* device instance cc_XD2_XDFFM_CLKB_XD3_dq r0 *1 0,0
Ccc_XD2_XDFFM_CLKB_XD3_dq XD2_XDFFM_CLKB XD3_dq 1.8151e-17
* device instance cc_XD2_XDFFM_CLKB_XD3_nm r0 *1 0,0
Ccc_XD2_XDFFM_CLKB_XD3_nm XD2_XDFFM_CLKB XD3_nm 1.21e-17
* device instance cc_XD2_XDFFM_CLKB_XD3_nt r0 *1 0,0
Ccc_XD2_XDFFM_CLKB_XD3_nt XD2_XDFFM_CLKB XD3_nt 1.21e-17
* device instance cc_XD2_XDFFM_CLKB_XD3_t1 r0 *1 0,0
Ccc_XD2_XDFFM_CLKB_XD3_t1 XD2_XDFFM_CLKB XD3_t1 1.21e-17
* device instance cc_XD2_XDFFM_CLKB_XD4_XDFFM_CLKB r0 *1 0,0
Ccc_XD2_XDFFM_CLKB_XD4_XDFFM_CLKB XD2_XDFFM_CLKB XD4_XDFFM_CLKB 1.8151e-17
* device instance cc_XD2_XDFFM_CLKB_XD4_XDFFM_M r0 *1 0,0
Ccc_XD2_XDFFM_CLKB_XD4_XDFFM_M XD2_XDFFM_CLKB XD4_XDFFM_M 2.4201e-17
* device instance cc_XD2_XDFFM_CLKB_XD4_XDFFM_MB r0 *1 0,0
Ccc_XD2_XDFFM_CLKB_XD4_XDFFM_MB XD2_XDFFM_CLKB XD4_XDFFM_MB 1.21e-17
* device instance cc_XD2_XDFFM_CLKB_XD4_XDFFM_S r0 *1 0,0
Ccc_XD2_XDFFM_CLKB_XD4_XDFFM_S XD2_XDFFM_CLKB XD4_XDFFM_S 1.8151e-17
* device instance cc_XD2_XDFFM_CLKB_XD4_XDFFM_SB r0 *1 0,0
Ccc_XD2_XDFFM_CLKB_XD4_XDFFM_SB XD2_XDFFM_CLKB XD4_XDFFM_SB 1.8151e-17
* device instance cc_XD2_XDFFM_CLKB_XD4_XDFFQ_CLKB r0 *1 0,0
Ccc_XD2_XDFFM_CLKB_XD4_XDFFQ_CLKB XD2_XDFFM_CLKB XD4_XDFFQ_CLKB 1.8151e-17
* device instance cc_XD2_XDFFM_CLKB_XD4_XDFFQ_M r0 *1 0,0
Ccc_XD2_XDFFM_CLKB_XD4_XDFFQ_M XD2_XDFFM_CLKB XD4_XDFFQ_M 2.4201e-17
* device instance cc_XD2_XDFFM_CLKB_XD4_XDFFQ_MB r0 *1 0,0
Ccc_XD2_XDFFM_CLKB_XD4_XDFFQ_MB XD2_XDFFM_CLKB XD4_XDFFQ_MB 1.21e-17
* device instance cc_XD2_XDFFM_CLKB_XD4_XDFFQ_S r0 *1 0,0
Ccc_XD2_XDFFM_CLKB_XD4_XDFFQ_S XD2_XDFFM_CLKB XD4_XDFFQ_S 1.8151e-17
* device instance cc_XD2_XDFFM_CLKB_XD4_XDFFQ_SB r0 *1 0,0
Ccc_XD2_XDFFM_CLKB_XD4_XDFFQ_SB XD2_XDFFM_CLKB XD4_XDFFQ_SB 1.8151e-17
* device instance cc_XD2_XDFFM_CLKB_XD4_XN2_mid1 r0 *1 0,0
Ccc_XD2_XDFFM_CLKB_XD4_XN2_mid1 XD2_XDFFM_CLKB XD4_XN2_mid1 1.21e-17
* device instance cc_XD2_XDFFM_CLKB_XD4_XN3_mid1 r0 *1 0,0
Ccc_XD2_XDFFM_CLKB_XD4_XN3_mid1 XD2_XDFFM_CLKB XD4_XN3_mid1 1.21e-17
* device instance cc_XD2_XDFFM_CLKB_XD4_XN3_mid2 r0 *1 0,0
Ccc_XD2_XDFFM_CLKB_XD4_XN3_mid2 XD2_XDFFM_CLKB XD4_XN3_mid2 1.21e-17
* device instance cc_XD2_XDFFM_CLKB_XD4_dmodout r0 *1 0,0
Ccc_XD2_XDFFM_CLKB_XD4_dmodout XD2_XDFFM_CLKB XD4_dmodout 1.21e-17
* device instance cc_XD2_XDFFM_CLKB_XD4_dq r0 *1 0,0
Ccc_XD2_XDFFM_CLKB_XD4_dq XD2_XDFFM_CLKB XD4_dq 1.8151e-17
* device instance cc_XD2_XDFFM_CLKB_XD4_nm r0 *1 0,0
Ccc_XD2_XDFFM_CLKB_XD4_nm XD2_XDFFM_CLKB XD4_nm 1.21e-17
* device instance cc_XD2_XDFFM_CLKB_XD4_nt r0 *1 0,0
Ccc_XD2_XDFFM_CLKB_XD4_nt XD2_XDFFM_CLKB XD4_nt 1.21e-17
* device instance cc_XD2_XDFFM_CLKB_XD4_t1 r0 *1 0,0
Ccc_XD2_XDFFM_CLKB_XD4_t1 XD2_XDFFM_CLKB XD4_t1 1.21e-17
* device instance cc_XD2_XDFFM_CLKB_XD5_XDFFM_CLKB r0 *1 0,0
Ccc_XD2_XDFFM_CLKB_XD5_XDFFM_CLKB XD2_XDFFM_CLKB XD5_XDFFM_CLKB 1.8151e-17
* device instance cc_XD2_XDFFM_CLKB_XD5_XDFFM_M r0 *1 0,0
Ccc_XD2_XDFFM_CLKB_XD5_XDFFM_M XD2_XDFFM_CLKB XD5_XDFFM_M 2.4201e-17
* device instance cc_XD2_XDFFM_CLKB_XD5_XDFFM_MB r0 *1 0,0
Ccc_XD2_XDFFM_CLKB_XD5_XDFFM_MB XD2_XDFFM_CLKB XD5_XDFFM_MB 1.21e-17
* device instance cc_XD2_XDFFM_CLKB_XD5_XDFFM_S r0 *1 0,0
Ccc_XD2_XDFFM_CLKB_XD5_XDFFM_S XD2_XDFFM_CLKB XD5_XDFFM_S 1.8151e-17
* device instance cc_XD2_XDFFM_CLKB_XD5_XDFFM_SB r0 *1 0,0
Ccc_XD2_XDFFM_CLKB_XD5_XDFFM_SB XD2_XDFFM_CLKB XD5_XDFFM_SB 1.8151e-17
* device instance cc_XD2_XDFFM_CLKB_XD5_XDFFQ_CLKB r0 *1 0,0
Ccc_XD2_XDFFM_CLKB_XD5_XDFFQ_CLKB XD2_XDFFM_CLKB XD5_XDFFQ_CLKB 1.8151e-17
* device instance cc_XD2_XDFFM_CLKB_XD5_XDFFQ_M r0 *1 0,0
Ccc_XD2_XDFFM_CLKB_XD5_XDFFQ_M XD2_XDFFM_CLKB XD5_XDFFQ_M 2.4201e-17
* device instance cc_XD2_XDFFM_CLKB_XD5_XDFFQ_MB r0 *1 0,0
Ccc_XD2_XDFFM_CLKB_XD5_XDFFQ_MB XD2_XDFFM_CLKB XD5_XDFFQ_MB 1.21e-17
* device instance cc_XD2_XDFFM_CLKB_XD5_XDFFQ_S r0 *1 0,0
Ccc_XD2_XDFFM_CLKB_XD5_XDFFQ_S XD2_XDFFM_CLKB XD5_XDFFQ_S 1.8151e-17
* device instance cc_XD2_XDFFM_CLKB_XD5_XDFFQ_SB r0 *1 0,0
Ccc_XD2_XDFFM_CLKB_XD5_XDFFQ_SB XD2_XDFFM_CLKB XD5_XDFFQ_SB 1.8151e-17
* device instance cc_XD2_XDFFM_CLKB_XD5_XN2_mid1 r0 *1 0,0
Ccc_XD2_XDFFM_CLKB_XD5_XN2_mid1 XD2_XDFFM_CLKB XD5_XN2_mid1 1.21e-17
* device instance cc_XD2_XDFFM_CLKB_XD5_XN3_mid1 r0 *1 0,0
Ccc_XD2_XDFFM_CLKB_XD5_XN3_mid1 XD2_XDFFM_CLKB XD5_XN3_mid1 1.21e-17
* device instance cc_XD2_XDFFM_CLKB_XD5_XN3_mid2 r0 *1 0,0
Ccc_XD2_XDFFM_CLKB_XD5_XN3_mid2 XD2_XDFFM_CLKB XD5_XN3_mid2 1.21e-17
* device instance cc_XD2_XDFFM_CLKB_XD5_dmodout r0 *1 0,0
Ccc_XD2_XDFFM_CLKB_XD5_dmodout XD2_XDFFM_CLKB XD5_dmodout 1.21e-17
* device instance cc_XD2_XDFFM_CLKB_XD5_dq r0 *1 0,0
Ccc_XD2_XDFFM_CLKB_XD5_dq XD2_XDFFM_CLKB XD5_dq 1.8151e-17
* device instance cc_XD2_XDFFM_CLKB_XD5_nm r0 *1 0,0
Ccc_XD2_XDFFM_CLKB_XD5_nm XD2_XDFFM_CLKB XD5_nm 1.21e-17
* device instance cc_XD2_XDFFM_CLKB_XD5_nt r0 *1 0,0
Ccc_XD2_XDFFM_CLKB_XD5_nt XD2_XDFFM_CLKB XD5_nt 1.21e-17
* device instance cc_XD2_XDFFM_CLKB_XD5_t1 r0 *1 0,0
Ccc_XD2_XDFFM_CLKB_XD5_t1 XD2_XDFFM_CLKB XD5_t1 1.21e-17
* device instance cc_XD2_XDFFM_CLKB_XFRT_CLKB r0 *1 0,0
Ccc_XD2_XDFFM_CLKB_XFRT_CLKB XD2_XDFFM_CLKB XFRT_CLKB 1.8151e-17
* device instance cc_XD2_XDFFM_CLKB_XFRT_M r0 *1 0,0
Ccc_XD2_XDFFM_CLKB_XFRT_M XD2_XDFFM_CLKB XFRT_M 2.4201e-17
* device instance cc_XD2_XDFFM_CLKB_XFRT_MB r0 *1 0,0
Ccc_XD2_XDFFM_CLKB_XFRT_MB XD2_XDFFM_CLKB XFRT_MB 1.21e-17
* device instance cc_XD2_XDFFM_CLKB_XFRT_S r0 *1 0,0
Ccc_XD2_XDFFM_CLKB_XFRT_S XD2_XDFFM_CLKB XFRT_S 1.8151e-17
* device instance cc_XD2_XDFFM_CLKB_XFRT_SB r0 *1 0,0
Ccc_XD2_XDFFM_CLKB_XFRT_SB XD2_XDFFM_CLKB XFRT_SB 1.8151e-17
* device instance cc_XD2_XDFFM_CLKB_ck1 r0 *1 0,0
Ccc_XD2_XDFFM_CLKB_ck1 XD2_XDFFM_CLKB ck1 5.4452e-17
* device instance cc_XD2_XDFFM_CLKB_ck2 r0 *1 0,0
Ccc_XD2_XDFFM_CLKB_ck2 XD2_XDFFM_CLKB ck2 6.0502e-17
* device instance cc_XD2_XDFFM_CLKB_ck3 r0 *1 0,0
Ccc_XD2_XDFFM_CLKB_ck3 XD2_XDFFM_CLKB ck3 5.4452e-17
* device instance cc_XD2_XDFFM_CLKB_ck4 r0 *1 0,0
Ccc_XD2_XDFFM_CLKB_ck4 XD2_XDFFM_CLKB ck4 5.4452e-17
* device instance cc_XD2_XDFFM_CLKB_ck5 r0 *1 0,0
Ccc_XD2_XDFFM_CLKB_ck5 XD2_XDFFM_CLKB ck5 5.4452e-17
* device instance cc_XD2_XDFFM_CLKB_mod0 r0 *1 0,0
Ccc_XD2_XDFFM_CLKB_mod0 XD2_XDFFM_CLKB mod0 2.4201e-17
* device instance cc_XD2_XDFFM_CLKB_mod1 r0 *1 0,0
Ccc_XD2_XDFFM_CLKB_mod1 XD2_XDFFM_CLKB mod1 2.4201e-17
* device instance cc_XD2_XDFFM_CLKB_mod2 r0 *1 0,0
Ccc_XD2_XDFFM_CLKB_mod2 XD2_XDFFM_CLKB mod2 2.4201e-17
* device instance cc_XD2_XDFFM_CLKB_mod3 r0 *1 0,0
Ccc_XD2_XDFFM_CLKB_mod3 XD2_XDFFM_CLKB mod3 2.4201e-17
* device instance cc_XD2_XDFFM_CLKB_mod4 r0 *1 0,0
Ccc_XD2_XDFFM_CLKB_mod4 XD2_XDFFM_CLKB mod4 2.4201e-17
* device instance cc_XD2_XDFFM_CLKB_net1 r0 *1 0,0
Ccc_XD2_XDFFM_CLKB_net1 XD2_XDFFM_CLKB net1 1.21e-17
* device instance cc_XD2_XDFFM_M_XD2_XDFFM_MB r0 *1 0,0
Ccc_XD2_XDFFM_M_XD2_XDFFM_MB XD2_XDFFM_M XD2_XDFFM_MB 3.4688e-17
* device instance cc_XD2_XDFFM_M_XD2_XDFFM_S r0 *1 0,0
Ccc_XD2_XDFFM_M_XD2_XDFFM_S XD2_XDFFM_M XD2_XDFFM_S 2.8638e-17
* device instance cc_XD2_XDFFM_M_XD2_XDFFM_SB r0 *1 0,0
Ccc_XD2_XDFFM_M_XD2_XDFFM_SB XD2_XDFFM_M XD2_XDFFM_SB 1.8151e-17
* device instance cc_XD2_XDFFM_M_XD2_XDFFQ_CLKB r0 *1 0,0
Ccc_XD2_XDFFM_M_XD2_XDFFQ_CLKB XD2_XDFFM_M XD2_XDFFQ_CLKB 1.8151e-17
* device instance cc_XD2_XDFFM_M_XD2_XDFFQ_M r0 *1 0,0
Ccc_XD2_XDFFM_M_XD2_XDFFQ_M XD2_XDFFM_M XD2_XDFFQ_M 2.4201e-17
* device instance cc_XD2_XDFFM_M_XD2_XDFFQ_MB r0 *1 0,0
Ccc_XD2_XDFFM_M_XD2_XDFFQ_MB XD2_XDFFM_M XD2_XDFFQ_MB 1.21e-17
* device instance cc_XD2_XDFFM_M_XD2_XDFFQ_S r0 *1 0,0
Ccc_XD2_XDFFM_M_XD2_XDFFQ_S XD2_XDFFM_M XD2_XDFFQ_S 1.8151e-17
* device instance cc_XD2_XDFFM_M_XD2_XDFFQ_SB r0 *1 0,0
Ccc_XD2_XDFFM_M_XD2_XDFFQ_SB XD2_XDFFM_M XD2_XDFFQ_SB 1.8151e-17
* device instance cc_XD2_XDFFM_M_XD2_XNOR_midp r0 *1 0,0
Ccc_XD2_XDFFM_M_XD2_XNOR_midp XD2_XDFFM_M XD2_XNOR_midp 1.21e-17
* device instance cc_XD2_XDFFM_M_XD2_dmodout r0 *1 0,0
Ccc_XD2_XDFFM_M_XD2_dmodout XD2_XDFFM_M XD2_dmodout 2.8638e-17
* device instance cc_XD2_XDFFM_M_XD2_dq r0 *1 0,0
Ccc_XD2_XDFFM_M_XD2_dq XD2_XDFFM_M XD2_dq 1.21e-17
* device instance cc_XD2_XDFFM_M_XD2_nm r0 *1 0,0
Ccc_XD2_XDFFM_M_XD2_nm XD2_XDFFM_M XD2_nm 1.8151e-17
* device instance cc_XD2_XDFFM_M_XD2_nt r0 *1 0,0
Ccc_XD2_XDFFM_M_XD2_nt XD2_XDFFM_M XD2_nt 2.4201e-17
* device instance cc_XD2_XDFFM_M_XD2_t1 r0 *1 0,0
Ccc_XD2_XDFFM_M_XD2_t1 XD2_XDFFM_M XD2_t1 1.21e-17
* device instance cc_XD2_XDFFM_M_XD3_XDFFM_CLKB r0 *1 0,0
Ccc_XD2_XDFFM_M_XD3_XDFFM_CLKB XD2_XDFFM_M XD3_XDFFM_CLKB 1.8151e-17
* device instance cc_XD2_XDFFM_M_XD3_XDFFM_M r0 *1 0,0
Ccc_XD2_XDFFM_M_XD3_XDFFM_M XD2_XDFFM_M XD3_XDFFM_M 2.4201e-17
* device instance cc_XD2_XDFFM_M_XD3_XDFFM_MB r0 *1 0,0
Ccc_XD2_XDFFM_M_XD3_XDFFM_MB XD2_XDFFM_M XD3_XDFFM_MB 1.21e-17
* device instance cc_XD2_XDFFM_M_XD3_XDFFM_S r0 *1 0,0
Ccc_XD2_XDFFM_M_XD3_XDFFM_S XD2_XDFFM_M XD3_XDFFM_S 1.8151e-17
* device instance cc_XD2_XDFFM_M_XD3_XDFFM_SB r0 *1 0,0
Ccc_XD2_XDFFM_M_XD3_XDFFM_SB XD2_XDFFM_M XD3_XDFFM_SB 1.8151e-17
* device instance cc_XD2_XDFFM_M_XD3_XDFFQ_CLKB r0 *1 0,0
Ccc_XD2_XDFFM_M_XD3_XDFFQ_CLKB XD2_XDFFM_M XD3_XDFFQ_CLKB 1.8151e-17
* device instance cc_XD2_XDFFM_M_XD3_XDFFQ_M r0 *1 0,0
Ccc_XD2_XDFFM_M_XD3_XDFFQ_M XD2_XDFFM_M XD3_XDFFQ_M 2.4201e-17
* device instance cc_XD2_XDFFM_M_XD3_XDFFQ_MB r0 *1 0,0
Ccc_XD2_XDFFM_M_XD3_XDFFQ_MB XD2_XDFFM_M XD3_XDFFQ_MB 1.21e-17
* device instance cc_XD2_XDFFM_M_XD3_XDFFQ_S r0 *1 0,0
Ccc_XD2_XDFFM_M_XD3_XDFFQ_S XD2_XDFFM_M XD3_XDFFQ_S 1.8151e-17
* device instance cc_XD2_XDFFM_M_XD3_XDFFQ_SB r0 *1 0,0
Ccc_XD2_XDFFM_M_XD3_XDFFQ_SB XD2_XDFFM_M XD3_XDFFQ_SB 1.8151e-17
* device instance cc_XD2_XDFFM_M_XD3_XN2_mid1 r0 *1 0,0
Ccc_XD2_XDFFM_M_XD3_XN2_mid1 XD2_XDFFM_M XD3_XN2_mid1 1.21e-17
* device instance cc_XD2_XDFFM_M_XD3_XN3_mid1 r0 *1 0,0
Ccc_XD2_XDFFM_M_XD3_XN3_mid1 XD2_XDFFM_M XD3_XN3_mid1 1.21e-17
* device instance cc_XD2_XDFFM_M_XD3_XN3_mid2 r0 *1 0,0
Ccc_XD2_XDFFM_M_XD3_XN3_mid2 XD2_XDFFM_M XD3_XN3_mid2 1.21e-17
* device instance cc_XD2_XDFFM_M_XD3_dmodout r0 *1 0,0
Ccc_XD2_XDFFM_M_XD3_dmodout XD2_XDFFM_M XD3_dmodout 1.21e-17
* device instance cc_XD2_XDFFM_M_XD3_dq r0 *1 0,0
Ccc_XD2_XDFFM_M_XD3_dq XD2_XDFFM_M XD3_dq 1.8151e-17
* device instance cc_XD2_XDFFM_M_XD3_nm r0 *1 0,0
Ccc_XD2_XDFFM_M_XD3_nm XD2_XDFFM_M XD3_nm 1.21e-17
* device instance cc_XD2_XDFFM_M_XD3_nt r0 *1 0,0
Ccc_XD2_XDFFM_M_XD3_nt XD2_XDFFM_M XD3_nt 1.21e-17
* device instance cc_XD2_XDFFM_M_XD3_t1 r0 *1 0,0
Ccc_XD2_XDFFM_M_XD3_t1 XD2_XDFFM_M XD3_t1 1.21e-17
* device instance cc_XD2_XDFFM_M_XD4_XDFFM_CLKB r0 *1 0,0
Ccc_XD2_XDFFM_M_XD4_XDFFM_CLKB XD2_XDFFM_M XD4_XDFFM_CLKB 1.8151e-17
* device instance cc_XD2_XDFFM_M_XD4_XDFFM_M r0 *1 0,0
Ccc_XD2_XDFFM_M_XD4_XDFFM_M XD2_XDFFM_M XD4_XDFFM_M 2.4201e-17
* device instance cc_XD2_XDFFM_M_XD4_XDFFM_MB r0 *1 0,0
Ccc_XD2_XDFFM_M_XD4_XDFFM_MB XD2_XDFFM_M XD4_XDFFM_MB 1.21e-17
* device instance cc_XD2_XDFFM_M_XD4_XDFFM_S r0 *1 0,0
Ccc_XD2_XDFFM_M_XD4_XDFFM_S XD2_XDFFM_M XD4_XDFFM_S 1.8151e-17
* device instance cc_XD2_XDFFM_M_XD4_XDFFM_SB r0 *1 0,0
Ccc_XD2_XDFFM_M_XD4_XDFFM_SB XD2_XDFFM_M XD4_XDFFM_SB 1.8151e-17
* device instance cc_XD2_XDFFM_M_XD4_XDFFQ_CLKB r0 *1 0,0
Ccc_XD2_XDFFM_M_XD4_XDFFQ_CLKB XD2_XDFFM_M XD4_XDFFQ_CLKB 1.8151e-17
* device instance cc_XD2_XDFFM_M_XD4_XDFFQ_M r0 *1 0,0
Ccc_XD2_XDFFM_M_XD4_XDFFQ_M XD2_XDFFM_M XD4_XDFFQ_M 2.4201e-17
* device instance cc_XD2_XDFFM_M_XD4_XDFFQ_MB r0 *1 0,0
Ccc_XD2_XDFFM_M_XD4_XDFFQ_MB XD2_XDFFM_M XD4_XDFFQ_MB 1.21e-17
* device instance cc_XD2_XDFFM_M_XD4_XDFFQ_S r0 *1 0,0
Ccc_XD2_XDFFM_M_XD4_XDFFQ_S XD2_XDFFM_M XD4_XDFFQ_S 1.8151e-17
* device instance cc_XD2_XDFFM_M_XD4_XDFFQ_SB r0 *1 0,0
Ccc_XD2_XDFFM_M_XD4_XDFFQ_SB XD2_XDFFM_M XD4_XDFFQ_SB 1.8151e-17
* device instance cc_XD2_XDFFM_M_XD4_XN2_mid1 r0 *1 0,0
Ccc_XD2_XDFFM_M_XD4_XN2_mid1 XD2_XDFFM_M XD4_XN2_mid1 1.21e-17
* device instance cc_XD2_XDFFM_M_XD4_XN3_mid1 r0 *1 0,0
Ccc_XD2_XDFFM_M_XD4_XN3_mid1 XD2_XDFFM_M XD4_XN3_mid1 1.21e-17
* device instance cc_XD2_XDFFM_M_XD4_XN3_mid2 r0 *1 0,0
Ccc_XD2_XDFFM_M_XD4_XN3_mid2 XD2_XDFFM_M XD4_XN3_mid2 1.21e-17
* device instance cc_XD2_XDFFM_M_XD4_dmodout r0 *1 0,0
Ccc_XD2_XDFFM_M_XD4_dmodout XD2_XDFFM_M XD4_dmodout 1.21e-17
* device instance cc_XD2_XDFFM_M_XD4_dq r0 *1 0,0
Ccc_XD2_XDFFM_M_XD4_dq XD2_XDFFM_M XD4_dq 1.8151e-17
* device instance cc_XD2_XDFFM_M_XD4_nm r0 *1 0,0
Ccc_XD2_XDFFM_M_XD4_nm XD2_XDFFM_M XD4_nm 1.21e-17
* device instance cc_XD2_XDFFM_M_XD4_nt r0 *1 0,0
Ccc_XD2_XDFFM_M_XD4_nt XD2_XDFFM_M XD4_nt 1.21e-17
* device instance cc_XD2_XDFFM_M_XD4_t1 r0 *1 0,0
Ccc_XD2_XDFFM_M_XD4_t1 XD2_XDFFM_M XD4_t1 1.21e-17
* device instance cc_XD2_XDFFM_M_XD5_XDFFM_CLKB r0 *1 0,0
Ccc_XD2_XDFFM_M_XD5_XDFFM_CLKB XD2_XDFFM_M XD5_XDFFM_CLKB 1.8151e-17
* device instance cc_XD2_XDFFM_M_XD5_XDFFM_M r0 *1 0,0
Ccc_XD2_XDFFM_M_XD5_XDFFM_M XD2_XDFFM_M XD5_XDFFM_M 2.4201e-17
* device instance cc_XD2_XDFFM_M_XD5_XDFFM_MB r0 *1 0,0
Ccc_XD2_XDFFM_M_XD5_XDFFM_MB XD2_XDFFM_M XD5_XDFFM_MB 1.21e-17
* device instance cc_XD2_XDFFM_M_XD5_XDFFM_S r0 *1 0,0
Ccc_XD2_XDFFM_M_XD5_XDFFM_S XD2_XDFFM_M XD5_XDFFM_S 1.8151e-17
* device instance cc_XD2_XDFFM_M_XD5_XDFFM_SB r0 *1 0,0
Ccc_XD2_XDFFM_M_XD5_XDFFM_SB XD2_XDFFM_M XD5_XDFFM_SB 1.8151e-17
* device instance cc_XD2_XDFFM_M_XD5_XDFFQ_CLKB r0 *1 0,0
Ccc_XD2_XDFFM_M_XD5_XDFFQ_CLKB XD2_XDFFM_M XD5_XDFFQ_CLKB 1.8151e-17
* device instance cc_XD2_XDFFM_M_XD5_XDFFQ_M r0 *1 0,0
Ccc_XD2_XDFFM_M_XD5_XDFFQ_M XD2_XDFFM_M XD5_XDFFQ_M 2.4201e-17
* device instance cc_XD2_XDFFM_M_XD5_XDFFQ_MB r0 *1 0,0
Ccc_XD2_XDFFM_M_XD5_XDFFQ_MB XD2_XDFFM_M XD5_XDFFQ_MB 1.21e-17
* device instance cc_XD2_XDFFM_M_XD5_XDFFQ_S r0 *1 0,0
Ccc_XD2_XDFFM_M_XD5_XDFFQ_S XD2_XDFFM_M XD5_XDFFQ_S 1.8151e-17
* device instance cc_XD2_XDFFM_M_XD5_XDFFQ_SB r0 *1 0,0
Ccc_XD2_XDFFM_M_XD5_XDFFQ_SB XD2_XDFFM_M XD5_XDFFQ_SB 1.8151e-17
* device instance cc_XD2_XDFFM_M_XD5_XN2_mid1 r0 *1 0,0
Ccc_XD2_XDFFM_M_XD5_XN2_mid1 XD2_XDFFM_M XD5_XN2_mid1 1.21e-17
* device instance cc_XD2_XDFFM_M_XD5_XN3_mid1 r0 *1 0,0
Ccc_XD2_XDFFM_M_XD5_XN3_mid1 XD2_XDFFM_M XD5_XN3_mid1 1.21e-17
* device instance cc_XD2_XDFFM_M_XD5_XN3_mid2 r0 *1 0,0
Ccc_XD2_XDFFM_M_XD5_XN3_mid2 XD2_XDFFM_M XD5_XN3_mid2 1.21e-17
* device instance cc_XD2_XDFFM_M_XD5_dmodout r0 *1 0,0
Ccc_XD2_XDFFM_M_XD5_dmodout XD2_XDFFM_M XD5_dmodout 1.21e-17
* device instance cc_XD2_XDFFM_M_XD5_dq r0 *1 0,0
Ccc_XD2_XDFFM_M_XD5_dq XD2_XDFFM_M XD5_dq 1.8151e-17
* device instance cc_XD2_XDFFM_M_XD5_nm r0 *1 0,0
Ccc_XD2_XDFFM_M_XD5_nm XD2_XDFFM_M XD5_nm 1.21e-17
* device instance cc_XD2_XDFFM_M_XD5_nt r0 *1 0,0
Ccc_XD2_XDFFM_M_XD5_nt XD2_XDFFM_M XD5_nt 1.21e-17
* device instance cc_XD2_XDFFM_M_XD5_t1 r0 *1 0,0
Ccc_XD2_XDFFM_M_XD5_t1 XD2_XDFFM_M XD5_t1 1.21e-17
* device instance cc_XD2_XDFFM_M_XFRT_CLKB r0 *1 0,0
Ccc_XD2_XDFFM_M_XFRT_CLKB XD2_XDFFM_M XFRT_CLKB 1.8151e-17
* device instance cc_XD2_XDFFM_M_XFRT_M r0 *1 0,0
Ccc_XD2_XDFFM_M_XFRT_M XD2_XDFFM_M XFRT_M 2.4201e-17
* device instance cc_XD2_XDFFM_M_XFRT_MB r0 *1 0,0
Ccc_XD2_XDFFM_M_XFRT_MB XD2_XDFFM_M XFRT_MB 1.21e-17
* device instance cc_XD2_XDFFM_M_XFRT_S r0 *1 0,0
Ccc_XD2_XDFFM_M_XFRT_S XD2_XDFFM_M XFRT_S 1.8151e-17
* device instance cc_XD2_XDFFM_M_XFRT_SB r0 *1 0,0
Ccc_XD2_XDFFM_M_XFRT_SB XD2_XDFFM_M XFRT_SB 1.8151e-17
* device instance cc_XD2_XDFFM_M_ck1 r0 *1 0,0
Ccc_XD2_XDFFM_M_ck1 XD2_XDFFM_M ck1 5.4452e-17
* device instance cc_XD2_XDFFM_M_ck2 r0 *1 0,0
Ccc_XD2_XDFFM_M_ck2 XD2_XDFFM_M ck2 6.0502e-17
* device instance cc_XD2_XDFFM_M_ck3 r0 *1 0,0
Ccc_XD2_XDFFM_M_ck3 XD2_XDFFM_M ck3 5.4452e-17
* device instance cc_XD2_XDFFM_M_ck4 r0 *1 0,0
Ccc_XD2_XDFFM_M_ck4 XD2_XDFFM_M ck4 5.4452e-17
* device instance cc_XD2_XDFFM_M_ck5 r0 *1 0,0
Ccc_XD2_XDFFM_M_ck5 XD2_XDFFM_M ck5 5.4452e-17
* device instance cc_XD2_XDFFM_M_mod0 r0 *1 0,0
Ccc_XD2_XDFFM_M_mod0 XD2_XDFFM_M mod0 2.4201e-17
* device instance cc_XD2_XDFFM_M_mod1 r0 *1 0,0
Ccc_XD2_XDFFM_M_mod1 XD2_XDFFM_M mod1 2.4201e-17
* device instance cc_XD2_XDFFM_M_mod2 r0 *1 0,0
Ccc_XD2_XDFFM_M_mod2 XD2_XDFFM_M mod2 2.4201e-17
* device instance cc_XD2_XDFFM_M_mod3 r0 *1 0,0
Ccc_XD2_XDFFM_M_mod3 XD2_XDFFM_M mod3 2.4201e-17
* device instance cc_XD2_XDFFM_M_mod4 r0 *1 0,0
Ccc_XD2_XDFFM_M_mod4 XD2_XDFFM_M mod4 2.4201e-17
* device instance cc_XD2_XDFFM_M_net1 r0 *1 0,0
Ccc_XD2_XDFFM_M_net1 XD2_XDFFM_M net1 1.21e-17
* device instance cc_XD2_XDFFM_MB_XD2_XDFFM_S r0 *1 0,0
Ccc_XD2_XDFFM_MB_XD2_XDFFM_S XD2_XDFFM_MB XD2_XDFFM_S 1.8151e-17
* device instance cc_XD2_XDFFM_MB_XD2_XDFFM_SB r0 *1 0,0
Ccc_XD2_XDFFM_MB_XD2_XDFFM_SB XD2_XDFFM_MB XD2_XDFFM_SB 1.8151e-17
* device instance cc_XD2_XDFFM_MB_XD2_XDFFQ_CLKB r0 *1 0,0
Ccc_XD2_XDFFM_MB_XD2_XDFFQ_CLKB XD2_XDFFM_MB XD2_XDFFQ_CLKB 1.8151e-17
* device instance cc_XD2_XDFFM_MB_XD2_XDFFQ_M r0 *1 0,0
Ccc_XD2_XDFFM_MB_XD2_XDFFQ_M XD2_XDFFM_MB XD2_XDFFQ_M 2.4201e-17
* device instance cc_XD2_XDFFM_MB_XD2_XDFFQ_MB r0 *1 0,0
Ccc_XD2_XDFFM_MB_XD2_XDFFQ_MB XD2_XDFFM_MB XD2_XDFFQ_MB 1.21e-17
* device instance cc_XD2_XDFFM_MB_XD2_XDFFQ_S r0 *1 0,0
Ccc_XD2_XDFFM_MB_XD2_XDFFQ_S XD2_XDFFM_MB XD2_XDFFQ_S 1.8151e-17
* device instance cc_XD2_XDFFM_MB_XD2_XDFFQ_SB r0 *1 0,0
Ccc_XD2_XDFFM_MB_XD2_XDFFQ_SB XD2_XDFFM_MB XD2_XDFFQ_SB 1.8151e-17
* device instance cc_XD2_XDFFM_MB_XD2_XNOR_midp r0 *1 0,0
Ccc_XD2_XDFFM_MB_XD2_XNOR_midp XD2_XDFFM_MB XD2_XNOR_midp 1.21e-17
* device instance cc_XD2_XDFFM_MB_XD2_dmodout r0 *1 0,0
Ccc_XD2_XDFFM_MB_XD2_dmodout XD2_XDFFM_MB XD2_dmodout 1.21e-17
* device instance cc_XD2_XDFFM_MB_XD2_dq r0 *1 0,0
Ccc_XD2_XDFFM_MB_XD2_dq XD2_XDFFM_MB XD2_dq 1.21e-17
* device instance cc_XD2_XDFFM_MB_XD2_nm r0 *1 0,0
Ccc_XD2_XDFFM_MB_XD2_nm XD2_XDFFM_MB XD2_nm 1.8151e-17
* device instance cc_XD2_XDFFM_MB_XD2_nt r0 *1 0,0
Ccc_XD2_XDFFM_MB_XD2_nt XD2_XDFFM_MB XD2_nt 2.4201e-17
* device instance cc_XD2_XDFFM_MB_XD2_t1 r0 *1 0,0
Ccc_XD2_XDFFM_MB_XD2_t1 XD2_XDFFM_MB XD2_t1 1.21e-17
* device instance cc_XD2_XDFFM_MB_XD3_XDFFM_CLKB r0 *1 0,0
Ccc_XD2_XDFFM_MB_XD3_XDFFM_CLKB XD2_XDFFM_MB XD3_XDFFM_CLKB 1.8151e-17
* device instance cc_XD2_XDFFM_MB_XD3_XDFFM_M r0 *1 0,0
Ccc_XD2_XDFFM_MB_XD3_XDFFM_M XD2_XDFFM_MB XD3_XDFFM_M 2.4201e-17
* device instance cc_XD2_XDFFM_MB_XD3_XDFFM_MB r0 *1 0,0
Ccc_XD2_XDFFM_MB_XD3_XDFFM_MB XD2_XDFFM_MB XD3_XDFFM_MB 1.21e-17
* device instance cc_XD2_XDFFM_MB_XD3_XDFFM_S r0 *1 0,0
Ccc_XD2_XDFFM_MB_XD3_XDFFM_S XD2_XDFFM_MB XD3_XDFFM_S 1.8151e-17
* device instance cc_XD2_XDFFM_MB_XD3_XDFFM_SB r0 *1 0,0
Ccc_XD2_XDFFM_MB_XD3_XDFFM_SB XD2_XDFFM_MB XD3_XDFFM_SB 1.8151e-17
* device instance cc_XD2_XDFFM_MB_XD3_XDFFQ_CLKB r0 *1 0,0
Ccc_XD2_XDFFM_MB_XD3_XDFFQ_CLKB XD2_XDFFM_MB XD3_XDFFQ_CLKB 1.8151e-17
* device instance cc_XD2_XDFFM_MB_XD3_XDFFQ_M r0 *1 0,0
Ccc_XD2_XDFFM_MB_XD3_XDFFQ_M XD2_XDFFM_MB XD3_XDFFQ_M 2.4201e-17
* device instance cc_XD2_XDFFM_MB_XD3_XDFFQ_MB r0 *1 0,0
Ccc_XD2_XDFFM_MB_XD3_XDFFQ_MB XD2_XDFFM_MB XD3_XDFFQ_MB 1.21e-17
* device instance cc_XD2_XDFFM_MB_XD3_XDFFQ_S r0 *1 0,0
Ccc_XD2_XDFFM_MB_XD3_XDFFQ_S XD2_XDFFM_MB XD3_XDFFQ_S 1.8151e-17
* device instance cc_XD2_XDFFM_MB_XD3_XDFFQ_SB r0 *1 0,0
Ccc_XD2_XDFFM_MB_XD3_XDFFQ_SB XD2_XDFFM_MB XD3_XDFFQ_SB 1.8151e-17
* device instance cc_XD2_XDFFM_MB_XD3_XN2_mid1 r0 *1 0,0
Ccc_XD2_XDFFM_MB_XD3_XN2_mid1 XD2_XDFFM_MB XD3_XN2_mid1 1.21e-17
* device instance cc_XD2_XDFFM_MB_XD3_XN3_mid1 r0 *1 0,0
Ccc_XD2_XDFFM_MB_XD3_XN3_mid1 XD2_XDFFM_MB XD3_XN3_mid1 1.21e-17
* device instance cc_XD2_XDFFM_MB_XD3_XN3_mid2 r0 *1 0,0
Ccc_XD2_XDFFM_MB_XD3_XN3_mid2 XD2_XDFFM_MB XD3_XN3_mid2 1.21e-17
* device instance cc_XD2_XDFFM_MB_XD3_dmodout r0 *1 0,0
Ccc_XD2_XDFFM_MB_XD3_dmodout XD2_XDFFM_MB XD3_dmodout 1.21e-17
* device instance cc_XD2_XDFFM_MB_XD3_dq r0 *1 0,0
Ccc_XD2_XDFFM_MB_XD3_dq XD2_XDFFM_MB XD3_dq 1.8151e-17
* device instance cc_XD2_XDFFM_MB_XD3_nm r0 *1 0,0
Ccc_XD2_XDFFM_MB_XD3_nm XD2_XDFFM_MB XD3_nm 1.21e-17
* device instance cc_XD2_XDFFM_MB_XD3_nt r0 *1 0,0
Ccc_XD2_XDFFM_MB_XD3_nt XD2_XDFFM_MB XD3_nt 1.21e-17
* device instance cc_XD2_XDFFM_MB_XD3_t1 r0 *1 0,0
Ccc_XD2_XDFFM_MB_XD3_t1 XD2_XDFFM_MB XD3_t1 1.21e-17
* device instance cc_XD2_XDFFM_MB_XD4_XDFFM_CLKB r0 *1 0,0
Ccc_XD2_XDFFM_MB_XD4_XDFFM_CLKB XD2_XDFFM_MB XD4_XDFFM_CLKB 1.8151e-17
* device instance cc_XD2_XDFFM_MB_XD4_XDFFM_M r0 *1 0,0
Ccc_XD2_XDFFM_MB_XD4_XDFFM_M XD2_XDFFM_MB XD4_XDFFM_M 2.4201e-17
* device instance cc_XD2_XDFFM_MB_XD4_XDFFM_MB r0 *1 0,0
Ccc_XD2_XDFFM_MB_XD4_XDFFM_MB XD2_XDFFM_MB XD4_XDFFM_MB 1.21e-17
* device instance cc_XD2_XDFFM_MB_XD4_XDFFM_S r0 *1 0,0
Ccc_XD2_XDFFM_MB_XD4_XDFFM_S XD2_XDFFM_MB XD4_XDFFM_S 1.8151e-17
* device instance cc_XD2_XDFFM_MB_XD4_XDFFM_SB r0 *1 0,0
Ccc_XD2_XDFFM_MB_XD4_XDFFM_SB XD2_XDFFM_MB XD4_XDFFM_SB 1.8151e-17
* device instance cc_XD2_XDFFM_MB_XD4_XDFFQ_CLKB r0 *1 0,0
Ccc_XD2_XDFFM_MB_XD4_XDFFQ_CLKB XD2_XDFFM_MB XD4_XDFFQ_CLKB 1.8151e-17
* device instance cc_XD2_XDFFM_MB_XD4_XDFFQ_M r0 *1 0,0
Ccc_XD2_XDFFM_MB_XD4_XDFFQ_M XD2_XDFFM_MB XD4_XDFFQ_M 2.4201e-17
* device instance cc_XD2_XDFFM_MB_XD4_XDFFQ_MB r0 *1 0,0
Ccc_XD2_XDFFM_MB_XD4_XDFFQ_MB XD2_XDFFM_MB XD4_XDFFQ_MB 1.21e-17
* device instance cc_XD2_XDFFM_MB_XD4_XDFFQ_S r0 *1 0,0
Ccc_XD2_XDFFM_MB_XD4_XDFFQ_S XD2_XDFFM_MB XD4_XDFFQ_S 1.8151e-17
* device instance cc_XD2_XDFFM_MB_XD4_XDFFQ_SB r0 *1 0,0
Ccc_XD2_XDFFM_MB_XD4_XDFFQ_SB XD2_XDFFM_MB XD4_XDFFQ_SB 1.8151e-17
* device instance cc_XD2_XDFFM_MB_XD4_XN2_mid1 r0 *1 0,0
Ccc_XD2_XDFFM_MB_XD4_XN2_mid1 XD2_XDFFM_MB XD4_XN2_mid1 1.21e-17
* device instance cc_XD2_XDFFM_MB_XD4_XN3_mid1 r0 *1 0,0
Ccc_XD2_XDFFM_MB_XD4_XN3_mid1 XD2_XDFFM_MB XD4_XN3_mid1 1.21e-17
* device instance cc_XD2_XDFFM_MB_XD4_XN3_mid2 r0 *1 0,0
Ccc_XD2_XDFFM_MB_XD4_XN3_mid2 XD2_XDFFM_MB XD4_XN3_mid2 1.21e-17
* device instance cc_XD2_XDFFM_MB_XD4_dmodout r0 *1 0,0
Ccc_XD2_XDFFM_MB_XD4_dmodout XD2_XDFFM_MB XD4_dmodout 1.21e-17
* device instance cc_XD2_XDFFM_MB_XD4_dq r0 *1 0,0
Ccc_XD2_XDFFM_MB_XD4_dq XD2_XDFFM_MB XD4_dq 1.8151e-17
* device instance cc_XD2_XDFFM_MB_XD4_nm r0 *1 0,0
Ccc_XD2_XDFFM_MB_XD4_nm XD2_XDFFM_MB XD4_nm 1.21e-17
* device instance cc_XD2_XDFFM_MB_XD4_nt r0 *1 0,0
Ccc_XD2_XDFFM_MB_XD4_nt XD2_XDFFM_MB XD4_nt 1.21e-17
* device instance cc_XD2_XDFFM_MB_XD4_t1 r0 *1 0,0
Ccc_XD2_XDFFM_MB_XD4_t1 XD2_XDFFM_MB XD4_t1 1.21e-17
* device instance cc_XD2_XDFFM_MB_XD5_XDFFM_CLKB r0 *1 0,0
Ccc_XD2_XDFFM_MB_XD5_XDFFM_CLKB XD2_XDFFM_MB XD5_XDFFM_CLKB 1.8151e-17
* device instance cc_XD2_XDFFM_MB_XD5_XDFFM_M r0 *1 0,0
Ccc_XD2_XDFFM_MB_XD5_XDFFM_M XD2_XDFFM_MB XD5_XDFFM_M 2.4201e-17
* device instance cc_XD2_XDFFM_MB_XD5_XDFFM_MB r0 *1 0,0
Ccc_XD2_XDFFM_MB_XD5_XDFFM_MB XD2_XDFFM_MB XD5_XDFFM_MB 1.21e-17
* device instance cc_XD2_XDFFM_MB_XD5_XDFFM_S r0 *1 0,0
Ccc_XD2_XDFFM_MB_XD5_XDFFM_S XD2_XDFFM_MB XD5_XDFFM_S 1.8151e-17
* device instance cc_XD2_XDFFM_MB_XD5_XDFFM_SB r0 *1 0,0
Ccc_XD2_XDFFM_MB_XD5_XDFFM_SB XD2_XDFFM_MB XD5_XDFFM_SB 1.8151e-17
* device instance cc_XD2_XDFFM_MB_XD5_XDFFQ_CLKB r0 *1 0,0
Ccc_XD2_XDFFM_MB_XD5_XDFFQ_CLKB XD2_XDFFM_MB XD5_XDFFQ_CLKB 1.8151e-17
* device instance cc_XD2_XDFFM_MB_XD5_XDFFQ_M r0 *1 0,0
Ccc_XD2_XDFFM_MB_XD5_XDFFQ_M XD2_XDFFM_MB XD5_XDFFQ_M 2.4201e-17
* device instance cc_XD2_XDFFM_MB_XD5_XDFFQ_MB r0 *1 0,0
Ccc_XD2_XDFFM_MB_XD5_XDFFQ_MB XD2_XDFFM_MB XD5_XDFFQ_MB 1.21e-17
* device instance cc_XD2_XDFFM_MB_XD5_XDFFQ_S r0 *1 0,0
Ccc_XD2_XDFFM_MB_XD5_XDFFQ_S XD2_XDFFM_MB XD5_XDFFQ_S 1.8151e-17
* device instance cc_XD2_XDFFM_MB_XD5_XDFFQ_SB r0 *1 0,0
Ccc_XD2_XDFFM_MB_XD5_XDFFQ_SB XD2_XDFFM_MB XD5_XDFFQ_SB 1.8151e-17
* device instance cc_XD2_XDFFM_MB_XD5_XN2_mid1 r0 *1 0,0
Ccc_XD2_XDFFM_MB_XD5_XN2_mid1 XD2_XDFFM_MB XD5_XN2_mid1 1.21e-17
* device instance cc_XD2_XDFFM_MB_XD5_XN3_mid1 r0 *1 0,0
Ccc_XD2_XDFFM_MB_XD5_XN3_mid1 XD2_XDFFM_MB XD5_XN3_mid1 1.21e-17
* device instance cc_XD2_XDFFM_MB_XD5_XN3_mid2 r0 *1 0,0
Ccc_XD2_XDFFM_MB_XD5_XN3_mid2 XD2_XDFFM_MB XD5_XN3_mid2 1.21e-17
* device instance cc_XD2_XDFFM_MB_XD5_dmodout r0 *1 0,0
Ccc_XD2_XDFFM_MB_XD5_dmodout XD2_XDFFM_MB XD5_dmodout 1.21e-17
* device instance cc_XD2_XDFFM_MB_XD5_dq r0 *1 0,0
Ccc_XD2_XDFFM_MB_XD5_dq XD2_XDFFM_MB XD5_dq 1.8151e-17
* device instance cc_XD2_XDFFM_MB_XD5_nm r0 *1 0,0
Ccc_XD2_XDFFM_MB_XD5_nm XD2_XDFFM_MB XD5_nm 1.21e-17
* device instance cc_XD2_XDFFM_MB_XD5_nt r0 *1 0,0
Ccc_XD2_XDFFM_MB_XD5_nt XD2_XDFFM_MB XD5_nt 1.21e-17
* device instance cc_XD2_XDFFM_MB_XD5_t1 r0 *1 0,0
Ccc_XD2_XDFFM_MB_XD5_t1 XD2_XDFFM_MB XD5_t1 1.21e-17
* device instance cc_XD2_XDFFM_MB_XFRT_CLKB r0 *1 0,0
Ccc_XD2_XDFFM_MB_XFRT_CLKB XD2_XDFFM_MB XFRT_CLKB 1.8151e-17
* device instance cc_XD2_XDFFM_MB_XFRT_M r0 *1 0,0
Ccc_XD2_XDFFM_MB_XFRT_M XD2_XDFFM_MB XFRT_M 2.4201e-17
* device instance cc_XD2_XDFFM_MB_XFRT_MB r0 *1 0,0
Ccc_XD2_XDFFM_MB_XFRT_MB XD2_XDFFM_MB XFRT_MB 1.21e-17
* device instance cc_XD2_XDFFM_MB_XFRT_S r0 *1 0,0
Ccc_XD2_XDFFM_MB_XFRT_S XD2_XDFFM_MB XFRT_S 1.8151e-17
* device instance cc_XD2_XDFFM_MB_XFRT_SB r0 *1 0,0
Ccc_XD2_XDFFM_MB_XFRT_SB XD2_XDFFM_MB XFRT_SB 1.8151e-17
* device instance cc_XD2_XDFFM_MB_ck1 r0 *1 0,0
Ccc_XD2_XDFFM_MB_ck1 XD2_XDFFM_MB ck1 5.4452e-17
* device instance cc_XD2_XDFFM_MB_ck2 r0 *1 0,0
Ccc_XD2_XDFFM_MB_ck2 XD2_XDFFM_MB ck2 6.0502e-17
* device instance cc_XD2_XDFFM_MB_ck3 r0 *1 0,0
Ccc_XD2_XDFFM_MB_ck3 XD2_XDFFM_MB ck3 5.4452e-17
* device instance cc_XD2_XDFFM_MB_ck4 r0 *1 0,0
Ccc_XD2_XDFFM_MB_ck4 XD2_XDFFM_MB ck4 5.4452e-17
* device instance cc_XD2_XDFFM_MB_ck5 r0 *1 0,0
Ccc_XD2_XDFFM_MB_ck5 XD2_XDFFM_MB ck5 5.4452e-17
* device instance cc_XD2_XDFFM_MB_mod0 r0 *1 0,0
Ccc_XD2_XDFFM_MB_mod0 XD2_XDFFM_MB mod0 2.4201e-17
* device instance cc_XD2_XDFFM_MB_mod1 r0 *1 0,0
Ccc_XD2_XDFFM_MB_mod1 XD2_XDFFM_MB mod1 2.4201e-17
* device instance cc_XD2_XDFFM_MB_mod2 r0 *1 0,0
Ccc_XD2_XDFFM_MB_mod2 XD2_XDFFM_MB mod2 2.4201e-17
* device instance cc_XD2_XDFFM_MB_mod3 r0 *1 0,0
Ccc_XD2_XDFFM_MB_mod3 XD2_XDFFM_MB mod3 2.4201e-17
* device instance cc_XD2_XDFFM_MB_mod4 r0 *1 0,0
Ccc_XD2_XDFFM_MB_mod4 XD2_XDFFM_MB mod4 2.4201e-17
* device instance cc_XD2_XDFFM_MB_net1 r0 *1 0,0
Ccc_XD2_XDFFM_MB_net1 XD2_XDFFM_MB net1 1.21e-17
* device instance cc_XD2_XDFFM_S_XD2_XDFFM_SB r0 *1 0,0
Ccc_XD2_XDFFM_S_XD2_XDFFM_SB XD2_XDFFM_S XD2_XDFFM_SB 4.0738e-17
* device instance cc_XD2_XDFFM_S_XD2_XDFFQ_CLKB r0 *1 0,0
Ccc_XD2_XDFFM_S_XD2_XDFFQ_CLKB XD2_XDFFM_S XD2_XDFFQ_CLKB 1.8151e-17
* device instance cc_XD2_XDFFM_S_XD2_XDFFQ_M r0 *1 0,0
Ccc_XD2_XDFFM_S_XD2_XDFFQ_M XD2_XDFFM_S XD2_XDFFQ_M 2.4201e-17
* device instance cc_XD2_XDFFM_S_XD2_XDFFQ_MB r0 *1 0,0
Ccc_XD2_XDFFM_S_XD2_XDFFQ_MB XD2_XDFFM_S XD2_XDFFQ_MB 1.21e-17
* device instance cc_XD2_XDFFM_S_XD2_XDFFQ_S r0 *1 0,0
Ccc_XD2_XDFFM_S_XD2_XDFFQ_S XD2_XDFFM_S XD2_XDFFQ_S 1.8151e-17
* device instance cc_XD2_XDFFM_S_XD2_XDFFQ_SB r0 *1 0,0
Ccc_XD2_XDFFM_S_XD2_XDFFQ_SB XD2_XDFFM_S XD2_XDFFQ_SB 1.8151e-17
* device instance cc_XD2_XDFFM_S_XD2_XNOR_midp r0 *1 0,0
Ccc_XD2_XDFFM_S_XD2_XNOR_midp XD2_XDFFM_S XD2_XNOR_midp 1.21e-17
* device instance cc_XD2_XDFFM_S_XD2_dmodout r0 *1 0,0
Ccc_XD2_XDFFM_S_XD2_dmodout XD2_XDFFM_S XD2_dmodout 1.21e-17
* device instance cc_XD2_XDFFM_S_XD2_dq r0 *1 0,0
Ccc_XD2_XDFFM_S_XD2_dq XD2_XDFFM_S XD2_dq 1.21e-17
* device instance cc_XD2_XDFFM_S_XD2_nm r0 *1 0,0
Ccc_XD2_XDFFM_S_XD2_nm XD2_XDFFM_S XD2_nm 1.8151e-17
* device instance cc_XD2_XDFFM_S_XD2_nt r0 *1 0,0
Ccc_XD2_XDFFM_S_XD2_nt XD2_XDFFM_S XD2_nt 2.4201e-17
* device instance cc_XD2_XDFFM_S_XD2_t1 r0 *1 0,0
Ccc_XD2_XDFFM_S_XD2_t1 XD2_XDFFM_S XD2_t1 1.21e-17
* device instance cc_XD2_XDFFM_S_XD3_XDFFM_CLKB r0 *1 0,0
Ccc_XD2_XDFFM_S_XD3_XDFFM_CLKB XD2_XDFFM_S XD3_XDFFM_CLKB 1.8151e-17
* device instance cc_XD2_XDFFM_S_XD3_XDFFM_M r0 *1 0,0
Ccc_XD2_XDFFM_S_XD3_XDFFM_M XD2_XDFFM_S XD3_XDFFM_M 2.4201e-17
* device instance cc_XD2_XDFFM_S_XD3_XDFFM_MB r0 *1 0,0
Ccc_XD2_XDFFM_S_XD3_XDFFM_MB XD2_XDFFM_S XD3_XDFFM_MB 1.21e-17
* device instance cc_XD2_XDFFM_S_XD3_XDFFM_S r0 *1 0,0
Ccc_XD2_XDFFM_S_XD3_XDFFM_S XD2_XDFFM_S XD3_XDFFM_S 1.8151e-17
* device instance cc_XD2_XDFFM_S_XD3_XDFFM_SB r0 *1 0,0
Ccc_XD2_XDFFM_S_XD3_XDFFM_SB XD2_XDFFM_S XD3_XDFFM_SB 1.8151e-17
* device instance cc_XD2_XDFFM_S_XD3_XDFFQ_CLKB r0 *1 0,0
Ccc_XD2_XDFFM_S_XD3_XDFFQ_CLKB XD2_XDFFM_S XD3_XDFFQ_CLKB 1.8151e-17
* device instance cc_XD2_XDFFM_S_XD3_XDFFQ_M r0 *1 0,0
Ccc_XD2_XDFFM_S_XD3_XDFFQ_M XD2_XDFFM_S XD3_XDFFQ_M 2.4201e-17
* device instance cc_XD2_XDFFM_S_XD3_XDFFQ_MB r0 *1 0,0
Ccc_XD2_XDFFM_S_XD3_XDFFQ_MB XD2_XDFFM_S XD3_XDFFQ_MB 1.21e-17
* device instance cc_XD2_XDFFM_S_XD3_XDFFQ_S r0 *1 0,0
Ccc_XD2_XDFFM_S_XD3_XDFFQ_S XD2_XDFFM_S XD3_XDFFQ_S 1.8151e-17
* device instance cc_XD2_XDFFM_S_XD3_XDFFQ_SB r0 *1 0,0
Ccc_XD2_XDFFM_S_XD3_XDFFQ_SB XD2_XDFFM_S XD3_XDFFQ_SB 1.8151e-17
* device instance cc_XD2_XDFFM_S_XD3_XN2_mid1 r0 *1 0,0
Ccc_XD2_XDFFM_S_XD3_XN2_mid1 XD2_XDFFM_S XD3_XN2_mid1 1.21e-17
* device instance cc_XD2_XDFFM_S_XD3_XN3_mid1 r0 *1 0,0
Ccc_XD2_XDFFM_S_XD3_XN3_mid1 XD2_XDFFM_S XD3_XN3_mid1 1.21e-17
* device instance cc_XD2_XDFFM_S_XD3_XN3_mid2 r0 *1 0,0
Ccc_XD2_XDFFM_S_XD3_XN3_mid2 XD2_XDFFM_S XD3_XN3_mid2 1.21e-17
* device instance cc_XD2_XDFFM_S_XD3_dmodout r0 *1 0,0
Ccc_XD2_XDFFM_S_XD3_dmodout XD2_XDFFM_S XD3_dmodout 1.21e-17
* device instance cc_XD2_XDFFM_S_XD3_dq r0 *1 0,0
Ccc_XD2_XDFFM_S_XD3_dq XD2_XDFFM_S XD3_dq 1.8151e-17
* device instance cc_XD2_XDFFM_S_XD3_nm r0 *1 0,0
Ccc_XD2_XDFFM_S_XD3_nm XD2_XDFFM_S XD3_nm 1.21e-17
* device instance cc_XD2_XDFFM_S_XD3_nt r0 *1 0,0
Ccc_XD2_XDFFM_S_XD3_nt XD2_XDFFM_S XD3_nt 1.21e-17
* device instance cc_XD2_XDFFM_S_XD3_t1 r0 *1 0,0
Ccc_XD2_XDFFM_S_XD3_t1 XD2_XDFFM_S XD3_t1 1.21e-17
* device instance cc_XD2_XDFFM_S_XD4_XDFFM_CLKB r0 *1 0,0
Ccc_XD2_XDFFM_S_XD4_XDFFM_CLKB XD2_XDFFM_S XD4_XDFFM_CLKB 1.8151e-17
* device instance cc_XD2_XDFFM_S_XD4_XDFFM_M r0 *1 0,0
Ccc_XD2_XDFFM_S_XD4_XDFFM_M XD2_XDFFM_S XD4_XDFFM_M 2.4201e-17
* device instance cc_XD2_XDFFM_S_XD4_XDFFM_MB r0 *1 0,0
Ccc_XD2_XDFFM_S_XD4_XDFFM_MB XD2_XDFFM_S XD4_XDFFM_MB 1.21e-17
* device instance cc_XD2_XDFFM_S_XD4_XDFFM_S r0 *1 0,0
Ccc_XD2_XDFFM_S_XD4_XDFFM_S XD2_XDFFM_S XD4_XDFFM_S 1.8151e-17
* device instance cc_XD2_XDFFM_S_XD4_XDFFM_SB r0 *1 0,0
Ccc_XD2_XDFFM_S_XD4_XDFFM_SB XD2_XDFFM_S XD4_XDFFM_SB 1.8151e-17
* device instance cc_XD2_XDFFM_S_XD4_XDFFQ_CLKB r0 *1 0,0
Ccc_XD2_XDFFM_S_XD4_XDFFQ_CLKB XD2_XDFFM_S XD4_XDFFQ_CLKB 1.8151e-17
* device instance cc_XD2_XDFFM_S_XD4_XDFFQ_M r0 *1 0,0
Ccc_XD2_XDFFM_S_XD4_XDFFQ_M XD2_XDFFM_S XD4_XDFFQ_M 2.4201e-17
* device instance cc_XD2_XDFFM_S_XD4_XDFFQ_MB r0 *1 0,0
Ccc_XD2_XDFFM_S_XD4_XDFFQ_MB XD2_XDFFM_S XD4_XDFFQ_MB 1.21e-17
* device instance cc_XD2_XDFFM_S_XD4_XDFFQ_S r0 *1 0,0
Ccc_XD2_XDFFM_S_XD4_XDFFQ_S XD2_XDFFM_S XD4_XDFFQ_S 1.8151e-17
* device instance cc_XD2_XDFFM_S_XD4_XDFFQ_SB r0 *1 0,0
Ccc_XD2_XDFFM_S_XD4_XDFFQ_SB XD2_XDFFM_S XD4_XDFFQ_SB 1.8151e-17
* device instance cc_XD2_XDFFM_S_XD4_XN2_mid1 r0 *1 0,0
Ccc_XD2_XDFFM_S_XD4_XN2_mid1 XD2_XDFFM_S XD4_XN2_mid1 1.21e-17
* device instance cc_XD2_XDFFM_S_XD4_XN3_mid1 r0 *1 0,0
Ccc_XD2_XDFFM_S_XD4_XN3_mid1 XD2_XDFFM_S XD4_XN3_mid1 1.21e-17
* device instance cc_XD2_XDFFM_S_XD4_XN3_mid2 r0 *1 0,0
Ccc_XD2_XDFFM_S_XD4_XN3_mid2 XD2_XDFFM_S XD4_XN3_mid2 1.21e-17
* device instance cc_XD2_XDFFM_S_XD4_dmodout r0 *1 0,0
Ccc_XD2_XDFFM_S_XD4_dmodout XD2_XDFFM_S XD4_dmodout 1.21e-17
* device instance cc_XD2_XDFFM_S_XD4_dq r0 *1 0,0
Ccc_XD2_XDFFM_S_XD4_dq XD2_XDFFM_S XD4_dq 1.8151e-17
* device instance cc_XD2_XDFFM_S_XD4_nm r0 *1 0,0
Ccc_XD2_XDFFM_S_XD4_nm XD2_XDFFM_S XD4_nm 1.21e-17
* device instance cc_XD2_XDFFM_S_XD4_nt r0 *1 0,0
Ccc_XD2_XDFFM_S_XD4_nt XD2_XDFFM_S XD4_nt 1.21e-17
* device instance cc_XD2_XDFFM_S_XD4_t1 r0 *1 0,0
Ccc_XD2_XDFFM_S_XD4_t1 XD2_XDFFM_S XD4_t1 1.21e-17
* device instance cc_XD2_XDFFM_S_XD5_XDFFM_CLKB r0 *1 0,0
Ccc_XD2_XDFFM_S_XD5_XDFFM_CLKB XD2_XDFFM_S XD5_XDFFM_CLKB 1.8151e-17
* device instance cc_XD2_XDFFM_S_XD5_XDFFM_M r0 *1 0,0
Ccc_XD2_XDFFM_S_XD5_XDFFM_M XD2_XDFFM_S XD5_XDFFM_M 2.4201e-17
* device instance cc_XD2_XDFFM_S_XD5_XDFFM_MB r0 *1 0,0
Ccc_XD2_XDFFM_S_XD5_XDFFM_MB XD2_XDFFM_S XD5_XDFFM_MB 1.21e-17
* device instance cc_XD2_XDFFM_S_XD5_XDFFM_S r0 *1 0,0
Ccc_XD2_XDFFM_S_XD5_XDFFM_S XD2_XDFFM_S XD5_XDFFM_S 1.8151e-17
* device instance cc_XD2_XDFFM_S_XD5_XDFFM_SB r0 *1 0,0
Ccc_XD2_XDFFM_S_XD5_XDFFM_SB XD2_XDFFM_S XD5_XDFFM_SB 1.8151e-17
* device instance cc_XD2_XDFFM_S_XD5_XDFFQ_CLKB r0 *1 0,0
Ccc_XD2_XDFFM_S_XD5_XDFFQ_CLKB XD2_XDFFM_S XD5_XDFFQ_CLKB 1.8151e-17
* device instance cc_XD2_XDFFM_S_XD5_XDFFQ_M r0 *1 0,0
Ccc_XD2_XDFFM_S_XD5_XDFFQ_M XD2_XDFFM_S XD5_XDFFQ_M 2.4201e-17
* device instance cc_XD2_XDFFM_S_XD5_XDFFQ_MB r0 *1 0,0
Ccc_XD2_XDFFM_S_XD5_XDFFQ_MB XD2_XDFFM_S XD5_XDFFQ_MB 1.21e-17
* device instance cc_XD2_XDFFM_S_XD5_XDFFQ_S r0 *1 0,0
Ccc_XD2_XDFFM_S_XD5_XDFFQ_S XD2_XDFFM_S XD5_XDFFQ_S 1.8151e-17
* device instance cc_XD2_XDFFM_S_XD5_XDFFQ_SB r0 *1 0,0
Ccc_XD2_XDFFM_S_XD5_XDFFQ_SB XD2_XDFFM_S XD5_XDFFQ_SB 1.8151e-17
* device instance cc_XD2_XDFFM_S_XD5_XN2_mid1 r0 *1 0,0
Ccc_XD2_XDFFM_S_XD5_XN2_mid1 XD2_XDFFM_S XD5_XN2_mid1 1.21e-17
* device instance cc_XD2_XDFFM_S_XD5_XN3_mid1 r0 *1 0,0
Ccc_XD2_XDFFM_S_XD5_XN3_mid1 XD2_XDFFM_S XD5_XN3_mid1 1.21e-17
* device instance cc_XD2_XDFFM_S_XD5_XN3_mid2 r0 *1 0,0
Ccc_XD2_XDFFM_S_XD5_XN3_mid2 XD2_XDFFM_S XD5_XN3_mid2 1.21e-17
* device instance cc_XD2_XDFFM_S_XD5_dmodout r0 *1 0,0
Ccc_XD2_XDFFM_S_XD5_dmodout XD2_XDFFM_S XD5_dmodout 1.21e-17
* device instance cc_XD2_XDFFM_S_XD5_dq r0 *1 0,0
Ccc_XD2_XDFFM_S_XD5_dq XD2_XDFFM_S XD5_dq 1.8151e-17
* device instance cc_XD2_XDFFM_S_XD5_nm r0 *1 0,0
Ccc_XD2_XDFFM_S_XD5_nm XD2_XDFFM_S XD5_nm 1.21e-17
* device instance cc_XD2_XDFFM_S_XD5_nt r0 *1 0,0
Ccc_XD2_XDFFM_S_XD5_nt XD2_XDFFM_S XD5_nt 1.21e-17
* device instance cc_XD2_XDFFM_S_XD5_t1 r0 *1 0,0
Ccc_XD2_XDFFM_S_XD5_t1 XD2_XDFFM_S XD5_t1 1.21e-17
* device instance cc_XD2_XDFFM_S_XFRT_CLKB r0 *1 0,0
Ccc_XD2_XDFFM_S_XFRT_CLKB XD2_XDFFM_S XFRT_CLKB 1.8151e-17
* device instance cc_XD2_XDFFM_S_XFRT_M r0 *1 0,0
Ccc_XD2_XDFFM_S_XFRT_M XD2_XDFFM_S XFRT_M 2.4201e-17
* device instance cc_XD2_XDFFM_S_XFRT_MB r0 *1 0,0
Ccc_XD2_XDFFM_S_XFRT_MB XD2_XDFFM_S XFRT_MB 1.21e-17
* device instance cc_XD2_XDFFM_S_XFRT_S r0 *1 0,0
Ccc_XD2_XDFFM_S_XFRT_S XD2_XDFFM_S XFRT_S 1.8151e-17
* device instance cc_XD2_XDFFM_S_XFRT_SB r0 *1 0,0
Ccc_XD2_XDFFM_S_XFRT_SB XD2_XDFFM_S XFRT_SB 1.8151e-17
* device instance cc_XD2_XDFFM_S_ck1 r0 *1 0,0
Ccc_XD2_XDFFM_S_ck1 XD2_XDFFM_S ck1 5.4452e-17
* device instance cc_XD2_XDFFM_S_ck2 r0 *1 0,0
Ccc_XD2_XDFFM_S_ck2 XD2_XDFFM_S ck2 5.4452e-17
* device instance cc_XD2_XDFFM_S_ck3 r0 *1 0,0
Ccc_XD2_XDFFM_S_ck3 XD2_XDFFM_S ck3 5.4452e-17
* device instance cc_XD2_XDFFM_S_ck4 r0 *1 0,0
Ccc_XD2_XDFFM_S_ck4 XD2_XDFFM_S ck4 5.4452e-17
* device instance cc_XD2_XDFFM_S_ck5 r0 *1 0,0
Ccc_XD2_XDFFM_S_ck5 XD2_XDFFM_S ck5 5.4452e-17
* device instance cc_XD2_XDFFM_S_mod0 r0 *1 0,0
Ccc_XD2_XDFFM_S_mod0 XD2_XDFFM_S mod0 2.4201e-17
* device instance cc_XD2_XDFFM_S_mod1 r0 *1 0,0
Ccc_XD2_XDFFM_S_mod1 XD2_XDFFM_S mod1 2.4201e-17
* device instance cc_XD2_XDFFM_S_mod2 r0 *1 0,0
Ccc_XD2_XDFFM_S_mod2 XD2_XDFFM_S mod2 2.4201e-17
* device instance cc_XD2_XDFFM_S_mod3 r0 *1 0,0
Ccc_XD2_XDFFM_S_mod3 XD2_XDFFM_S mod3 2.4201e-17
* device instance cc_XD2_XDFFM_S_mod4 r0 *1 0,0
Ccc_XD2_XDFFM_S_mod4 XD2_XDFFM_S mod4 2.4201e-17
* device instance cc_XD2_XDFFM_S_net1 r0 *1 0,0
Ccc_XD2_XDFFM_S_net1 XD2_XDFFM_S net1 1.21e-17
* device instance cc_XD2_XDFFM_SB_XD2_XDFFQ_CLKB r0 *1 0,0
Ccc_XD2_XDFFM_SB_XD2_XDFFQ_CLKB XD2_XDFFM_SB XD2_XDFFQ_CLKB 1.8151e-17
* device instance cc_XD2_XDFFM_SB_XD2_XDFFQ_M r0 *1 0,0
Ccc_XD2_XDFFM_SB_XD2_XDFFQ_M XD2_XDFFM_SB XD2_XDFFQ_M 2.4201e-17
* device instance cc_XD2_XDFFM_SB_XD2_XDFFQ_MB r0 *1 0,0
Ccc_XD2_XDFFM_SB_XD2_XDFFQ_MB XD2_XDFFM_SB XD2_XDFFQ_MB 1.21e-17
* device instance cc_XD2_XDFFM_SB_XD2_XDFFQ_S r0 *1 0,0
Ccc_XD2_XDFFM_SB_XD2_XDFFQ_S XD2_XDFFM_SB XD2_XDFFQ_S 1.8151e-17
* device instance cc_XD2_XDFFM_SB_XD2_XDFFQ_SB r0 *1 0,0
Ccc_XD2_XDFFM_SB_XD2_XDFFQ_SB XD2_XDFFM_SB XD2_XDFFQ_SB 1.8151e-17
* device instance cc_XD2_XDFFM_SB_XD2_XNOR_midp r0 *1 0,0
Ccc_XD2_XDFFM_SB_XD2_XNOR_midp XD2_XDFFM_SB XD2_XNOR_midp 1.21e-17
* device instance cc_XD2_XDFFM_SB_XD2_dmodout r0 *1 0,0
Ccc_XD2_XDFFM_SB_XD2_dmodout XD2_XDFFM_SB XD2_dmodout 1.21e-17
* device instance cc_XD2_XDFFM_SB_XD2_dq r0 *1 0,0
Ccc_XD2_XDFFM_SB_XD2_dq XD2_XDFFM_SB XD2_dq 1.21e-17
* device instance cc_XD2_XDFFM_SB_XD2_nm r0 *1 0,0
Ccc_XD2_XDFFM_SB_XD2_nm XD2_XDFFM_SB XD2_nm 1.8151e-17
* device instance cc_XD2_XDFFM_SB_XD2_nt r0 *1 0,0
Ccc_XD2_XDFFM_SB_XD2_nt XD2_XDFFM_SB XD2_nt 2.4201e-17
* device instance cc_XD2_XDFFM_SB_XD2_t1 r0 *1 0,0
Ccc_XD2_XDFFM_SB_XD2_t1 XD2_XDFFM_SB XD2_t1 1.21e-17
* device instance cc_XD2_XDFFM_SB_XD3_XDFFM_CLKB r0 *1 0,0
Ccc_XD2_XDFFM_SB_XD3_XDFFM_CLKB XD2_XDFFM_SB XD3_XDFFM_CLKB 1.8151e-17
* device instance cc_XD2_XDFFM_SB_XD3_XDFFM_M r0 *1 0,0
Ccc_XD2_XDFFM_SB_XD3_XDFFM_M XD2_XDFFM_SB XD3_XDFFM_M 2.4201e-17
* device instance cc_XD2_XDFFM_SB_XD3_XDFFM_MB r0 *1 0,0
Ccc_XD2_XDFFM_SB_XD3_XDFFM_MB XD2_XDFFM_SB XD3_XDFFM_MB 1.21e-17
* device instance cc_XD2_XDFFM_SB_XD3_XDFFM_S r0 *1 0,0
Ccc_XD2_XDFFM_SB_XD3_XDFFM_S XD2_XDFFM_SB XD3_XDFFM_S 1.8151e-17
* device instance cc_XD2_XDFFM_SB_XD3_XDFFM_SB r0 *1 0,0
Ccc_XD2_XDFFM_SB_XD3_XDFFM_SB XD2_XDFFM_SB XD3_XDFFM_SB 1.8151e-17
* device instance cc_XD2_XDFFM_SB_XD3_XDFFQ_CLKB r0 *1 0,0
Ccc_XD2_XDFFM_SB_XD3_XDFFQ_CLKB XD2_XDFFM_SB XD3_XDFFQ_CLKB 1.8151e-17
* device instance cc_XD2_XDFFM_SB_XD3_XDFFQ_M r0 *1 0,0
Ccc_XD2_XDFFM_SB_XD3_XDFFQ_M XD2_XDFFM_SB XD3_XDFFQ_M 2.4201e-17
* device instance cc_XD2_XDFFM_SB_XD3_XDFFQ_MB r0 *1 0,0
Ccc_XD2_XDFFM_SB_XD3_XDFFQ_MB XD2_XDFFM_SB XD3_XDFFQ_MB 1.21e-17
* device instance cc_XD2_XDFFM_SB_XD3_XDFFQ_S r0 *1 0,0
Ccc_XD2_XDFFM_SB_XD3_XDFFQ_S XD2_XDFFM_SB XD3_XDFFQ_S 1.8151e-17
* device instance cc_XD2_XDFFM_SB_XD3_XDFFQ_SB r0 *1 0,0
Ccc_XD2_XDFFM_SB_XD3_XDFFQ_SB XD2_XDFFM_SB XD3_XDFFQ_SB 1.8151e-17
* device instance cc_XD2_XDFFM_SB_XD3_XN2_mid1 r0 *1 0,0
Ccc_XD2_XDFFM_SB_XD3_XN2_mid1 XD2_XDFFM_SB XD3_XN2_mid1 1.21e-17
* device instance cc_XD2_XDFFM_SB_XD3_XN3_mid1 r0 *1 0,0
Ccc_XD2_XDFFM_SB_XD3_XN3_mid1 XD2_XDFFM_SB XD3_XN3_mid1 1.21e-17
* device instance cc_XD2_XDFFM_SB_XD3_XN3_mid2 r0 *1 0,0
Ccc_XD2_XDFFM_SB_XD3_XN3_mid2 XD2_XDFFM_SB XD3_XN3_mid2 1.21e-17
* device instance cc_XD2_XDFFM_SB_XD3_dmodout r0 *1 0,0
Ccc_XD2_XDFFM_SB_XD3_dmodout XD2_XDFFM_SB XD3_dmodout 1.21e-17
* device instance cc_XD2_XDFFM_SB_XD3_dq r0 *1 0,0
Ccc_XD2_XDFFM_SB_XD3_dq XD2_XDFFM_SB XD3_dq 1.8151e-17
* device instance cc_XD2_XDFFM_SB_XD3_nm r0 *1 0,0
Ccc_XD2_XDFFM_SB_XD3_nm XD2_XDFFM_SB XD3_nm 1.21e-17
* device instance cc_XD2_XDFFM_SB_XD3_nt r0 *1 0,0
Ccc_XD2_XDFFM_SB_XD3_nt XD2_XDFFM_SB XD3_nt 1.21e-17
* device instance cc_XD2_XDFFM_SB_XD3_t1 r0 *1 0,0
Ccc_XD2_XDFFM_SB_XD3_t1 XD2_XDFFM_SB XD3_t1 1.21e-17
* device instance cc_XD2_XDFFM_SB_XD4_XDFFM_CLKB r0 *1 0,0
Ccc_XD2_XDFFM_SB_XD4_XDFFM_CLKB XD2_XDFFM_SB XD4_XDFFM_CLKB 1.8151e-17
* device instance cc_XD2_XDFFM_SB_XD4_XDFFM_M r0 *1 0,0
Ccc_XD2_XDFFM_SB_XD4_XDFFM_M XD2_XDFFM_SB XD4_XDFFM_M 2.4201e-17
* device instance cc_XD2_XDFFM_SB_XD4_XDFFM_MB r0 *1 0,0
Ccc_XD2_XDFFM_SB_XD4_XDFFM_MB XD2_XDFFM_SB XD4_XDFFM_MB 1.21e-17
* device instance cc_XD2_XDFFM_SB_XD4_XDFFM_S r0 *1 0,0
Ccc_XD2_XDFFM_SB_XD4_XDFFM_S XD2_XDFFM_SB XD4_XDFFM_S 1.8151e-17
* device instance cc_XD2_XDFFM_SB_XD4_XDFFM_SB r0 *1 0,0
Ccc_XD2_XDFFM_SB_XD4_XDFFM_SB XD2_XDFFM_SB XD4_XDFFM_SB 1.8151e-17
* device instance cc_XD2_XDFFM_SB_XD4_XDFFQ_CLKB r0 *1 0,0
Ccc_XD2_XDFFM_SB_XD4_XDFFQ_CLKB XD2_XDFFM_SB XD4_XDFFQ_CLKB 1.8151e-17
* device instance cc_XD2_XDFFM_SB_XD4_XDFFQ_M r0 *1 0,0
Ccc_XD2_XDFFM_SB_XD4_XDFFQ_M XD2_XDFFM_SB XD4_XDFFQ_M 2.4201e-17
* device instance cc_XD2_XDFFM_SB_XD4_XDFFQ_MB r0 *1 0,0
Ccc_XD2_XDFFM_SB_XD4_XDFFQ_MB XD2_XDFFM_SB XD4_XDFFQ_MB 1.21e-17
* device instance cc_XD2_XDFFM_SB_XD4_XDFFQ_S r0 *1 0,0
Ccc_XD2_XDFFM_SB_XD4_XDFFQ_S XD2_XDFFM_SB XD4_XDFFQ_S 1.8151e-17
* device instance cc_XD2_XDFFM_SB_XD4_XDFFQ_SB r0 *1 0,0
Ccc_XD2_XDFFM_SB_XD4_XDFFQ_SB XD2_XDFFM_SB XD4_XDFFQ_SB 1.8151e-17
* device instance cc_XD2_XDFFM_SB_XD4_XN2_mid1 r0 *1 0,0
Ccc_XD2_XDFFM_SB_XD4_XN2_mid1 XD2_XDFFM_SB XD4_XN2_mid1 1.21e-17
* device instance cc_XD2_XDFFM_SB_XD4_XN3_mid1 r0 *1 0,0
Ccc_XD2_XDFFM_SB_XD4_XN3_mid1 XD2_XDFFM_SB XD4_XN3_mid1 1.21e-17
* device instance cc_XD2_XDFFM_SB_XD4_XN3_mid2 r0 *1 0,0
Ccc_XD2_XDFFM_SB_XD4_XN3_mid2 XD2_XDFFM_SB XD4_XN3_mid2 1.21e-17
* device instance cc_XD2_XDFFM_SB_XD4_dmodout r0 *1 0,0
Ccc_XD2_XDFFM_SB_XD4_dmodout XD2_XDFFM_SB XD4_dmodout 1.21e-17
* device instance cc_XD2_XDFFM_SB_XD4_dq r0 *1 0,0
Ccc_XD2_XDFFM_SB_XD4_dq XD2_XDFFM_SB XD4_dq 1.8151e-17
* device instance cc_XD2_XDFFM_SB_XD4_nm r0 *1 0,0
Ccc_XD2_XDFFM_SB_XD4_nm XD2_XDFFM_SB XD4_nm 1.21e-17
* device instance cc_XD2_XDFFM_SB_XD4_nt r0 *1 0,0
Ccc_XD2_XDFFM_SB_XD4_nt XD2_XDFFM_SB XD4_nt 1.21e-17
* device instance cc_XD2_XDFFM_SB_XD4_t1 r0 *1 0,0
Ccc_XD2_XDFFM_SB_XD4_t1 XD2_XDFFM_SB XD4_t1 1.21e-17
* device instance cc_XD2_XDFFM_SB_XD5_XDFFM_CLKB r0 *1 0,0
Ccc_XD2_XDFFM_SB_XD5_XDFFM_CLKB XD2_XDFFM_SB XD5_XDFFM_CLKB 1.8151e-17
* device instance cc_XD2_XDFFM_SB_XD5_XDFFM_M r0 *1 0,0
Ccc_XD2_XDFFM_SB_XD5_XDFFM_M XD2_XDFFM_SB XD5_XDFFM_M 2.4201e-17
* device instance cc_XD2_XDFFM_SB_XD5_XDFFM_MB r0 *1 0,0
Ccc_XD2_XDFFM_SB_XD5_XDFFM_MB XD2_XDFFM_SB XD5_XDFFM_MB 1.21e-17
* device instance cc_XD2_XDFFM_SB_XD5_XDFFM_S r0 *1 0,0
Ccc_XD2_XDFFM_SB_XD5_XDFFM_S XD2_XDFFM_SB XD5_XDFFM_S 1.8151e-17
* device instance cc_XD2_XDFFM_SB_XD5_XDFFM_SB r0 *1 0,0
Ccc_XD2_XDFFM_SB_XD5_XDFFM_SB XD2_XDFFM_SB XD5_XDFFM_SB 1.8151e-17
* device instance cc_XD2_XDFFM_SB_XD5_XDFFQ_CLKB r0 *1 0,0
Ccc_XD2_XDFFM_SB_XD5_XDFFQ_CLKB XD2_XDFFM_SB XD5_XDFFQ_CLKB 1.8151e-17
* device instance cc_XD2_XDFFM_SB_XD5_XDFFQ_M r0 *1 0,0
Ccc_XD2_XDFFM_SB_XD5_XDFFQ_M XD2_XDFFM_SB XD5_XDFFQ_M 2.4201e-17
* device instance cc_XD2_XDFFM_SB_XD5_XDFFQ_MB r0 *1 0,0
Ccc_XD2_XDFFM_SB_XD5_XDFFQ_MB XD2_XDFFM_SB XD5_XDFFQ_MB 1.21e-17
* device instance cc_XD2_XDFFM_SB_XD5_XDFFQ_S r0 *1 0,0
Ccc_XD2_XDFFM_SB_XD5_XDFFQ_S XD2_XDFFM_SB XD5_XDFFQ_S 1.8151e-17
* device instance cc_XD2_XDFFM_SB_XD5_XDFFQ_SB r0 *1 0,0
Ccc_XD2_XDFFM_SB_XD5_XDFFQ_SB XD2_XDFFM_SB XD5_XDFFQ_SB 1.8151e-17
* device instance cc_XD2_XDFFM_SB_XD5_XN2_mid1 r0 *1 0,0
Ccc_XD2_XDFFM_SB_XD5_XN2_mid1 XD2_XDFFM_SB XD5_XN2_mid1 1.21e-17
* device instance cc_XD2_XDFFM_SB_XD5_XN3_mid1 r0 *1 0,0
Ccc_XD2_XDFFM_SB_XD5_XN3_mid1 XD2_XDFFM_SB XD5_XN3_mid1 1.21e-17
* device instance cc_XD2_XDFFM_SB_XD5_XN3_mid2 r0 *1 0,0
Ccc_XD2_XDFFM_SB_XD5_XN3_mid2 XD2_XDFFM_SB XD5_XN3_mid2 1.21e-17
* device instance cc_XD2_XDFFM_SB_XD5_dmodout r0 *1 0,0
Ccc_XD2_XDFFM_SB_XD5_dmodout XD2_XDFFM_SB XD5_dmodout 1.21e-17
* device instance cc_XD2_XDFFM_SB_XD5_dq r0 *1 0,0
Ccc_XD2_XDFFM_SB_XD5_dq XD2_XDFFM_SB XD5_dq 1.8151e-17
* device instance cc_XD2_XDFFM_SB_XD5_nm r0 *1 0,0
Ccc_XD2_XDFFM_SB_XD5_nm XD2_XDFFM_SB XD5_nm 1.21e-17
* device instance cc_XD2_XDFFM_SB_XD5_nt r0 *1 0,0
Ccc_XD2_XDFFM_SB_XD5_nt XD2_XDFFM_SB XD5_nt 1.21e-17
* device instance cc_XD2_XDFFM_SB_XD5_t1 r0 *1 0,0
Ccc_XD2_XDFFM_SB_XD5_t1 XD2_XDFFM_SB XD5_t1 1.21e-17
* device instance cc_XD2_XDFFM_SB_XFRT_CLKB r0 *1 0,0
Ccc_XD2_XDFFM_SB_XFRT_CLKB XD2_XDFFM_SB XFRT_CLKB 1.8151e-17
* device instance cc_XD2_XDFFM_SB_XFRT_M r0 *1 0,0
Ccc_XD2_XDFFM_SB_XFRT_M XD2_XDFFM_SB XFRT_M 2.4201e-17
* device instance cc_XD2_XDFFM_SB_XFRT_MB r0 *1 0,0
Ccc_XD2_XDFFM_SB_XFRT_MB XD2_XDFFM_SB XFRT_MB 1.21e-17
* device instance cc_XD2_XDFFM_SB_XFRT_S r0 *1 0,0
Ccc_XD2_XDFFM_SB_XFRT_S XD2_XDFFM_SB XFRT_S 1.8151e-17
* device instance cc_XD2_XDFFM_SB_XFRT_SB r0 *1 0,0
Ccc_XD2_XDFFM_SB_XFRT_SB XD2_XDFFM_SB XFRT_SB 1.8151e-17
* device instance cc_XD2_XDFFM_SB_ck1 r0 *1 0,0
Ccc_XD2_XDFFM_SB_ck1 XD2_XDFFM_SB ck1 5.4452e-17
* device instance cc_XD2_XDFFM_SB_ck2 r0 *1 0,0
Ccc_XD2_XDFFM_SB_ck2 XD2_XDFFM_SB ck2 5.4452e-17
* device instance cc_XD2_XDFFM_SB_ck3 r0 *1 0,0
Ccc_XD2_XDFFM_SB_ck3 XD2_XDFFM_SB ck3 5.4452e-17
* device instance cc_XD2_XDFFM_SB_ck4 r0 *1 0,0
Ccc_XD2_XDFFM_SB_ck4 XD2_XDFFM_SB ck4 5.4452e-17
* device instance cc_XD2_XDFFM_SB_ck5 r0 *1 0,0
Ccc_XD2_XDFFM_SB_ck5 XD2_XDFFM_SB ck5 5.4452e-17
* device instance cc_XD2_XDFFM_SB_mod0 r0 *1 0,0
Ccc_XD2_XDFFM_SB_mod0 XD2_XDFFM_SB mod0 2.4201e-17
* device instance cc_XD2_XDFFM_SB_mod1 r0 *1 0,0
Ccc_XD2_XDFFM_SB_mod1 XD2_XDFFM_SB mod1 2.4201e-17
* device instance cc_XD2_XDFFM_SB_mod2 r0 *1 0,0
Ccc_XD2_XDFFM_SB_mod2 XD2_XDFFM_SB mod2 2.4201e-17
* device instance cc_XD2_XDFFM_SB_mod3 r0 *1 0,0
Ccc_XD2_XDFFM_SB_mod3 XD2_XDFFM_SB mod3 2.4201e-17
* device instance cc_XD2_XDFFM_SB_mod4 r0 *1 0,0
Ccc_XD2_XDFFM_SB_mod4 XD2_XDFFM_SB mod4 2.4201e-17
* device instance cc_XD2_XDFFM_SB_net1 r0 *1 0,0
Ccc_XD2_XDFFM_SB_net1 XD2_XDFFM_SB net1 1.21e-17
* device instance cc_XD2_XDFFQ_CLKB_XD2_XDFFQ_M r0 *1 0,0
Ccc_XD2_XDFFQ_CLKB_XD2_XDFFQ_M XD2_XDFFQ_CLKB XD2_XDFFQ_M 4.2352e-17
* device instance cc_XD2_XDFFQ_CLKB_XD2_XDFFQ_MB r0 *1 0,0
Ccc_XD2_XDFFQ_CLKB_XD2_XDFFQ_MB XD2_XDFFQ_CLKB XD2_XDFFQ_MB 2.4201e-17
* device instance cc_XD2_XDFFQ_CLKB_XD2_XDFFQ_S r0 *1 0,0
Ccc_XD2_XDFFQ_CLKB_XD2_XDFFQ_S XD2_XDFFQ_CLKB XD2_XDFFQ_S 1.8151e-17
* device instance cc_XD2_XDFFQ_CLKB_XD2_XDFFQ_SB r0 *1 0,0
Ccc_XD2_XDFFQ_CLKB_XD2_XDFFQ_SB XD2_XDFFQ_CLKB XD2_XDFFQ_SB 1.8151e-17
* device instance cc_XD2_XDFFQ_CLKB_XD2_XN2_mid1 r0 *1 0,0
Ccc_XD2_XDFFQ_CLKB_XD2_XN2_mid1 XD2_XDFFQ_CLKB XD2_XN2_mid1 1.21e-17
* device instance cc_XD2_XDFFQ_CLKB_XD2_XNOR_midp r0 *1 0,0
Ccc_XD2_XDFFQ_CLKB_XD2_XNOR_midp XD2_XDFFQ_CLKB XD2_XNOR_midp 1.21e-17
* device instance cc_XD2_XDFFQ_CLKB_XD2_dmodout r0 *1 0,0
Ccc_XD2_XDFFQ_CLKB_XD2_dmodout XD2_XDFFQ_CLKB XD2_dmodout 1.21e-17
* device instance cc_XD2_XDFFQ_CLKB_XD2_dq r0 *1 0,0
Ccc_XD2_XDFFQ_CLKB_XD2_dq XD2_XDFFQ_CLKB XD2_dq 1.8151e-17
* device instance cc_XD2_XDFFQ_CLKB_XD2_nm r0 *1 0,0
Ccc_XD2_XDFFQ_CLKB_XD2_nm XD2_XDFFQ_CLKB XD2_nm 1.21e-17
* device instance cc_XD2_XDFFQ_CLKB_XD2_nt r0 *1 0,0
Ccc_XD2_XDFFQ_CLKB_XD2_nt XD2_XDFFQ_CLKB XD2_nt 2.4201e-17
* device instance cc_XD2_XDFFQ_CLKB_XD2_t1 r0 *1 0,0
Ccc_XD2_XDFFQ_CLKB_XD2_t1 XD2_XDFFQ_CLKB XD2_t1 1.21e-17
* device instance cc_XD2_XDFFQ_CLKB_XD3_XDFFM_CLKB r0 *1 0,0
Ccc_XD2_XDFFQ_CLKB_XD3_XDFFM_CLKB XD2_XDFFQ_CLKB XD3_XDFFM_CLKB 1.8151e-17
* device instance cc_XD2_XDFFQ_CLKB_XD3_XDFFM_M r0 *1 0,0
Ccc_XD2_XDFFQ_CLKB_XD3_XDFFM_M XD2_XDFFQ_CLKB XD3_XDFFM_M 2.4201e-17
* device instance cc_XD2_XDFFQ_CLKB_XD3_XDFFM_MB r0 *1 0,0
Ccc_XD2_XDFFQ_CLKB_XD3_XDFFM_MB XD2_XDFFQ_CLKB XD3_XDFFM_MB 1.21e-17
* device instance cc_XD2_XDFFQ_CLKB_XD3_XDFFM_S r0 *1 0,0
Ccc_XD2_XDFFQ_CLKB_XD3_XDFFM_S XD2_XDFFQ_CLKB XD3_XDFFM_S 1.8151e-17
* device instance cc_XD2_XDFFQ_CLKB_XD3_XDFFM_SB r0 *1 0,0
Ccc_XD2_XDFFQ_CLKB_XD3_XDFFM_SB XD2_XDFFQ_CLKB XD3_XDFFM_SB 1.8151e-17
* device instance cc_XD2_XDFFQ_CLKB_XD3_XDFFQ_CLKB r0 *1 0,0
Ccc_XD2_XDFFQ_CLKB_XD3_XDFFQ_CLKB XD2_XDFFQ_CLKB XD3_XDFFQ_CLKB 1.8151e-17
* device instance cc_XD2_XDFFQ_CLKB_XD3_XDFFQ_M r0 *1 0,0
Ccc_XD2_XDFFQ_CLKB_XD3_XDFFQ_M XD2_XDFFQ_CLKB XD3_XDFFQ_M 2.4201e-17
* device instance cc_XD2_XDFFQ_CLKB_XD3_XDFFQ_MB r0 *1 0,0
Ccc_XD2_XDFFQ_CLKB_XD3_XDFFQ_MB XD2_XDFFQ_CLKB XD3_XDFFQ_MB 1.21e-17
* device instance cc_XD2_XDFFQ_CLKB_XD3_XDFFQ_S r0 *1 0,0
Ccc_XD2_XDFFQ_CLKB_XD3_XDFFQ_S XD2_XDFFQ_CLKB XD3_XDFFQ_S 1.8151e-17
* device instance cc_XD2_XDFFQ_CLKB_XD3_XDFFQ_SB r0 *1 0,0
Ccc_XD2_XDFFQ_CLKB_XD3_XDFFQ_SB XD2_XDFFQ_CLKB XD3_XDFFQ_SB 1.8151e-17
* device instance cc_XD2_XDFFQ_CLKB_XD3_XN2_mid1 r0 *1 0,0
Ccc_XD2_XDFFQ_CLKB_XD3_XN2_mid1 XD2_XDFFQ_CLKB XD3_XN2_mid1 1.21e-17
* device instance cc_XD2_XDFFQ_CLKB_XD3_XN3_mid1 r0 *1 0,0
Ccc_XD2_XDFFQ_CLKB_XD3_XN3_mid1 XD2_XDFFQ_CLKB XD3_XN3_mid1 1.21e-17
* device instance cc_XD2_XDFFQ_CLKB_XD3_XN3_mid2 r0 *1 0,0
Ccc_XD2_XDFFQ_CLKB_XD3_XN3_mid2 XD2_XDFFQ_CLKB XD3_XN3_mid2 1.21e-17
* device instance cc_XD2_XDFFQ_CLKB_XD3_dmodout r0 *1 0,0
Ccc_XD2_XDFFQ_CLKB_XD3_dmodout XD2_XDFFQ_CLKB XD3_dmodout 1.21e-17
* device instance cc_XD2_XDFFQ_CLKB_XD3_dq r0 *1 0,0
Ccc_XD2_XDFFQ_CLKB_XD3_dq XD2_XDFFQ_CLKB XD3_dq 1.8151e-17
* device instance cc_XD2_XDFFQ_CLKB_XD3_nm r0 *1 0,0
Ccc_XD2_XDFFQ_CLKB_XD3_nm XD2_XDFFQ_CLKB XD3_nm 1.21e-17
* device instance cc_XD2_XDFFQ_CLKB_XD3_nt r0 *1 0,0
Ccc_XD2_XDFFQ_CLKB_XD3_nt XD2_XDFFQ_CLKB XD3_nt 1.21e-17
* device instance cc_XD2_XDFFQ_CLKB_XD3_t1 r0 *1 0,0
Ccc_XD2_XDFFQ_CLKB_XD3_t1 XD2_XDFFQ_CLKB XD3_t1 1.21e-17
* device instance cc_XD2_XDFFQ_CLKB_XD4_XDFFM_CLKB r0 *1 0,0
Ccc_XD2_XDFFQ_CLKB_XD4_XDFFM_CLKB XD2_XDFFQ_CLKB XD4_XDFFM_CLKB 1.8151e-17
* device instance cc_XD2_XDFFQ_CLKB_XD4_XDFFM_M r0 *1 0,0
Ccc_XD2_XDFFQ_CLKB_XD4_XDFFM_M XD2_XDFFQ_CLKB XD4_XDFFM_M 2.4201e-17
* device instance cc_XD2_XDFFQ_CLKB_XD4_XDFFM_MB r0 *1 0,0
Ccc_XD2_XDFFQ_CLKB_XD4_XDFFM_MB XD2_XDFFQ_CLKB XD4_XDFFM_MB 1.21e-17
* device instance cc_XD2_XDFFQ_CLKB_XD4_XDFFM_S r0 *1 0,0
Ccc_XD2_XDFFQ_CLKB_XD4_XDFFM_S XD2_XDFFQ_CLKB XD4_XDFFM_S 1.8151e-17
* device instance cc_XD2_XDFFQ_CLKB_XD4_XDFFM_SB r0 *1 0,0
Ccc_XD2_XDFFQ_CLKB_XD4_XDFFM_SB XD2_XDFFQ_CLKB XD4_XDFFM_SB 1.8151e-17
* device instance cc_XD2_XDFFQ_CLKB_XD4_XDFFQ_CLKB r0 *1 0,0
Ccc_XD2_XDFFQ_CLKB_XD4_XDFFQ_CLKB XD2_XDFFQ_CLKB XD4_XDFFQ_CLKB 1.8151e-17
* device instance cc_XD2_XDFFQ_CLKB_XD4_XDFFQ_M r0 *1 0,0
Ccc_XD2_XDFFQ_CLKB_XD4_XDFFQ_M XD2_XDFFQ_CLKB XD4_XDFFQ_M 2.4201e-17
* device instance cc_XD2_XDFFQ_CLKB_XD4_XDFFQ_MB r0 *1 0,0
Ccc_XD2_XDFFQ_CLKB_XD4_XDFFQ_MB XD2_XDFFQ_CLKB XD4_XDFFQ_MB 1.21e-17
* device instance cc_XD2_XDFFQ_CLKB_XD4_XDFFQ_S r0 *1 0,0
Ccc_XD2_XDFFQ_CLKB_XD4_XDFFQ_S XD2_XDFFQ_CLKB XD4_XDFFQ_S 1.8151e-17
* device instance cc_XD2_XDFFQ_CLKB_XD4_XDFFQ_SB r0 *1 0,0
Ccc_XD2_XDFFQ_CLKB_XD4_XDFFQ_SB XD2_XDFFQ_CLKB XD4_XDFFQ_SB 1.8151e-17
* device instance cc_XD2_XDFFQ_CLKB_XD4_XN2_mid1 r0 *1 0,0
Ccc_XD2_XDFFQ_CLKB_XD4_XN2_mid1 XD2_XDFFQ_CLKB XD4_XN2_mid1 1.21e-17
* device instance cc_XD2_XDFFQ_CLKB_XD4_XN3_mid1 r0 *1 0,0
Ccc_XD2_XDFFQ_CLKB_XD4_XN3_mid1 XD2_XDFFQ_CLKB XD4_XN3_mid1 1.21e-17
* device instance cc_XD2_XDFFQ_CLKB_XD4_XN3_mid2 r0 *1 0,0
Ccc_XD2_XDFFQ_CLKB_XD4_XN3_mid2 XD2_XDFFQ_CLKB XD4_XN3_mid2 1.21e-17
* device instance cc_XD2_XDFFQ_CLKB_XD4_dmodout r0 *1 0,0
Ccc_XD2_XDFFQ_CLKB_XD4_dmodout XD2_XDFFQ_CLKB XD4_dmodout 1.21e-17
* device instance cc_XD2_XDFFQ_CLKB_XD4_dq r0 *1 0,0
Ccc_XD2_XDFFQ_CLKB_XD4_dq XD2_XDFFQ_CLKB XD4_dq 1.8151e-17
* device instance cc_XD2_XDFFQ_CLKB_XD4_nm r0 *1 0,0
Ccc_XD2_XDFFQ_CLKB_XD4_nm XD2_XDFFQ_CLKB XD4_nm 1.21e-17
* device instance cc_XD2_XDFFQ_CLKB_XD4_nt r0 *1 0,0
Ccc_XD2_XDFFQ_CLKB_XD4_nt XD2_XDFFQ_CLKB XD4_nt 1.21e-17
* device instance cc_XD2_XDFFQ_CLKB_XD4_t1 r0 *1 0,0
Ccc_XD2_XDFFQ_CLKB_XD4_t1 XD2_XDFFQ_CLKB XD4_t1 1.21e-17
* device instance cc_XD2_XDFFQ_CLKB_XD5_XDFFM_CLKB r0 *1 0,0
Ccc_XD2_XDFFQ_CLKB_XD5_XDFFM_CLKB XD2_XDFFQ_CLKB XD5_XDFFM_CLKB 1.8151e-17
* device instance cc_XD2_XDFFQ_CLKB_XD5_XDFFM_M r0 *1 0,0
Ccc_XD2_XDFFQ_CLKB_XD5_XDFFM_M XD2_XDFFQ_CLKB XD5_XDFFM_M 2.4201e-17
* device instance cc_XD2_XDFFQ_CLKB_XD5_XDFFM_MB r0 *1 0,0
Ccc_XD2_XDFFQ_CLKB_XD5_XDFFM_MB XD2_XDFFQ_CLKB XD5_XDFFM_MB 1.21e-17
* device instance cc_XD2_XDFFQ_CLKB_XD5_XDFFM_S r0 *1 0,0
Ccc_XD2_XDFFQ_CLKB_XD5_XDFFM_S XD2_XDFFQ_CLKB XD5_XDFFM_S 1.8151e-17
* device instance cc_XD2_XDFFQ_CLKB_XD5_XDFFM_SB r0 *1 0,0
Ccc_XD2_XDFFQ_CLKB_XD5_XDFFM_SB XD2_XDFFQ_CLKB XD5_XDFFM_SB 1.8151e-17
* device instance cc_XD2_XDFFQ_CLKB_XD5_XDFFQ_CLKB r0 *1 0,0
Ccc_XD2_XDFFQ_CLKB_XD5_XDFFQ_CLKB XD2_XDFFQ_CLKB XD5_XDFFQ_CLKB 1.8151e-17
* device instance cc_XD2_XDFFQ_CLKB_XD5_XDFFQ_M r0 *1 0,0
Ccc_XD2_XDFFQ_CLKB_XD5_XDFFQ_M XD2_XDFFQ_CLKB XD5_XDFFQ_M 2.4201e-17
* device instance cc_XD2_XDFFQ_CLKB_XD5_XDFFQ_MB r0 *1 0,0
Ccc_XD2_XDFFQ_CLKB_XD5_XDFFQ_MB XD2_XDFFQ_CLKB XD5_XDFFQ_MB 1.21e-17
* device instance cc_XD2_XDFFQ_CLKB_XD5_XDFFQ_S r0 *1 0,0
Ccc_XD2_XDFFQ_CLKB_XD5_XDFFQ_S XD2_XDFFQ_CLKB XD5_XDFFQ_S 1.8151e-17
* device instance cc_XD2_XDFFQ_CLKB_XD5_XDFFQ_SB r0 *1 0,0
Ccc_XD2_XDFFQ_CLKB_XD5_XDFFQ_SB XD2_XDFFQ_CLKB XD5_XDFFQ_SB 1.8151e-17
* device instance cc_XD2_XDFFQ_CLKB_XD5_XN2_mid1 r0 *1 0,0
Ccc_XD2_XDFFQ_CLKB_XD5_XN2_mid1 XD2_XDFFQ_CLKB XD5_XN2_mid1 1.21e-17
* device instance cc_XD2_XDFFQ_CLKB_XD5_XN3_mid1 r0 *1 0,0
Ccc_XD2_XDFFQ_CLKB_XD5_XN3_mid1 XD2_XDFFQ_CLKB XD5_XN3_mid1 1.21e-17
* device instance cc_XD2_XDFFQ_CLKB_XD5_XN3_mid2 r0 *1 0,0
Ccc_XD2_XDFFQ_CLKB_XD5_XN3_mid2 XD2_XDFFQ_CLKB XD5_XN3_mid2 1.21e-17
* device instance cc_XD2_XDFFQ_CLKB_XD5_dmodout r0 *1 0,0
Ccc_XD2_XDFFQ_CLKB_XD5_dmodout XD2_XDFFQ_CLKB XD5_dmodout 1.21e-17
* device instance cc_XD2_XDFFQ_CLKB_XD5_dq r0 *1 0,0
Ccc_XD2_XDFFQ_CLKB_XD5_dq XD2_XDFFQ_CLKB XD5_dq 1.8151e-17
* device instance cc_XD2_XDFFQ_CLKB_XD5_nm r0 *1 0,0
Ccc_XD2_XDFFQ_CLKB_XD5_nm XD2_XDFFQ_CLKB XD5_nm 1.21e-17
* device instance cc_XD2_XDFFQ_CLKB_XD5_nt r0 *1 0,0
Ccc_XD2_XDFFQ_CLKB_XD5_nt XD2_XDFFQ_CLKB XD5_nt 1.21e-17
* device instance cc_XD2_XDFFQ_CLKB_XD5_t1 r0 *1 0,0
Ccc_XD2_XDFFQ_CLKB_XD5_t1 XD2_XDFFQ_CLKB XD5_t1 1.21e-17
* device instance cc_XD2_XDFFQ_CLKB_XFRT_CLKB r0 *1 0,0
Ccc_XD2_XDFFQ_CLKB_XFRT_CLKB XD2_XDFFQ_CLKB XFRT_CLKB 1.8151e-17
* device instance cc_XD2_XDFFQ_CLKB_XFRT_M r0 *1 0,0
Ccc_XD2_XDFFQ_CLKB_XFRT_M XD2_XDFFQ_CLKB XFRT_M 2.4201e-17
* device instance cc_XD2_XDFFQ_CLKB_XFRT_MB r0 *1 0,0
Ccc_XD2_XDFFQ_CLKB_XFRT_MB XD2_XDFFQ_CLKB XFRT_MB 1.21e-17
* device instance cc_XD2_XDFFQ_CLKB_XFRT_S r0 *1 0,0
Ccc_XD2_XDFFQ_CLKB_XFRT_S XD2_XDFFQ_CLKB XFRT_S 1.8151e-17
* device instance cc_XD2_XDFFQ_CLKB_XFRT_SB r0 *1 0,0
Ccc_XD2_XDFFQ_CLKB_XFRT_SB XD2_XDFFQ_CLKB XFRT_SB 1.8151e-17
* device instance cc_XD2_XDFFQ_CLKB_ck1 r0 *1 0,0
Ccc_XD2_XDFFQ_CLKB_ck1 XD2_XDFFQ_CLKB ck1 5.4452e-17
* device instance cc_XD2_XDFFQ_CLKB_ck2 r0 *1 0,0
Ccc_XD2_XDFFQ_CLKB_ck2 XD2_XDFFQ_CLKB ck2 6.0502e-17
* device instance cc_XD2_XDFFQ_CLKB_ck3 r0 *1 0,0
Ccc_XD2_XDFFQ_CLKB_ck3 XD2_XDFFQ_CLKB ck3 5.4452e-17
* device instance cc_XD2_XDFFQ_CLKB_ck4 r0 *1 0,0
Ccc_XD2_XDFFQ_CLKB_ck4 XD2_XDFFQ_CLKB ck4 5.4452e-17
* device instance cc_XD2_XDFFQ_CLKB_ck5 r0 *1 0,0
Ccc_XD2_XDFFQ_CLKB_ck5 XD2_XDFFQ_CLKB ck5 5.4452e-17
* device instance cc_XD2_XDFFQ_CLKB_mod0 r0 *1 0,0
Ccc_XD2_XDFFQ_CLKB_mod0 XD2_XDFFQ_CLKB mod0 2.4201e-17
* device instance cc_XD2_XDFFQ_CLKB_mod1 r0 *1 0,0
Ccc_XD2_XDFFQ_CLKB_mod1 XD2_XDFFQ_CLKB mod1 2.4201e-17
* device instance cc_XD2_XDFFQ_CLKB_mod2 r0 *1 0,0
Ccc_XD2_XDFFQ_CLKB_mod2 XD2_XDFFQ_CLKB mod2 2.4201e-17
* device instance cc_XD2_XDFFQ_CLKB_mod3 r0 *1 0,0
Ccc_XD2_XDFFQ_CLKB_mod3 XD2_XDFFQ_CLKB mod3 2.4201e-17
* device instance cc_XD2_XDFFQ_CLKB_mod4 r0 *1 0,0
Ccc_XD2_XDFFQ_CLKB_mod4 XD2_XDFFQ_CLKB mod4 2.4201e-17
* device instance cc_XD2_XDFFQ_CLKB_net1 r0 *1 0,0
Ccc_XD2_XDFFQ_CLKB_net1 XD2_XDFFQ_CLKB net1 1.21e-17
* device instance cc_XD2_XDFFQ_M_XD2_XDFFQ_MB r0 *1 0,0
Ccc_XD2_XDFFQ_M_XD2_XDFFQ_MB XD2_XDFFQ_M XD2_XDFFQ_MB 3.4688e-17
* device instance cc_XD2_XDFFQ_M_XD2_XDFFQ_S r0 *1 0,0
Ccc_XD2_XDFFQ_M_XD2_XDFFQ_S XD2_XDFFQ_M XD2_XDFFQ_S 2.8638e-17
* device instance cc_XD2_XDFFQ_M_XD2_XDFFQ_SB r0 *1 0,0
Ccc_XD2_XDFFQ_M_XD2_XDFFQ_SB XD2_XDFFQ_M XD2_XDFFQ_SB 1.8151e-17
* device instance cc_XD2_XDFFQ_M_XD2_XN2_mid1 r0 *1 0,0
Ccc_XD2_XDFFQ_M_XD2_XN2_mid1 XD2_XDFFQ_M XD2_XN2_mid1 1.21e-17
* device instance cc_XD2_XDFFQ_M_XD2_XNOR_midp r0 *1 0,0
Ccc_XD2_XDFFQ_M_XD2_XNOR_midp XD2_XDFFQ_M XD2_XNOR_midp 1.21e-17
* device instance cc_XD2_XDFFQ_M_XD2_dmodout r0 *1 0,0
Ccc_XD2_XDFFQ_M_XD2_dmodout XD2_XDFFQ_M XD2_dmodout 1.21e-17
* device instance cc_XD2_XDFFQ_M_XD2_dq r0 *1 0,0
Ccc_XD2_XDFFQ_M_XD2_dq XD2_XDFFQ_M XD2_dq 2.8638e-17
* device instance cc_XD2_XDFFQ_M_XD2_nm r0 *1 0,0
Ccc_XD2_XDFFQ_M_XD2_nm XD2_XDFFQ_M XD2_nm 1.21e-17
* device instance cc_XD2_XDFFQ_M_XD2_nt r0 *1 0,0
Ccc_XD2_XDFFQ_M_XD2_nt XD2_XDFFQ_M XD2_nt 2.4201e-17
* device instance cc_XD2_XDFFQ_M_XD2_t1 r0 *1 0,0
Ccc_XD2_XDFFQ_M_XD2_t1 XD2_XDFFQ_M XD2_t1 1.21e-17
* device instance cc_XD2_XDFFQ_M_XD3_XDFFM_CLKB r0 *1 0,0
Ccc_XD2_XDFFQ_M_XD3_XDFFM_CLKB XD2_XDFFQ_M XD3_XDFFM_CLKB 1.8151e-17
* device instance cc_XD2_XDFFQ_M_XD3_XDFFM_M r0 *1 0,0
Ccc_XD2_XDFFQ_M_XD3_XDFFM_M XD2_XDFFQ_M XD3_XDFFM_M 2.4201e-17
* device instance cc_XD2_XDFFQ_M_XD3_XDFFM_MB r0 *1 0,0
Ccc_XD2_XDFFQ_M_XD3_XDFFM_MB XD2_XDFFQ_M XD3_XDFFM_MB 1.21e-17
* device instance cc_XD2_XDFFQ_M_XD3_XDFFM_S r0 *1 0,0
Ccc_XD2_XDFFQ_M_XD3_XDFFM_S XD2_XDFFQ_M XD3_XDFFM_S 1.8151e-17
* device instance cc_XD2_XDFFQ_M_XD3_XDFFM_SB r0 *1 0,0
Ccc_XD2_XDFFQ_M_XD3_XDFFM_SB XD2_XDFFQ_M XD3_XDFFM_SB 1.8151e-17
* device instance cc_XD2_XDFFQ_M_XD3_XDFFQ_CLKB r0 *1 0,0
Ccc_XD2_XDFFQ_M_XD3_XDFFQ_CLKB XD2_XDFFQ_M XD3_XDFFQ_CLKB 1.8151e-17
* device instance cc_XD2_XDFFQ_M_XD3_XDFFQ_M r0 *1 0,0
Ccc_XD2_XDFFQ_M_XD3_XDFFQ_M XD2_XDFFQ_M XD3_XDFFQ_M 2.4201e-17
* device instance cc_XD2_XDFFQ_M_XD3_XDFFQ_MB r0 *1 0,0
Ccc_XD2_XDFFQ_M_XD3_XDFFQ_MB XD2_XDFFQ_M XD3_XDFFQ_MB 1.21e-17
* device instance cc_XD2_XDFFQ_M_XD3_XDFFQ_S r0 *1 0,0
Ccc_XD2_XDFFQ_M_XD3_XDFFQ_S XD2_XDFFQ_M XD3_XDFFQ_S 1.8151e-17
* device instance cc_XD2_XDFFQ_M_XD3_XDFFQ_SB r0 *1 0,0
Ccc_XD2_XDFFQ_M_XD3_XDFFQ_SB XD2_XDFFQ_M XD3_XDFFQ_SB 1.8151e-17
* device instance cc_XD2_XDFFQ_M_XD3_XN2_mid1 r0 *1 0,0
Ccc_XD2_XDFFQ_M_XD3_XN2_mid1 XD2_XDFFQ_M XD3_XN2_mid1 1.21e-17
* device instance cc_XD2_XDFFQ_M_XD3_XN3_mid1 r0 *1 0,0
Ccc_XD2_XDFFQ_M_XD3_XN3_mid1 XD2_XDFFQ_M XD3_XN3_mid1 1.21e-17
* device instance cc_XD2_XDFFQ_M_XD3_XN3_mid2 r0 *1 0,0
Ccc_XD2_XDFFQ_M_XD3_XN3_mid2 XD2_XDFFQ_M XD3_XN3_mid2 1.21e-17
* device instance cc_XD2_XDFFQ_M_XD3_dmodout r0 *1 0,0
Ccc_XD2_XDFFQ_M_XD3_dmodout XD2_XDFFQ_M XD3_dmodout 1.21e-17
* device instance cc_XD2_XDFFQ_M_XD3_dq r0 *1 0,0
Ccc_XD2_XDFFQ_M_XD3_dq XD2_XDFFQ_M XD3_dq 1.8151e-17
* device instance cc_XD2_XDFFQ_M_XD3_nm r0 *1 0,0
Ccc_XD2_XDFFQ_M_XD3_nm XD2_XDFFQ_M XD3_nm 1.21e-17
* device instance cc_XD2_XDFFQ_M_XD3_nt r0 *1 0,0
Ccc_XD2_XDFFQ_M_XD3_nt XD2_XDFFQ_M XD3_nt 1.21e-17
* device instance cc_XD2_XDFFQ_M_XD3_t1 r0 *1 0,0
Ccc_XD2_XDFFQ_M_XD3_t1 XD2_XDFFQ_M XD3_t1 1.21e-17
* device instance cc_XD2_XDFFQ_M_XD4_XDFFM_CLKB r0 *1 0,0
Ccc_XD2_XDFFQ_M_XD4_XDFFM_CLKB XD2_XDFFQ_M XD4_XDFFM_CLKB 1.8151e-17
* device instance cc_XD2_XDFFQ_M_XD4_XDFFM_M r0 *1 0,0
Ccc_XD2_XDFFQ_M_XD4_XDFFM_M XD2_XDFFQ_M XD4_XDFFM_M 2.4201e-17
* device instance cc_XD2_XDFFQ_M_XD4_XDFFM_MB r0 *1 0,0
Ccc_XD2_XDFFQ_M_XD4_XDFFM_MB XD2_XDFFQ_M XD4_XDFFM_MB 1.21e-17
* device instance cc_XD2_XDFFQ_M_XD4_XDFFM_S r0 *1 0,0
Ccc_XD2_XDFFQ_M_XD4_XDFFM_S XD2_XDFFQ_M XD4_XDFFM_S 1.8151e-17
* device instance cc_XD2_XDFFQ_M_XD4_XDFFM_SB r0 *1 0,0
Ccc_XD2_XDFFQ_M_XD4_XDFFM_SB XD2_XDFFQ_M XD4_XDFFM_SB 1.8151e-17
* device instance cc_XD2_XDFFQ_M_XD4_XDFFQ_CLKB r0 *1 0,0
Ccc_XD2_XDFFQ_M_XD4_XDFFQ_CLKB XD2_XDFFQ_M XD4_XDFFQ_CLKB 1.8151e-17
* device instance cc_XD2_XDFFQ_M_XD4_XDFFQ_M r0 *1 0,0
Ccc_XD2_XDFFQ_M_XD4_XDFFQ_M XD2_XDFFQ_M XD4_XDFFQ_M 2.4201e-17
* device instance cc_XD2_XDFFQ_M_XD4_XDFFQ_MB r0 *1 0,0
Ccc_XD2_XDFFQ_M_XD4_XDFFQ_MB XD2_XDFFQ_M XD4_XDFFQ_MB 1.21e-17
* device instance cc_XD2_XDFFQ_M_XD4_XDFFQ_S r0 *1 0,0
Ccc_XD2_XDFFQ_M_XD4_XDFFQ_S XD2_XDFFQ_M XD4_XDFFQ_S 1.8151e-17
* device instance cc_XD2_XDFFQ_M_XD4_XDFFQ_SB r0 *1 0,0
Ccc_XD2_XDFFQ_M_XD4_XDFFQ_SB XD2_XDFFQ_M XD4_XDFFQ_SB 1.8151e-17
* device instance cc_XD2_XDFFQ_M_XD4_XN2_mid1 r0 *1 0,0
Ccc_XD2_XDFFQ_M_XD4_XN2_mid1 XD2_XDFFQ_M XD4_XN2_mid1 1.21e-17
* device instance cc_XD2_XDFFQ_M_XD4_XN3_mid1 r0 *1 0,0
Ccc_XD2_XDFFQ_M_XD4_XN3_mid1 XD2_XDFFQ_M XD4_XN3_mid1 1.21e-17
* device instance cc_XD2_XDFFQ_M_XD4_XN3_mid2 r0 *1 0,0
Ccc_XD2_XDFFQ_M_XD4_XN3_mid2 XD2_XDFFQ_M XD4_XN3_mid2 1.21e-17
* device instance cc_XD2_XDFFQ_M_XD4_dmodout r0 *1 0,0
Ccc_XD2_XDFFQ_M_XD4_dmodout XD2_XDFFQ_M XD4_dmodout 1.21e-17
* device instance cc_XD2_XDFFQ_M_XD4_dq r0 *1 0,0
Ccc_XD2_XDFFQ_M_XD4_dq XD2_XDFFQ_M XD4_dq 1.8151e-17
* device instance cc_XD2_XDFFQ_M_XD4_nm r0 *1 0,0
Ccc_XD2_XDFFQ_M_XD4_nm XD2_XDFFQ_M XD4_nm 1.21e-17
* device instance cc_XD2_XDFFQ_M_XD4_nt r0 *1 0,0
Ccc_XD2_XDFFQ_M_XD4_nt XD2_XDFFQ_M XD4_nt 1.21e-17
* device instance cc_XD2_XDFFQ_M_XD4_t1 r0 *1 0,0
Ccc_XD2_XDFFQ_M_XD4_t1 XD2_XDFFQ_M XD4_t1 1.21e-17
* device instance cc_XD2_XDFFQ_M_XD5_XDFFM_CLKB r0 *1 0,0
Ccc_XD2_XDFFQ_M_XD5_XDFFM_CLKB XD2_XDFFQ_M XD5_XDFFM_CLKB 1.8151e-17
* device instance cc_XD2_XDFFQ_M_XD5_XDFFM_M r0 *1 0,0
Ccc_XD2_XDFFQ_M_XD5_XDFFM_M XD2_XDFFQ_M XD5_XDFFM_M 2.4201e-17
* device instance cc_XD2_XDFFQ_M_XD5_XDFFM_MB r0 *1 0,0
Ccc_XD2_XDFFQ_M_XD5_XDFFM_MB XD2_XDFFQ_M XD5_XDFFM_MB 1.21e-17
* device instance cc_XD2_XDFFQ_M_XD5_XDFFM_S r0 *1 0,0
Ccc_XD2_XDFFQ_M_XD5_XDFFM_S XD2_XDFFQ_M XD5_XDFFM_S 1.8151e-17
* device instance cc_XD2_XDFFQ_M_XD5_XDFFM_SB r0 *1 0,0
Ccc_XD2_XDFFQ_M_XD5_XDFFM_SB XD2_XDFFQ_M XD5_XDFFM_SB 1.8151e-17
* device instance cc_XD2_XDFFQ_M_XD5_XDFFQ_CLKB r0 *1 0,0
Ccc_XD2_XDFFQ_M_XD5_XDFFQ_CLKB XD2_XDFFQ_M XD5_XDFFQ_CLKB 1.8151e-17
* device instance cc_XD2_XDFFQ_M_XD5_XDFFQ_M r0 *1 0,0
Ccc_XD2_XDFFQ_M_XD5_XDFFQ_M XD2_XDFFQ_M XD5_XDFFQ_M 2.4201e-17
* device instance cc_XD2_XDFFQ_M_XD5_XDFFQ_MB r0 *1 0,0
Ccc_XD2_XDFFQ_M_XD5_XDFFQ_MB XD2_XDFFQ_M XD5_XDFFQ_MB 1.21e-17
* device instance cc_XD2_XDFFQ_M_XD5_XDFFQ_S r0 *1 0,0
Ccc_XD2_XDFFQ_M_XD5_XDFFQ_S XD2_XDFFQ_M XD5_XDFFQ_S 1.8151e-17
* device instance cc_XD2_XDFFQ_M_XD5_XDFFQ_SB r0 *1 0,0
Ccc_XD2_XDFFQ_M_XD5_XDFFQ_SB XD2_XDFFQ_M XD5_XDFFQ_SB 1.8151e-17
* device instance cc_XD2_XDFFQ_M_XD5_XN2_mid1 r0 *1 0,0
Ccc_XD2_XDFFQ_M_XD5_XN2_mid1 XD2_XDFFQ_M XD5_XN2_mid1 1.21e-17
* device instance cc_XD2_XDFFQ_M_XD5_XN3_mid1 r0 *1 0,0
Ccc_XD2_XDFFQ_M_XD5_XN3_mid1 XD2_XDFFQ_M XD5_XN3_mid1 1.21e-17
* device instance cc_XD2_XDFFQ_M_XD5_XN3_mid2 r0 *1 0,0
Ccc_XD2_XDFFQ_M_XD5_XN3_mid2 XD2_XDFFQ_M XD5_XN3_mid2 1.21e-17
* device instance cc_XD2_XDFFQ_M_XD5_dmodout r0 *1 0,0
Ccc_XD2_XDFFQ_M_XD5_dmodout XD2_XDFFQ_M XD5_dmodout 1.21e-17
* device instance cc_XD2_XDFFQ_M_XD5_dq r0 *1 0,0
Ccc_XD2_XDFFQ_M_XD5_dq XD2_XDFFQ_M XD5_dq 1.8151e-17
* device instance cc_XD2_XDFFQ_M_XD5_nm r0 *1 0,0
Ccc_XD2_XDFFQ_M_XD5_nm XD2_XDFFQ_M XD5_nm 1.21e-17
* device instance cc_XD2_XDFFQ_M_XD5_nt r0 *1 0,0
Ccc_XD2_XDFFQ_M_XD5_nt XD2_XDFFQ_M XD5_nt 1.21e-17
* device instance cc_XD2_XDFFQ_M_XD5_t1 r0 *1 0,0
Ccc_XD2_XDFFQ_M_XD5_t1 XD2_XDFFQ_M XD5_t1 1.21e-17
* device instance cc_XD2_XDFFQ_M_XFRT_CLKB r0 *1 0,0
Ccc_XD2_XDFFQ_M_XFRT_CLKB XD2_XDFFQ_M XFRT_CLKB 1.8151e-17
* device instance cc_XD2_XDFFQ_M_XFRT_M r0 *1 0,0
Ccc_XD2_XDFFQ_M_XFRT_M XD2_XDFFQ_M XFRT_M 2.4201e-17
* device instance cc_XD2_XDFFQ_M_XFRT_MB r0 *1 0,0
Ccc_XD2_XDFFQ_M_XFRT_MB XD2_XDFFQ_M XFRT_MB 1.21e-17
* device instance cc_XD2_XDFFQ_M_XFRT_S r0 *1 0,0
Ccc_XD2_XDFFQ_M_XFRT_S XD2_XDFFQ_M XFRT_S 1.8151e-17
* device instance cc_XD2_XDFFQ_M_XFRT_SB r0 *1 0,0
Ccc_XD2_XDFFQ_M_XFRT_SB XD2_XDFFQ_M XFRT_SB 1.8151e-17
* device instance cc_XD2_XDFFQ_M_ck1 r0 *1 0,0
Ccc_XD2_XDFFQ_M_ck1 XD2_XDFFQ_M ck1 5.4452e-17
* device instance cc_XD2_XDFFQ_M_ck2 r0 *1 0,0
Ccc_XD2_XDFFQ_M_ck2 XD2_XDFFQ_M ck2 6.0502e-17
* device instance cc_XD2_XDFFQ_M_ck3 r0 *1 0,0
Ccc_XD2_XDFFQ_M_ck3 XD2_XDFFQ_M ck3 5.4452e-17
* device instance cc_XD2_XDFFQ_M_ck4 r0 *1 0,0
Ccc_XD2_XDFFQ_M_ck4 XD2_XDFFQ_M ck4 5.4452e-17
* device instance cc_XD2_XDFFQ_M_ck5 r0 *1 0,0
Ccc_XD2_XDFFQ_M_ck5 XD2_XDFFQ_M ck5 5.4452e-17
* device instance cc_XD2_XDFFQ_M_mod0 r0 *1 0,0
Ccc_XD2_XDFFQ_M_mod0 XD2_XDFFQ_M mod0 2.4201e-17
* device instance cc_XD2_XDFFQ_M_mod1 r0 *1 0,0
Ccc_XD2_XDFFQ_M_mod1 XD2_XDFFQ_M mod1 2.4201e-17
* device instance cc_XD2_XDFFQ_M_mod2 r0 *1 0,0
Ccc_XD2_XDFFQ_M_mod2 XD2_XDFFQ_M mod2 2.4201e-17
* device instance cc_XD2_XDFFQ_M_mod3 r0 *1 0,0
Ccc_XD2_XDFFQ_M_mod3 XD2_XDFFQ_M mod3 2.4201e-17
* device instance cc_XD2_XDFFQ_M_mod4 r0 *1 0,0
Ccc_XD2_XDFFQ_M_mod4 XD2_XDFFQ_M mod4 2.4201e-17
* device instance cc_XD2_XDFFQ_M_net1 r0 *1 0,0
Ccc_XD2_XDFFQ_M_net1 XD2_XDFFQ_M net1 1.21e-17
* device instance cc_XD2_XDFFQ_MB_XD2_XDFFQ_S r0 *1 0,0
Ccc_XD2_XDFFQ_MB_XD2_XDFFQ_S XD2_XDFFQ_MB XD2_XDFFQ_S 1.8151e-17
* device instance cc_XD2_XDFFQ_MB_XD2_XDFFQ_SB r0 *1 0,0
Ccc_XD2_XDFFQ_MB_XD2_XDFFQ_SB XD2_XDFFQ_MB XD2_XDFFQ_SB 1.8151e-17
* device instance cc_XD2_XDFFQ_MB_XD2_XN2_mid1 r0 *1 0,0
Ccc_XD2_XDFFQ_MB_XD2_XN2_mid1 XD2_XDFFQ_MB XD2_XN2_mid1 1.21e-17
* device instance cc_XD2_XDFFQ_MB_XD2_XNOR_midp r0 *1 0,0
Ccc_XD2_XDFFQ_MB_XD2_XNOR_midp XD2_XDFFQ_MB XD2_XNOR_midp 1.21e-17
* device instance cc_XD2_XDFFQ_MB_XD2_dmodout r0 *1 0,0
Ccc_XD2_XDFFQ_MB_XD2_dmodout XD2_XDFFQ_MB XD2_dmodout 1.21e-17
* device instance cc_XD2_XDFFQ_MB_XD2_dq r0 *1 0,0
Ccc_XD2_XDFFQ_MB_XD2_dq XD2_XDFFQ_MB XD2_dq 1.21e-17
* device instance cc_XD2_XDFFQ_MB_XD2_nm r0 *1 0,0
Ccc_XD2_XDFFQ_MB_XD2_nm XD2_XDFFQ_MB XD2_nm 1.21e-17
* device instance cc_XD2_XDFFQ_MB_XD2_nt r0 *1 0,0
Ccc_XD2_XDFFQ_MB_XD2_nt XD2_XDFFQ_MB XD2_nt 2.4201e-17
* device instance cc_XD2_XDFFQ_MB_XD2_t1 r0 *1 0,0
Ccc_XD2_XDFFQ_MB_XD2_t1 XD2_XDFFQ_MB XD2_t1 1.21e-17
* device instance cc_XD2_XDFFQ_MB_XD3_XDFFM_CLKB r0 *1 0,0
Ccc_XD2_XDFFQ_MB_XD3_XDFFM_CLKB XD2_XDFFQ_MB XD3_XDFFM_CLKB 1.8151e-17
* device instance cc_XD2_XDFFQ_MB_XD3_XDFFM_M r0 *1 0,0
Ccc_XD2_XDFFQ_MB_XD3_XDFFM_M XD2_XDFFQ_MB XD3_XDFFM_M 2.4201e-17
* device instance cc_XD2_XDFFQ_MB_XD3_XDFFM_MB r0 *1 0,0
Ccc_XD2_XDFFQ_MB_XD3_XDFFM_MB XD2_XDFFQ_MB XD3_XDFFM_MB 1.21e-17
* device instance cc_XD2_XDFFQ_MB_XD3_XDFFM_S r0 *1 0,0
Ccc_XD2_XDFFQ_MB_XD3_XDFFM_S XD2_XDFFQ_MB XD3_XDFFM_S 1.8151e-17
* device instance cc_XD2_XDFFQ_MB_XD3_XDFFM_SB r0 *1 0,0
Ccc_XD2_XDFFQ_MB_XD3_XDFFM_SB XD2_XDFFQ_MB XD3_XDFFM_SB 1.8151e-17
* device instance cc_XD2_XDFFQ_MB_XD3_XDFFQ_CLKB r0 *1 0,0
Ccc_XD2_XDFFQ_MB_XD3_XDFFQ_CLKB XD2_XDFFQ_MB XD3_XDFFQ_CLKB 1.8151e-17
* device instance cc_XD2_XDFFQ_MB_XD3_XDFFQ_M r0 *1 0,0
Ccc_XD2_XDFFQ_MB_XD3_XDFFQ_M XD2_XDFFQ_MB XD3_XDFFQ_M 2.4201e-17
* device instance cc_XD2_XDFFQ_MB_XD3_XDFFQ_MB r0 *1 0,0
Ccc_XD2_XDFFQ_MB_XD3_XDFFQ_MB XD2_XDFFQ_MB XD3_XDFFQ_MB 1.21e-17
* device instance cc_XD2_XDFFQ_MB_XD3_XDFFQ_S r0 *1 0,0
Ccc_XD2_XDFFQ_MB_XD3_XDFFQ_S XD2_XDFFQ_MB XD3_XDFFQ_S 1.8151e-17
* device instance cc_XD2_XDFFQ_MB_XD3_XDFFQ_SB r0 *1 0,0
Ccc_XD2_XDFFQ_MB_XD3_XDFFQ_SB XD2_XDFFQ_MB XD3_XDFFQ_SB 1.8151e-17
* device instance cc_XD2_XDFFQ_MB_XD3_XN2_mid1 r0 *1 0,0
Ccc_XD2_XDFFQ_MB_XD3_XN2_mid1 XD2_XDFFQ_MB XD3_XN2_mid1 1.21e-17
* device instance cc_XD2_XDFFQ_MB_XD3_XN3_mid1 r0 *1 0,0
Ccc_XD2_XDFFQ_MB_XD3_XN3_mid1 XD2_XDFFQ_MB XD3_XN3_mid1 1.21e-17
* device instance cc_XD2_XDFFQ_MB_XD3_XN3_mid2 r0 *1 0,0
Ccc_XD2_XDFFQ_MB_XD3_XN3_mid2 XD2_XDFFQ_MB XD3_XN3_mid2 1.21e-17
* device instance cc_XD2_XDFFQ_MB_XD3_dmodout r0 *1 0,0
Ccc_XD2_XDFFQ_MB_XD3_dmodout XD2_XDFFQ_MB XD3_dmodout 1.21e-17
* device instance cc_XD2_XDFFQ_MB_XD3_dq r0 *1 0,0
Ccc_XD2_XDFFQ_MB_XD3_dq XD2_XDFFQ_MB XD3_dq 1.8151e-17
* device instance cc_XD2_XDFFQ_MB_XD3_nm r0 *1 0,0
Ccc_XD2_XDFFQ_MB_XD3_nm XD2_XDFFQ_MB XD3_nm 1.21e-17
* device instance cc_XD2_XDFFQ_MB_XD3_nt r0 *1 0,0
Ccc_XD2_XDFFQ_MB_XD3_nt XD2_XDFFQ_MB XD3_nt 1.21e-17
* device instance cc_XD2_XDFFQ_MB_XD3_t1 r0 *1 0,0
Ccc_XD2_XDFFQ_MB_XD3_t1 XD2_XDFFQ_MB XD3_t1 1.21e-17
* device instance cc_XD2_XDFFQ_MB_XD4_XDFFM_CLKB r0 *1 0,0
Ccc_XD2_XDFFQ_MB_XD4_XDFFM_CLKB XD2_XDFFQ_MB XD4_XDFFM_CLKB 1.8151e-17
* device instance cc_XD2_XDFFQ_MB_XD4_XDFFM_M r0 *1 0,0
Ccc_XD2_XDFFQ_MB_XD4_XDFFM_M XD2_XDFFQ_MB XD4_XDFFM_M 2.4201e-17
* device instance cc_XD2_XDFFQ_MB_XD4_XDFFM_MB r0 *1 0,0
Ccc_XD2_XDFFQ_MB_XD4_XDFFM_MB XD2_XDFFQ_MB XD4_XDFFM_MB 1.21e-17
* device instance cc_XD2_XDFFQ_MB_XD4_XDFFM_S r0 *1 0,0
Ccc_XD2_XDFFQ_MB_XD4_XDFFM_S XD2_XDFFQ_MB XD4_XDFFM_S 1.8151e-17
* device instance cc_XD2_XDFFQ_MB_XD4_XDFFM_SB r0 *1 0,0
Ccc_XD2_XDFFQ_MB_XD4_XDFFM_SB XD2_XDFFQ_MB XD4_XDFFM_SB 1.8151e-17
* device instance cc_XD2_XDFFQ_MB_XD4_XDFFQ_CLKB r0 *1 0,0
Ccc_XD2_XDFFQ_MB_XD4_XDFFQ_CLKB XD2_XDFFQ_MB XD4_XDFFQ_CLKB 1.8151e-17
* device instance cc_XD2_XDFFQ_MB_XD4_XDFFQ_M r0 *1 0,0
Ccc_XD2_XDFFQ_MB_XD4_XDFFQ_M XD2_XDFFQ_MB XD4_XDFFQ_M 2.4201e-17
* device instance cc_XD2_XDFFQ_MB_XD4_XDFFQ_MB r0 *1 0,0
Ccc_XD2_XDFFQ_MB_XD4_XDFFQ_MB XD2_XDFFQ_MB XD4_XDFFQ_MB 1.21e-17
* device instance cc_XD2_XDFFQ_MB_XD4_XDFFQ_S r0 *1 0,0
Ccc_XD2_XDFFQ_MB_XD4_XDFFQ_S XD2_XDFFQ_MB XD4_XDFFQ_S 1.8151e-17
* device instance cc_XD2_XDFFQ_MB_XD4_XDFFQ_SB r0 *1 0,0
Ccc_XD2_XDFFQ_MB_XD4_XDFFQ_SB XD2_XDFFQ_MB XD4_XDFFQ_SB 1.8151e-17
* device instance cc_XD2_XDFFQ_MB_XD4_XN2_mid1 r0 *1 0,0
Ccc_XD2_XDFFQ_MB_XD4_XN2_mid1 XD2_XDFFQ_MB XD4_XN2_mid1 1.21e-17
* device instance cc_XD2_XDFFQ_MB_XD4_XN3_mid1 r0 *1 0,0
Ccc_XD2_XDFFQ_MB_XD4_XN3_mid1 XD2_XDFFQ_MB XD4_XN3_mid1 1.21e-17
* device instance cc_XD2_XDFFQ_MB_XD4_XN3_mid2 r0 *1 0,0
Ccc_XD2_XDFFQ_MB_XD4_XN3_mid2 XD2_XDFFQ_MB XD4_XN3_mid2 1.21e-17
* device instance cc_XD2_XDFFQ_MB_XD4_dmodout r0 *1 0,0
Ccc_XD2_XDFFQ_MB_XD4_dmodout XD2_XDFFQ_MB XD4_dmodout 1.21e-17
* device instance cc_XD2_XDFFQ_MB_XD4_dq r0 *1 0,0
Ccc_XD2_XDFFQ_MB_XD4_dq XD2_XDFFQ_MB XD4_dq 1.8151e-17
* device instance cc_XD2_XDFFQ_MB_XD4_nm r0 *1 0,0
Ccc_XD2_XDFFQ_MB_XD4_nm XD2_XDFFQ_MB XD4_nm 1.21e-17
* device instance cc_XD2_XDFFQ_MB_XD4_nt r0 *1 0,0
Ccc_XD2_XDFFQ_MB_XD4_nt XD2_XDFFQ_MB XD4_nt 1.21e-17
* device instance cc_XD2_XDFFQ_MB_XD4_t1 r0 *1 0,0
Ccc_XD2_XDFFQ_MB_XD4_t1 XD2_XDFFQ_MB XD4_t1 1.21e-17
* device instance cc_XD2_XDFFQ_MB_XD5_XDFFM_CLKB r0 *1 0,0
Ccc_XD2_XDFFQ_MB_XD5_XDFFM_CLKB XD2_XDFFQ_MB XD5_XDFFM_CLKB 1.8151e-17
* device instance cc_XD2_XDFFQ_MB_XD5_XDFFM_M r0 *1 0,0
Ccc_XD2_XDFFQ_MB_XD5_XDFFM_M XD2_XDFFQ_MB XD5_XDFFM_M 2.4201e-17
* device instance cc_XD2_XDFFQ_MB_XD5_XDFFM_MB r0 *1 0,0
Ccc_XD2_XDFFQ_MB_XD5_XDFFM_MB XD2_XDFFQ_MB XD5_XDFFM_MB 1.21e-17
* device instance cc_XD2_XDFFQ_MB_XD5_XDFFM_S r0 *1 0,0
Ccc_XD2_XDFFQ_MB_XD5_XDFFM_S XD2_XDFFQ_MB XD5_XDFFM_S 1.8151e-17
* device instance cc_XD2_XDFFQ_MB_XD5_XDFFM_SB r0 *1 0,0
Ccc_XD2_XDFFQ_MB_XD5_XDFFM_SB XD2_XDFFQ_MB XD5_XDFFM_SB 1.8151e-17
* device instance cc_XD2_XDFFQ_MB_XD5_XDFFQ_CLKB r0 *1 0,0
Ccc_XD2_XDFFQ_MB_XD5_XDFFQ_CLKB XD2_XDFFQ_MB XD5_XDFFQ_CLKB 1.8151e-17
* device instance cc_XD2_XDFFQ_MB_XD5_XDFFQ_M r0 *1 0,0
Ccc_XD2_XDFFQ_MB_XD5_XDFFQ_M XD2_XDFFQ_MB XD5_XDFFQ_M 2.4201e-17
* device instance cc_XD2_XDFFQ_MB_XD5_XDFFQ_MB r0 *1 0,0
Ccc_XD2_XDFFQ_MB_XD5_XDFFQ_MB XD2_XDFFQ_MB XD5_XDFFQ_MB 1.21e-17
* device instance cc_XD2_XDFFQ_MB_XD5_XDFFQ_S r0 *1 0,0
Ccc_XD2_XDFFQ_MB_XD5_XDFFQ_S XD2_XDFFQ_MB XD5_XDFFQ_S 1.8151e-17
* device instance cc_XD2_XDFFQ_MB_XD5_XDFFQ_SB r0 *1 0,0
Ccc_XD2_XDFFQ_MB_XD5_XDFFQ_SB XD2_XDFFQ_MB XD5_XDFFQ_SB 1.8151e-17
* device instance cc_XD2_XDFFQ_MB_XD5_XN2_mid1 r0 *1 0,0
Ccc_XD2_XDFFQ_MB_XD5_XN2_mid1 XD2_XDFFQ_MB XD5_XN2_mid1 1.21e-17
* device instance cc_XD2_XDFFQ_MB_XD5_XN3_mid1 r0 *1 0,0
Ccc_XD2_XDFFQ_MB_XD5_XN3_mid1 XD2_XDFFQ_MB XD5_XN3_mid1 1.21e-17
* device instance cc_XD2_XDFFQ_MB_XD5_XN3_mid2 r0 *1 0,0
Ccc_XD2_XDFFQ_MB_XD5_XN3_mid2 XD2_XDFFQ_MB XD5_XN3_mid2 1.21e-17
* device instance cc_XD2_XDFFQ_MB_XD5_dmodout r0 *1 0,0
Ccc_XD2_XDFFQ_MB_XD5_dmodout XD2_XDFFQ_MB XD5_dmodout 1.21e-17
* device instance cc_XD2_XDFFQ_MB_XD5_dq r0 *1 0,0
Ccc_XD2_XDFFQ_MB_XD5_dq XD2_XDFFQ_MB XD5_dq 1.8151e-17
* device instance cc_XD2_XDFFQ_MB_XD5_nm r0 *1 0,0
Ccc_XD2_XDFFQ_MB_XD5_nm XD2_XDFFQ_MB XD5_nm 1.21e-17
* device instance cc_XD2_XDFFQ_MB_XD5_nt r0 *1 0,0
Ccc_XD2_XDFFQ_MB_XD5_nt XD2_XDFFQ_MB XD5_nt 1.21e-17
* device instance cc_XD2_XDFFQ_MB_XD5_t1 r0 *1 0,0
Ccc_XD2_XDFFQ_MB_XD5_t1 XD2_XDFFQ_MB XD5_t1 1.21e-17
* device instance cc_XD2_XDFFQ_MB_XFRT_CLKB r0 *1 0,0
Ccc_XD2_XDFFQ_MB_XFRT_CLKB XD2_XDFFQ_MB XFRT_CLKB 1.8151e-17
* device instance cc_XD2_XDFFQ_MB_XFRT_M r0 *1 0,0
Ccc_XD2_XDFFQ_MB_XFRT_M XD2_XDFFQ_MB XFRT_M 2.4201e-17
* device instance cc_XD2_XDFFQ_MB_XFRT_MB r0 *1 0,0
Ccc_XD2_XDFFQ_MB_XFRT_MB XD2_XDFFQ_MB XFRT_MB 1.21e-17
* device instance cc_XD2_XDFFQ_MB_XFRT_S r0 *1 0,0
Ccc_XD2_XDFFQ_MB_XFRT_S XD2_XDFFQ_MB XFRT_S 1.8151e-17
* device instance cc_XD2_XDFFQ_MB_XFRT_SB r0 *1 0,0
Ccc_XD2_XDFFQ_MB_XFRT_SB XD2_XDFFQ_MB XFRT_SB 1.8151e-17
* device instance cc_XD2_XDFFQ_MB_ck1 r0 *1 0,0
Ccc_XD2_XDFFQ_MB_ck1 XD2_XDFFQ_MB ck1 5.4452e-17
* device instance cc_XD2_XDFFQ_MB_ck2 r0 *1 0,0
Ccc_XD2_XDFFQ_MB_ck2 XD2_XDFFQ_MB ck2 6.0502e-17
* device instance cc_XD2_XDFFQ_MB_ck3 r0 *1 0,0
Ccc_XD2_XDFFQ_MB_ck3 XD2_XDFFQ_MB ck3 5.4452e-17
* device instance cc_XD2_XDFFQ_MB_ck4 r0 *1 0,0
Ccc_XD2_XDFFQ_MB_ck4 XD2_XDFFQ_MB ck4 5.4452e-17
* device instance cc_XD2_XDFFQ_MB_ck5 r0 *1 0,0
Ccc_XD2_XDFFQ_MB_ck5 XD2_XDFFQ_MB ck5 5.4452e-17
* device instance cc_XD2_XDFFQ_MB_mod0 r0 *1 0,0
Ccc_XD2_XDFFQ_MB_mod0 XD2_XDFFQ_MB mod0 2.4201e-17
* device instance cc_XD2_XDFFQ_MB_mod1 r0 *1 0,0
Ccc_XD2_XDFFQ_MB_mod1 XD2_XDFFQ_MB mod1 2.4201e-17
* device instance cc_XD2_XDFFQ_MB_mod2 r0 *1 0,0
Ccc_XD2_XDFFQ_MB_mod2 XD2_XDFFQ_MB mod2 2.4201e-17
* device instance cc_XD2_XDFFQ_MB_mod3 r0 *1 0,0
Ccc_XD2_XDFFQ_MB_mod3 XD2_XDFFQ_MB mod3 2.4201e-17
* device instance cc_XD2_XDFFQ_MB_mod4 r0 *1 0,0
Ccc_XD2_XDFFQ_MB_mod4 XD2_XDFFQ_MB mod4 2.4201e-17
* device instance cc_XD2_XDFFQ_MB_net1 r0 *1 0,0
Ccc_XD2_XDFFQ_MB_net1 XD2_XDFFQ_MB net1 1.21e-17
* device instance cc_XD2_XDFFQ_S_XD2_XDFFQ_SB r0 *1 0,0
Ccc_XD2_XDFFQ_S_XD2_XDFFQ_SB XD2_XDFFQ_S XD2_XDFFQ_SB 4.0738e-17
* device instance cc_XD2_XDFFQ_S_XD2_XN2_mid1 r0 *1 0,0
Ccc_XD2_XDFFQ_S_XD2_XN2_mid1 XD2_XDFFQ_S XD2_XN2_mid1 1.21e-17
* device instance cc_XD2_XDFFQ_S_XD2_XNOR_midp r0 *1 0,0
Ccc_XD2_XDFFQ_S_XD2_XNOR_midp XD2_XDFFQ_S XD2_XNOR_midp 1.21e-17
* device instance cc_XD2_XDFFQ_S_XD2_dmodout r0 *1 0,0
Ccc_XD2_XDFFQ_S_XD2_dmodout XD2_XDFFQ_S XD2_dmodout 1.21e-17
* device instance cc_XD2_XDFFQ_S_XD2_dq r0 *1 0,0
Ccc_XD2_XDFFQ_S_XD2_dq XD2_XDFFQ_S XD2_dq 1.21e-17
* device instance cc_XD2_XDFFQ_S_XD2_nm r0 *1 0,0
Ccc_XD2_XDFFQ_S_XD2_nm XD2_XDFFQ_S XD2_nm 1.21e-17
* device instance cc_XD2_XDFFQ_S_XD2_nt r0 *1 0,0
Ccc_XD2_XDFFQ_S_XD2_nt XD2_XDFFQ_S XD2_nt 2.4201e-17
* device instance cc_XD2_XDFFQ_S_XD2_t1 r0 *1 0,0
Ccc_XD2_XDFFQ_S_XD2_t1 XD2_XDFFQ_S XD2_t1 1.21e-17
* device instance cc_XD2_XDFFQ_S_XD3_XDFFM_CLKB r0 *1 0,0
Ccc_XD2_XDFFQ_S_XD3_XDFFM_CLKB XD2_XDFFQ_S XD3_XDFFM_CLKB 1.8151e-17
* device instance cc_XD2_XDFFQ_S_XD3_XDFFM_M r0 *1 0,0
Ccc_XD2_XDFFQ_S_XD3_XDFFM_M XD2_XDFFQ_S XD3_XDFFM_M 2.4201e-17
* device instance cc_XD2_XDFFQ_S_XD3_XDFFM_MB r0 *1 0,0
Ccc_XD2_XDFFQ_S_XD3_XDFFM_MB XD2_XDFFQ_S XD3_XDFFM_MB 1.21e-17
* device instance cc_XD2_XDFFQ_S_XD3_XDFFM_S r0 *1 0,0
Ccc_XD2_XDFFQ_S_XD3_XDFFM_S XD2_XDFFQ_S XD3_XDFFM_S 1.8151e-17
* device instance cc_XD2_XDFFQ_S_XD3_XDFFM_SB r0 *1 0,0
Ccc_XD2_XDFFQ_S_XD3_XDFFM_SB XD2_XDFFQ_S XD3_XDFFM_SB 1.8151e-17
* device instance cc_XD2_XDFFQ_S_XD3_XDFFQ_CLKB r0 *1 0,0
Ccc_XD2_XDFFQ_S_XD3_XDFFQ_CLKB XD2_XDFFQ_S XD3_XDFFQ_CLKB 1.8151e-17
* device instance cc_XD2_XDFFQ_S_XD3_XDFFQ_M r0 *1 0,0
Ccc_XD2_XDFFQ_S_XD3_XDFFQ_M XD2_XDFFQ_S XD3_XDFFQ_M 2.4201e-17
* device instance cc_XD2_XDFFQ_S_XD3_XDFFQ_MB r0 *1 0,0
Ccc_XD2_XDFFQ_S_XD3_XDFFQ_MB XD2_XDFFQ_S XD3_XDFFQ_MB 1.21e-17
* device instance cc_XD2_XDFFQ_S_XD3_XDFFQ_S r0 *1 0,0
Ccc_XD2_XDFFQ_S_XD3_XDFFQ_S XD2_XDFFQ_S XD3_XDFFQ_S 1.8151e-17
* device instance cc_XD2_XDFFQ_S_XD3_XDFFQ_SB r0 *1 0,0
Ccc_XD2_XDFFQ_S_XD3_XDFFQ_SB XD2_XDFFQ_S XD3_XDFFQ_SB 1.8151e-17
* device instance cc_XD2_XDFFQ_S_XD3_XN2_mid1 r0 *1 0,0
Ccc_XD2_XDFFQ_S_XD3_XN2_mid1 XD2_XDFFQ_S XD3_XN2_mid1 1.21e-17
* device instance cc_XD2_XDFFQ_S_XD3_XN3_mid1 r0 *1 0,0
Ccc_XD2_XDFFQ_S_XD3_XN3_mid1 XD2_XDFFQ_S XD3_XN3_mid1 1.21e-17
* device instance cc_XD2_XDFFQ_S_XD3_XN3_mid2 r0 *1 0,0
Ccc_XD2_XDFFQ_S_XD3_XN3_mid2 XD2_XDFFQ_S XD3_XN3_mid2 1.21e-17
* device instance cc_XD2_XDFFQ_S_XD3_dmodout r0 *1 0,0
Ccc_XD2_XDFFQ_S_XD3_dmodout XD2_XDFFQ_S XD3_dmodout 1.21e-17
* device instance cc_XD2_XDFFQ_S_XD3_dq r0 *1 0,0
Ccc_XD2_XDFFQ_S_XD3_dq XD2_XDFFQ_S XD3_dq 1.8151e-17
* device instance cc_XD2_XDFFQ_S_XD3_nm r0 *1 0,0
Ccc_XD2_XDFFQ_S_XD3_nm XD2_XDFFQ_S XD3_nm 1.21e-17
* device instance cc_XD2_XDFFQ_S_XD3_nt r0 *1 0,0
Ccc_XD2_XDFFQ_S_XD3_nt XD2_XDFFQ_S XD3_nt 1.21e-17
* device instance cc_XD2_XDFFQ_S_XD3_t1 r0 *1 0,0
Ccc_XD2_XDFFQ_S_XD3_t1 XD2_XDFFQ_S XD3_t1 1.21e-17
* device instance cc_XD2_XDFFQ_S_XD4_XDFFM_CLKB r0 *1 0,0
Ccc_XD2_XDFFQ_S_XD4_XDFFM_CLKB XD2_XDFFQ_S XD4_XDFFM_CLKB 1.8151e-17
* device instance cc_XD2_XDFFQ_S_XD4_XDFFM_M r0 *1 0,0
Ccc_XD2_XDFFQ_S_XD4_XDFFM_M XD2_XDFFQ_S XD4_XDFFM_M 2.4201e-17
* device instance cc_XD2_XDFFQ_S_XD4_XDFFM_MB r0 *1 0,0
Ccc_XD2_XDFFQ_S_XD4_XDFFM_MB XD2_XDFFQ_S XD4_XDFFM_MB 1.21e-17
* device instance cc_XD2_XDFFQ_S_XD4_XDFFM_S r0 *1 0,0
Ccc_XD2_XDFFQ_S_XD4_XDFFM_S XD2_XDFFQ_S XD4_XDFFM_S 1.8151e-17
* device instance cc_XD2_XDFFQ_S_XD4_XDFFM_SB r0 *1 0,0
Ccc_XD2_XDFFQ_S_XD4_XDFFM_SB XD2_XDFFQ_S XD4_XDFFM_SB 1.8151e-17
* device instance cc_XD2_XDFFQ_S_XD4_XDFFQ_CLKB r0 *1 0,0
Ccc_XD2_XDFFQ_S_XD4_XDFFQ_CLKB XD2_XDFFQ_S XD4_XDFFQ_CLKB 1.8151e-17
* device instance cc_XD2_XDFFQ_S_XD4_XDFFQ_M r0 *1 0,0
Ccc_XD2_XDFFQ_S_XD4_XDFFQ_M XD2_XDFFQ_S XD4_XDFFQ_M 2.4201e-17
* device instance cc_XD2_XDFFQ_S_XD4_XDFFQ_MB r0 *1 0,0
Ccc_XD2_XDFFQ_S_XD4_XDFFQ_MB XD2_XDFFQ_S XD4_XDFFQ_MB 1.21e-17
* device instance cc_XD2_XDFFQ_S_XD4_XDFFQ_S r0 *1 0,0
Ccc_XD2_XDFFQ_S_XD4_XDFFQ_S XD2_XDFFQ_S XD4_XDFFQ_S 1.8151e-17
* device instance cc_XD2_XDFFQ_S_XD4_XDFFQ_SB r0 *1 0,0
Ccc_XD2_XDFFQ_S_XD4_XDFFQ_SB XD2_XDFFQ_S XD4_XDFFQ_SB 1.8151e-17
* device instance cc_XD2_XDFFQ_S_XD4_XN2_mid1 r0 *1 0,0
Ccc_XD2_XDFFQ_S_XD4_XN2_mid1 XD2_XDFFQ_S XD4_XN2_mid1 1.21e-17
* device instance cc_XD2_XDFFQ_S_XD4_XN3_mid1 r0 *1 0,0
Ccc_XD2_XDFFQ_S_XD4_XN3_mid1 XD2_XDFFQ_S XD4_XN3_mid1 1.21e-17
* device instance cc_XD2_XDFFQ_S_XD4_XN3_mid2 r0 *1 0,0
Ccc_XD2_XDFFQ_S_XD4_XN3_mid2 XD2_XDFFQ_S XD4_XN3_mid2 1.21e-17
* device instance cc_XD2_XDFFQ_S_XD4_dmodout r0 *1 0,0
Ccc_XD2_XDFFQ_S_XD4_dmodout XD2_XDFFQ_S XD4_dmodout 1.21e-17
* device instance cc_XD2_XDFFQ_S_XD4_dq r0 *1 0,0
Ccc_XD2_XDFFQ_S_XD4_dq XD2_XDFFQ_S XD4_dq 1.8151e-17
* device instance cc_XD2_XDFFQ_S_XD4_nm r0 *1 0,0
Ccc_XD2_XDFFQ_S_XD4_nm XD2_XDFFQ_S XD4_nm 1.21e-17
* device instance cc_XD2_XDFFQ_S_XD4_nt r0 *1 0,0
Ccc_XD2_XDFFQ_S_XD4_nt XD2_XDFFQ_S XD4_nt 1.21e-17
* device instance cc_XD2_XDFFQ_S_XD4_t1 r0 *1 0,0
Ccc_XD2_XDFFQ_S_XD4_t1 XD2_XDFFQ_S XD4_t1 1.21e-17
* device instance cc_XD2_XDFFQ_S_XD5_XDFFM_CLKB r0 *1 0,0
Ccc_XD2_XDFFQ_S_XD5_XDFFM_CLKB XD2_XDFFQ_S XD5_XDFFM_CLKB 1.8151e-17
* device instance cc_XD2_XDFFQ_S_XD5_XDFFM_M r0 *1 0,0
Ccc_XD2_XDFFQ_S_XD5_XDFFM_M XD2_XDFFQ_S XD5_XDFFM_M 2.4201e-17
* device instance cc_XD2_XDFFQ_S_XD5_XDFFM_MB r0 *1 0,0
Ccc_XD2_XDFFQ_S_XD5_XDFFM_MB XD2_XDFFQ_S XD5_XDFFM_MB 1.21e-17
* device instance cc_XD2_XDFFQ_S_XD5_XDFFM_S r0 *1 0,0
Ccc_XD2_XDFFQ_S_XD5_XDFFM_S XD2_XDFFQ_S XD5_XDFFM_S 1.8151e-17
* device instance cc_XD2_XDFFQ_S_XD5_XDFFM_SB r0 *1 0,0
Ccc_XD2_XDFFQ_S_XD5_XDFFM_SB XD2_XDFFQ_S XD5_XDFFM_SB 1.8151e-17
* device instance cc_XD2_XDFFQ_S_XD5_XDFFQ_CLKB r0 *1 0,0
Ccc_XD2_XDFFQ_S_XD5_XDFFQ_CLKB XD2_XDFFQ_S XD5_XDFFQ_CLKB 1.8151e-17
* device instance cc_XD2_XDFFQ_S_XD5_XDFFQ_M r0 *1 0,0
Ccc_XD2_XDFFQ_S_XD5_XDFFQ_M XD2_XDFFQ_S XD5_XDFFQ_M 2.4201e-17
* device instance cc_XD2_XDFFQ_S_XD5_XDFFQ_MB r0 *1 0,0
Ccc_XD2_XDFFQ_S_XD5_XDFFQ_MB XD2_XDFFQ_S XD5_XDFFQ_MB 1.21e-17
* device instance cc_XD2_XDFFQ_S_XD5_XDFFQ_S r0 *1 0,0
Ccc_XD2_XDFFQ_S_XD5_XDFFQ_S XD2_XDFFQ_S XD5_XDFFQ_S 1.8151e-17
* device instance cc_XD2_XDFFQ_S_XD5_XDFFQ_SB r0 *1 0,0
Ccc_XD2_XDFFQ_S_XD5_XDFFQ_SB XD2_XDFFQ_S XD5_XDFFQ_SB 1.8151e-17
* device instance cc_XD2_XDFFQ_S_XD5_XN2_mid1 r0 *1 0,0
Ccc_XD2_XDFFQ_S_XD5_XN2_mid1 XD2_XDFFQ_S XD5_XN2_mid1 1.21e-17
* device instance cc_XD2_XDFFQ_S_XD5_XN3_mid1 r0 *1 0,0
Ccc_XD2_XDFFQ_S_XD5_XN3_mid1 XD2_XDFFQ_S XD5_XN3_mid1 1.21e-17
* device instance cc_XD2_XDFFQ_S_XD5_XN3_mid2 r0 *1 0,0
Ccc_XD2_XDFFQ_S_XD5_XN3_mid2 XD2_XDFFQ_S XD5_XN3_mid2 1.21e-17
* device instance cc_XD2_XDFFQ_S_XD5_dmodout r0 *1 0,0
Ccc_XD2_XDFFQ_S_XD5_dmodout XD2_XDFFQ_S XD5_dmodout 1.21e-17
* device instance cc_XD2_XDFFQ_S_XD5_dq r0 *1 0,0
Ccc_XD2_XDFFQ_S_XD5_dq XD2_XDFFQ_S XD5_dq 1.8151e-17
* device instance cc_XD2_XDFFQ_S_XD5_nm r0 *1 0,0
Ccc_XD2_XDFFQ_S_XD5_nm XD2_XDFFQ_S XD5_nm 1.21e-17
* device instance cc_XD2_XDFFQ_S_XD5_nt r0 *1 0,0
Ccc_XD2_XDFFQ_S_XD5_nt XD2_XDFFQ_S XD5_nt 1.21e-17
* device instance cc_XD2_XDFFQ_S_XD5_t1 r0 *1 0,0
Ccc_XD2_XDFFQ_S_XD5_t1 XD2_XDFFQ_S XD5_t1 1.21e-17
* device instance cc_XD2_XDFFQ_S_XFRT_CLKB r0 *1 0,0
Ccc_XD2_XDFFQ_S_XFRT_CLKB XD2_XDFFQ_S XFRT_CLKB 1.8151e-17
* device instance cc_XD2_XDFFQ_S_XFRT_M r0 *1 0,0
Ccc_XD2_XDFFQ_S_XFRT_M XD2_XDFFQ_S XFRT_M 2.4201e-17
* device instance cc_XD2_XDFFQ_S_XFRT_MB r0 *1 0,0
Ccc_XD2_XDFFQ_S_XFRT_MB XD2_XDFFQ_S XFRT_MB 1.21e-17
* device instance cc_XD2_XDFFQ_S_XFRT_S r0 *1 0,0
Ccc_XD2_XDFFQ_S_XFRT_S XD2_XDFFQ_S XFRT_S 1.8151e-17
* device instance cc_XD2_XDFFQ_S_XFRT_SB r0 *1 0,0
Ccc_XD2_XDFFQ_S_XFRT_SB XD2_XDFFQ_S XFRT_SB 1.8151e-17
* device instance cc_XD2_XDFFQ_S_ck1 r0 *1 0,0
Ccc_XD2_XDFFQ_S_ck1 XD2_XDFFQ_S ck1 5.4452e-17
* device instance cc_XD2_XDFFQ_S_ck2 r0 *1 0,0
Ccc_XD2_XDFFQ_S_ck2 XD2_XDFFQ_S ck2 5.4452e-17
* device instance cc_XD2_XDFFQ_S_ck3 r0 *1 0,0
Ccc_XD2_XDFFQ_S_ck3 XD2_XDFFQ_S ck3 5.4452e-17
* device instance cc_XD2_XDFFQ_S_ck4 r0 *1 0,0
Ccc_XD2_XDFFQ_S_ck4 XD2_XDFFQ_S ck4 5.4452e-17
* device instance cc_XD2_XDFFQ_S_ck5 r0 *1 0,0
Ccc_XD2_XDFFQ_S_ck5 XD2_XDFFQ_S ck5 5.4452e-17
* device instance cc_XD2_XDFFQ_S_mod0 r0 *1 0,0
Ccc_XD2_XDFFQ_S_mod0 XD2_XDFFQ_S mod0 2.4201e-17
* device instance cc_XD2_XDFFQ_S_mod1 r0 *1 0,0
Ccc_XD2_XDFFQ_S_mod1 XD2_XDFFQ_S mod1 2.4201e-17
* device instance cc_XD2_XDFFQ_S_mod2 r0 *1 0,0
Ccc_XD2_XDFFQ_S_mod2 XD2_XDFFQ_S mod2 2.4201e-17
* device instance cc_XD2_XDFFQ_S_mod3 r0 *1 0,0
Ccc_XD2_XDFFQ_S_mod3 XD2_XDFFQ_S mod3 2.4201e-17
* device instance cc_XD2_XDFFQ_S_mod4 r0 *1 0,0
Ccc_XD2_XDFFQ_S_mod4 XD2_XDFFQ_S mod4 2.4201e-17
* device instance cc_XD2_XDFFQ_S_net1 r0 *1 0,0
Ccc_XD2_XDFFQ_S_net1 XD2_XDFFQ_S net1 1.21e-17
* device instance cc_XD2_XDFFQ_SB_XD2_XN2_mid1 r0 *1 0,0
Ccc_XD2_XDFFQ_SB_XD2_XN2_mid1 XD2_XDFFQ_SB XD2_XN2_mid1 1.21e-17
* device instance cc_XD2_XDFFQ_SB_XD2_XNOR_midp r0 *1 0,0
Ccc_XD2_XDFFQ_SB_XD2_XNOR_midp XD2_XDFFQ_SB XD2_XNOR_midp 1.21e-17
* device instance cc_XD2_XDFFQ_SB_XD2_dmodout r0 *1 0,0
Ccc_XD2_XDFFQ_SB_XD2_dmodout XD2_XDFFQ_SB XD2_dmodout 1.21e-17
* device instance cc_XD2_XDFFQ_SB_XD2_dq r0 *1 0,0
Ccc_XD2_XDFFQ_SB_XD2_dq XD2_XDFFQ_SB XD2_dq 1.21e-17
* device instance cc_XD2_XDFFQ_SB_XD2_nm r0 *1 0,0
Ccc_XD2_XDFFQ_SB_XD2_nm XD2_XDFFQ_SB XD2_nm 1.21e-17
* device instance cc_XD2_XDFFQ_SB_XD2_nt r0 *1 0,0
Ccc_XD2_XDFFQ_SB_XD2_nt XD2_XDFFQ_SB XD2_nt 2.4201e-17
* device instance cc_XD2_XDFFQ_SB_XD2_t1 r0 *1 0,0
Ccc_XD2_XDFFQ_SB_XD2_t1 XD2_XDFFQ_SB XD2_t1 1.21e-17
* device instance cc_XD2_XDFFQ_SB_XD3_XDFFM_CLKB r0 *1 0,0
Ccc_XD2_XDFFQ_SB_XD3_XDFFM_CLKB XD2_XDFFQ_SB XD3_XDFFM_CLKB 1.8151e-17
* device instance cc_XD2_XDFFQ_SB_XD3_XDFFM_M r0 *1 0,0
Ccc_XD2_XDFFQ_SB_XD3_XDFFM_M XD2_XDFFQ_SB XD3_XDFFM_M 2.4201e-17
* device instance cc_XD2_XDFFQ_SB_XD3_XDFFM_MB r0 *1 0,0
Ccc_XD2_XDFFQ_SB_XD3_XDFFM_MB XD2_XDFFQ_SB XD3_XDFFM_MB 1.21e-17
* device instance cc_XD2_XDFFQ_SB_XD3_XDFFM_S r0 *1 0,0
Ccc_XD2_XDFFQ_SB_XD3_XDFFM_S XD2_XDFFQ_SB XD3_XDFFM_S 1.8151e-17
* device instance cc_XD2_XDFFQ_SB_XD3_XDFFM_SB r0 *1 0,0
Ccc_XD2_XDFFQ_SB_XD3_XDFFM_SB XD2_XDFFQ_SB XD3_XDFFM_SB 1.8151e-17
* device instance cc_XD2_XDFFQ_SB_XD3_XDFFQ_CLKB r0 *1 0,0
Ccc_XD2_XDFFQ_SB_XD3_XDFFQ_CLKB XD2_XDFFQ_SB XD3_XDFFQ_CLKB 1.8151e-17
* device instance cc_XD2_XDFFQ_SB_XD3_XDFFQ_M r0 *1 0,0
Ccc_XD2_XDFFQ_SB_XD3_XDFFQ_M XD2_XDFFQ_SB XD3_XDFFQ_M 2.4201e-17
* device instance cc_XD2_XDFFQ_SB_XD3_XDFFQ_MB r0 *1 0,0
Ccc_XD2_XDFFQ_SB_XD3_XDFFQ_MB XD2_XDFFQ_SB XD3_XDFFQ_MB 1.21e-17
* device instance cc_XD2_XDFFQ_SB_XD3_XDFFQ_S r0 *1 0,0
Ccc_XD2_XDFFQ_SB_XD3_XDFFQ_S XD2_XDFFQ_SB XD3_XDFFQ_S 1.8151e-17
* device instance cc_XD2_XDFFQ_SB_XD3_XDFFQ_SB r0 *1 0,0
Ccc_XD2_XDFFQ_SB_XD3_XDFFQ_SB XD2_XDFFQ_SB XD3_XDFFQ_SB 1.8151e-17
* device instance cc_XD2_XDFFQ_SB_XD3_XN2_mid1 r0 *1 0,0
Ccc_XD2_XDFFQ_SB_XD3_XN2_mid1 XD2_XDFFQ_SB XD3_XN2_mid1 1.21e-17
* device instance cc_XD2_XDFFQ_SB_XD3_XN3_mid1 r0 *1 0,0
Ccc_XD2_XDFFQ_SB_XD3_XN3_mid1 XD2_XDFFQ_SB XD3_XN3_mid1 1.21e-17
* device instance cc_XD2_XDFFQ_SB_XD3_XN3_mid2 r0 *1 0,0
Ccc_XD2_XDFFQ_SB_XD3_XN3_mid2 XD2_XDFFQ_SB XD3_XN3_mid2 1.21e-17
* device instance cc_XD2_XDFFQ_SB_XD3_dmodout r0 *1 0,0
Ccc_XD2_XDFFQ_SB_XD3_dmodout XD2_XDFFQ_SB XD3_dmodout 1.21e-17
* device instance cc_XD2_XDFFQ_SB_XD3_dq r0 *1 0,0
Ccc_XD2_XDFFQ_SB_XD3_dq XD2_XDFFQ_SB XD3_dq 1.8151e-17
* device instance cc_XD2_XDFFQ_SB_XD3_nm r0 *1 0,0
Ccc_XD2_XDFFQ_SB_XD3_nm XD2_XDFFQ_SB XD3_nm 1.21e-17
* device instance cc_XD2_XDFFQ_SB_XD3_nt r0 *1 0,0
Ccc_XD2_XDFFQ_SB_XD3_nt XD2_XDFFQ_SB XD3_nt 1.21e-17
* device instance cc_XD2_XDFFQ_SB_XD3_t1 r0 *1 0,0
Ccc_XD2_XDFFQ_SB_XD3_t1 XD2_XDFFQ_SB XD3_t1 1.21e-17
* device instance cc_XD2_XDFFQ_SB_XD4_XDFFM_CLKB r0 *1 0,0
Ccc_XD2_XDFFQ_SB_XD4_XDFFM_CLKB XD2_XDFFQ_SB XD4_XDFFM_CLKB 1.8151e-17
* device instance cc_XD2_XDFFQ_SB_XD4_XDFFM_M r0 *1 0,0
Ccc_XD2_XDFFQ_SB_XD4_XDFFM_M XD2_XDFFQ_SB XD4_XDFFM_M 2.4201e-17
* device instance cc_XD2_XDFFQ_SB_XD4_XDFFM_MB r0 *1 0,0
Ccc_XD2_XDFFQ_SB_XD4_XDFFM_MB XD2_XDFFQ_SB XD4_XDFFM_MB 1.21e-17
* device instance cc_XD2_XDFFQ_SB_XD4_XDFFM_S r0 *1 0,0
Ccc_XD2_XDFFQ_SB_XD4_XDFFM_S XD2_XDFFQ_SB XD4_XDFFM_S 1.8151e-17
* device instance cc_XD2_XDFFQ_SB_XD4_XDFFM_SB r0 *1 0,0
Ccc_XD2_XDFFQ_SB_XD4_XDFFM_SB XD2_XDFFQ_SB XD4_XDFFM_SB 1.8151e-17
* device instance cc_XD2_XDFFQ_SB_XD4_XDFFQ_CLKB r0 *1 0,0
Ccc_XD2_XDFFQ_SB_XD4_XDFFQ_CLKB XD2_XDFFQ_SB XD4_XDFFQ_CLKB 1.8151e-17
* device instance cc_XD2_XDFFQ_SB_XD4_XDFFQ_M r0 *1 0,0
Ccc_XD2_XDFFQ_SB_XD4_XDFFQ_M XD2_XDFFQ_SB XD4_XDFFQ_M 2.4201e-17
* device instance cc_XD2_XDFFQ_SB_XD4_XDFFQ_MB r0 *1 0,0
Ccc_XD2_XDFFQ_SB_XD4_XDFFQ_MB XD2_XDFFQ_SB XD4_XDFFQ_MB 1.21e-17
* device instance cc_XD2_XDFFQ_SB_XD4_XDFFQ_S r0 *1 0,0
Ccc_XD2_XDFFQ_SB_XD4_XDFFQ_S XD2_XDFFQ_SB XD4_XDFFQ_S 1.8151e-17
* device instance cc_XD2_XDFFQ_SB_XD4_XDFFQ_SB r0 *1 0,0
Ccc_XD2_XDFFQ_SB_XD4_XDFFQ_SB XD2_XDFFQ_SB XD4_XDFFQ_SB 1.8151e-17
* device instance cc_XD2_XDFFQ_SB_XD4_XN2_mid1 r0 *1 0,0
Ccc_XD2_XDFFQ_SB_XD4_XN2_mid1 XD2_XDFFQ_SB XD4_XN2_mid1 1.21e-17
* device instance cc_XD2_XDFFQ_SB_XD4_XN3_mid1 r0 *1 0,0
Ccc_XD2_XDFFQ_SB_XD4_XN3_mid1 XD2_XDFFQ_SB XD4_XN3_mid1 1.21e-17
* device instance cc_XD2_XDFFQ_SB_XD4_XN3_mid2 r0 *1 0,0
Ccc_XD2_XDFFQ_SB_XD4_XN3_mid2 XD2_XDFFQ_SB XD4_XN3_mid2 1.21e-17
* device instance cc_XD2_XDFFQ_SB_XD4_dmodout r0 *1 0,0
Ccc_XD2_XDFFQ_SB_XD4_dmodout XD2_XDFFQ_SB XD4_dmodout 1.21e-17
* device instance cc_XD2_XDFFQ_SB_XD4_dq r0 *1 0,0
Ccc_XD2_XDFFQ_SB_XD4_dq XD2_XDFFQ_SB XD4_dq 1.8151e-17
* device instance cc_XD2_XDFFQ_SB_XD4_nm r0 *1 0,0
Ccc_XD2_XDFFQ_SB_XD4_nm XD2_XDFFQ_SB XD4_nm 1.21e-17
* device instance cc_XD2_XDFFQ_SB_XD4_nt r0 *1 0,0
Ccc_XD2_XDFFQ_SB_XD4_nt XD2_XDFFQ_SB XD4_nt 1.21e-17
* device instance cc_XD2_XDFFQ_SB_XD4_t1 r0 *1 0,0
Ccc_XD2_XDFFQ_SB_XD4_t1 XD2_XDFFQ_SB XD4_t1 1.21e-17
* device instance cc_XD2_XDFFQ_SB_XD5_XDFFM_CLKB r0 *1 0,0
Ccc_XD2_XDFFQ_SB_XD5_XDFFM_CLKB XD2_XDFFQ_SB XD5_XDFFM_CLKB 1.8151e-17
* device instance cc_XD2_XDFFQ_SB_XD5_XDFFM_M r0 *1 0,0
Ccc_XD2_XDFFQ_SB_XD5_XDFFM_M XD2_XDFFQ_SB XD5_XDFFM_M 2.4201e-17
* device instance cc_XD2_XDFFQ_SB_XD5_XDFFM_MB r0 *1 0,0
Ccc_XD2_XDFFQ_SB_XD5_XDFFM_MB XD2_XDFFQ_SB XD5_XDFFM_MB 1.21e-17
* device instance cc_XD2_XDFFQ_SB_XD5_XDFFM_S r0 *1 0,0
Ccc_XD2_XDFFQ_SB_XD5_XDFFM_S XD2_XDFFQ_SB XD5_XDFFM_S 1.8151e-17
* device instance cc_XD2_XDFFQ_SB_XD5_XDFFM_SB r0 *1 0,0
Ccc_XD2_XDFFQ_SB_XD5_XDFFM_SB XD2_XDFFQ_SB XD5_XDFFM_SB 1.8151e-17
* device instance cc_XD2_XDFFQ_SB_XD5_XDFFQ_CLKB r0 *1 0,0
Ccc_XD2_XDFFQ_SB_XD5_XDFFQ_CLKB XD2_XDFFQ_SB XD5_XDFFQ_CLKB 1.8151e-17
* device instance cc_XD2_XDFFQ_SB_XD5_XDFFQ_M r0 *1 0,0
Ccc_XD2_XDFFQ_SB_XD5_XDFFQ_M XD2_XDFFQ_SB XD5_XDFFQ_M 2.4201e-17
* device instance cc_XD2_XDFFQ_SB_XD5_XDFFQ_MB r0 *1 0,0
Ccc_XD2_XDFFQ_SB_XD5_XDFFQ_MB XD2_XDFFQ_SB XD5_XDFFQ_MB 1.21e-17
* device instance cc_XD2_XDFFQ_SB_XD5_XDFFQ_S r0 *1 0,0
Ccc_XD2_XDFFQ_SB_XD5_XDFFQ_S XD2_XDFFQ_SB XD5_XDFFQ_S 1.8151e-17
* device instance cc_XD2_XDFFQ_SB_XD5_XDFFQ_SB r0 *1 0,0
Ccc_XD2_XDFFQ_SB_XD5_XDFFQ_SB XD2_XDFFQ_SB XD5_XDFFQ_SB 1.8151e-17
* device instance cc_XD2_XDFFQ_SB_XD5_XN2_mid1 r0 *1 0,0
Ccc_XD2_XDFFQ_SB_XD5_XN2_mid1 XD2_XDFFQ_SB XD5_XN2_mid1 1.21e-17
* device instance cc_XD2_XDFFQ_SB_XD5_XN3_mid1 r0 *1 0,0
Ccc_XD2_XDFFQ_SB_XD5_XN3_mid1 XD2_XDFFQ_SB XD5_XN3_mid1 1.21e-17
* device instance cc_XD2_XDFFQ_SB_XD5_XN3_mid2 r0 *1 0,0
Ccc_XD2_XDFFQ_SB_XD5_XN3_mid2 XD2_XDFFQ_SB XD5_XN3_mid2 1.21e-17
* device instance cc_XD2_XDFFQ_SB_XD5_dmodout r0 *1 0,0
Ccc_XD2_XDFFQ_SB_XD5_dmodout XD2_XDFFQ_SB XD5_dmodout 1.21e-17
* device instance cc_XD2_XDFFQ_SB_XD5_dq r0 *1 0,0
Ccc_XD2_XDFFQ_SB_XD5_dq XD2_XDFFQ_SB XD5_dq 1.8151e-17
* device instance cc_XD2_XDFFQ_SB_XD5_nm r0 *1 0,0
Ccc_XD2_XDFFQ_SB_XD5_nm XD2_XDFFQ_SB XD5_nm 1.21e-17
* device instance cc_XD2_XDFFQ_SB_XD5_nt r0 *1 0,0
Ccc_XD2_XDFFQ_SB_XD5_nt XD2_XDFFQ_SB XD5_nt 1.21e-17
* device instance cc_XD2_XDFFQ_SB_XD5_t1 r0 *1 0,0
Ccc_XD2_XDFFQ_SB_XD5_t1 XD2_XDFFQ_SB XD5_t1 1.21e-17
* device instance cc_XD2_XDFFQ_SB_XFRT_CLKB r0 *1 0,0
Ccc_XD2_XDFFQ_SB_XFRT_CLKB XD2_XDFFQ_SB XFRT_CLKB 1.8151e-17
* device instance cc_XD2_XDFFQ_SB_XFRT_M r0 *1 0,0
Ccc_XD2_XDFFQ_SB_XFRT_M XD2_XDFFQ_SB XFRT_M 2.4201e-17
* device instance cc_XD2_XDFFQ_SB_XFRT_MB r0 *1 0,0
Ccc_XD2_XDFFQ_SB_XFRT_MB XD2_XDFFQ_SB XFRT_MB 1.21e-17
* device instance cc_XD2_XDFFQ_SB_XFRT_S r0 *1 0,0
Ccc_XD2_XDFFQ_SB_XFRT_S XD2_XDFFQ_SB XFRT_S 1.8151e-17
* device instance cc_XD2_XDFFQ_SB_XFRT_SB r0 *1 0,0
Ccc_XD2_XDFFQ_SB_XFRT_SB XD2_XDFFQ_SB XFRT_SB 1.8151e-17
* device instance cc_XD2_XDFFQ_SB_ck1 r0 *1 0,0
Ccc_XD2_XDFFQ_SB_ck1 XD2_XDFFQ_SB ck1 5.4452e-17
* device instance cc_XD2_XDFFQ_SB_ck2 r0 *1 0,0
Ccc_XD2_XDFFQ_SB_ck2 XD2_XDFFQ_SB ck2 5.4452e-17
* device instance cc_XD2_XDFFQ_SB_ck3 r0 *1 0,0
Ccc_XD2_XDFFQ_SB_ck3 XD2_XDFFQ_SB ck3 5.4452e-17
* device instance cc_XD2_XDFFQ_SB_ck4 r0 *1 0,0
Ccc_XD2_XDFFQ_SB_ck4 XD2_XDFFQ_SB ck4 5.4452e-17
* device instance cc_XD2_XDFFQ_SB_ck5 r0 *1 0,0
Ccc_XD2_XDFFQ_SB_ck5 XD2_XDFFQ_SB ck5 5.4452e-17
* device instance cc_XD2_XDFFQ_SB_mod0 r0 *1 0,0
Ccc_XD2_XDFFQ_SB_mod0 XD2_XDFFQ_SB mod0 2.4201e-17
* device instance cc_XD2_XDFFQ_SB_mod1 r0 *1 0,0
Ccc_XD2_XDFFQ_SB_mod1 XD2_XDFFQ_SB mod1 2.4201e-17
* device instance cc_XD2_XDFFQ_SB_mod2 r0 *1 0,0
Ccc_XD2_XDFFQ_SB_mod2 XD2_XDFFQ_SB mod2 2.4201e-17
* device instance cc_XD2_XDFFQ_SB_mod3 r0 *1 0,0
Ccc_XD2_XDFFQ_SB_mod3 XD2_XDFFQ_SB mod3 2.4201e-17
* device instance cc_XD2_XDFFQ_SB_mod4 r0 *1 0,0
Ccc_XD2_XDFFQ_SB_mod4 XD2_XDFFQ_SB mod4 2.4201e-17
* device instance cc_XD2_XDFFQ_SB_net1 r0 *1 0,0
Ccc_XD2_XDFFQ_SB_net1 XD2_XDFFQ_SB net1 1.21e-17
* device instance cc_XD2_XN2_mid1_XD2_nm r0 *1 0,0
Ccc_XD2_XN2_mid1_XD2_nm XD2_XN2_mid1 XD2_nm 1.1294e-17
* device instance cc_XD2_XN2_mid1_ck3 r0 *1 0,0
Ccc_XD2_XN2_mid1_ck3 XD2_XN2_mid1 ck3 6.05e-18
* device instance cc_XD2_XN3_mid1_XD2_XN3_mid2 r0 *1 0,0
Ccc_XD2_XN3_mid1_XD2_XN3_mid2 XD2_XN3_mid1 XD2_XN3_mid2 1.1294e-17
* device instance cc_XD2_XN3_mid1_XD2_nt r0 *1 0,0
Ccc_XD2_XN3_mid1_XD2_nt XD2_XN3_mid1 XD2_nt 1.1294e-17
* device instance cc_XD2_XN3_mid2_mod1 r0 *1 0,0
Ccc_XD2_XN3_mid2_mod1 XD2_XN3_mid2 mod1 6.05e-18
* device instance cc_XD2_XNOR_midp_XD2_dq r0 *1 0,0
Ccc_XD2_XNOR_midp_XD2_dq XD2_XNOR_midp XD2_dq 5.244e-18
* device instance cc_XD2_XNOR_midp_XD2_t1 r0 *1 0,0
Ccc_XD2_XNOR_midp_XD2_t1 XD2_XNOR_midp XD2_t1 6.05e-18
* device instance cc_XD2_dmodout_XD2_dq r0 *1 0,0
Ccc_XD2_dmodout_XD2_dq XD2_dmodout XD2_dq 1.21e-17
* device instance cc_XD2_dmodout_XD2_nm r0 *1 0,0
Ccc_XD2_dmodout_XD2_nm XD2_dmodout XD2_nm 1.8151e-17
* device instance cc_XD2_dmodout_XD2_nt r0 *1 0,0
Ccc_XD2_dmodout_XD2_nt XD2_dmodout XD2_nt 2.4201e-17
* device instance cc_XD2_dmodout_XD2_t1 r0 *1 0,0
Ccc_XD2_dmodout_XD2_t1 XD2_dmodout XD2_t1 1.21e-17
* device instance cc_XD2_dmodout_XD3_XDFFM_CLKB r0 *1 0,0
Ccc_XD2_dmodout_XD3_XDFFM_CLKB XD2_dmodout XD3_XDFFM_CLKB 1.8151e-17
* device instance cc_XD2_dmodout_XD3_XDFFM_M r0 *1 0,0
Ccc_XD2_dmodout_XD3_XDFFM_M XD2_dmodout XD3_XDFFM_M 2.4201e-17
* device instance cc_XD2_dmodout_XD3_XDFFM_MB r0 *1 0,0
Ccc_XD2_dmodout_XD3_XDFFM_MB XD2_dmodout XD3_XDFFM_MB 1.21e-17
* device instance cc_XD2_dmodout_XD3_XDFFM_S r0 *1 0,0
Ccc_XD2_dmodout_XD3_XDFFM_S XD2_dmodout XD3_XDFFM_S 1.8151e-17
* device instance cc_XD2_dmodout_XD3_XDFFM_SB r0 *1 0,0
Ccc_XD2_dmodout_XD3_XDFFM_SB XD2_dmodout XD3_XDFFM_SB 1.8151e-17
* device instance cc_XD2_dmodout_XD3_XDFFQ_CLKB r0 *1 0,0
Ccc_XD2_dmodout_XD3_XDFFQ_CLKB XD2_dmodout XD3_XDFFQ_CLKB 1.8151e-17
* device instance cc_XD2_dmodout_XD3_XDFFQ_M r0 *1 0,0
Ccc_XD2_dmodout_XD3_XDFFQ_M XD2_dmodout XD3_XDFFQ_M 2.4201e-17
* device instance cc_XD2_dmodout_XD3_XDFFQ_MB r0 *1 0,0
Ccc_XD2_dmodout_XD3_XDFFQ_MB XD2_dmodout XD3_XDFFQ_MB 1.21e-17
* device instance cc_XD2_dmodout_XD3_XDFFQ_S r0 *1 0,0
Ccc_XD2_dmodout_XD3_XDFFQ_S XD2_dmodout XD3_XDFFQ_S 1.8151e-17
* device instance cc_XD2_dmodout_XD3_XDFFQ_SB r0 *1 0,0
Ccc_XD2_dmodout_XD3_XDFFQ_SB XD2_dmodout XD3_XDFFQ_SB 1.8151e-17
* device instance cc_XD2_dmodout_XD3_XN2_mid1 r0 *1 0,0
Ccc_XD2_dmodout_XD3_XN2_mid1 XD2_dmodout XD3_XN2_mid1 1.21e-17
* device instance cc_XD2_dmodout_XD3_XN3_mid1 r0 *1 0,0
Ccc_XD2_dmodout_XD3_XN3_mid1 XD2_dmodout XD3_XN3_mid1 1.21e-17
* device instance cc_XD2_dmodout_XD3_XN3_mid2 r0 *1 0,0
Ccc_XD2_dmodout_XD3_XN3_mid2 XD2_dmodout XD3_XN3_mid2 1.21e-17
* device instance cc_XD2_dmodout_XD3_dmodout r0 *1 0,0
Ccc_XD2_dmodout_XD3_dmodout XD2_dmodout XD3_dmodout 1.21e-17
* device instance cc_XD2_dmodout_XD3_dq r0 *1 0,0
Ccc_XD2_dmodout_XD3_dq XD2_dmodout XD3_dq 1.8151e-17
* device instance cc_XD2_dmodout_XD3_nm r0 *1 0,0
Ccc_XD2_dmodout_XD3_nm XD2_dmodout XD3_nm 1.21e-17
* device instance cc_XD2_dmodout_XD3_nt r0 *1 0,0
Ccc_XD2_dmodout_XD3_nt XD2_dmodout XD3_nt 1.21e-17
* device instance cc_XD2_dmodout_XD3_t1 r0 *1 0,0
Ccc_XD2_dmodout_XD3_t1 XD2_dmodout XD3_t1 1.21e-17
* device instance cc_XD2_dmodout_XD4_XDFFM_CLKB r0 *1 0,0
Ccc_XD2_dmodout_XD4_XDFFM_CLKB XD2_dmodout XD4_XDFFM_CLKB 1.8151e-17
* device instance cc_XD2_dmodout_XD4_XDFFM_M r0 *1 0,0
Ccc_XD2_dmodout_XD4_XDFFM_M XD2_dmodout XD4_XDFFM_M 2.4201e-17
* device instance cc_XD2_dmodout_XD4_XDFFM_MB r0 *1 0,0
Ccc_XD2_dmodout_XD4_XDFFM_MB XD2_dmodout XD4_XDFFM_MB 1.21e-17
* device instance cc_XD2_dmodout_XD4_XDFFM_S r0 *1 0,0
Ccc_XD2_dmodout_XD4_XDFFM_S XD2_dmodout XD4_XDFFM_S 1.8151e-17
* device instance cc_XD2_dmodout_XD4_XDFFM_SB r0 *1 0,0
Ccc_XD2_dmodout_XD4_XDFFM_SB XD2_dmodout XD4_XDFFM_SB 1.8151e-17
* device instance cc_XD2_dmodout_XD4_XDFFQ_CLKB r0 *1 0,0
Ccc_XD2_dmodout_XD4_XDFFQ_CLKB XD2_dmodout XD4_XDFFQ_CLKB 1.8151e-17
* device instance cc_XD2_dmodout_XD4_XDFFQ_M r0 *1 0,0
Ccc_XD2_dmodout_XD4_XDFFQ_M XD2_dmodout XD4_XDFFQ_M 2.4201e-17
* device instance cc_XD2_dmodout_XD4_XDFFQ_MB r0 *1 0,0
Ccc_XD2_dmodout_XD4_XDFFQ_MB XD2_dmodout XD4_XDFFQ_MB 1.21e-17
* device instance cc_XD2_dmodout_XD4_XDFFQ_S r0 *1 0,0
Ccc_XD2_dmodout_XD4_XDFFQ_S XD2_dmodout XD4_XDFFQ_S 1.8151e-17
* device instance cc_XD2_dmodout_XD4_XDFFQ_SB r0 *1 0,0
Ccc_XD2_dmodout_XD4_XDFFQ_SB XD2_dmodout XD4_XDFFQ_SB 1.8151e-17
* device instance cc_XD2_dmodout_XD4_XN2_mid1 r0 *1 0,0
Ccc_XD2_dmodout_XD4_XN2_mid1 XD2_dmodout XD4_XN2_mid1 1.21e-17
* device instance cc_XD2_dmodout_XD4_XN3_mid1 r0 *1 0,0
Ccc_XD2_dmodout_XD4_XN3_mid1 XD2_dmodout XD4_XN3_mid1 1.21e-17
* device instance cc_XD2_dmodout_XD4_XN3_mid2 r0 *1 0,0
Ccc_XD2_dmodout_XD4_XN3_mid2 XD2_dmodout XD4_XN3_mid2 1.21e-17
* device instance cc_XD2_dmodout_XD4_dmodout r0 *1 0,0
Ccc_XD2_dmodout_XD4_dmodout XD2_dmodout XD4_dmodout 1.21e-17
* device instance cc_XD2_dmodout_XD4_dq r0 *1 0,0
Ccc_XD2_dmodout_XD4_dq XD2_dmodout XD4_dq 1.8151e-17
* device instance cc_XD2_dmodout_XD4_nm r0 *1 0,0
Ccc_XD2_dmodout_XD4_nm XD2_dmodout XD4_nm 1.21e-17
* device instance cc_XD2_dmodout_XD4_nt r0 *1 0,0
Ccc_XD2_dmodout_XD4_nt XD2_dmodout XD4_nt 1.21e-17
* device instance cc_XD2_dmodout_XD4_t1 r0 *1 0,0
Ccc_XD2_dmodout_XD4_t1 XD2_dmodout XD4_t1 1.21e-17
* device instance cc_XD2_dmodout_XD5_XDFFM_CLKB r0 *1 0,0
Ccc_XD2_dmodout_XD5_XDFFM_CLKB XD2_dmodout XD5_XDFFM_CLKB 1.8151e-17
* device instance cc_XD2_dmodout_XD5_XDFFM_M r0 *1 0,0
Ccc_XD2_dmodout_XD5_XDFFM_M XD2_dmodout XD5_XDFFM_M 2.4201e-17
* device instance cc_XD2_dmodout_XD5_XDFFM_MB r0 *1 0,0
Ccc_XD2_dmodout_XD5_XDFFM_MB XD2_dmodout XD5_XDFFM_MB 1.21e-17
* device instance cc_XD2_dmodout_XD5_XDFFM_S r0 *1 0,0
Ccc_XD2_dmodout_XD5_XDFFM_S XD2_dmodout XD5_XDFFM_S 1.8151e-17
* device instance cc_XD2_dmodout_XD5_XDFFM_SB r0 *1 0,0
Ccc_XD2_dmodout_XD5_XDFFM_SB XD2_dmodout XD5_XDFFM_SB 1.8151e-17
* device instance cc_XD2_dmodout_XD5_XDFFQ_CLKB r0 *1 0,0
Ccc_XD2_dmodout_XD5_XDFFQ_CLKB XD2_dmodout XD5_XDFFQ_CLKB 1.8151e-17
* device instance cc_XD2_dmodout_XD5_XDFFQ_M r0 *1 0,0
Ccc_XD2_dmodout_XD5_XDFFQ_M XD2_dmodout XD5_XDFFQ_M 2.4201e-17
* device instance cc_XD2_dmodout_XD5_XDFFQ_MB r0 *1 0,0
Ccc_XD2_dmodout_XD5_XDFFQ_MB XD2_dmodout XD5_XDFFQ_MB 1.21e-17
* device instance cc_XD2_dmodout_XD5_XDFFQ_S r0 *1 0,0
Ccc_XD2_dmodout_XD5_XDFFQ_S XD2_dmodout XD5_XDFFQ_S 1.8151e-17
* device instance cc_XD2_dmodout_XD5_XDFFQ_SB r0 *1 0,0
Ccc_XD2_dmodout_XD5_XDFFQ_SB XD2_dmodout XD5_XDFFQ_SB 1.8151e-17
* device instance cc_XD2_dmodout_XD5_XN2_mid1 r0 *1 0,0
Ccc_XD2_dmodout_XD5_XN2_mid1 XD2_dmodout XD5_XN2_mid1 1.21e-17
* device instance cc_XD2_dmodout_XD5_XN3_mid1 r0 *1 0,0
Ccc_XD2_dmodout_XD5_XN3_mid1 XD2_dmodout XD5_XN3_mid1 1.21e-17
* device instance cc_XD2_dmodout_XD5_XN3_mid2 r0 *1 0,0
Ccc_XD2_dmodout_XD5_XN3_mid2 XD2_dmodout XD5_XN3_mid2 1.21e-17
* device instance cc_XD2_dmodout_XD5_dmodout r0 *1 0,0
Ccc_XD2_dmodout_XD5_dmodout XD2_dmodout XD5_dmodout 1.21e-17
* device instance cc_XD2_dmodout_XD5_dq r0 *1 0,0
Ccc_XD2_dmodout_XD5_dq XD2_dmodout XD5_dq 1.8151e-17
* device instance cc_XD2_dmodout_XD5_nm r0 *1 0,0
Ccc_XD2_dmodout_XD5_nm XD2_dmodout XD5_nm 1.21e-17
* device instance cc_XD2_dmodout_XD5_nt r0 *1 0,0
Ccc_XD2_dmodout_XD5_nt XD2_dmodout XD5_nt 1.21e-17
* device instance cc_XD2_dmodout_XD5_t1 r0 *1 0,0
Ccc_XD2_dmodout_XD5_t1 XD2_dmodout XD5_t1 1.21e-17
* device instance cc_XD2_dmodout_XFRT_CLKB r0 *1 0,0
Ccc_XD2_dmodout_XFRT_CLKB XD2_dmodout XFRT_CLKB 1.8151e-17
* device instance cc_XD2_dmodout_XFRT_M r0 *1 0,0
Ccc_XD2_dmodout_XFRT_M XD2_dmodout XFRT_M 2.4201e-17
* device instance cc_XD2_dmodout_XFRT_MB r0 *1 0,0
Ccc_XD2_dmodout_XFRT_MB XD2_dmodout XFRT_MB 1.21e-17
* device instance cc_XD2_dmodout_XFRT_S r0 *1 0,0
Ccc_XD2_dmodout_XFRT_S XD2_dmodout XFRT_S 1.8151e-17
* device instance cc_XD2_dmodout_XFRT_SB r0 *1 0,0
Ccc_XD2_dmodout_XFRT_SB XD2_dmodout XFRT_SB 1.8151e-17
* device instance cc_XD2_dmodout_ck1 r0 *1 0,0
Ccc_XD2_dmodout_ck1 XD2_dmodout ck1 5.4452e-17
* device instance cc_XD2_dmodout_ck2 r0 *1 0,0
Ccc_XD2_dmodout_ck2 XD2_dmodout ck2 6.6553e-17
* device instance cc_XD2_dmodout_ck3 r0 *1 0,0
Ccc_XD2_dmodout_ck3 XD2_dmodout ck3 5.4452e-17
* device instance cc_XD2_dmodout_ck4 r0 *1 0,0
Ccc_XD2_dmodout_ck4 XD2_dmodout ck4 5.4452e-17
* device instance cc_XD2_dmodout_ck5 r0 *1 0,0
Ccc_XD2_dmodout_ck5 XD2_dmodout ck5 5.4452e-17
* device instance cc_XD2_dmodout_mod0 r0 *1 0,0
Ccc_XD2_dmodout_mod0 XD2_dmodout mod0 2.4201e-17
* device instance cc_XD2_dmodout_mod1 r0 *1 0,0
Ccc_XD2_dmodout_mod1 XD2_dmodout mod1 2.4201e-17
* device instance cc_XD2_dmodout_mod2 r0 *1 0,0
Ccc_XD2_dmodout_mod2 XD2_dmodout mod2 2.4201e-17
* device instance cc_XD2_dmodout_mod3 r0 *1 0,0
Ccc_XD2_dmodout_mod3 XD2_dmodout mod3 2.4201e-17
* device instance cc_XD2_dmodout_mod4 r0 *1 0,0
Ccc_XD2_dmodout_mod4 XD2_dmodout mod4 2.4201e-17
* device instance cc_XD2_dmodout_net1 r0 *1 0,0
Ccc_XD2_dmodout_net1 XD2_dmodout net1 1.21e-17
* device instance cc_XD2_dq_XD2_nm r0 *1 0,0
Ccc_XD2_dq_XD2_nm XD2_dq XD2_nm 1.21e-17
* device instance cc_XD2_dq_XD2_nt r0 *1 0,0
Ccc_XD2_dq_XD2_nt XD2_dq XD2_nt 2.4201e-17
* device instance cc_XD2_dq_XD2_t1 r0 *1 0,0
Ccc_XD2_dq_XD2_t1 XD2_dq XD2_t1 1.8151e-17
* device instance cc_XD2_dq_XD3_XDFFM_CLKB r0 *1 0,0
Ccc_XD2_dq_XD3_XDFFM_CLKB XD2_dq XD3_XDFFM_CLKB 1.8151e-17
* device instance cc_XD2_dq_XD3_XDFFM_M r0 *1 0,0
Ccc_XD2_dq_XD3_XDFFM_M XD2_dq XD3_XDFFM_M 2.4201e-17
* device instance cc_XD2_dq_XD3_XDFFM_MB r0 *1 0,0
Ccc_XD2_dq_XD3_XDFFM_MB XD2_dq XD3_XDFFM_MB 1.21e-17
* device instance cc_XD2_dq_XD3_XDFFM_S r0 *1 0,0
Ccc_XD2_dq_XD3_XDFFM_S XD2_dq XD3_XDFFM_S 1.8151e-17
* device instance cc_XD2_dq_XD3_XDFFM_SB r0 *1 0,0
Ccc_XD2_dq_XD3_XDFFM_SB XD2_dq XD3_XDFFM_SB 1.8151e-17
* device instance cc_XD2_dq_XD3_XDFFQ_CLKB r0 *1 0,0
Ccc_XD2_dq_XD3_XDFFQ_CLKB XD2_dq XD3_XDFFQ_CLKB 1.8151e-17
* device instance cc_XD2_dq_XD3_XDFFQ_M r0 *1 0,0
Ccc_XD2_dq_XD3_XDFFQ_M XD2_dq XD3_XDFFQ_M 2.4201e-17
* device instance cc_XD2_dq_XD3_XDFFQ_MB r0 *1 0,0
Ccc_XD2_dq_XD3_XDFFQ_MB XD2_dq XD3_XDFFQ_MB 1.21e-17
* device instance cc_XD2_dq_XD3_XDFFQ_S r0 *1 0,0
Ccc_XD2_dq_XD3_XDFFQ_S XD2_dq XD3_XDFFQ_S 1.8151e-17
* device instance cc_XD2_dq_XD3_XDFFQ_SB r0 *1 0,0
Ccc_XD2_dq_XD3_XDFFQ_SB XD2_dq XD3_XDFFQ_SB 1.8151e-17
* device instance cc_XD2_dq_XD3_XN2_mid1 r0 *1 0,0
Ccc_XD2_dq_XD3_XN2_mid1 XD2_dq XD3_XN2_mid1 1.21e-17
* device instance cc_XD2_dq_XD3_XN3_mid1 r0 *1 0,0
Ccc_XD2_dq_XD3_XN3_mid1 XD2_dq XD3_XN3_mid1 1.21e-17
* device instance cc_XD2_dq_XD3_XN3_mid2 r0 *1 0,0
Ccc_XD2_dq_XD3_XN3_mid2 XD2_dq XD3_XN3_mid2 1.21e-17
* device instance cc_XD2_dq_XD3_dmodout r0 *1 0,0
Ccc_XD2_dq_XD3_dmodout XD2_dq XD3_dmodout 1.21e-17
* device instance cc_XD2_dq_XD3_dq r0 *1 0,0
Ccc_XD2_dq_XD3_dq XD2_dq XD3_dq 1.8151e-17
* device instance cc_XD2_dq_XD3_nm r0 *1 0,0
Ccc_XD2_dq_XD3_nm XD2_dq XD3_nm 1.21e-17
* device instance cc_XD2_dq_XD3_nt r0 *1 0,0
Ccc_XD2_dq_XD3_nt XD2_dq XD3_nt 1.21e-17
* device instance cc_XD2_dq_XD3_t1 r0 *1 0,0
Ccc_XD2_dq_XD3_t1 XD2_dq XD3_t1 1.21e-17
* device instance cc_XD2_dq_XD4_XDFFM_CLKB r0 *1 0,0
Ccc_XD2_dq_XD4_XDFFM_CLKB XD2_dq XD4_XDFFM_CLKB 1.8151e-17
* device instance cc_XD2_dq_XD4_XDFFM_M r0 *1 0,0
Ccc_XD2_dq_XD4_XDFFM_M XD2_dq XD4_XDFFM_M 2.4201e-17
* device instance cc_XD2_dq_XD4_XDFFM_MB r0 *1 0,0
Ccc_XD2_dq_XD4_XDFFM_MB XD2_dq XD4_XDFFM_MB 1.21e-17
* device instance cc_XD2_dq_XD4_XDFFM_S r0 *1 0,0
Ccc_XD2_dq_XD4_XDFFM_S XD2_dq XD4_XDFFM_S 1.8151e-17
* device instance cc_XD2_dq_XD4_XDFFM_SB r0 *1 0,0
Ccc_XD2_dq_XD4_XDFFM_SB XD2_dq XD4_XDFFM_SB 1.8151e-17
* device instance cc_XD2_dq_XD4_XDFFQ_CLKB r0 *1 0,0
Ccc_XD2_dq_XD4_XDFFQ_CLKB XD2_dq XD4_XDFFQ_CLKB 1.8151e-17
* device instance cc_XD2_dq_XD4_XDFFQ_M r0 *1 0,0
Ccc_XD2_dq_XD4_XDFFQ_M XD2_dq XD4_XDFFQ_M 2.4201e-17
* device instance cc_XD2_dq_XD4_XDFFQ_MB r0 *1 0,0
Ccc_XD2_dq_XD4_XDFFQ_MB XD2_dq XD4_XDFFQ_MB 1.21e-17
* device instance cc_XD2_dq_XD4_XDFFQ_S r0 *1 0,0
Ccc_XD2_dq_XD4_XDFFQ_S XD2_dq XD4_XDFFQ_S 1.8151e-17
* device instance cc_XD2_dq_XD4_XDFFQ_SB r0 *1 0,0
Ccc_XD2_dq_XD4_XDFFQ_SB XD2_dq XD4_XDFFQ_SB 1.8151e-17
* device instance cc_XD2_dq_XD4_XN2_mid1 r0 *1 0,0
Ccc_XD2_dq_XD4_XN2_mid1 XD2_dq XD4_XN2_mid1 1.21e-17
* device instance cc_XD2_dq_XD4_XN3_mid1 r0 *1 0,0
Ccc_XD2_dq_XD4_XN3_mid1 XD2_dq XD4_XN3_mid1 1.21e-17
* device instance cc_XD2_dq_XD4_XN3_mid2 r0 *1 0,0
Ccc_XD2_dq_XD4_XN3_mid2 XD2_dq XD4_XN3_mid2 1.21e-17
* device instance cc_XD2_dq_XD4_dmodout r0 *1 0,0
Ccc_XD2_dq_XD4_dmodout XD2_dq XD4_dmodout 1.21e-17
* device instance cc_XD2_dq_XD4_dq r0 *1 0,0
Ccc_XD2_dq_XD4_dq XD2_dq XD4_dq 1.8151e-17
* device instance cc_XD2_dq_XD4_nm r0 *1 0,0
Ccc_XD2_dq_XD4_nm XD2_dq XD4_nm 1.21e-17
* device instance cc_XD2_dq_XD4_nt r0 *1 0,0
Ccc_XD2_dq_XD4_nt XD2_dq XD4_nt 1.21e-17
* device instance cc_XD2_dq_XD4_t1 r0 *1 0,0
Ccc_XD2_dq_XD4_t1 XD2_dq XD4_t1 1.21e-17
* device instance cc_XD2_dq_XD5_XDFFM_CLKB r0 *1 0,0
Ccc_XD2_dq_XD5_XDFFM_CLKB XD2_dq XD5_XDFFM_CLKB 1.8151e-17
* device instance cc_XD2_dq_XD5_XDFFM_M r0 *1 0,0
Ccc_XD2_dq_XD5_XDFFM_M XD2_dq XD5_XDFFM_M 2.4201e-17
* device instance cc_XD2_dq_XD5_XDFFM_MB r0 *1 0,0
Ccc_XD2_dq_XD5_XDFFM_MB XD2_dq XD5_XDFFM_MB 1.21e-17
* device instance cc_XD2_dq_XD5_XDFFM_S r0 *1 0,0
Ccc_XD2_dq_XD5_XDFFM_S XD2_dq XD5_XDFFM_S 1.8151e-17
* device instance cc_XD2_dq_XD5_XDFFM_SB r0 *1 0,0
Ccc_XD2_dq_XD5_XDFFM_SB XD2_dq XD5_XDFFM_SB 1.8151e-17
* device instance cc_XD2_dq_XD5_XDFFQ_CLKB r0 *1 0,0
Ccc_XD2_dq_XD5_XDFFQ_CLKB XD2_dq XD5_XDFFQ_CLKB 1.8151e-17
* device instance cc_XD2_dq_XD5_XDFFQ_M r0 *1 0,0
Ccc_XD2_dq_XD5_XDFFQ_M XD2_dq XD5_XDFFQ_M 2.4201e-17
* device instance cc_XD2_dq_XD5_XDFFQ_MB r0 *1 0,0
Ccc_XD2_dq_XD5_XDFFQ_MB XD2_dq XD5_XDFFQ_MB 1.21e-17
* device instance cc_XD2_dq_XD5_XDFFQ_S r0 *1 0,0
Ccc_XD2_dq_XD5_XDFFQ_S XD2_dq XD5_XDFFQ_S 1.8151e-17
* device instance cc_XD2_dq_XD5_XDFFQ_SB r0 *1 0,0
Ccc_XD2_dq_XD5_XDFFQ_SB XD2_dq XD5_XDFFQ_SB 1.8151e-17
* device instance cc_XD2_dq_XD5_XN2_mid1 r0 *1 0,0
Ccc_XD2_dq_XD5_XN2_mid1 XD2_dq XD5_XN2_mid1 1.21e-17
* device instance cc_XD2_dq_XD5_XN3_mid1 r0 *1 0,0
Ccc_XD2_dq_XD5_XN3_mid1 XD2_dq XD5_XN3_mid1 1.21e-17
* device instance cc_XD2_dq_XD5_XN3_mid2 r0 *1 0,0
Ccc_XD2_dq_XD5_XN3_mid2 XD2_dq XD5_XN3_mid2 1.21e-17
* device instance cc_XD2_dq_XD5_dmodout r0 *1 0,0
Ccc_XD2_dq_XD5_dmodout XD2_dq XD5_dmodout 1.21e-17
* device instance cc_XD2_dq_XD5_dq r0 *1 0,0
Ccc_XD2_dq_XD5_dq XD2_dq XD5_dq 1.8151e-17
* device instance cc_XD2_dq_XD5_nm r0 *1 0,0
Ccc_XD2_dq_XD5_nm XD2_dq XD5_nm 1.21e-17
* device instance cc_XD2_dq_XD5_nt r0 *1 0,0
Ccc_XD2_dq_XD5_nt XD2_dq XD5_nt 1.21e-17
* device instance cc_XD2_dq_XD5_t1 r0 *1 0,0
Ccc_XD2_dq_XD5_t1 XD2_dq XD5_t1 1.21e-17
* device instance cc_XD2_dq_XFRT_CLKB r0 *1 0,0
Ccc_XD2_dq_XFRT_CLKB XD2_dq XFRT_CLKB 1.8151e-17
* device instance cc_XD2_dq_XFRT_M r0 *1 0,0
Ccc_XD2_dq_XFRT_M XD2_dq XFRT_M 2.4201e-17
* device instance cc_XD2_dq_XFRT_MB r0 *1 0,0
Ccc_XD2_dq_XFRT_MB XD2_dq XFRT_MB 1.21e-17
* device instance cc_XD2_dq_XFRT_S r0 *1 0,0
Ccc_XD2_dq_XFRT_S XD2_dq XFRT_S 1.8151e-17
* device instance cc_XD2_dq_XFRT_SB r0 *1 0,0
Ccc_XD2_dq_XFRT_SB XD2_dq XFRT_SB 1.8151e-17
* device instance cc_XD2_dq_ck1 r0 *1 0,0
Ccc_XD2_dq_ck1 XD2_dq ck1 5.4452e-17
* device instance cc_XD2_dq_ck2 r0 *1 0,0
Ccc_XD2_dq_ck2 XD2_dq ck2 6.6553e-17
* device instance cc_XD2_dq_ck3 r0 *1 0,0
Ccc_XD2_dq_ck3 XD2_dq ck3 5.4452e-17
* device instance cc_XD2_dq_ck4 r0 *1 0,0
Ccc_XD2_dq_ck4 XD2_dq ck4 5.4452e-17
* device instance cc_XD2_dq_ck5 r0 *1 0,0
Ccc_XD2_dq_ck5 XD2_dq ck5 5.4452e-17
* device instance cc_XD2_dq_mod0 r0 *1 0,0
Ccc_XD2_dq_mod0 XD2_dq mod0 2.4201e-17
* device instance cc_XD2_dq_mod1 r0 *1 0,0
Ccc_XD2_dq_mod1 XD2_dq mod1 2.4201e-17
* device instance cc_XD2_dq_mod2 r0 *1 0,0
Ccc_XD2_dq_mod2 XD2_dq mod2 2.4201e-17
* device instance cc_XD2_dq_mod3 r0 *1 0,0
Ccc_XD2_dq_mod3 XD2_dq mod3 2.4201e-17
* device instance cc_XD2_dq_mod4 r0 *1 0,0
Ccc_XD2_dq_mod4 XD2_dq mod4 2.4201e-17
* device instance cc_XD2_dq_net1 r0 *1 0,0
Ccc_XD2_dq_net1 XD2_dq net1 1.21e-17
* device instance cc_XD2_nm_XD2_nt r0 *1 0,0
Ccc_XD2_nm_XD2_nt XD2_nm XD2_nt 2.4201e-17
* device instance cc_XD2_nm_XD2_t1 r0 *1 0,0
Ccc_XD2_nm_XD2_t1 XD2_nm XD2_t1 1.21e-17
* device instance cc_XD2_nm_XD3_XDFFM_CLKB r0 *1 0,0
Ccc_XD2_nm_XD3_XDFFM_CLKB XD2_nm XD3_XDFFM_CLKB 1.8151e-17
* device instance cc_XD2_nm_XD3_XDFFM_M r0 *1 0,0
Ccc_XD2_nm_XD3_XDFFM_M XD2_nm XD3_XDFFM_M 2.4201e-17
* device instance cc_XD2_nm_XD3_XDFFM_MB r0 *1 0,0
Ccc_XD2_nm_XD3_XDFFM_MB XD2_nm XD3_XDFFM_MB 1.21e-17
* device instance cc_XD2_nm_XD3_XDFFM_S r0 *1 0,0
Ccc_XD2_nm_XD3_XDFFM_S XD2_nm XD3_XDFFM_S 1.8151e-17
* device instance cc_XD2_nm_XD3_XDFFM_SB r0 *1 0,0
Ccc_XD2_nm_XD3_XDFFM_SB XD2_nm XD3_XDFFM_SB 1.8151e-17
* device instance cc_XD2_nm_XD3_XDFFQ_CLKB r0 *1 0,0
Ccc_XD2_nm_XD3_XDFFQ_CLKB XD2_nm XD3_XDFFQ_CLKB 1.8151e-17
* device instance cc_XD2_nm_XD3_XDFFQ_M r0 *1 0,0
Ccc_XD2_nm_XD3_XDFFQ_M XD2_nm XD3_XDFFQ_M 2.4201e-17
* device instance cc_XD2_nm_XD3_XDFFQ_MB r0 *1 0,0
Ccc_XD2_nm_XD3_XDFFQ_MB XD2_nm XD3_XDFFQ_MB 1.21e-17
* device instance cc_XD2_nm_XD3_XDFFQ_S r0 *1 0,0
Ccc_XD2_nm_XD3_XDFFQ_S XD2_nm XD3_XDFFQ_S 1.8151e-17
* device instance cc_XD2_nm_XD3_XDFFQ_SB r0 *1 0,0
Ccc_XD2_nm_XD3_XDFFQ_SB XD2_nm XD3_XDFFQ_SB 1.8151e-17
* device instance cc_XD2_nm_XD3_XN2_mid1 r0 *1 0,0
Ccc_XD2_nm_XD3_XN2_mid1 XD2_nm XD3_XN2_mid1 1.21e-17
* device instance cc_XD2_nm_XD3_XN3_mid1 r0 *1 0,0
Ccc_XD2_nm_XD3_XN3_mid1 XD2_nm XD3_XN3_mid1 1.21e-17
* device instance cc_XD2_nm_XD3_XN3_mid2 r0 *1 0,0
Ccc_XD2_nm_XD3_XN3_mid2 XD2_nm XD3_XN3_mid2 1.21e-17
* device instance cc_XD2_nm_XD3_dmodout r0 *1 0,0
Ccc_XD2_nm_XD3_dmodout XD2_nm XD3_dmodout 1.21e-17
* device instance cc_XD2_nm_XD3_dq r0 *1 0,0
Ccc_XD2_nm_XD3_dq XD2_nm XD3_dq 1.8151e-17
* device instance cc_XD2_nm_XD3_nm r0 *1 0,0
Ccc_XD2_nm_XD3_nm XD2_nm XD3_nm 1.21e-17
* device instance cc_XD2_nm_XD3_nt r0 *1 0,0
Ccc_XD2_nm_XD3_nt XD2_nm XD3_nt 1.21e-17
* device instance cc_XD2_nm_XD3_t1 r0 *1 0,0
Ccc_XD2_nm_XD3_t1 XD2_nm XD3_t1 1.21e-17
* device instance cc_XD2_nm_XD4_XDFFM_CLKB r0 *1 0,0
Ccc_XD2_nm_XD4_XDFFM_CLKB XD2_nm XD4_XDFFM_CLKB 1.8151e-17
* device instance cc_XD2_nm_XD4_XDFFM_M r0 *1 0,0
Ccc_XD2_nm_XD4_XDFFM_M XD2_nm XD4_XDFFM_M 2.4201e-17
* device instance cc_XD2_nm_XD4_XDFFM_MB r0 *1 0,0
Ccc_XD2_nm_XD4_XDFFM_MB XD2_nm XD4_XDFFM_MB 1.21e-17
* device instance cc_XD2_nm_XD4_XDFFM_S r0 *1 0,0
Ccc_XD2_nm_XD4_XDFFM_S XD2_nm XD4_XDFFM_S 1.8151e-17
* device instance cc_XD2_nm_XD4_XDFFM_SB r0 *1 0,0
Ccc_XD2_nm_XD4_XDFFM_SB XD2_nm XD4_XDFFM_SB 1.8151e-17
* device instance cc_XD2_nm_XD4_XDFFQ_CLKB r0 *1 0,0
Ccc_XD2_nm_XD4_XDFFQ_CLKB XD2_nm XD4_XDFFQ_CLKB 1.8151e-17
* device instance cc_XD2_nm_XD4_XDFFQ_M r0 *1 0,0
Ccc_XD2_nm_XD4_XDFFQ_M XD2_nm XD4_XDFFQ_M 2.4201e-17
* device instance cc_XD2_nm_XD4_XDFFQ_MB r0 *1 0,0
Ccc_XD2_nm_XD4_XDFFQ_MB XD2_nm XD4_XDFFQ_MB 1.21e-17
* device instance cc_XD2_nm_XD4_XDFFQ_S r0 *1 0,0
Ccc_XD2_nm_XD4_XDFFQ_S XD2_nm XD4_XDFFQ_S 1.8151e-17
* device instance cc_XD2_nm_XD4_XDFFQ_SB r0 *1 0,0
Ccc_XD2_nm_XD4_XDFFQ_SB XD2_nm XD4_XDFFQ_SB 1.8151e-17
* device instance cc_XD2_nm_XD4_XN2_mid1 r0 *1 0,0
Ccc_XD2_nm_XD4_XN2_mid1 XD2_nm XD4_XN2_mid1 1.21e-17
* device instance cc_XD2_nm_XD4_XN3_mid1 r0 *1 0,0
Ccc_XD2_nm_XD4_XN3_mid1 XD2_nm XD4_XN3_mid1 1.21e-17
* device instance cc_XD2_nm_XD4_XN3_mid2 r0 *1 0,0
Ccc_XD2_nm_XD4_XN3_mid2 XD2_nm XD4_XN3_mid2 1.21e-17
* device instance cc_XD2_nm_XD4_dmodout r0 *1 0,0
Ccc_XD2_nm_XD4_dmodout XD2_nm XD4_dmodout 1.21e-17
* device instance cc_XD2_nm_XD4_dq r0 *1 0,0
Ccc_XD2_nm_XD4_dq XD2_nm XD4_dq 1.8151e-17
* device instance cc_XD2_nm_XD4_nm r0 *1 0,0
Ccc_XD2_nm_XD4_nm XD2_nm XD4_nm 1.21e-17
* device instance cc_XD2_nm_XD4_nt r0 *1 0,0
Ccc_XD2_nm_XD4_nt XD2_nm XD4_nt 1.21e-17
* device instance cc_XD2_nm_XD4_t1 r0 *1 0,0
Ccc_XD2_nm_XD4_t1 XD2_nm XD4_t1 1.21e-17
* device instance cc_XD2_nm_XD5_XDFFM_CLKB r0 *1 0,0
Ccc_XD2_nm_XD5_XDFFM_CLKB XD2_nm XD5_XDFFM_CLKB 1.8151e-17
* device instance cc_XD2_nm_XD5_XDFFM_M r0 *1 0,0
Ccc_XD2_nm_XD5_XDFFM_M XD2_nm XD5_XDFFM_M 2.4201e-17
* device instance cc_XD2_nm_XD5_XDFFM_MB r0 *1 0,0
Ccc_XD2_nm_XD5_XDFFM_MB XD2_nm XD5_XDFFM_MB 1.21e-17
* device instance cc_XD2_nm_XD5_XDFFM_S r0 *1 0,0
Ccc_XD2_nm_XD5_XDFFM_S XD2_nm XD5_XDFFM_S 1.8151e-17
* device instance cc_XD2_nm_XD5_XDFFM_SB r0 *1 0,0
Ccc_XD2_nm_XD5_XDFFM_SB XD2_nm XD5_XDFFM_SB 1.8151e-17
* device instance cc_XD2_nm_XD5_XDFFQ_CLKB r0 *1 0,0
Ccc_XD2_nm_XD5_XDFFQ_CLKB XD2_nm XD5_XDFFQ_CLKB 1.8151e-17
* device instance cc_XD2_nm_XD5_XDFFQ_M r0 *1 0,0
Ccc_XD2_nm_XD5_XDFFQ_M XD2_nm XD5_XDFFQ_M 2.4201e-17
* device instance cc_XD2_nm_XD5_XDFFQ_MB r0 *1 0,0
Ccc_XD2_nm_XD5_XDFFQ_MB XD2_nm XD5_XDFFQ_MB 1.21e-17
* device instance cc_XD2_nm_XD5_XDFFQ_S r0 *1 0,0
Ccc_XD2_nm_XD5_XDFFQ_S XD2_nm XD5_XDFFQ_S 1.8151e-17
* device instance cc_XD2_nm_XD5_XDFFQ_SB r0 *1 0,0
Ccc_XD2_nm_XD5_XDFFQ_SB XD2_nm XD5_XDFFQ_SB 1.8151e-17
* device instance cc_XD2_nm_XD5_XN2_mid1 r0 *1 0,0
Ccc_XD2_nm_XD5_XN2_mid1 XD2_nm XD5_XN2_mid1 1.21e-17
* device instance cc_XD2_nm_XD5_XN3_mid1 r0 *1 0,0
Ccc_XD2_nm_XD5_XN3_mid1 XD2_nm XD5_XN3_mid1 1.21e-17
* device instance cc_XD2_nm_XD5_XN3_mid2 r0 *1 0,0
Ccc_XD2_nm_XD5_XN3_mid2 XD2_nm XD5_XN3_mid2 1.21e-17
* device instance cc_XD2_nm_XD5_dmodout r0 *1 0,0
Ccc_XD2_nm_XD5_dmodout XD2_nm XD5_dmodout 1.21e-17
* device instance cc_XD2_nm_XD5_dq r0 *1 0,0
Ccc_XD2_nm_XD5_dq XD2_nm XD5_dq 1.8151e-17
* device instance cc_XD2_nm_XD5_nm r0 *1 0,0
Ccc_XD2_nm_XD5_nm XD2_nm XD5_nm 1.21e-17
* device instance cc_XD2_nm_XD5_nt r0 *1 0,0
Ccc_XD2_nm_XD5_nt XD2_nm XD5_nt 1.21e-17
* device instance cc_XD2_nm_XD5_t1 r0 *1 0,0
Ccc_XD2_nm_XD5_t1 XD2_nm XD5_t1 1.21e-17
* device instance cc_XD2_nm_XFRT_CLKB r0 *1 0,0
Ccc_XD2_nm_XFRT_CLKB XD2_nm XFRT_CLKB 1.8151e-17
* device instance cc_XD2_nm_XFRT_M r0 *1 0,0
Ccc_XD2_nm_XFRT_M XD2_nm XFRT_M 2.4201e-17
* device instance cc_XD2_nm_XFRT_MB r0 *1 0,0
Ccc_XD2_nm_XFRT_MB XD2_nm XFRT_MB 1.21e-17
* device instance cc_XD2_nm_XFRT_S r0 *1 0,0
Ccc_XD2_nm_XFRT_S XD2_nm XFRT_S 1.8151e-17
* device instance cc_XD2_nm_XFRT_SB r0 *1 0,0
Ccc_XD2_nm_XFRT_SB XD2_nm XFRT_SB 1.8151e-17
* device instance cc_XD2_nm_ck1 r0 *1 0,0
Ccc_XD2_nm_ck1 XD2_nm ck1 5.4452e-17
* device instance cc_XD2_nm_ck2 r0 *1 0,0
Ccc_XD2_nm_ck2 XD2_nm ck2 5.4452e-17
* device instance cc_XD2_nm_ck3 r0 *1 0,0
Ccc_XD2_nm_ck3 XD2_nm ck3 6.0502e-17
* device instance cc_XD2_nm_ck4 r0 *1 0,0
Ccc_XD2_nm_ck4 XD2_nm ck4 5.4452e-17
* device instance cc_XD2_nm_ck5 r0 *1 0,0
Ccc_XD2_nm_ck5 XD2_nm ck5 5.4452e-17
* device instance cc_XD2_nm_mod0 r0 *1 0,0
Ccc_XD2_nm_mod0 XD2_nm mod0 2.4201e-17
* device instance cc_XD2_nm_mod1 r0 *1 0,0
Ccc_XD2_nm_mod1 XD2_nm mod1 2.4201e-17
* device instance cc_XD2_nm_mod2 r0 *1 0,0
Ccc_XD2_nm_mod2 XD2_nm mod2 2.4201e-17
* device instance cc_XD2_nm_mod3 r0 *1 0,0
Ccc_XD2_nm_mod3 XD2_nm mod3 2.4201e-17
* device instance cc_XD2_nm_mod4 r0 *1 0,0
Ccc_XD2_nm_mod4 XD2_nm mod4 2.4201e-17
* device instance cc_XD2_nm_net1 r0 *1 0,0
Ccc_XD2_nm_net1 XD2_nm net1 1.21e-17
* device instance cc_XD2_nt_XD2_t1 r0 *1 0,0
Ccc_XD2_nt_XD2_t1 XD2_nt XD2_t1 1.21e-17
* device instance cc_XD2_nt_XD3_XDFFM_CLKB r0 *1 0,0
Ccc_XD2_nt_XD3_XDFFM_CLKB XD2_nt XD3_XDFFM_CLKB 1.8151e-17
* device instance cc_XD2_nt_XD3_XDFFM_M r0 *1 0,0
Ccc_XD2_nt_XD3_XDFFM_M XD2_nt XD3_XDFFM_M 2.4201e-17
* device instance cc_XD2_nt_XD3_XDFFM_MB r0 *1 0,0
Ccc_XD2_nt_XD3_XDFFM_MB XD2_nt XD3_XDFFM_MB 1.21e-17
* device instance cc_XD2_nt_XD3_XDFFM_S r0 *1 0,0
Ccc_XD2_nt_XD3_XDFFM_S XD2_nt XD3_XDFFM_S 1.8151e-17
* device instance cc_XD2_nt_XD3_XDFFM_SB r0 *1 0,0
Ccc_XD2_nt_XD3_XDFFM_SB XD2_nt XD3_XDFFM_SB 1.8151e-17
* device instance cc_XD2_nt_XD3_XDFFQ_CLKB r0 *1 0,0
Ccc_XD2_nt_XD3_XDFFQ_CLKB XD2_nt XD3_XDFFQ_CLKB 1.8151e-17
* device instance cc_XD2_nt_XD3_XDFFQ_M r0 *1 0,0
Ccc_XD2_nt_XD3_XDFFQ_M XD2_nt XD3_XDFFQ_M 2.4201e-17
* device instance cc_XD2_nt_XD3_XDFFQ_MB r0 *1 0,0
Ccc_XD2_nt_XD3_XDFFQ_MB XD2_nt XD3_XDFFQ_MB 1.21e-17
* device instance cc_XD2_nt_XD3_XDFFQ_S r0 *1 0,0
Ccc_XD2_nt_XD3_XDFFQ_S XD2_nt XD3_XDFFQ_S 1.8151e-17
* device instance cc_XD2_nt_XD3_XDFFQ_SB r0 *1 0,0
Ccc_XD2_nt_XD3_XDFFQ_SB XD2_nt XD3_XDFFQ_SB 1.8151e-17
* device instance cc_XD2_nt_XD3_XN2_mid1 r0 *1 0,0
Ccc_XD2_nt_XD3_XN2_mid1 XD2_nt XD3_XN2_mid1 1.21e-17
* device instance cc_XD2_nt_XD3_XN3_mid1 r0 *1 0,0
Ccc_XD2_nt_XD3_XN3_mid1 XD2_nt XD3_XN3_mid1 1.21e-17
* device instance cc_XD2_nt_XD3_XN3_mid2 r0 *1 0,0
Ccc_XD2_nt_XD3_XN3_mid2 XD2_nt XD3_XN3_mid2 1.21e-17
* device instance cc_XD2_nt_XD3_dmodout r0 *1 0,0
Ccc_XD2_nt_XD3_dmodout XD2_nt XD3_dmodout 1.21e-17
* device instance cc_XD2_nt_XD3_dq r0 *1 0,0
Ccc_XD2_nt_XD3_dq XD2_nt XD3_dq 1.8151e-17
* device instance cc_XD2_nt_XD3_nm r0 *1 0,0
Ccc_XD2_nt_XD3_nm XD2_nt XD3_nm 1.21e-17
* device instance cc_XD2_nt_XD3_nt r0 *1 0,0
Ccc_XD2_nt_XD3_nt XD2_nt XD3_nt 1.21e-17
* device instance cc_XD2_nt_XD3_t1 r0 *1 0,0
Ccc_XD2_nt_XD3_t1 XD2_nt XD3_t1 1.21e-17
* device instance cc_XD2_nt_XD4_XDFFM_CLKB r0 *1 0,0
Ccc_XD2_nt_XD4_XDFFM_CLKB XD2_nt XD4_XDFFM_CLKB 1.8151e-17
* device instance cc_XD2_nt_XD4_XDFFM_M r0 *1 0,0
Ccc_XD2_nt_XD4_XDFFM_M XD2_nt XD4_XDFFM_M 2.4201e-17
* device instance cc_XD2_nt_XD4_XDFFM_MB r0 *1 0,0
Ccc_XD2_nt_XD4_XDFFM_MB XD2_nt XD4_XDFFM_MB 1.21e-17
* device instance cc_XD2_nt_XD4_XDFFM_S r0 *1 0,0
Ccc_XD2_nt_XD4_XDFFM_S XD2_nt XD4_XDFFM_S 1.8151e-17
* device instance cc_XD2_nt_XD4_XDFFM_SB r0 *1 0,0
Ccc_XD2_nt_XD4_XDFFM_SB XD2_nt XD4_XDFFM_SB 1.8151e-17
* device instance cc_XD2_nt_XD4_XDFFQ_CLKB r0 *1 0,0
Ccc_XD2_nt_XD4_XDFFQ_CLKB XD2_nt XD4_XDFFQ_CLKB 1.8151e-17
* device instance cc_XD2_nt_XD4_XDFFQ_M r0 *1 0,0
Ccc_XD2_nt_XD4_XDFFQ_M XD2_nt XD4_XDFFQ_M 2.4201e-17
* device instance cc_XD2_nt_XD4_XDFFQ_MB r0 *1 0,0
Ccc_XD2_nt_XD4_XDFFQ_MB XD2_nt XD4_XDFFQ_MB 1.21e-17
* device instance cc_XD2_nt_XD4_XDFFQ_S r0 *1 0,0
Ccc_XD2_nt_XD4_XDFFQ_S XD2_nt XD4_XDFFQ_S 1.8151e-17
* device instance cc_XD2_nt_XD4_XDFFQ_SB r0 *1 0,0
Ccc_XD2_nt_XD4_XDFFQ_SB XD2_nt XD4_XDFFQ_SB 1.8151e-17
* device instance cc_XD2_nt_XD4_XN2_mid1 r0 *1 0,0
Ccc_XD2_nt_XD4_XN2_mid1 XD2_nt XD4_XN2_mid1 1.21e-17
* device instance cc_XD2_nt_XD4_XN3_mid1 r0 *1 0,0
Ccc_XD2_nt_XD4_XN3_mid1 XD2_nt XD4_XN3_mid1 1.21e-17
* device instance cc_XD2_nt_XD4_XN3_mid2 r0 *1 0,0
Ccc_XD2_nt_XD4_XN3_mid2 XD2_nt XD4_XN3_mid2 1.21e-17
* device instance cc_XD2_nt_XD4_dmodout r0 *1 0,0
Ccc_XD2_nt_XD4_dmodout XD2_nt XD4_dmodout 1.21e-17
* device instance cc_XD2_nt_XD4_dq r0 *1 0,0
Ccc_XD2_nt_XD4_dq XD2_nt XD4_dq 1.8151e-17
* device instance cc_XD2_nt_XD4_nm r0 *1 0,0
Ccc_XD2_nt_XD4_nm XD2_nt XD4_nm 1.21e-17
* device instance cc_XD2_nt_XD4_nt r0 *1 0,0
Ccc_XD2_nt_XD4_nt XD2_nt XD4_nt 1.21e-17
* device instance cc_XD2_nt_XD4_t1 r0 *1 0,0
Ccc_XD2_nt_XD4_t1 XD2_nt XD4_t1 1.21e-17
* device instance cc_XD2_nt_XD5_XDFFM_CLKB r0 *1 0,0
Ccc_XD2_nt_XD5_XDFFM_CLKB XD2_nt XD5_XDFFM_CLKB 1.8151e-17
* device instance cc_XD2_nt_XD5_XDFFM_M r0 *1 0,0
Ccc_XD2_nt_XD5_XDFFM_M XD2_nt XD5_XDFFM_M 2.4201e-17
* device instance cc_XD2_nt_XD5_XDFFM_MB r0 *1 0,0
Ccc_XD2_nt_XD5_XDFFM_MB XD2_nt XD5_XDFFM_MB 1.21e-17
* device instance cc_XD2_nt_XD5_XDFFM_S r0 *1 0,0
Ccc_XD2_nt_XD5_XDFFM_S XD2_nt XD5_XDFFM_S 1.8151e-17
* device instance cc_XD2_nt_XD5_XDFFM_SB r0 *1 0,0
Ccc_XD2_nt_XD5_XDFFM_SB XD2_nt XD5_XDFFM_SB 1.8151e-17
* device instance cc_XD2_nt_XD5_XDFFQ_CLKB r0 *1 0,0
Ccc_XD2_nt_XD5_XDFFQ_CLKB XD2_nt XD5_XDFFQ_CLKB 1.8151e-17
* device instance cc_XD2_nt_XD5_XDFFQ_M r0 *1 0,0
Ccc_XD2_nt_XD5_XDFFQ_M XD2_nt XD5_XDFFQ_M 2.4201e-17
* device instance cc_XD2_nt_XD5_XDFFQ_MB r0 *1 0,0
Ccc_XD2_nt_XD5_XDFFQ_MB XD2_nt XD5_XDFFQ_MB 1.21e-17
* device instance cc_XD2_nt_XD5_XDFFQ_S r0 *1 0,0
Ccc_XD2_nt_XD5_XDFFQ_S XD2_nt XD5_XDFFQ_S 1.8151e-17
* device instance cc_XD2_nt_XD5_XDFFQ_SB r0 *1 0,0
Ccc_XD2_nt_XD5_XDFFQ_SB XD2_nt XD5_XDFFQ_SB 1.8151e-17
* device instance cc_XD2_nt_XD5_XN2_mid1 r0 *1 0,0
Ccc_XD2_nt_XD5_XN2_mid1 XD2_nt XD5_XN2_mid1 1.21e-17
* device instance cc_XD2_nt_XD5_XN3_mid1 r0 *1 0,0
Ccc_XD2_nt_XD5_XN3_mid1 XD2_nt XD5_XN3_mid1 1.21e-17
* device instance cc_XD2_nt_XD5_XN3_mid2 r0 *1 0,0
Ccc_XD2_nt_XD5_XN3_mid2 XD2_nt XD5_XN3_mid2 1.21e-17
* device instance cc_XD2_nt_XD5_dmodout r0 *1 0,0
Ccc_XD2_nt_XD5_dmodout XD2_nt XD5_dmodout 1.21e-17
* device instance cc_XD2_nt_XD5_dq r0 *1 0,0
Ccc_XD2_nt_XD5_dq XD2_nt XD5_dq 1.8151e-17
* device instance cc_XD2_nt_XD5_nm r0 *1 0,0
Ccc_XD2_nt_XD5_nm XD2_nt XD5_nm 1.21e-17
* device instance cc_XD2_nt_XD5_nt r0 *1 0,0
Ccc_XD2_nt_XD5_nt XD2_nt XD5_nt 1.21e-17
* device instance cc_XD2_nt_XD5_t1 r0 *1 0,0
Ccc_XD2_nt_XD5_t1 XD2_nt XD5_t1 1.21e-17
* device instance cc_XD2_nt_XFRT_CLKB r0 *1 0,0
Ccc_XD2_nt_XFRT_CLKB XD2_nt XFRT_CLKB 1.8151e-17
* device instance cc_XD2_nt_XFRT_M r0 *1 0,0
Ccc_XD2_nt_XFRT_M XD2_nt XFRT_M 2.4201e-17
* device instance cc_XD2_nt_XFRT_MB r0 *1 0,0
Ccc_XD2_nt_XFRT_MB XD2_nt XFRT_MB 1.21e-17
* device instance cc_XD2_nt_XFRT_S r0 *1 0,0
Ccc_XD2_nt_XFRT_S XD2_nt XFRT_S 1.8151e-17
* device instance cc_XD2_nt_XFRT_SB r0 *1 0,0
Ccc_XD2_nt_XFRT_SB XD2_nt XFRT_SB 1.8151e-17
* device instance cc_XD2_nt_ck1 r0 *1 0,0
Ccc_XD2_nt_ck1 XD2_nt ck1 5.4452e-17
* device instance cc_XD2_nt_ck2 r0 *1 0,0
Ccc_XD2_nt_ck2 XD2_nt ck2 5.4452e-17
* device instance cc_XD2_nt_ck3 r0 *1 0,0
Ccc_XD2_nt_ck3 XD2_nt ck3 5.4452e-17
* device instance cc_XD2_nt_ck4 r0 *1 0,0
Ccc_XD2_nt_ck4 XD2_nt ck4 5.4452e-17
* device instance cc_XD2_nt_ck5 r0 *1 0,0
Ccc_XD2_nt_ck5 XD2_nt ck5 5.4452e-17
* device instance cc_XD2_nt_mod0 r0 *1 0,0
Ccc_XD2_nt_mod0 XD2_nt mod0 2.4201e-17
* device instance cc_XD2_nt_mod1 r0 *1 0,0
Ccc_XD2_nt_mod1 XD2_nt mod1 3.0251e-17
* device instance cc_XD2_nt_mod2 r0 *1 0,0
Ccc_XD2_nt_mod2 XD2_nt mod2 2.4201e-17
* device instance cc_XD2_nt_mod3 r0 *1 0,0
Ccc_XD2_nt_mod3 XD2_nt mod3 2.4201e-17
* device instance cc_XD2_nt_mod4 r0 *1 0,0
Ccc_XD2_nt_mod4 XD2_nt mod4 2.4201e-17
* device instance cc_XD2_nt_net1 r0 *1 0,0
Ccc_XD2_nt_net1 XD2_nt net1 1.21e-17
* device instance cc_XD2_t1_XD3_XDFFM_CLKB r0 *1 0,0
Ccc_XD2_t1_XD3_XDFFM_CLKB XD2_t1 XD3_XDFFM_CLKB 1.8151e-17
* device instance cc_XD2_t1_XD3_XDFFM_M r0 *1 0,0
Ccc_XD2_t1_XD3_XDFFM_M XD2_t1 XD3_XDFFM_M 2.4201e-17
* device instance cc_XD2_t1_XD3_XDFFM_MB r0 *1 0,0
Ccc_XD2_t1_XD3_XDFFM_MB XD2_t1 XD3_XDFFM_MB 1.21e-17
* device instance cc_XD2_t1_XD3_XDFFM_S r0 *1 0,0
Ccc_XD2_t1_XD3_XDFFM_S XD2_t1 XD3_XDFFM_S 1.8151e-17
* device instance cc_XD2_t1_XD3_XDFFM_SB r0 *1 0,0
Ccc_XD2_t1_XD3_XDFFM_SB XD2_t1 XD3_XDFFM_SB 1.8151e-17
* device instance cc_XD2_t1_XD3_XDFFQ_CLKB r0 *1 0,0
Ccc_XD2_t1_XD3_XDFFQ_CLKB XD2_t1 XD3_XDFFQ_CLKB 1.8151e-17
* device instance cc_XD2_t1_XD3_XDFFQ_M r0 *1 0,0
Ccc_XD2_t1_XD3_XDFFQ_M XD2_t1 XD3_XDFFQ_M 2.4201e-17
* device instance cc_XD2_t1_XD3_XDFFQ_MB r0 *1 0,0
Ccc_XD2_t1_XD3_XDFFQ_MB XD2_t1 XD3_XDFFQ_MB 1.21e-17
* device instance cc_XD2_t1_XD3_XDFFQ_S r0 *1 0,0
Ccc_XD2_t1_XD3_XDFFQ_S XD2_t1 XD3_XDFFQ_S 1.8151e-17
* device instance cc_XD2_t1_XD3_XDFFQ_SB r0 *1 0,0
Ccc_XD2_t1_XD3_XDFFQ_SB XD2_t1 XD3_XDFFQ_SB 1.8151e-17
* device instance cc_XD2_t1_XD3_XN2_mid1 r0 *1 0,0
Ccc_XD2_t1_XD3_XN2_mid1 XD2_t1 XD3_XN2_mid1 1.21e-17
* device instance cc_XD2_t1_XD3_XN3_mid1 r0 *1 0,0
Ccc_XD2_t1_XD3_XN3_mid1 XD2_t1 XD3_XN3_mid1 1.21e-17
* device instance cc_XD2_t1_XD3_XN3_mid2 r0 *1 0,0
Ccc_XD2_t1_XD3_XN3_mid2 XD2_t1 XD3_XN3_mid2 1.21e-17
* device instance cc_XD2_t1_XD3_dmodout r0 *1 0,0
Ccc_XD2_t1_XD3_dmodout XD2_t1 XD3_dmodout 1.21e-17
* device instance cc_XD2_t1_XD3_dq r0 *1 0,0
Ccc_XD2_t1_XD3_dq XD2_t1 XD3_dq 1.8151e-17
* device instance cc_XD2_t1_XD3_nm r0 *1 0,0
Ccc_XD2_t1_XD3_nm XD2_t1 XD3_nm 1.21e-17
* device instance cc_XD2_t1_XD3_nt r0 *1 0,0
Ccc_XD2_t1_XD3_nt XD2_t1 XD3_nt 1.21e-17
* device instance cc_XD2_t1_XD3_t1 r0 *1 0,0
Ccc_XD2_t1_XD3_t1 XD2_t1 XD3_t1 1.21e-17
* device instance cc_XD2_t1_XD4_XDFFM_CLKB r0 *1 0,0
Ccc_XD2_t1_XD4_XDFFM_CLKB XD2_t1 XD4_XDFFM_CLKB 1.8151e-17
* device instance cc_XD2_t1_XD4_XDFFM_M r0 *1 0,0
Ccc_XD2_t1_XD4_XDFFM_M XD2_t1 XD4_XDFFM_M 2.4201e-17
* device instance cc_XD2_t1_XD4_XDFFM_MB r0 *1 0,0
Ccc_XD2_t1_XD4_XDFFM_MB XD2_t1 XD4_XDFFM_MB 1.21e-17
* device instance cc_XD2_t1_XD4_XDFFM_S r0 *1 0,0
Ccc_XD2_t1_XD4_XDFFM_S XD2_t1 XD4_XDFFM_S 1.8151e-17
* device instance cc_XD2_t1_XD4_XDFFM_SB r0 *1 0,0
Ccc_XD2_t1_XD4_XDFFM_SB XD2_t1 XD4_XDFFM_SB 1.8151e-17
* device instance cc_XD2_t1_XD4_XDFFQ_CLKB r0 *1 0,0
Ccc_XD2_t1_XD4_XDFFQ_CLKB XD2_t1 XD4_XDFFQ_CLKB 1.8151e-17
* device instance cc_XD2_t1_XD4_XDFFQ_M r0 *1 0,0
Ccc_XD2_t1_XD4_XDFFQ_M XD2_t1 XD4_XDFFQ_M 2.4201e-17
* device instance cc_XD2_t1_XD4_XDFFQ_MB r0 *1 0,0
Ccc_XD2_t1_XD4_XDFFQ_MB XD2_t1 XD4_XDFFQ_MB 1.21e-17
* device instance cc_XD2_t1_XD4_XDFFQ_S r0 *1 0,0
Ccc_XD2_t1_XD4_XDFFQ_S XD2_t1 XD4_XDFFQ_S 1.8151e-17
* device instance cc_XD2_t1_XD4_XDFFQ_SB r0 *1 0,0
Ccc_XD2_t1_XD4_XDFFQ_SB XD2_t1 XD4_XDFFQ_SB 1.8151e-17
* device instance cc_XD2_t1_XD4_XN2_mid1 r0 *1 0,0
Ccc_XD2_t1_XD4_XN2_mid1 XD2_t1 XD4_XN2_mid1 1.21e-17
* device instance cc_XD2_t1_XD4_XN3_mid1 r0 *1 0,0
Ccc_XD2_t1_XD4_XN3_mid1 XD2_t1 XD4_XN3_mid1 1.21e-17
* device instance cc_XD2_t1_XD4_XN3_mid2 r0 *1 0,0
Ccc_XD2_t1_XD4_XN3_mid2 XD2_t1 XD4_XN3_mid2 1.21e-17
* device instance cc_XD2_t1_XD4_dmodout r0 *1 0,0
Ccc_XD2_t1_XD4_dmodout XD2_t1 XD4_dmodout 1.21e-17
* device instance cc_XD2_t1_XD4_dq r0 *1 0,0
Ccc_XD2_t1_XD4_dq XD2_t1 XD4_dq 1.8151e-17
* device instance cc_XD2_t1_XD4_nm r0 *1 0,0
Ccc_XD2_t1_XD4_nm XD2_t1 XD4_nm 1.21e-17
* device instance cc_XD2_t1_XD4_nt r0 *1 0,0
Ccc_XD2_t1_XD4_nt XD2_t1 XD4_nt 1.21e-17
* device instance cc_XD2_t1_XD4_t1 r0 *1 0,0
Ccc_XD2_t1_XD4_t1 XD2_t1 XD4_t1 1.21e-17
* device instance cc_XD2_t1_XD5_XDFFM_CLKB r0 *1 0,0
Ccc_XD2_t1_XD5_XDFFM_CLKB XD2_t1 XD5_XDFFM_CLKB 1.8151e-17
* device instance cc_XD2_t1_XD5_XDFFM_M r0 *1 0,0
Ccc_XD2_t1_XD5_XDFFM_M XD2_t1 XD5_XDFFM_M 2.4201e-17
* device instance cc_XD2_t1_XD5_XDFFM_MB r0 *1 0,0
Ccc_XD2_t1_XD5_XDFFM_MB XD2_t1 XD5_XDFFM_MB 1.21e-17
* device instance cc_XD2_t1_XD5_XDFFM_S r0 *1 0,0
Ccc_XD2_t1_XD5_XDFFM_S XD2_t1 XD5_XDFFM_S 1.8151e-17
* device instance cc_XD2_t1_XD5_XDFFM_SB r0 *1 0,0
Ccc_XD2_t1_XD5_XDFFM_SB XD2_t1 XD5_XDFFM_SB 1.8151e-17
* device instance cc_XD2_t1_XD5_XDFFQ_CLKB r0 *1 0,0
Ccc_XD2_t1_XD5_XDFFQ_CLKB XD2_t1 XD5_XDFFQ_CLKB 1.8151e-17
* device instance cc_XD2_t1_XD5_XDFFQ_M r0 *1 0,0
Ccc_XD2_t1_XD5_XDFFQ_M XD2_t1 XD5_XDFFQ_M 2.4201e-17
* device instance cc_XD2_t1_XD5_XDFFQ_MB r0 *1 0,0
Ccc_XD2_t1_XD5_XDFFQ_MB XD2_t1 XD5_XDFFQ_MB 1.21e-17
* device instance cc_XD2_t1_XD5_XDFFQ_S r0 *1 0,0
Ccc_XD2_t1_XD5_XDFFQ_S XD2_t1 XD5_XDFFQ_S 1.8151e-17
* device instance cc_XD2_t1_XD5_XDFFQ_SB r0 *1 0,0
Ccc_XD2_t1_XD5_XDFFQ_SB XD2_t1 XD5_XDFFQ_SB 1.8151e-17
* device instance cc_XD2_t1_XD5_XN2_mid1 r0 *1 0,0
Ccc_XD2_t1_XD5_XN2_mid1 XD2_t1 XD5_XN2_mid1 1.21e-17
* device instance cc_XD2_t1_XD5_XN3_mid1 r0 *1 0,0
Ccc_XD2_t1_XD5_XN3_mid1 XD2_t1 XD5_XN3_mid1 1.21e-17
* device instance cc_XD2_t1_XD5_XN3_mid2 r0 *1 0,0
Ccc_XD2_t1_XD5_XN3_mid2 XD2_t1 XD5_XN3_mid2 1.21e-17
* device instance cc_XD2_t1_XD5_dmodout r0 *1 0,0
Ccc_XD2_t1_XD5_dmodout XD2_t1 XD5_dmodout 1.21e-17
* device instance cc_XD2_t1_XD5_dq r0 *1 0,0
Ccc_XD2_t1_XD5_dq XD2_t1 XD5_dq 1.8151e-17
* device instance cc_XD2_t1_XD5_nm r0 *1 0,0
Ccc_XD2_t1_XD5_nm XD2_t1 XD5_nm 1.21e-17
* device instance cc_XD2_t1_XD5_nt r0 *1 0,0
Ccc_XD2_t1_XD5_nt XD2_t1 XD5_nt 1.21e-17
* device instance cc_XD2_t1_XD5_t1 r0 *1 0,0
Ccc_XD2_t1_XD5_t1 XD2_t1 XD5_t1 1.21e-17
* device instance cc_XD2_t1_XFRT_CLKB r0 *1 0,0
Ccc_XD2_t1_XFRT_CLKB XD2_t1 XFRT_CLKB 1.8151e-17
* device instance cc_XD2_t1_XFRT_M r0 *1 0,0
Ccc_XD2_t1_XFRT_M XD2_t1 XFRT_M 2.4201e-17
* device instance cc_XD2_t1_XFRT_MB r0 *1 0,0
Ccc_XD2_t1_XFRT_MB XD2_t1 XFRT_MB 1.21e-17
* device instance cc_XD2_t1_XFRT_S r0 *1 0,0
Ccc_XD2_t1_XFRT_S XD2_t1 XFRT_S 1.8151e-17
* device instance cc_XD2_t1_XFRT_SB r0 *1 0,0
Ccc_XD2_t1_XFRT_SB XD2_t1 XFRT_SB 1.8151e-17
* device instance cc_XD2_t1_ck1 r0 *1 0,0
Ccc_XD2_t1_ck1 XD2_t1 ck1 5.4452e-17
* device instance cc_XD2_t1_ck2 r0 *1 0,0
Ccc_XD2_t1_ck2 XD2_t1 ck2 5.4452e-17
* device instance cc_XD2_t1_ck3 r0 *1 0,0
Ccc_XD2_t1_ck3 XD2_t1 ck3 6.0502e-17
* device instance cc_XD2_t1_ck4 r0 *1 0,0
Ccc_XD2_t1_ck4 XD2_t1 ck4 5.4452e-17
* device instance cc_XD2_t1_ck5 r0 *1 0,0
Ccc_XD2_t1_ck5 XD2_t1 ck5 5.4452e-17
* device instance cc_XD2_t1_mod0 r0 *1 0,0
Ccc_XD2_t1_mod0 XD2_t1 mod0 2.4201e-17
* device instance cc_XD2_t1_mod1 r0 *1 0,0
Ccc_XD2_t1_mod1 XD2_t1 mod1 2.4201e-17
* device instance cc_XD2_t1_mod2 r0 *1 0,0
Ccc_XD2_t1_mod2 XD2_t1 mod2 2.4201e-17
* device instance cc_XD2_t1_mod3 r0 *1 0,0
Ccc_XD2_t1_mod3 XD2_t1 mod3 2.4201e-17
* device instance cc_XD2_t1_mod4 r0 *1 0,0
Ccc_XD2_t1_mod4 XD2_t1 mod4 2.4201e-17
* device instance cc_XD2_t1_net1 r0 *1 0,0
Ccc_XD2_t1_net1 XD2_t1 net1 1.21e-17
* device instance cc_XD3_XDFFM_CLKB_XD3_XDFFM_M r0 *1 0,0
Ccc_XD3_XDFFM_CLKB_XD3_XDFFM_M XD3_XDFFM_CLKB XD3_XDFFM_M 4.2352e-17
* device instance cc_XD3_XDFFM_CLKB_XD3_XDFFM_MB r0 *1 0,0
Ccc_XD3_XDFFM_CLKB_XD3_XDFFM_MB XD3_XDFFM_CLKB XD3_XDFFM_MB 2.4201e-17
* device instance cc_XD3_XDFFM_CLKB_XD3_XDFFM_S r0 *1 0,0
Ccc_XD3_XDFFM_CLKB_XD3_XDFFM_S XD3_XDFFM_CLKB XD3_XDFFM_S 1.8151e-17
* device instance cc_XD3_XDFFM_CLKB_XD3_XDFFM_SB r0 *1 0,0
Ccc_XD3_XDFFM_CLKB_XD3_XDFFM_SB XD3_XDFFM_CLKB XD3_XDFFM_SB 1.8151e-17
* device instance cc_XD3_XDFFM_CLKB_XD3_XDFFQ_CLKB r0 *1 0,0
Ccc_XD3_XDFFM_CLKB_XD3_XDFFQ_CLKB XD3_XDFFM_CLKB XD3_XDFFQ_CLKB 1.8151e-17
* device instance cc_XD3_XDFFM_CLKB_XD3_XDFFQ_M r0 *1 0,0
Ccc_XD3_XDFFM_CLKB_XD3_XDFFQ_M XD3_XDFFM_CLKB XD3_XDFFQ_M 2.4201e-17
* device instance cc_XD3_XDFFM_CLKB_XD3_XDFFQ_MB r0 *1 0,0
Ccc_XD3_XDFFM_CLKB_XD3_XDFFQ_MB XD3_XDFFM_CLKB XD3_XDFFQ_MB 1.21e-17
* device instance cc_XD3_XDFFM_CLKB_XD3_XDFFQ_S r0 *1 0,0
Ccc_XD3_XDFFM_CLKB_XD3_XDFFQ_S XD3_XDFFM_CLKB XD3_XDFFQ_S 1.8151e-17
* device instance cc_XD3_XDFFM_CLKB_XD3_XDFFQ_SB r0 *1 0,0
Ccc_XD3_XDFFM_CLKB_XD3_XDFFQ_SB XD3_XDFFM_CLKB XD3_XDFFQ_SB 1.8151e-17
* device instance cc_XD3_XDFFM_CLKB_XD3_XNOR_midp r0 *1 0,0
Ccc_XD3_XDFFM_CLKB_XD3_XNOR_midp XD3_XDFFM_CLKB XD3_XNOR_midp 1.21e-17
* device instance cc_XD3_XDFFM_CLKB_XD3_dmodout r0 *1 0,0
Ccc_XD3_XDFFM_CLKB_XD3_dmodout XD3_XDFFM_CLKB XD3_dmodout 1.8151e-17
* device instance cc_XD3_XDFFM_CLKB_XD3_dq r0 *1 0,0
Ccc_XD3_XDFFM_CLKB_XD3_dq XD3_XDFFM_CLKB XD3_dq 1.21e-17
* device instance cc_XD3_XDFFM_CLKB_XD3_nm r0 *1 0,0
Ccc_XD3_XDFFM_CLKB_XD3_nm XD3_XDFFM_CLKB XD3_nm 1.8151e-17
* device instance cc_XD3_XDFFM_CLKB_XD3_nt r0 *1 0,0
Ccc_XD3_XDFFM_CLKB_XD3_nt XD3_XDFFM_CLKB XD3_nt 2.4201e-17
* device instance cc_XD3_XDFFM_CLKB_XD3_t1 r0 *1 0,0
Ccc_XD3_XDFFM_CLKB_XD3_t1 XD3_XDFFM_CLKB XD3_t1 1.21e-17
* device instance cc_XD3_XDFFM_CLKB_XD4_XDFFM_CLKB r0 *1 0,0
Ccc_XD3_XDFFM_CLKB_XD4_XDFFM_CLKB XD3_XDFFM_CLKB XD4_XDFFM_CLKB 1.8151e-17
* device instance cc_XD3_XDFFM_CLKB_XD4_XDFFM_M r0 *1 0,0
Ccc_XD3_XDFFM_CLKB_XD4_XDFFM_M XD3_XDFFM_CLKB XD4_XDFFM_M 2.4201e-17
* device instance cc_XD3_XDFFM_CLKB_XD4_XDFFM_MB r0 *1 0,0
Ccc_XD3_XDFFM_CLKB_XD4_XDFFM_MB XD3_XDFFM_CLKB XD4_XDFFM_MB 1.21e-17
* device instance cc_XD3_XDFFM_CLKB_XD4_XDFFM_S r0 *1 0,0
Ccc_XD3_XDFFM_CLKB_XD4_XDFFM_S XD3_XDFFM_CLKB XD4_XDFFM_S 1.8151e-17
* device instance cc_XD3_XDFFM_CLKB_XD4_XDFFM_SB r0 *1 0,0
Ccc_XD3_XDFFM_CLKB_XD4_XDFFM_SB XD3_XDFFM_CLKB XD4_XDFFM_SB 1.8151e-17
* device instance cc_XD3_XDFFM_CLKB_XD4_XDFFQ_CLKB r0 *1 0,0
Ccc_XD3_XDFFM_CLKB_XD4_XDFFQ_CLKB XD3_XDFFM_CLKB XD4_XDFFQ_CLKB 1.8151e-17
* device instance cc_XD3_XDFFM_CLKB_XD4_XDFFQ_M r0 *1 0,0
Ccc_XD3_XDFFM_CLKB_XD4_XDFFQ_M XD3_XDFFM_CLKB XD4_XDFFQ_M 2.4201e-17
* device instance cc_XD3_XDFFM_CLKB_XD4_XDFFQ_MB r0 *1 0,0
Ccc_XD3_XDFFM_CLKB_XD4_XDFFQ_MB XD3_XDFFM_CLKB XD4_XDFFQ_MB 1.21e-17
* device instance cc_XD3_XDFFM_CLKB_XD4_XDFFQ_S r0 *1 0,0
Ccc_XD3_XDFFM_CLKB_XD4_XDFFQ_S XD3_XDFFM_CLKB XD4_XDFFQ_S 1.8151e-17
* device instance cc_XD3_XDFFM_CLKB_XD4_XDFFQ_SB r0 *1 0,0
Ccc_XD3_XDFFM_CLKB_XD4_XDFFQ_SB XD3_XDFFM_CLKB XD4_XDFFQ_SB 1.8151e-17
* device instance cc_XD3_XDFFM_CLKB_XD4_XN2_mid1 r0 *1 0,0
Ccc_XD3_XDFFM_CLKB_XD4_XN2_mid1 XD3_XDFFM_CLKB XD4_XN2_mid1 1.21e-17
* device instance cc_XD3_XDFFM_CLKB_XD4_XN3_mid1 r0 *1 0,0
Ccc_XD3_XDFFM_CLKB_XD4_XN3_mid1 XD3_XDFFM_CLKB XD4_XN3_mid1 1.21e-17
* device instance cc_XD3_XDFFM_CLKB_XD4_XN3_mid2 r0 *1 0,0
Ccc_XD3_XDFFM_CLKB_XD4_XN3_mid2 XD3_XDFFM_CLKB XD4_XN3_mid2 1.21e-17
* device instance cc_XD3_XDFFM_CLKB_XD4_dmodout r0 *1 0,0
Ccc_XD3_XDFFM_CLKB_XD4_dmodout XD3_XDFFM_CLKB XD4_dmodout 1.21e-17
* device instance cc_XD3_XDFFM_CLKB_XD4_dq r0 *1 0,0
Ccc_XD3_XDFFM_CLKB_XD4_dq XD3_XDFFM_CLKB XD4_dq 1.8151e-17
* device instance cc_XD3_XDFFM_CLKB_XD4_nm r0 *1 0,0
Ccc_XD3_XDFFM_CLKB_XD4_nm XD3_XDFFM_CLKB XD4_nm 1.21e-17
* device instance cc_XD3_XDFFM_CLKB_XD4_nt r0 *1 0,0
Ccc_XD3_XDFFM_CLKB_XD4_nt XD3_XDFFM_CLKB XD4_nt 1.21e-17
* device instance cc_XD3_XDFFM_CLKB_XD4_t1 r0 *1 0,0
Ccc_XD3_XDFFM_CLKB_XD4_t1 XD3_XDFFM_CLKB XD4_t1 1.21e-17
* device instance cc_XD3_XDFFM_CLKB_XD5_XDFFM_CLKB r0 *1 0,0
Ccc_XD3_XDFFM_CLKB_XD5_XDFFM_CLKB XD3_XDFFM_CLKB XD5_XDFFM_CLKB 1.8151e-17
* device instance cc_XD3_XDFFM_CLKB_XD5_XDFFM_M r0 *1 0,0
Ccc_XD3_XDFFM_CLKB_XD5_XDFFM_M XD3_XDFFM_CLKB XD5_XDFFM_M 2.4201e-17
* device instance cc_XD3_XDFFM_CLKB_XD5_XDFFM_MB r0 *1 0,0
Ccc_XD3_XDFFM_CLKB_XD5_XDFFM_MB XD3_XDFFM_CLKB XD5_XDFFM_MB 1.21e-17
* device instance cc_XD3_XDFFM_CLKB_XD5_XDFFM_S r0 *1 0,0
Ccc_XD3_XDFFM_CLKB_XD5_XDFFM_S XD3_XDFFM_CLKB XD5_XDFFM_S 1.8151e-17
* device instance cc_XD3_XDFFM_CLKB_XD5_XDFFM_SB r0 *1 0,0
Ccc_XD3_XDFFM_CLKB_XD5_XDFFM_SB XD3_XDFFM_CLKB XD5_XDFFM_SB 1.8151e-17
* device instance cc_XD3_XDFFM_CLKB_XD5_XDFFQ_CLKB r0 *1 0,0
Ccc_XD3_XDFFM_CLKB_XD5_XDFFQ_CLKB XD3_XDFFM_CLKB XD5_XDFFQ_CLKB 1.8151e-17
* device instance cc_XD3_XDFFM_CLKB_XD5_XDFFQ_M r0 *1 0,0
Ccc_XD3_XDFFM_CLKB_XD5_XDFFQ_M XD3_XDFFM_CLKB XD5_XDFFQ_M 2.4201e-17
* device instance cc_XD3_XDFFM_CLKB_XD5_XDFFQ_MB r0 *1 0,0
Ccc_XD3_XDFFM_CLKB_XD5_XDFFQ_MB XD3_XDFFM_CLKB XD5_XDFFQ_MB 1.21e-17
* device instance cc_XD3_XDFFM_CLKB_XD5_XDFFQ_S r0 *1 0,0
Ccc_XD3_XDFFM_CLKB_XD5_XDFFQ_S XD3_XDFFM_CLKB XD5_XDFFQ_S 1.8151e-17
* device instance cc_XD3_XDFFM_CLKB_XD5_XDFFQ_SB r0 *1 0,0
Ccc_XD3_XDFFM_CLKB_XD5_XDFFQ_SB XD3_XDFFM_CLKB XD5_XDFFQ_SB 1.8151e-17
* device instance cc_XD3_XDFFM_CLKB_XD5_XN2_mid1 r0 *1 0,0
Ccc_XD3_XDFFM_CLKB_XD5_XN2_mid1 XD3_XDFFM_CLKB XD5_XN2_mid1 1.21e-17
* device instance cc_XD3_XDFFM_CLKB_XD5_XN3_mid1 r0 *1 0,0
Ccc_XD3_XDFFM_CLKB_XD5_XN3_mid1 XD3_XDFFM_CLKB XD5_XN3_mid1 1.21e-17
* device instance cc_XD3_XDFFM_CLKB_XD5_XN3_mid2 r0 *1 0,0
Ccc_XD3_XDFFM_CLKB_XD5_XN3_mid2 XD3_XDFFM_CLKB XD5_XN3_mid2 1.21e-17
* device instance cc_XD3_XDFFM_CLKB_XD5_dmodout r0 *1 0,0
Ccc_XD3_XDFFM_CLKB_XD5_dmodout XD3_XDFFM_CLKB XD5_dmodout 1.21e-17
* device instance cc_XD3_XDFFM_CLKB_XD5_dq r0 *1 0,0
Ccc_XD3_XDFFM_CLKB_XD5_dq XD3_XDFFM_CLKB XD5_dq 1.8151e-17
* device instance cc_XD3_XDFFM_CLKB_XD5_nm r0 *1 0,0
Ccc_XD3_XDFFM_CLKB_XD5_nm XD3_XDFFM_CLKB XD5_nm 1.21e-17
* device instance cc_XD3_XDFFM_CLKB_XD5_nt r0 *1 0,0
Ccc_XD3_XDFFM_CLKB_XD5_nt XD3_XDFFM_CLKB XD5_nt 1.21e-17
* device instance cc_XD3_XDFFM_CLKB_XD5_t1 r0 *1 0,0
Ccc_XD3_XDFFM_CLKB_XD5_t1 XD3_XDFFM_CLKB XD5_t1 1.21e-17
* device instance cc_XD3_XDFFM_CLKB_XFRT_CLKB r0 *1 0,0
Ccc_XD3_XDFFM_CLKB_XFRT_CLKB XD3_XDFFM_CLKB XFRT_CLKB 1.8151e-17
* device instance cc_XD3_XDFFM_CLKB_XFRT_M r0 *1 0,0
Ccc_XD3_XDFFM_CLKB_XFRT_M XD3_XDFFM_CLKB XFRT_M 2.4201e-17
* device instance cc_XD3_XDFFM_CLKB_XFRT_MB r0 *1 0,0
Ccc_XD3_XDFFM_CLKB_XFRT_MB XD3_XDFFM_CLKB XFRT_MB 1.21e-17
* device instance cc_XD3_XDFFM_CLKB_XFRT_S r0 *1 0,0
Ccc_XD3_XDFFM_CLKB_XFRT_S XD3_XDFFM_CLKB XFRT_S 1.8151e-17
* device instance cc_XD3_XDFFM_CLKB_XFRT_SB r0 *1 0,0
Ccc_XD3_XDFFM_CLKB_XFRT_SB XD3_XDFFM_CLKB XFRT_SB 1.8151e-17
* device instance cc_XD3_XDFFM_CLKB_ck1 r0 *1 0,0
Ccc_XD3_XDFFM_CLKB_ck1 XD3_XDFFM_CLKB ck1 5.4452e-17
* device instance cc_XD3_XDFFM_CLKB_ck2 r0 *1 0,0
Ccc_XD3_XDFFM_CLKB_ck2 XD3_XDFFM_CLKB ck2 5.4452e-17
* device instance cc_XD3_XDFFM_CLKB_ck3 r0 *1 0,0
Ccc_XD3_XDFFM_CLKB_ck3 XD3_XDFFM_CLKB ck3 6.0502e-17
* device instance cc_XD3_XDFFM_CLKB_ck4 r0 *1 0,0
Ccc_XD3_XDFFM_CLKB_ck4 XD3_XDFFM_CLKB ck4 5.4452e-17
* device instance cc_XD3_XDFFM_CLKB_ck5 r0 *1 0,0
Ccc_XD3_XDFFM_CLKB_ck5 XD3_XDFFM_CLKB ck5 5.4452e-17
* device instance cc_XD3_XDFFM_CLKB_mod0 r0 *1 0,0
Ccc_XD3_XDFFM_CLKB_mod0 XD3_XDFFM_CLKB mod0 2.4201e-17
* device instance cc_XD3_XDFFM_CLKB_mod1 r0 *1 0,0
Ccc_XD3_XDFFM_CLKB_mod1 XD3_XDFFM_CLKB mod1 2.4201e-17
* device instance cc_XD3_XDFFM_CLKB_mod2 r0 *1 0,0
Ccc_XD3_XDFFM_CLKB_mod2 XD3_XDFFM_CLKB mod2 2.4201e-17
* device instance cc_XD3_XDFFM_CLKB_mod3 r0 *1 0,0
Ccc_XD3_XDFFM_CLKB_mod3 XD3_XDFFM_CLKB mod3 2.4201e-17
* device instance cc_XD3_XDFFM_CLKB_mod4 r0 *1 0,0
Ccc_XD3_XDFFM_CLKB_mod4 XD3_XDFFM_CLKB mod4 2.4201e-17
* device instance cc_XD3_XDFFM_CLKB_net1 r0 *1 0,0
Ccc_XD3_XDFFM_CLKB_net1 XD3_XDFFM_CLKB net1 1.21e-17
* device instance cc_XD3_XDFFM_M_XD3_XDFFM_MB r0 *1 0,0
Ccc_XD3_XDFFM_M_XD3_XDFFM_MB XD3_XDFFM_M XD3_XDFFM_MB 3.4688e-17
* device instance cc_XD3_XDFFM_M_XD3_XDFFM_S r0 *1 0,0
Ccc_XD3_XDFFM_M_XD3_XDFFM_S XD3_XDFFM_M XD3_XDFFM_S 2.8638e-17
* device instance cc_XD3_XDFFM_M_XD3_XDFFM_SB r0 *1 0,0
Ccc_XD3_XDFFM_M_XD3_XDFFM_SB XD3_XDFFM_M XD3_XDFFM_SB 1.8151e-17
* device instance cc_XD3_XDFFM_M_XD3_XDFFQ_CLKB r0 *1 0,0
Ccc_XD3_XDFFM_M_XD3_XDFFQ_CLKB XD3_XDFFM_M XD3_XDFFQ_CLKB 1.8151e-17
* device instance cc_XD3_XDFFM_M_XD3_XDFFQ_M r0 *1 0,0
Ccc_XD3_XDFFM_M_XD3_XDFFQ_M XD3_XDFFM_M XD3_XDFFQ_M 2.4201e-17
* device instance cc_XD3_XDFFM_M_XD3_XDFFQ_MB r0 *1 0,0
Ccc_XD3_XDFFM_M_XD3_XDFFQ_MB XD3_XDFFM_M XD3_XDFFQ_MB 1.21e-17
* device instance cc_XD3_XDFFM_M_XD3_XDFFQ_S r0 *1 0,0
Ccc_XD3_XDFFM_M_XD3_XDFFQ_S XD3_XDFFM_M XD3_XDFFQ_S 1.8151e-17
* device instance cc_XD3_XDFFM_M_XD3_XDFFQ_SB r0 *1 0,0
Ccc_XD3_XDFFM_M_XD3_XDFFQ_SB XD3_XDFFM_M XD3_XDFFQ_SB 1.8151e-17
* device instance cc_XD3_XDFFM_M_XD3_XNOR_midp r0 *1 0,0
Ccc_XD3_XDFFM_M_XD3_XNOR_midp XD3_XDFFM_M XD3_XNOR_midp 1.21e-17
* device instance cc_XD3_XDFFM_M_XD3_dmodout r0 *1 0,0
Ccc_XD3_XDFFM_M_XD3_dmodout XD3_XDFFM_M XD3_dmodout 2.8638e-17
* device instance cc_XD3_XDFFM_M_XD3_dq r0 *1 0,0
Ccc_XD3_XDFFM_M_XD3_dq XD3_XDFFM_M XD3_dq 1.21e-17
* device instance cc_XD3_XDFFM_M_XD3_nm r0 *1 0,0
Ccc_XD3_XDFFM_M_XD3_nm XD3_XDFFM_M XD3_nm 1.8151e-17
* device instance cc_XD3_XDFFM_M_XD3_nt r0 *1 0,0
Ccc_XD3_XDFFM_M_XD3_nt XD3_XDFFM_M XD3_nt 2.4201e-17
* device instance cc_XD3_XDFFM_M_XD3_t1 r0 *1 0,0
Ccc_XD3_XDFFM_M_XD3_t1 XD3_XDFFM_M XD3_t1 1.21e-17
* device instance cc_XD3_XDFFM_M_XD4_XDFFM_CLKB r0 *1 0,0
Ccc_XD3_XDFFM_M_XD4_XDFFM_CLKB XD3_XDFFM_M XD4_XDFFM_CLKB 1.8151e-17
* device instance cc_XD3_XDFFM_M_XD4_XDFFM_M r0 *1 0,0
Ccc_XD3_XDFFM_M_XD4_XDFFM_M XD3_XDFFM_M XD4_XDFFM_M 2.4201e-17
* device instance cc_XD3_XDFFM_M_XD4_XDFFM_MB r0 *1 0,0
Ccc_XD3_XDFFM_M_XD4_XDFFM_MB XD3_XDFFM_M XD4_XDFFM_MB 1.21e-17
* device instance cc_XD3_XDFFM_M_XD4_XDFFM_S r0 *1 0,0
Ccc_XD3_XDFFM_M_XD4_XDFFM_S XD3_XDFFM_M XD4_XDFFM_S 1.8151e-17
* device instance cc_XD3_XDFFM_M_XD4_XDFFM_SB r0 *1 0,0
Ccc_XD3_XDFFM_M_XD4_XDFFM_SB XD3_XDFFM_M XD4_XDFFM_SB 1.8151e-17
* device instance cc_XD3_XDFFM_M_XD4_XDFFQ_CLKB r0 *1 0,0
Ccc_XD3_XDFFM_M_XD4_XDFFQ_CLKB XD3_XDFFM_M XD4_XDFFQ_CLKB 1.8151e-17
* device instance cc_XD3_XDFFM_M_XD4_XDFFQ_M r0 *1 0,0
Ccc_XD3_XDFFM_M_XD4_XDFFQ_M XD3_XDFFM_M XD4_XDFFQ_M 2.4201e-17
* device instance cc_XD3_XDFFM_M_XD4_XDFFQ_MB r0 *1 0,0
Ccc_XD3_XDFFM_M_XD4_XDFFQ_MB XD3_XDFFM_M XD4_XDFFQ_MB 1.21e-17
* device instance cc_XD3_XDFFM_M_XD4_XDFFQ_S r0 *1 0,0
Ccc_XD3_XDFFM_M_XD4_XDFFQ_S XD3_XDFFM_M XD4_XDFFQ_S 1.8151e-17
* device instance cc_XD3_XDFFM_M_XD4_XDFFQ_SB r0 *1 0,0
Ccc_XD3_XDFFM_M_XD4_XDFFQ_SB XD3_XDFFM_M XD4_XDFFQ_SB 1.8151e-17
* device instance cc_XD3_XDFFM_M_XD4_XN2_mid1 r0 *1 0,0
Ccc_XD3_XDFFM_M_XD4_XN2_mid1 XD3_XDFFM_M XD4_XN2_mid1 1.21e-17
* device instance cc_XD3_XDFFM_M_XD4_XN3_mid1 r0 *1 0,0
Ccc_XD3_XDFFM_M_XD4_XN3_mid1 XD3_XDFFM_M XD4_XN3_mid1 1.21e-17
* device instance cc_XD3_XDFFM_M_XD4_XN3_mid2 r0 *1 0,0
Ccc_XD3_XDFFM_M_XD4_XN3_mid2 XD3_XDFFM_M XD4_XN3_mid2 1.21e-17
* device instance cc_XD3_XDFFM_M_XD4_dmodout r0 *1 0,0
Ccc_XD3_XDFFM_M_XD4_dmodout XD3_XDFFM_M XD4_dmodout 1.21e-17
* device instance cc_XD3_XDFFM_M_XD4_dq r0 *1 0,0
Ccc_XD3_XDFFM_M_XD4_dq XD3_XDFFM_M XD4_dq 1.8151e-17
* device instance cc_XD3_XDFFM_M_XD4_nm r0 *1 0,0
Ccc_XD3_XDFFM_M_XD4_nm XD3_XDFFM_M XD4_nm 1.21e-17
* device instance cc_XD3_XDFFM_M_XD4_nt r0 *1 0,0
Ccc_XD3_XDFFM_M_XD4_nt XD3_XDFFM_M XD4_nt 1.21e-17
* device instance cc_XD3_XDFFM_M_XD4_t1 r0 *1 0,0
Ccc_XD3_XDFFM_M_XD4_t1 XD3_XDFFM_M XD4_t1 1.21e-17
* device instance cc_XD3_XDFFM_M_XD5_XDFFM_CLKB r0 *1 0,0
Ccc_XD3_XDFFM_M_XD5_XDFFM_CLKB XD3_XDFFM_M XD5_XDFFM_CLKB 1.8151e-17
* device instance cc_XD3_XDFFM_M_XD5_XDFFM_M r0 *1 0,0
Ccc_XD3_XDFFM_M_XD5_XDFFM_M XD3_XDFFM_M XD5_XDFFM_M 2.4201e-17
* device instance cc_XD3_XDFFM_M_XD5_XDFFM_MB r0 *1 0,0
Ccc_XD3_XDFFM_M_XD5_XDFFM_MB XD3_XDFFM_M XD5_XDFFM_MB 1.21e-17
* device instance cc_XD3_XDFFM_M_XD5_XDFFM_S r0 *1 0,0
Ccc_XD3_XDFFM_M_XD5_XDFFM_S XD3_XDFFM_M XD5_XDFFM_S 1.8151e-17
* device instance cc_XD3_XDFFM_M_XD5_XDFFM_SB r0 *1 0,0
Ccc_XD3_XDFFM_M_XD5_XDFFM_SB XD3_XDFFM_M XD5_XDFFM_SB 1.8151e-17
* device instance cc_XD3_XDFFM_M_XD5_XDFFQ_CLKB r0 *1 0,0
Ccc_XD3_XDFFM_M_XD5_XDFFQ_CLKB XD3_XDFFM_M XD5_XDFFQ_CLKB 1.8151e-17
* device instance cc_XD3_XDFFM_M_XD5_XDFFQ_M r0 *1 0,0
Ccc_XD3_XDFFM_M_XD5_XDFFQ_M XD3_XDFFM_M XD5_XDFFQ_M 2.4201e-17
* device instance cc_XD3_XDFFM_M_XD5_XDFFQ_MB r0 *1 0,0
Ccc_XD3_XDFFM_M_XD5_XDFFQ_MB XD3_XDFFM_M XD5_XDFFQ_MB 1.21e-17
* device instance cc_XD3_XDFFM_M_XD5_XDFFQ_S r0 *1 0,0
Ccc_XD3_XDFFM_M_XD5_XDFFQ_S XD3_XDFFM_M XD5_XDFFQ_S 1.8151e-17
* device instance cc_XD3_XDFFM_M_XD5_XDFFQ_SB r0 *1 0,0
Ccc_XD3_XDFFM_M_XD5_XDFFQ_SB XD3_XDFFM_M XD5_XDFFQ_SB 1.8151e-17
* device instance cc_XD3_XDFFM_M_XD5_XN2_mid1 r0 *1 0,0
Ccc_XD3_XDFFM_M_XD5_XN2_mid1 XD3_XDFFM_M XD5_XN2_mid1 1.21e-17
* device instance cc_XD3_XDFFM_M_XD5_XN3_mid1 r0 *1 0,0
Ccc_XD3_XDFFM_M_XD5_XN3_mid1 XD3_XDFFM_M XD5_XN3_mid1 1.21e-17
* device instance cc_XD3_XDFFM_M_XD5_XN3_mid2 r0 *1 0,0
Ccc_XD3_XDFFM_M_XD5_XN3_mid2 XD3_XDFFM_M XD5_XN3_mid2 1.21e-17
* device instance cc_XD3_XDFFM_M_XD5_dmodout r0 *1 0,0
Ccc_XD3_XDFFM_M_XD5_dmodout XD3_XDFFM_M XD5_dmodout 1.21e-17
* device instance cc_XD3_XDFFM_M_XD5_dq r0 *1 0,0
Ccc_XD3_XDFFM_M_XD5_dq XD3_XDFFM_M XD5_dq 1.8151e-17
* device instance cc_XD3_XDFFM_M_XD5_nm r0 *1 0,0
Ccc_XD3_XDFFM_M_XD5_nm XD3_XDFFM_M XD5_nm 1.21e-17
* device instance cc_XD3_XDFFM_M_XD5_nt r0 *1 0,0
Ccc_XD3_XDFFM_M_XD5_nt XD3_XDFFM_M XD5_nt 1.21e-17
* device instance cc_XD3_XDFFM_M_XD5_t1 r0 *1 0,0
Ccc_XD3_XDFFM_M_XD5_t1 XD3_XDFFM_M XD5_t1 1.21e-17
* device instance cc_XD3_XDFFM_M_XFRT_CLKB r0 *1 0,0
Ccc_XD3_XDFFM_M_XFRT_CLKB XD3_XDFFM_M XFRT_CLKB 1.8151e-17
* device instance cc_XD3_XDFFM_M_XFRT_M r0 *1 0,0
Ccc_XD3_XDFFM_M_XFRT_M XD3_XDFFM_M XFRT_M 2.4201e-17
* device instance cc_XD3_XDFFM_M_XFRT_MB r0 *1 0,0
Ccc_XD3_XDFFM_M_XFRT_MB XD3_XDFFM_M XFRT_MB 1.21e-17
* device instance cc_XD3_XDFFM_M_XFRT_S r0 *1 0,0
Ccc_XD3_XDFFM_M_XFRT_S XD3_XDFFM_M XFRT_S 1.8151e-17
* device instance cc_XD3_XDFFM_M_XFRT_SB r0 *1 0,0
Ccc_XD3_XDFFM_M_XFRT_SB XD3_XDFFM_M XFRT_SB 1.8151e-17
* device instance cc_XD3_XDFFM_M_ck1 r0 *1 0,0
Ccc_XD3_XDFFM_M_ck1 XD3_XDFFM_M ck1 5.4452e-17
* device instance cc_XD3_XDFFM_M_ck2 r0 *1 0,0
Ccc_XD3_XDFFM_M_ck2 XD3_XDFFM_M ck2 5.4452e-17
* device instance cc_XD3_XDFFM_M_ck3 r0 *1 0,0
Ccc_XD3_XDFFM_M_ck3 XD3_XDFFM_M ck3 6.0502e-17
* device instance cc_XD3_XDFFM_M_ck4 r0 *1 0,0
Ccc_XD3_XDFFM_M_ck4 XD3_XDFFM_M ck4 5.4452e-17
* device instance cc_XD3_XDFFM_M_ck5 r0 *1 0,0
Ccc_XD3_XDFFM_M_ck5 XD3_XDFFM_M ck5 5.4452e-17
* device instance cc_XD3_XDFFM_M_mod0 r0 *1 0,0
Ccc_XD3_XDFFM_M_mod0 XD3_XDFFM_M mod0 2.4201e-17
* device instance cc_XD3_XDFFM_M_mod1 r0 *1 0,0
Ccc_XD3_XDFFM_M_mod1 XD3_XDFFM_M mod1 2.4201e-17
* device instance cc_XD3_XDFFM_M_mod2 r0 *1 0,0
Ccc_XD3_XDFFM_M_mod2 XD3_XDFFM_M mod2 2.4201e-17
* device instance cc_XD3_XDFFM_M_mod3 r0 *1 0,0
Ccc_XD3_XDFFM_M_mod3 XD3_XDFFM_M mod3 2.4201e-17
* device instance cc_XD3_XDFFM_M_mod4 r0 *1 0,0
Ccc_XD3_XDFFM_M_mod4 XD3_XDFFM_M mod4 2.4201e-17
* device instance cc_XD3_XDFFM_M_net1 r0 *1 0,0
Ccc_XD3_XDFFM_M_net1 XD3_XDFFM_M net1 1.21e-17
* device instance cc_XD3_XDFFM_MB_XD3_XDFFM_S r0 *1 0,0
Ccc_XD3_XDFFM_MB_XD3_XDFFM_S XD3_XDFFM_MB XD3_XDFFM_S 1.8151e-17
* device instance cc_XD3_XDFFM_MB_XD3_XDFFM_SB r0 *1 0,0
Ccc_XD3_XDFFM_MB_XD3_XDFFM_SB XD3_XDFFM_MB XD3_XDFFM_SB 1.8151e-17
* device instance cc_XD3_XDFFM_MB_XD3_XDFFQ_CLKB r0 *1 0,0
Ccc_XD3_XDFFM_MB_XD3_XDFFQ_CLKB XD3_XDFFM_MB XD3_XDFFQ_CLKB 1.8151e-17
* device instance cc_XD3_XDFFM_MB_XD3_XDFFQ_M r0 *1 0,0
Ccc_XD3_XDFFM_MB_XD3_XDFFQ_M XD3_XDFFM_MB XD3_XDFFQ_M 2.4201e-17
* device instance cc_XD3_XDFFM_MB_XD3_XDFFQ_MB r0 *1 0,0
Ccc_XD3_XDFFM_MB_XD3_XDFFQ_MB XD3_XDFFM_MB XD3_XDFFQ_MB 1.21e-17
* device instance cc_XD3_XDFFM_MB_XD3_XDFFQ_S r0 *1 0,0
Ccc_XD3_XDFFM_MB_XD3_XDFFQ_S XD3_XDFFM_MB XD3_XDFFQ_S 1.8151e-17
* device instance cc_XD3_XDFFM_MB_XD3_XDFFQ_SB r0 *1 0,0
Ccc_XD3_XDFFM_MB_XD3_XDFFQ_SB XD3_XDFFM_MB XD3_XDFFQ_SB 1.8151e-17
* device instance cc_XD3_XDFFM_MB_XD3_XNOR_midp r0 *1 0,0
Ccc_XD3_XDFFM_MB_XD3_XNOR_midp XD3_XDFFM_MB XD3_XNOR_midp 1.21e-17
* device instance cc_XD3_XDFFM_MB_XD3_dmodout r0 *1 0,0
Ccc_XD3_XDFFM_MB_XD3_dmodout XD3_XDFFM_MB XD3_dmodout 1.21e-17
* device instance cc_XD3_XDFFM_MB_XD3_dq r0 *1 0,0
Ccc_XD3_XDFFM_MB_XD3_dq XD3_XDFFM_MB XD3_dq 1.21e-17
* device instance cc_XD3_XDFFM_MB_XD3_nm r0 *1 0,0
Ccc_XD3_XDFFM_MB_XD3_nm XD3_XDFFM_MB XD3_nm 1.8151e-17
* device instance cc_XD3_XDFFM_MB_XD3_nt r0 *1 0,0
Ccc_XD3_XDFFM_MB_XD3_nt XD3_XDFFM_MB XD3_nt 2.4201e-17
* device instance cc_XD3_XDFFM_MB_XD3_t1 r0 *1 0,0
Ccc_XD3_XDFFM_MB_XD3_t1 XD3_XDFFM_MB XD3_t1 1.21e-17
* device instance cc_XD3_XDFFM_MB_XD4_XDFFM_CLKB r0 *1 0,0
Ccc_XD3_XDFFM_MB_XD4_XDFFM_CLKB XD3_XDFFM_MB XD4_XDFFM_CLKB 1.8151e-17
* device instance cc_XD3_XDFFM_MB_XD4_XDFFM_M r0 *1 0,0
Ccc_XD3_XDFFM_MB_XD4_XDFFM_M XD3_XDFFM_MB XD4_XDFFM_M 2.4201e-17
* device instance cc_XD3_XDFFM_MB_XD4_XDFFM_MB r0 *1 0,0
Ccc_XD3_XDFFM_MB_XD4_XDFFM_MB XD3_XDFFM_MB XD4_XDFFM_MB 1.21e-17
* device instance cc_XD3_XDFFM_MB_XD4_XDFFM_S r0 *1 0,0
Ccc_XD3_XDFFM_MB_XD4_XDFFM_S XD3_XDFFM_MB XD4_XDFFM_S 1.8151e-17
* device instance cc_XD3_XDFFM_MB_XD4_XDFFM_SB r0 *1 0,0
Ccc_XD3_XDFFM_MB_XD4_XDFFM_SB XD3_XDFFM_MB XD4_XDFFM_SB 1.8151e-17
* device instance cc_XD3_XDFFM_MB_XD4_XDFFQ_CLKB r0 *1 0,0
Ccc_XD3_XDFFM_MB_XD4_XDFFQ_CLKB XD3_XDFFM_MB XD4_XDFFQ_CLKB 1.8151e-17
* device instance cc_XD3_XDFFM_MB_XD4_XDFFQ_M r0 *1 0,0
Ccc_XD3_XDFFM_MB_XD4_XDFFQ_M XD3_XDFFM_MB XD4_XDFFQ_M 2.4201e-17
* device instance cc_XD3_XDFFM_MB_XD4_XDFFQ_MB r0 *1 0,0
Ccc_XD3_XDFFM_MB_XD4_XDFFQ_MB XD3_XDFFM_MB XD4_XDFFQ_MB 1.21e-17
* device instance cc_XD3_XDFFM_MB_XD4_XDFFQ_S r0 *1 0,0
Ccc_XD3_XDFFM_MB_XD4_XDFFQ_S XD3_XDFFM_MB XD4_XDFFQ_S 1.8151e-17
* device instance cc_XD3_XDFFM_MB_XD4_XDFFQ_SB r0 *1 0,0
Ccc_XD3_XDFFM_MB_XD4_XDFFQ_SB XD3_XDFFM_MB XD4_XDFFQ_SB 1.8151e-17
* device instance cc_XD3_XDFFM_MB_XD4_XN2_mid1 r0 *1 0,0
Ccc_XD3_XDFFM_MB_XD4_XN2_mid1 XD3_XDFFM_MB XD4_XN2_mid1 1.21e-17
* device instance cc_XD3_XDFFM_MB_XD4_XN3_mid1 r0 *1 0,0
Ccc_XD3_XDFFM_MB_XD4_XN3_mid1 XD3_XDFFM_MB XD4_XN3_mid1 1.21e-17
* device instance cc_XD3_XDFFM_MB_XD4_XN3_mid2 r0 *1 0,0
Ccc_XD3_XDFFM_MB_XD4_XN3_mid2 XD3_XDFFM_MB XD4_XN3_mid2 1.21e-17
* device instance cc_XD3_XDFFM_MB_XD4_dmodout r0 *1 0,0
Ccc_XD3_XDFFM_MB_XD4_dmodout XD3_XDFFM_MB XD4_dmodout 1.21e-17
* device instance cc_XD3_XDFFM_MB_XD4_dq r0 *1 0,0
Ccc_XD3_XDFFM_MB_XD4_dq XD3_XDFFM_MB XD4_dq 1.8151e-17
* device instance cc_XD3_XDFFM_MB_XD4_nm r0 *1 0,0
Ccc_XD3_XDFFM_MB_XD4_nm XD3_XDFFM_MB XD4_nm 1.21e-17
* device instance cc_XD3_XDFFM_MB_XD4_nt r0 *1 0,0
Ccc_XD3_XDFFM_MB_XD4_nt XD3_XDFFM_MB XD4_nt 1.21e-17
* device instance cc_XD3_XDFFM_MB_XD4_t1 r0 *1 0,0
Ccc_XD3_XDFFM_MB_XD4_t1 XD3_XDFFM_MB XD4_t1 1.21e-17
* device instance cc_XD3_XDFFM_MB_XD5_XDFFM_CLKB r0 *1 0,0
Ccc_XD3_XDFFM_MB_XD5_XDFFM_CLKB XD3_XDFFM_MB XD5_XDFFM_CLKB 1.8151e-17
* device instance cc_XD3_XDFFM_MB_XD5_XDFFM_M r0 *1 0,0
Ccc_XD3_XDFFM_MB_XD5_XDFFM_M XD3_XDFFM_MB XD5_XDFFM_M 2.4201e-17
* device instance cc_XD3_XDFFM_MB_XD5_XDFFM_MB r0 *1 0,0
Ccc_XD3_XDFFM_MB_XD5_XDFFM_MB XD3_XDFFM_MB XD5_XDFFM_MB 1.21e-17
* device instance cc_XD3_XDFFM_MB_XD5_XDFFM_S r0 *1 0,0
Ccc_XD3_XDFFM_MB_XD5_XDFFM_S XD3_XDFFM_MB XD5_XDFFM_S 1.8151e-17
* device instance cc_XD3_XDFFM_MB_XD5_XDFFM_SB r0 *1 0,0
Ccc_XD3_XDFFM_MB_XD5_XDFFM_SB XD3_XDFFM_MB XD5_XDFFM_SB 1.8151e-17
* device instance cc_XD3_XDFFM_MB_XD5_XDFFQ_CLKB r0 *1 0,0
Ccc_XD3_XDFFM_MB_XD5_XDFFQ_CLKB XD3_XDFFM_MB XD5_XDFFQ_CLKB 1.8151e-17
* device instance cc_XD3_XDFFM_MB_XD5_XDFFQ_M r0 *1 0,0
Ccc_XD3_XDFFM_MB_XD5_XDFFQ_M XD3_XDFFM_MB XD5_XDFFQ_M 2.4201e-17
* device instance cc_XD3_XDFFM_MB_XD5_XDFFQ_MB r0 *1 0,0
Ccc_XD3_XDFFM_MB_XD5_XDFFQ_MB XD3_XDFFM_MB XD5_XDFFQ_MB 1.21e-17
* device instance cc_XD3_XDFFM_MB_XD5_XDFFQ_S r0 *1 0,0
Ccc_XD3_XDFFM_MB_XD5_XDFFQ_S XD3_XDFFM_MB XD5_XDFFQ_S 1.8151e-17
* device instance cc_XD3_XDFFM_MB_XD5_XDFFQ_SB r0 *1 0,0
Ccc_XD3_XDFFM_MB_XD5_XDFFQ_SB XD3_XDFFM_MB XD5_XDFFQ_SB 1.8151e-17
* device instance cc_XD3_XDFFM_MB_XD5_XN2_mid1 r0 *1 0,0
Ccc_XD3_XDFFM_MB_XD5_XN2_mid1 XD3_XDFFM_MB XD5_XN2_mid1 1.21e-17
* device instance cc_XD3_XDFFM_MB_XD5_XN3_mid1 r0 *1 0,0
Ccc_XD3_XDFFM_MB_XD5_XN3_mid1 XD3_XDFFM_MB XD5_XN3_mid1 1.21e-17
* device instance cc_XD3_XDFFM_MB_XD5_XN3_mid2 r0 *1 0,0
Ccc_XD3_XDFFM_MB_XD5_XN3_mid2 XD3_XDFFM_MB XD5_XN3_mid2 1.21e-17
* device instance cc_XD3_XDFFM_MB_XD5_dmodout r0 *1 0,0
Ccc_XD3_XDFFM_MB_XD5_dmodout XD3_XDFFM_MB XD5_dmodout 1.21e-17
* device instance cc_XD3_XDFFM_MB_XD5_dq r0 *1 0,0
Ccc_XD3_XDFFM_MB_XD5_dq XD3_XDFFM_MB XD5_dq 1.8151e-17
* device instance cc_XD3_XDFFM_MB_XD5_nm r0 *1 0,0
Ccc_XD3_XDFFM_MB_XD5_nm XD3_XDFFM_MB XD5_nm 1.21e-17
* device instance cc_XD3_XDFFM_MB_XD5_nt r0 *1 0,0
Ccc_XD3_XDFFM_MB_XD5_nt XD3_XDFFM_MB XD5_nt 1.21e-17
* device instance cc_XD3_XDFFM_MB_XD5_t1 r0 *1 0,0
Ccc_XD3_XDFFM_MB_XD5_t1 XD3_XDFFM_MB XD5_t1 1.21e-17
* device instance cc_XD3_XDFFM_MB_XFRT_CLKB r0 *1 0,0
Ccc_XD3_XDFFM_MB_XFRT_CLKB XD3_XDFFM_MB XFRT_CLKB 1.8151e-17
* device instance cc_XD3_XDFFM_MB_XFRT_M r0 *1 0,0
Ccc_XD3_XDFFM_MB_XFRT_M XD3_XDFFM_MB XFRT_M 2.4201e-17
* device instance cc_XD3_XDFFM_MB_XFRT_MB r0 *1 0,0
Ccc_XD3_XDFFM_MB_XFRT_MB XD3_XDFFM_MB XFRT_MB 1.21e-17
* device instance cc_XD3_XDFFM_MB_XFRT_S r0 *1 0,0
Ccc_XD3_XDFFM_MB_XFRT_S XD3_XDFFM_MB XFRT_S 1.8151e-17
* device instance cc_XD3_XDFFM_MB_XFRT_SB r0 *1 0,0
Ccc_XD3_XDFFM_MB_XFRT_SB XD3_XDFFM_MB XFRT_SB 1.8151e-17
* device instance cc_XD3_XDFFM_MB_ck1 r0 *1 0,0
Ccc_XD3_XDFFM_MB_ck1 XD3_XDFFM_MB ck1 5.4452e-17
* device instance cc_XD3_XDFFM_MB_ck2 r0 *1 0,0
Ccc_XD3_XDFFM_MB_ck2 XD3_XDFFM_MB ck2 5.4452e-17
* device instance cc_XD3_XDFFM_MB_ck3 r0 *1 0,0
Ccc_XD3_XDFFM_MB_ck3 XD3_XDFFM_MB ck3 6.0502e-17
* device instance cc_XD3_XDFFM_MB_ck4 r0 *1 0,0
Ccc_XD3_XDFFM_MB_ck4 XD3_XDFFM_MB ck4 5.4452e-17
* device instance cc_XD3_XDFFM_MB_ck5 r0 *1 0,0
Ccc_XD3_XDFFM_MB_ck5 XD3_XDFFM_MB ck5 5.4452e-17
* device instance cc_XD3_XDFFM_MB_mod0 r0 *1 0,0
Ccc_XD3_XDFFM_MB_mod0 XD3_XDFFM_MB mod0 2.4201e-17
* device instance cc_XD3_XDFFM_MB_mod1 r0 *1 0,0
Ccc_XD3_XDFFM_MB_mod1 XD3_XDFFM_MB mod1 2.4201e-17
* device instance cc_XD3_XDFFM_MB_mod2 r0 *1 0,0
Ccc_XD3_XDFFM_MB_mod2 XD3_XDFFM_MB mod2 2.4201e-17
* device instance cc_XD3_XDFFM_MB_mod3 r0 *1 0,0
Ccc_XD3_XDFFM_MB_mod3 XD3_XDFFM_MB mod3 2.4201e-17
* device instance cc_XD3_XDFFM_MB_mod4 r0 *1 0,0
Ccc_XD3_XDFFM_MB_mod4 XD3_XDFFM_MB mod4 2.4201e-17
* device instance cc_XD3_XDFFM_MB_net1 r0 *1 0,0
Ccc_XD3_XDFFM_MB_net1 XD3_XDFFM_MB net1 1.21e-17
* device instance cc_XD3_XDFFM_S_XD3_XDFFM_SB r0 *1 0,0
Ccc_XD3_XDFFM_S_XD3_XDFFM_SB XD3_XDFFM_S XD3_XDFFM_SB 4.0738e-17
* device instance cc_XD3_XDFFM_S_XD3_XDFFQ_CLKB r0 *1 0,0
Ccc_XD3_XDFFM_S_XD3_XDFFQ_CLKB XD3_XDFFM_S XD3_XDFFQ_CLKB 1.8151e-17
* device instance cc_XD3_XDFFM_S_XD3_XDFFQ_M r0 *1 0,0
Ccc_XD3_XDFFM_S_XD3_XDFFQ_M XD3_XDFFM_S XD3_XDFFQ_M 2.4201e-17
* device instance cc_XD3_XDFFM_S_XD3_XDFFQ_MB r0 *1 0,0
Ccc_XD3_XDFFM_S_XD3_XDFFQ_MB XD3_XDFFM_S XD3_XDFFQ_MB 1.21e-17
* device instance cc_XD3_XDFFM_S_XD3_XDFFQ_S r0 *1 0,0
Ccc_XD3_XDFFM_S_XD3_XDFFQ_S XD3_XDFFM_S XD3_XDFFQ_S 1.8151e-17
* device instance cc_XD3_XDFFM_S_XD3_XDFFQ_SB r0 *1 0,0
Ccc_XD3_XDFFM_S_XD3_XDFFQ_SB XD3_XDFFM_S XD3_XDFFQ_SB 1.8151e-17
* device instance cc_XD3_XDFFM_S_XD3_XNOR_midp r0 *1 0,0
Ccc_XD3_XDFFM_S_XD3_XNOR_midp XD3_XDFFM_S XD3_XNOR_midp 1.21e-17
* device instance cc_XD3_XDFFM_S_XD3_dmodout r0 *1 0,0
Ccc_XD3_XDFFM_S_XD3_dmodout XD3_XDFFM_S XD3_dmodout 1.21e-17
* device instance cc_XD3_XDFFM_S_XD3_dq r0 *1 0,0
Ccc_XD3_XDFFM_S_XD3_dq XD3_XDFFM_S XD3_dq 1.21e-17
* device instance cc_XD3_XDFFM_S_XD3_nm r0 *1 0,0
Ccc_XD3_XDFFM_S_XD3_nm XD3_XDFFM_S XD3_nm 1.8151e-17
* device instance cc_XD3_XDFFM_S_XD3_nt r0 *1 0,0
Ccc_XD3_XDFFM_S_XD3_nt XD3_XDFFM_S XD3_nt 2.4201e-17
* device instance cc_XD3_XDFFM_S_XD3_t1 r0 *1 0,0
Ccc_XD3_XDFFM_S_XD3_t1 XD3_XDFFM_S XD3_t1 1.21e-17
* device instance cc_XD3_XDFFM_S_XD4_XDFFM_CLKB r0 *1 0,0
Ccc_XD3_XDFFM_S_XD4_XDFFM_CLKB XD3_XDFFM_S XD4_XDFFM_CLKB 1.8151e-17
* device instance cc_XD3_XDFFM_S_XD4_XDFFM_M r0 *1 0,0
Ccc_XD3_XDFFM_S_XD4_XDFFM_M XD3_XDFFM_S XD4_XDFFM_M 2.4201e-17
* device instance cc_XD3_XDFFM_S_XD4_XDFFM_MB r0 *1 0,0
Ccc_XD3_XDFFM_S_XD4_XDFFM_MB XD3_XDFFM_S XD4_XDFFM_MB 1.21e-17
* device instance cc_XD3_XDFFM_S_XD4_XDFFM_S r0 *1 0,0
Ccc_XD3_XDFFM_S_XD4_XDFFM_S XD3_XDFFM_S XD4_XDFFM_S 1.8151e-17
* device instance cc_XD3_XDFFM_S_XD4_XDFFM_SB r0 *1 0,0
Ccc_XD3_XDFFM_S_XD4_XDFFM_SB XD3_XDFFM_S XD4_XDFFM_SB 1.8151e-17
* device instance cc_XD3_XDFFM_S_XD4_XDFFQ_CLKB r0 *1 0,0
Ccc_XD3_XDFFM_S_XD4_XDFFQ_CLKB XD3_XDFFM_S XD4_XDFFQ_CLKB 1.8151e-17
* device instance cc_XD3_XDFFM_S_XD4_XDFFQ_M r0 *1 0,0
Ccc_XD3_XDFFM_S_XD4_XDFFQ_M XD3_XDFFM_S XD4_XDFFQ_M 2.4201e-17
* device instance cc_XD3_XDFFM_S_XD4_XDFFQ_MB r0 *1 0,0
Ccc_XD3_XDFFM_S_XD4_XDFFQ_MB XD3_XDFFM_S XD4_XDFFQ_MB 1.21e-17
* device instance cc_XD3_XDFFM_S_XD4_XDFFQ_S r0 *1 0,0
Ccc_XD3_XDFFM_S_XD4_XDFFQ_S XD3_XDFFM_S XD4_XDFFQ_S 1.8151e-17
* device instance cc_XD3_XDFFM_S_XD4_XDFFQ_SB r0 *1 0,0
Ccc_XD3_XDFFM_S_XD4_XDFFQ_SB XD3_XDFFM_S XD4_XDFFQ_SB 1.8151e-17
* device instance cc_XD3_XDFFM_S_XD4_XN2_mid1 r0 *1 0,0
Ccc_XD3_XDFFM_S_XD4_XN2_mid1 XD3_XDFFM_S XD4_XN2_mid1 1.21e-17
* device instance cc_XD3_XDFFM_S_XD4_XN3_mid1 r0 *1 0,0
Ccc_XD3_XDFFM_S_XD4_XN3_mid1 XD3_XDFFM_S XD4_XN3_mid1 1.21e-17
* device instance cc_XD3_XDFFM_S_XD4_XN3_mid2 r0 *1 0,0
Ccc_XD3_XDFFM_S_XD4_XN3_mid2 XD3_XDFFM_S XD4_XN3_mid2 1.21e-17
* device instance cc_XD3_XDFFM_S_XD4_dmodout r0 *1 0,0
Ccc_XD3_XDFFM_S_XD4_dmodout XD3_XDFFM_S XD4_dmodout 1.21e-17
* device instance cc_XD3_XDFFM_S_XD4_dq r0 *1 0,0
Ccc_XD3_XDFFM_S_XD4_dq XD3_XDFFM_S XD4_dq 1.8151e-17
* device instance cc_XD3_XDFFM_S_XD4_nm r0 *1 0,0
Ccc_XD3_XDFFM_S_XD4_nm XD3_XDFFM_S XD4_nm 1.21e-17
* device instance cc_XD3_XDFFM_S_XD4_nt r0 *1 0,0
Ccc_XD3_XDFFM_S_XD4_nt XD3_XDFFM_S XD4_nt 1.21e-17
* device instance cc_XD3_XDFFM_S_XD4_t1 r0 *1 0,0
Ccc_XD3_XDFFM_S_XD4_t1 XD3_XDFFM_S XD4_t1 1.21e-17
* device instance cc_XD3_XDFFM_S_XD5_XDFFM_CLKB r0 *1 0,0
Ccc_XD3_XDFFM_S_XD5_XDFFM_CLKB XD3_XDFFM_S XD5_XDFFM_CLKB 1.8151e-17
* device instance cc_XD3_XDFFM_S_XD5_XDFFM_M r0 *1 0,0
Ccc_XD3_XDFFM_S_XD5_XDFFM_M XD3_XDFFM_S XD5_XDFFM_M 2.4201e-17
* device instance cc_XD3_XDFFM_S_XD5_XDFFM_MB r0 *1 0,0
Ccc_XD3_XDFFM_S_XD5_XDFFM_MB XD3_XDFFM_S XD5_XDFFM_MB 1.21e-17
* device instance cc_XD3_XDFFM_S_XD5_XDFFM_S r0 *1 0,0
Ccc_XD3_XDFFM_S_XD5_XDFFM_S XD3_XDFFM_S XD5_XDFFM_S 1.8151e-17
* device instance cc_XD3_XDFFM_S_XD5_XDFFM_SB r0 *1 0,0
Ccc_XD3_XDFFM_S_XD5_XDFFM_SB XD3_XDFFM_S XD5_XDFFM_SB 1.8151e-17
* device instance cc_XD3_XDFFM_S_XD5_XDFFQ_CLKB r0 *1 0,0
Ccc_XD3_XDFFM_S_XD5_XDFFQ_CLKB XD3_XDFFM_S XD5_XDFFQ_CLKB 1.8151e-17
* device instance cc_XD3_XDFFM_S_XD5_XDFFQ_M r0 *1 0,0
Ccc_XD3_XDFFM_S_XD5_XDFFQ_M XD3_XDFFM_S XD5_XDFFQ_M 2.4201e-17
* device instance cc_XD3_XDFFM_S_XD5_XDFFQ_MB r0 *1 0,0
Ccc_XD3_XDFFM_S_XD5_XDFFQ_MB XD3_XDFFM_S XD5_XDFFQ_MB 1.21e-17
* device instance cc_XD3_XDFFM_S_XD5_XDFFQ_S r0 *1 0,0
Ccc_XD3_XDFFM_S_XD5_XDFFQ_S XD3_XDFFM_S XD5_XDFFQ_S 1.8151e-17
* device instance cc_XD3_XDFFM_S_XD5_XDFFQ_SB r0 *1 0,0
Ccc_XD3_XDFFM_S_XD5_XDFFQ_SB XD3_XDFFM_S XD5_XDFFQ_SB 1.8151e-17
* device instance cc_XD3_XDFFM_S_XD5_XN2_mid1 r0 *1 0,0
Ccc_XD3_XDFFM_S_XD5_XN2_mid1 XD3_XDFFM_S XD5_XN2_mid1 1.21e-17
* device instance cc_XD3_XDFFM_S_XD5_XN3_mid1 r0 *1 0,0
Ccc_XD3_XDFFM_S_XD5_XN3_mid1 XD3_XDFFM_S XD5_XN3_mid1 1.21e-17
* device instance cc_XD3_XDFFM_S_XD5_XN3_mid2 r0 *1 0,0
Ccc_XD3_XDFFM_S_XD5_XN3_mid2 XD3_XDFFM_S XD5_XN3_mid2 1.21e-17
* device instance cc_XD3_XDFFM_S_XD5_dmodout r0 *1 0,0
Ccc_XD3_XDFFM_S_XD5_dmodout XD3_XDFFM_S XD5_dmodout 1.21e-17
* device instance cc_XD3_XDFFM_S_XD5_dq r0 *1 0,0
Ccc_XD3_XDFFM_S_XD5_dq XD3_XDFFM_S XD5_dq 1.8151e-17
* device instance cc_XD3_XDFFM_S_XD5_nm r0 *1 0,0
Ccc_XD3_XDFFM_S_XD5_nm XD3_XDFFM_S XD5_nm 1.21e-17
* device instance cc_XD3_XDFFM_S_XD5_nt r0 *1 0,0
Ccc_XD3_XDFFM_S_XD5_nt XD3_XDFFM_S XD5_nt 1.21e-17
* device instance cc_XD3_XDFFM_S_XD5_t1 r0 *1 0,0
Ccc_XD3_XDFFM_S_XD5_t1 XD3_XDFFM_S XD5_t1 1.21e-17
* device instance cc_XD3_XDFFM_S_XFRT_CLKB r0 *1 0,0
Ccc_XD3_XDFFM_S_XFRT_CLKB XD3_XDFFM_S XFRT_CLKB 1.8151e-17
* device instance cc_XD3_XDFFM_S_XFRT_M r0 *1 0,0
Ccc_XD3_XDFFM_S_XFRT_M XD3_XDFFM_S XFRT_M 2.4201e-17
* device instance cc_XD3_XDFFM_S_XFRT_MB r0 *1 0,0
Ccc_XD3_XDFFM_S_XFRT_MB XD3_XDFFM_S XFRT_MB 1.21e-17
* device instance cc_XD3_XDFFM_S_XFRT_S r0 *1 0,0
Ccc_XD3_XDFFM_S_XFRT_S XD3_XDFFM_S XFRT_S 1.8151e-17
* device instance cc_XD3_XDFFM_S_XFRT_SB r0 *1 0,0
Ccc_XD3_XDFFM_S_XFRT_SB XD3_XDFFM_S XFRT_SB 1.8151e-17
* device instance cc_XD3_XDFFM_S_ck1 r0 *1 0,0
Ccc_XD3_XDFFM_S_ck1 XD3_XDFFM_S ck1 5.4452e-17
* device instance cc_XD3_XDFFM_S_ck2 r0 *1 0,0
Ccc_XD3_XDFFM_S_ck2 XD3_XDFFM_S ck2 5.4452e-17
* device instance cc_XD3_XDFFM_S_ck3 r0 *1 0,0
Ccc_XD3_XDFFM_S_ck3 XD3_XDFFM_S ck3 5.4452e-17
* device instance cc_XD3_XDFFM_S_ck4 r0 *1 0,0
Ccc_XD3_XDFFM_S_ck4 XD3_XDFFM_S ck4 5.4452e-17
* device instance cc_XD3_XDFFM_S_ck5 r0 *1 0,0
Ccc_XD3_XDFFM_S_ck5 XD3_XDFFM_S ck5 5.4452e-17
* device instance cc_XD3_XDFFM_S_mod0 r0 *1 0,0
Ccc_XD3_XDFFM_S_mod0 XD3_XDFFM_S mod0 2.4201e-17
* device instance cc_XD3_XDFFM_S_mod1 r0 *1 0,0
Ccc_XD3_XDFFM_S_mod1 XD3_XDFFM_S mod1 2.4201e-17
* device instance cc_XD3_XDFFM_S_mod2 r0 *1 0,0
Ccc_XD3_XDFFM_S_mod2 XD3_XDFFM_S mod2 2.4201e-17
* device instance cc_XD3_XDFFM_S_mod3 r0 *1 0,0
Ccc_XD3_XDFFM_S_mod3 XD3_XDFFM_S mod3 2.4201e-17
* device instance cc_XD3_XDFFM_S_mod4 r0 *1 0,0
Ccc_XD3_XDFFM_S_mod4 XD3_XDFFM_S mod4 2.4201e-17
* device instance cc_XD3_XDFFM_S_net1 r0 *1 0,0
Ccc_XD3_XDFFM_S_net1 XD3_XDFFM_S net1 1.21e-17
* device instance cc_XD3_XDFFM_SB_XD3_XDFFQ_CLKB r0 *1 0,0
Ccc_XD3_XDFFM_SB_XD3_XDFFQ_CLKB XD3_XDFFM_SB XD3_XDFFQ_CLKB 1.8151e-17
* device instance cc_XD3_XDFFM_SB_XD3_XDFFQ_M r0 *1 0,0
Ccc_XD3_XDFFM_SB_XD3_XDFFQ_M XD3_XDFFM_SB XD3_XDFFQ_M 2.4201e-17
* device instance cc_XD3_XDFFM_SB_XD3_XDFFQ_MB r0 *1 0,0
Ccc_XD3_XDFFM_SB_XD3_XDFFQ_MB XD3_XDFFM_SB XD3_XDFFQ_MB 1.21e-17
* device instance cc_XD3_XDFFM_SB_XD3_XDFFQ_S r0 *1 0,0
Ccc_XD3_XDFFM_SB_XD3_XDFFQ_S XD3_XDFFM_SB XD3_XDFFQ_S 1.8151e-17
* device instance cc_XD3_XDFFM_SB_XD3_XDFFQ_SB r0 *1 0,0
Ccc_XD3_XDFFM_SB_XD3_XDFFQ_SB XD3_XDFFM_SB XD3_XDFFQ_SB 1.8151e-17
* device instance cc_XD3_XDFFM_SB_XD3_XNOR_midp r0 *1 0,0
Ccc_XD3_XDFFM_SB_XD3_XNOR_midp XD3_XDFFM_SB XD3_XNOR_midp 1.21e-17
* device instance cc_XD3_XDFFM_SB_XD3_dmodout r0 *1 0,0
Ccc_XD3_XDFFM_SB_XD3_dmodout XD3_XDFFM_SB XD3_dmodout 1.21e-17
* device instance cc_XD3_XDFFM_SB_XD3_dq r0 *1 0,0
Ccc_XD3_XDFFM_SB_XD3_dq XD3_XDFFM_SB XD3_dq 1.21e-17
* device instance cc_XD3_XDFFM_SB_XD3_nm r0 *1 0,0
Ccc_XD3_XDFFM_SB_XD3_nm XD3_XDFFM_SB XD3_nm 1.8151e-17
* device instance cc_XD3_XDFFM_SB_XD3_nt r0 *1 0,0
Ccc_XD3_XDFFM_SB_XD3_nt XD3_XDFFM_SB XD3_nt 2.4201e-17
* device instance cc_XD3_XDFFM_SB_XD3_t1 r0 *1 0,0
Ccc_XD3_XDFFM_SB_XD3_t1 XD3_XDFFM_SB XD3_t1 1.21e-17
* device instance cc_XD3_XDFFM_SB_XD4_XDFFM_CLKB r0 *1 0,0
Ccc_XD3_XDFFM_SB_XD4_XDFFM_CLKB XD3_XDFFM_SB XD4_XDFFM_CLKB 1.8151e-17
* device instance cc_XD3_XDFFM_SB_XD4_XDFFM_M r0 *1 0,0
Ccc_XD3_XDFFM_SB_XD4_XDFFM_M XD3_XDFFM_SB XD4_XDFFM_M 2.4201e-17
* device instance cc_XD3_XDFFM_SB_XD4_XDFFM_MB r0 *1 0,0
Ccc_XD3_XDFFM_SB_XD4_XDFFM_MB XD3_XDFFM_SB XD4_XDFFM_MB 1.21e-17
* device instance cc_XD3_XDFFM_SB_XD4_XDFFM_S r0 *1 0,0
Ccc_XD3_XDFFM_SB_XD4_XDFFM_S XD3_XDFFM_SB XD4_XDFFM_S 1.8151e-17
* device instance cc_XD3_XDFFM_SB_XD4_XDFFM_SB r0 *1 0,0
Ccc_XD3_XDFFM_SB_XD4_XDFFM_SB XD3_XDFFM_SB XD4_XDFFM_SB 1.8151e-17
* device instance cc_XD3_XDFFM_SB_XD4_XDFFQ_CLKB r0 *1 0,0
Ccc_XD3_XDFFM_SB_XD4_XDFFQ_CLKB XD3_XDFFM_SB XD4_XDFFQ_CLKB 1.8151e-17
* device instance cc_XD3_XDFFM_SB_XD4_XDFFQ_M r0 *1 0,0
Ccc_XD3_XDFFM_SB_XD4_XDFFQ_M XD3_XDFFM_SB XD4_XDFFQ_M 2.4201e-17
* device instance cc_XD3_XDFFM_SB_XD4_XDFFQ_MB r0 *1 0,0
Ccc_XD3_XDFFM_SB_XD4_XDFFQ_MB XD3_XDFFM_SB XD4_XDFFQ_MB 1.21e-17
* device instance cc_XD3_XDFFM_SB_XD4_XDFFQ_S r0 *1 0,0
Ccc_XD3_XDFFM_SB_XD4_XDFFQ_S XD3_XDFFM_SB XD4_XDFFQ_S 1.8151e-17
* device instance cc_XD3_XDFFM_SB_XD4_XDFFQ_SB r0 *1 0,0
Ccc_XD3_XDFFM_SB_XD4_XDFFQ_SB XD3_XDFFM_SB XD4_XDFFQ_SB 1.8151e-17
* device instance cc_XD3_XDFFM_SB_XD4_XN2_mid1 r0 *1 0,0
Ccc_XD3_XDFFM_SB_XD4_XN2_mid1 XD3_XDFFM_SB XD4_XN2_mid1 1.21e-17
* device instance cc_XD3_XDFFM_SB_XD4_XN3_mid1 r0 *1 0,0
Ccc_XD3_XDFFM_SB_XD4_XN3_mid1 XD3_XDFFM_SB XD4_XN3_mid1 1.21e-17
* device instance cc_XD3_XDFFM_SB_XD4_XN3_mid2 r0 *1 0,0
Ccc_XD3_XDFFM_SB_XD4_XN3_mid2 XD3_XDFFM_SB XD4_XN3_mid2 1.21e-17
* device instance cc_XD3_XDFFM_SB_XD4_dmodout r0 *1 0,0
Ccc_XD3_XDFFM_SB_XD4_dmodout XD3_XDFFM_SB XD4_dmodout 1.21e-17
* device instance cc_XD3_XDFFM_SB_XD4_dq r0 *1 0,0
Ccc_XD3_XDFFM_SB_XD4_dq XD3_XDFFM_SB XD4_dq 1.8151e-17
* device instance cc_XD3_XDFFM_SB_XD4_nm r0 *1 0,0
Ccc_XD3_XDFFM_SB_XD4_nm XD3_XDFFM_SB XD4_nm 1.21e-17
* device instance cc_XD3_XDFFM_SB_XD4_nt r0 *1 0,0
Ccc_XD3_XDFFM_SB_XD4_nt XD3_XDFFM_SB XD4_nt 1.21e-17
* device instance cc_XD3_XDFFM_SB_XD4_t1 r0 *1 0,0
Ccc_XD3_XDFFM_SB_XD4_t1 XD3_XDFFM_SB XD4_t1 1.21e-17
* device instance cc_XD3_XDFFM_SB_XD5_XDFFM_CLKB r0 *1 0,0
Ccc_XD3_XDFFM_SB_XD5_XDFFM_CLKB XD3_XDFFM_SB XD5_XDFFM_CLKB 1.8151e-17
* device instance cc_XD3_XDFFM_SB_XD5_XDFFM_M r0 *1 0,0
Ccc_XD3_XDFFM_SB_XD5_XDFFM_M XD3_XDFFM_SB XD5_XDFFM_M 2.4201e-17
* device instance cc_XD3_XDFFM_SB_XD5_XDFFM_MB r0 *1 0,0
Ccc_XD3_XDFFM_SB_XD5_XDFFM_MB XD3_XDFFM_SB XD5_XDFFM_MB 1.21e-17
* device instance cc_XD3_XDFFM_SB_XD5_XDFFM_S r0 *1 0,0
Ccc_XD3_XDFFM_SB_XD5_XDFFM_S XD3_XDFFM_SB XD5_XDFFM_S 1.8151e-17
* device instance cc_XD3_XDFFM_SB_XD5_XDFFM_SB r0 *1 0,0
Ccc_XD3_XDFFM_SB_XD5_XDFFM_SB XD3_XDFFM_SB XD5_XDFFM_SB 1.8151e-17
* device instance cc_XD3_XDFFM_SB_XD5_XDFFQ_CLKB r0 *1 0,0
Ccc_XD3_XDFFM_SB_XD5_XDFFQ_CLKB XD3_XDFFM_SB XD5_XDFFQ_CLKB 1.8151e-17
* device instance cc_XD3_XDFFM_SB_XD5_XDFFQ_M r0 *1 0,0
Ccc_XD3_XDFFM_SB_XD5_XDFFQ_M XD3_XDFFM_SB XD5_XDFFQ_M 2.4201e-17
* device instance cc_XD3_XDFFM_SB_XD5_XDFFQ_MB r0 *1 0,0
Ccc_XD3_XDFFM_SB_XD5_XDFFQ_MB XD3_XDFFM_SB XD5_XDFFQ_MB 1.21e-17
* device instance cc_XD3_XDFFM_SB_XD5_XDFFQ_S r0 *1 0,0
Ccc_XD3_XDFFM_SB_XD5_XDFFQ_S XD3_XDFFM_SB XD5_XDFFQ_S 1.8151e-17
* device instance cc_XD3_XDFFM_SB_XD5_XDFFQ_SB r0 *1 0,0
Ccc_XD3_XDFFM_SB_XD5_XDFFQ_SB XD3_XDFFM_SB XD5_XDFFQ_SB 1.8151e-17
* device instance cc_XD3_XDFFM_SB_XD5_XN2_mid1 r0 *1 0,0
Ccc_XD3_XDFFM_SB_XD5_XN2_mid1 XD3_XDFFM_SB XD5_XN2_mid1 1.21e-17
* device instance cc_XD3_XDFFM_SB_XD5_XN3_mid1 r0 *1 0,0
Ccc_XD3_XDFFM_SB_XD5_XN3_mid1 XD3_XDFFM_SB XD5_XN3_mid1 1.21e-17
* device instance cc_XD3_XDFFM_SB_XD5_XN3_mid2 r0 *1 0,0
Ccc_XD3_XDFFM_SB_XD5_XN3_mid2 XD3_XDFFM_SB XD5_XN3_mid2 1.21e-17
* device instance cc_XD3_XDFFM_SB_XD5_dmodout r0 *1 0,0
Ccc_XD3_XDFFM_SB_XD5_dmodout XD3_XDFFM_SB XD5_dmodout 1.21e-17
* device instance cc_XD3_XDFFM_SB_XD5_dq r0 *1 0,0
Ccc_XD3_XDFFM_SB_XD5_dq XD3_XDFFM_SB XD5_dq 1.8151e-17
* device instance cc_XD3_XDFFM_SB_XD5_nm r0 *1 0,0
Ccc_XD3_XDFFM_SB_XD5_nm XD3_XDFFM_SB XD5_nm 1.21e-17
* device instance cc_XD3_XDFFM_SB_XD5_nt r0 *1 0,0
Ccc_XD3_XDFFM_SB_XD5_nt XD3_XDFFM_SB XD5_nt 1.21e-17
* device instance cc_XD3_XDFFM_SB_XD5_t1 r0 *1 0,0
Ccc_XD3_XDFFM_SB_XD5_t1 XD3_XDFFM_SB XD5_t1 1.21e-17
* device instance cc_XD3_XDFFM_SB_XFRT_CLKB r0 *1 0,0
Ccc_XD3_XDFFM_SB_XFRT_CLKB XD3_XDFFM_SB XFRT_CLKB 1.8151e-17
* device instance cc_XD3_XDFFM_SB_XFRT_M r0 *1 0,0
Ccc_XD3_XDFFM_SB_XFRT_M XD3_XDFFM_SB XFRT_M 2.4201e-17
* device instance cc_XD3_XDFFM_SB_XFRT_MB r0 *1 0,0
Ccc_XD3_XDFFM_SB_XFRT_MB XD3_XDFFM_SB XFRT_MB 1.21e-17
* device instance cc_XD3_XDFFM_SB_XFRT_S r0 *1 0,0
Ccc_XD3_XDFFM_SB_XFRT_S XD3_XDFFM_SB XFRT_S 1.8151e-17
* device instance cc_XD3_XDFFM_SB_XFRT_SB r0 *1 0,0
Ccc_XD3_XDFFM_SB_XFRT_SB XD3_XDFFM_SB XFRT_SB 1.8151e-17
* device instance cc_XD3_XDFFM_SB_ck1 r0 *1 0,0
Ccc_XD3_XDFFM_SB_ck1 XD3_XDFFM_SB ck1 5.4452e-17
* device instance cc_XD3_XDFFM_SB_ck2 r0 *1 0,0
Ccc_XD3_XDFFM_SB_ck2 XD3_XDFFM_SB ck2 5.4452e-17
* device instance cc_XD3_XDFFM_SB_ck3 r0 *1 0,0
Ccc_XD3_XDFFM_SB_ck3 XD3_XDFFM_SB ck3 5.4452e-17
* device instance cc_XD3_XDFFM_SB_ck4 r0 *1 0,0
Ccc_XD3_XDFFM_SB_ck4 XD3_XDFFM_SB ck4 5.4452e-17
* device instance cc_XD3_XDFFM_SB_ck5 r0 *1 0,0
Ccc_XD3_XDFFM_SB_ck5 XD3_XDFFM_SB ck5 5.4452e-17
* device instance cc_XD3_XDFFM_SB_mod0 r0 *1 0,0
Ccc_XD3_XDFFM_SB_mod0 XD3_XDFFM_SB mod0 2.4201e-17
* device instance cc_XD3_XDFFM_SB_mod1 r0 *1 0,0
Ccc_XD3_XDFFM_SB_mod1 XD3_XDFFM_SB mod1 2.4201e-17
* device instance cc_XD3_XDFFM_SB_mod2 r0 *1 0,0
Ccc_XD3_XDFFM_SB_mod2 XD3_XDFFM_SB mod2 2.4201e-17
* device instance cc_XD3_XDFFM_SB_mod3 r0 *1 0,0
Ccc_XD3_XDFFM_SB_mod3 XD3_XDFFM_SB mod3 2.4201e-17
* device instance cc_XD3_XDFFM_SB_mod4 r0 *1 0,0
Ccc_XD3_XDFFM_SB_mod4 XD3_XDFFM_SB mod4 2.4201e-17
* device instance cc_XD3_XDFFM_SB_net1 r0 *1 0,0
Ccc_XD3_XDFFM_SB_net1 XD3_XDFFM_SB net1 1.21e-17
* device instance cc_XD3_XDFFQ_CLKB_XD3_XDFFQ_M r0 *1 0,0
Ccc_XD3_XDFFQ_CLKB_XD3_XDFFQ_M XD3_XDFFQ_CLKB XD3_XDFFQ_M 4.2352e-17
* device instance cc_XD3_XDFFQ_CLKB_XD3_XDFFQ_MB r0 *1 0,0
Ccc_XD3_XDFFQ_CLKB_XD3_XDFFQ_MB XD3_XDFFQ_CLKB XD3_XDFFQ_MB 2.4201e-17
* device instance cc_XD3_XDFFQ_CLKB_XD3_XDFFQ_S r0 *1 0,0
Ccc_XD3_XDFFQ_CLKB_XD3_XDFFQ_S XD3_XDFFQ_CLKB XD3_XDFFQ_S 1.8151e-17
* device instance cc_XD3_XDFFQ_CLKB_XD3_XDFFQ_SB r0 *1 0,0
Ccc_XD3_XDFFQ_CLKB_XD3_XDFFQ_SB XD3_XDFFQ_CLKB XD3_XDFFQ_SB 1.8151e-17
* device instance cc_XD3_XDFFQ_CLKB_XD3_XN2_mid1 r0 *1 0,0
Ccc_XD3_XDFFQ_CLKB_XD3_XN2_mid1 XD3_XDFFQ_CLKB XD3_XN2_mid1 1.21e-17
* device instance cc_XD3_XDFFQ_CLKB_XD3_XNOR_midp r0 *1 0,0
Ccc_XD3_XDFFQ_CLKB_XD3_XNOR_midp XD3_XDFFQ_CLKB XD3_XNOR_midp 1.21e-17
* device instance cc_XD3_XDFFQ_CLKB_XD3_dmodout r0 *1 0,0
Ccc_XD3_XDFFQ_CLKB_XD3_dmodout XD3_XDFFQ_CLKB XD3_dmodout 1.21e-17
* device instance cc_XD3_XDFFQ_CLKB_XD3_dq r0 *1 0,0
Ccc_XD3_XDFFQ_CLKB_XD3_dq XD3_XDFFQ_CLKB XD3_dq 1.8151e-17
* device instance cc_XD3_XDFFQ_CLKB_XD3_nm r0 *1 0,0
Ccc_XD3_XDFFQ_CLKB_XD3_nm XD3_XDFFQ_CLKB XD3_nm 1.21e-17
* device instance cc_XD3_XDFFQ_CLKB_XD3_nt r0 *1 0,0
Ccc_XD3_XDFFQ_CLKB_XD3_nt XD3_XDFFQ_CLKB XD3_nt 2.4201e-17
* device instance cc_XD3_XDFFQ_CLKB_XD3_t1 r0 *1 0,0
Ccc_XD3_XDFFQ_CLKB_XD3_t1 XD3_XDFFQ_CLKB XD3_t1 1.21e-17
* device instance cc_XD3_XDFFQ_CLKB_XD4_XDFFM_CLKB r0 *1 0,0
Ccc_XD3_XDFFQ_CLKB_XD4_XDFFM_CLKB XD3_XDFFQ_CLKB XD4_XDFFM_CLKB 1.8151e-17
* device instance cc_XD3_XDFFQ_CLKB_XD4_XDFFM_M r0 *1 0,0
Ccc_XD3_XDFFQ_CLKB_XD4_XDFFM_M XD3_XDFFQ_CLKB XD4_XDFFM_M 2.4201e-17
* device instance cc_XD3_XDFFQ_CLKB_XD4_XDFFM_MB r0 *1 0,0
Ccc_XD3_XDFFQ_CLKB_XD4_XDFFM_MB XD3_XDFFQ_CLKB XD4_XDFFM_MB 1.21e-17
* device instance cc_XD3_XDFFQ_CLKB_XD4_XDFFM_S r0 *1 0,0
Ccc_XD3_XDFFQ_CLKB_XD4_XDFFM_S XD3_XDFFQ_CLKB XD4_XDFFM_S 1.8151e-17
* device instance cc_XD3_XDFFQ_CLKB_XD4_XDFFM_SB r0 *1 0,0
Ccc_XD3_XDFFQ_CLKB_XD4_XDFFM_SB XD3_XDFFQ_CLKB XD4_XDFFM_SB 1.8151e-17
* device instance cc_XD3_XDFFQ_CLKB_XD4_XDFFQ_CLKB r0 *1 0,0
Ccc_XD3_XDFFQ_CLKB_XD4_XDFFQ_CLKB XD3_XDFFQ_CLKB XD4_XDFFQ_CLKB 1.8151e-17
* device instance cc_XD3_XDFFQ_CLKB_XD4_XDFFQ_M r0 *1 0,0
Ccc_XD3_XDFFQ_CLKB_XD4_XDFFQ_M XD3_XDFFQ_CLKB XD4_XDFFQ_M 2.4201e-17
* device instance cc_XD3_XDFFQ_CLKB_XD4_XDFFQ_MB r0 *1 0,0
Ccc_XD3_XDFFQ_CLKB_XD4_XDFFQ_MB XD3_XDFFQ_CLKB XD4_XDFFQ_MB 1.21e-17
* device instance cc_XD3_XDFFQ_CLKB_XD4_XDFFQ_S r0 *1 0,0
Ccc_XD3_XDFFQ_CLKB_XD4_XDFFQ_S XD3_XDFFQ_CLKB XD4_XDFFQ_S 1.8151e-17
* device instance cc_XD3_XDFFQ_CLKB_XD4_XDFFQ_SB r0 *1 0,0
Ccc_XD3_XDFFQ_CLKB_XD4_XDFFQ_SB XD3_XDFFQ_CLKB XD4_XDFFQ_SB 1.8151e-17
* device instance cc_XD3_XDFFQ_CLKB_XD4_XN2_mid1 r0 *1 0,0
Ccc_XD3_XDFFQ_CLKB_XD4_XN2_mid1 XD3_XDFFQ_CLKB XD4_XN2_mid1 1.21e-17
* device instance cc_XD3_XDFFQ_CLKB_XD4_XN3_mid1 r0 *1 0,0
Ccc_XD3_XDFFQ_CLKB_XD4_XN3_mid1 XD3_XDFFQ_CLKB XD4_XN3_mid1 1.21e-17
* device instance cc_XD3_XDFFQ_CLKB_XD4_XN3_mid2 r0 *1 0,0
Ccc_XD3_XDFFQ_CLKB_XD4_XN3_mid2 XD3_XDFFQ_CLKB XD4_XN3_mid2 1.21e-17
* device instance cc_XD3_XDFFQ_CLKB_XD4_dmodout r0 *1 0,0
Ccc_XD3_XDFFQ_CLKB_XD4_dmodout XD3_XDFFQ_CLKB XD4_dmodout 1.21e-17
* device instance cc_XD3_XDFFQ_CLKB_XD4_dq r0 *1 0,0
Ccc_XD3_XDFFQ_CLKB_XD4_dq XD3_XDFFQ_CLKB XD4_dq 1.8151e-17
* device instance cc_XD3_XDFFQ_CLKB_XD4_nm r0 *1 0,0
Ccc_XD3_XDFFQ_CLKB_XD4_nm XD3_XDFFQ_CLKB XD4_nm 1.21e-17
* device instance cc_XD3_XDFFQ_CLKB_XD4_nt r0 *1 0,0
Ccc_XD3_XDFFQ_CLKB_XD4_nt XD3_XDFFQ_CLKB XD4_nt 1.21e-17
* device instance cc_XD3_XDFFQ_CLKB_XD4_t1 r0 *1 0,0
Ccc_XD3_XDFFQ_CLKB_XD4_t1 XD3_XDFFQ_CLKB XD4_t1 1.21e-17
* device instance cc_XD3_XDFFQ_CLKB_XD5_XDFFM_CLKB r0 *1 0,0
Ccc_XD3_XDFFQ_CLKB_XD5_XDFFM_CLKB XD3_XDFFQ_CLKB XD5_XDFFM_CLKB 1.8151e-17
* device instance cc_XD3_XDFFQ_CLKB_XD5_XDFFM_M r0 *1 0,0
Ccc_XD3_XDFFQ_CLKB_XD5_XDFFM_M XD3_XDFFQ_CLKB XD5_XDFFM_M 2.4201e-17
* device instance cc_XD3_XDFFQ_CLKB_XD5_XDFFM_MB r0 *1 0,0
Ccc_XD3_XDFFQ_CLKB_XD5_XDFFM_MB XD3_XDFFQ_CLKB XD5_XDFFM_MB 1.21e-17
* device instance cc_XD3_XDFFQ_CLKB_XD5_XDFFM_S r0 *1 0,0
Ccc_XD3_XDFFQ_CLKB_XD5_XDFFM_S XD3_XDFFQ_CLKB XD5_XDFFM_S 1.8151e-17
* device instance cc_XD3_XDFFQ_CLKB_XD5_XDFFM_SB r0 *1 0,0
Ccc_XD3_XDFFQ_CLKB_XD5_XDFFM_SB XD3_XDFFQ_CLKB XD5_XDFFM_SB 1.8151e-17
* device instance cc_XD3_XDFFQ_CLKB_XD5_XDFFQ_CLKB r0 *1 0,0
Ccc_XD3_XDFFQ_CLKB_XD5_XDFFQ_CLKB XD3_XDFFQ_CLKB XD5_XDFFQ_CLKB 1.8151e-17
* device instance cc_XD3_XDFFQ_CLKB_XD5_XDFFQ_M r0 *1 0,0
Ccc_XD3_XDFFQ_CLKB_XD5_XDFFQ_M XD3_XDFFQ_CLKB XD5_XDFFQ_M 2.4201e-17
* device instance cc_XD3_XDFFQ_CLKB_XD5_XDFFQ_MB r0 *1 0,0
Ccc_XD3_XDFFQ_CLKB_XD5_XDFFQ_MB XD3_XDFFQ_CLKB XD5_XDFFQ_MB 1.21e-17
* device instance cc_XD3_XDFFQ_CLKB_XD5_XDFFQ_S r0 *1 0,0
Ccc_XD3_XDFFQ_CLKB_XD5_XDFFQ_S XD3_XDFFQ_CLKB XD5_XDFFQ_S 1.8151e-17
* device instance cc_XD3_XDFFQ_CLKB_XD5_XDFFQ_SB r0 *1 0,0
Ccc_XD3_XDFFQ_CLKB_XD5_XDFFQ_SB XD3_XDFFQ_CLKB XD5_XDFFQ_SB 1.8151e-17
* device instance cc_XD3_XDFFQ_CLKB_XD5_XN2_mid1 r0 *1 0,0
Ccc_XD3_XDFFQ_CLKB_XD5_XN2_mid1 XD3_XDFFQ_CLKB XD5_XN2_mid1 1.21e-17
* device instance cc_XD3_XDFFQ_CLKB_XD5_XN3_mid1 r0 *1 0,0
Ccc_XD3_XDFFQ_CLKB_XD5_XN3_mid1 XD3_XDFFQ_CLKB XD5_XN3_mid1 1.21e-17
* device instance cc_XD3_XDFFQ_CLKB_XD5_XN3_mid2 r0 *1 0,0
Ccc_XD3_XDFFQ_CLKB_XD5_XN3_mid2 XD3_XDFFQ_CLKB XD5_XN3_mid2 1.21e-17
* device instance cc_XD3_XDFFQ_CLKB_XD5_dmodout r0 *1 0,0
Ccc_XD3_XDFFQ_CLKB_XD5_dmodout XD3_XDFFQ_CLKB XD5_dmodout 1.21e-17
* device instance cc_XD3_XDFFQ_CLKB_XD5_dq r0 *1 0,0
Ccc_XD3_XDFFQ_CLKB_XD5_dq XD3_XDFFQ_CLKB XD5_dq 1.8151e-17
* device instance cc_XD3_XDFFQ_CLKB_XD5_nm r0 *1 0,0
Ccc_XD3_XDFFQ_CLKB_XD5_nm XD3_XDFFQ_CLKB XD5_nm 1.21e-17
* device instance cc_XD3_XDFFQ_CLKB_XD5_nt r0 *1 0,0
Ccc_XD3_XDFFQ_CLKB_XD5_nt XD3_XDFFQ_CLKB XD5_nt 1.21e-17
* device instance cc_XD3_XDFFQ_CLKB_XD5_t1 r0 *1 0,0
Ccc_XD3_XDFFQ_CLKB_XD5_t1 XD3_XDFFQ_CLKB XD5_t1 1.21e-17
* device instance cc_XD3_XDFFQ_CLKB_XFRT_CLKB r0 *1 0,0
Ccc_XD3_XDFFQ_CLKB_XFRT_CLKB XD3_XDFFQ_CLKB XFRT_CLKB 1.8151e-17
* device instance cc_XD3_XDFFQ_CLKB_XFRT_M r0 *1 0,0
Ccc_XD3_XDFFQ_CLKB_XFRT_M XD3_XDFFQ_CLKB XFRT_M 2.4201e-17
* device instance cc_XD3_XDFFQ_CLKB_XFRT_MB r0 *1 0,0
Ccc_XD3_XDFFQ_CLKB_XFRT_MB XD3_XDFFQ_CLKB XFRT_MB 1.21e-17
* device instance cc_XD3_XDFFQ_CLKB_XFRT_S r0 *1 0,0
Ccc_XD3_XDFFQ_CLKB_XFRT_S XD3_XDFFQ_CLKB XFRT_S 1.8151e-17
* device instance cc_XD3_XDFFQ_CLKB_XFRT_SB r0 *1 0,0
Ccc_XD3_XDFFQ_CLKB_XFRT_SB XD3_XDFFQ_CLKB XFRT_SB 1.8151e-17
* device instance cc_XD3_XDFFQ_CLKB_ck1 r0 *1 0,0
Ccc_XD3_XDFFQ_CLKB_ck1 XD3_XDFFQ_CLKB ck1 5.4452e-17
* device instance cc_XD3_XDFFQ_CLKB_ck2 r0 *1 0,0
Ccc_XD3_XDFFQ_CLKB_ck2 XD3_XDFFQ_CLKB ck2 5.4452e-17
* device instance cc_XD3_XDFFQ_CLKB_ck3 r0 *1 0,0
Ccc_XD3_XDFFQ_CLKB_ck3 XD3_XDFFQ_CLKB ck3 6.0502e-17
* device instance cc_XD3_XDFFQ_CLKB_ck4 r0 *1 0,0
Ccc_XD3_XDFFQ_CLKB_ck4 XD3_XDFFQ_CLKB ck4 5.4452e-17
* device instance cc_XD3_XDFFQ_CLKB_ck5 r0 *1 0,0
Ccc_XD3_XDFFQ_CLKB_ck5 XD3_XDFFQ_CLKB ck5 5.4452e-17
* device instance cc_XD3_XDFFQ_CLKB_mod0 r0 *1 0,0
Ccc_XD3_XDFFQ_CLKB_mod0 XD3_XDFFQ_CLKB mod0 2.4201e-17
* device instance cc_XD3_XDFFQ_CLKB_mod1 r0 *1 0,0
Ccc_XD3_XDFFQ_CLKB_mod1 XD3_XDFFQ_CLKB mod1 2.4201e-17
* device instance cc_XD3_XDFFQ_CLKB_mod2 r0 *1 0,0
Ccc_XD3_XDFFQ_CLKB_mod2 XD3_XDFFQ_CLKB mod2 2.4201e-17
* device instance cc_XD3_XDFFQ_CLKB_mod3 r0 *1 0,0
Ccc_XD3_XDFFQ_CLKB_mod3 XD3_XDFFQ_CLKB mod3 2.4201e-17
* device instance cc_XD3_XDFFQ_CLKB_mod4 r0 *1 0,0
Ccc_XD3_XDFFQ_CLKB_mod4 XD3_XDFFQ_CLKB mod4 2.4201e-17
* device instance cc_XD3_XDFFQ_CLKB_net1 r0 *1 0,0
Ccc_XD3_XDFFQ_CLKB_net1 XD3_XDFFQ_CLKB net1 1.21e-17
* device instance cc_XD3_XDFFQ_M_XD3_XDFFQ_MB r0 *1 0,0
Ccc_XD3_XDFFQ_M_XD3_XDFFQ_MB XD3_XDFFQ_M XD3_XDFFQ_MB 3.4688e-17
* device instance cc_XD3_XDFFQ_M_XD3_XDFFQ_S r0 *1 0,0
Ccc_XD3_XDFFQ_M_XD3_XDFFQ_S XD3_XDFFQ_M XD3_XDFFQ_S 2.8638e-17
* device instance cc_XD3_XDFFQ_M_XD3_XDFFQ_SB r0 *1 0,0
Ccc_XD3_XDFFQ_M_XD3_XDFFQ_SB XD3_XDFFQ_M XD3_XDFFQ_SB 1.8151e-17
* device instance cc_XD3_XDFFQ_M_XD3_XN2_mid1 r0 *1 0,0
Ccc_XD3_XDFFQ_M_XD3_XN2_mid1 XD3_XDFFQ_M XD3_XN2_mid1 1.21e-17
* device instance cc_XD3_XDFFQ_M_XD3_XNOR_midp r0 *1 0,0
Ccc_XD3_XDFFQ_M_XD3_XNOR_midp XD3_XDFFQ_M XD3_XNOR_midp 1.21e-17
* device instance cc_XD3_XDFFQ_M_XD3_dmodout r0 *1 0,0
Ccc_XD3_XDFFQ_M_XD3_dmodout XD3_XDFFQ_M XD3_dmodout 1.21e-17
* device instance cc_XD3_XDFFQ_M_XD3_dq r0 *1 0,0
Ccc_XD3_XDFFQ_M_XD3_dq XD3_XDFFQ_M XD3_dq 2.8638e-17
* device instance cc_XD3_XDFFQ_M_XD3_nm r0 *1 0,0
Ccc_XD3_XDFFQ_M_XD3_nm XD3_XDFFQ_M XD3_nm 1.21e-17
* device instance cc_XD3_XDFFQ_M_XD3_nt r0 *1 0,0
Ccc_XD3_XDFFQ_M_XD3_nt XD3_XDFFQ_M XD3_nt 2.4201e-17
* device instance cc_XD3_XDFFQ_M_XD3_t1 r0 *1 0,0
Ccc_XD3_XDFFQ_M_XD3_t1 XD3_XDFFQ_M XD3_t1 1.21e-17
* device instance cc_XD3_XDFFQ_M_XD4_XDFFM_CLKB r0 *1 0,0
Ccc_XD3_XDFFQ_M_XD4_XDFFM_CLKB XD3_XDFFQ_M XD4_XDFFM_CLKB 1.8151e-17
* device instance cc_XD3_XDFFQ_M_XD4_XDFFM_M r0 *1 0,0
Ccc_XD3_XDFFQ_M_XD4_XDFFM_M XD3_XDFFQ_M XD4_XDFFM_M 2.4201e-17
* device instance cc_XD3_XDFFQ_M_XD4_XDFFM_MB r0 *1 0,0
Ccc_XD3_XDFFQ_M_XD4_XDFFM_MB XD3_XDFFQ_M XD4_XDFFM_MB 1.21e-17
* device instance cc_XD3_XDFFQ_M_XD4_XDFFM_S r0 *1 0,0
Ccc_XD3_XDFFQ_M_XD4_XDFFM_S XD3_XDFFQ_M XD4_XDFFM_S 1.8151e-17
* device instance cc_XD3_XDFFQ_M_XD4_XDFFM_SB r0 *1 0,0
Ccc_XD3_XDFFQ_M_XD4_XDFFM_SB XD3_XDFFQ_M XD4_XDFFM_SB 1.8151e-17
* device instance cc_XD3_XDFFQ_M_XD4_XDFFQ_CLKB r0 *1 0,0
Ccc_XD3_XDFFQ_M_XD4_XDFFQ_CLKB XD3_XDFFQ_M XD4_XDFFQ_CLKB 1.8151e-17
* device instance cc_XD3_XDFFQ_M_XD4_XDFFQ_M r0 *1 0,0
Ccc_XD3_XDFFQ_M_XD4_XDFFQ_M XD3_XDFFQ_M XD4_XDFFQ_M 2.4201e-17
* device instance cc_XD3_XDFFQ_M_XD4_XDFFQ_MB r0 *1 0,0
Ccc_XD3_XDFFQ_M_XD4_XDFFQ_MB XD3_XDFFQ_M XD4_XDFFQ_MB 1.21e-17
* device instance cc_XD3_XDFFQ_M_XD4_XDFFQ_S r0 *1 0,0
Ccc_XD3_XDFFQ_M_XD4_XDFFQ_S XD3_XDFFQ_M XD4_XDFFQ_S 1.8151e-17
* device instance cc_XD3_XDFFQ_M_XD4_XDFFQ_SB r0 *1 0,0
Ccc_XD3_XDFFQ_M_XD4_XDFFQ_SB XD3_XDFFQ_M XD4_XDFFQ_SB 1.8151e-17
* device instance cc_XD3_XDFFQ_M_XD4_XN2_mid1 r0 *1 0,0
Ccc_XD3_XDFFQ_M_XD4_XN2_mid1 XD3_XDFFQ_M XD4_XN2_mid1 1.21e-17
* device instance cc_XD3_XDFFQ_M_XD4_XN3_mid1 r0 *1 0,0
Ccc_XD3_XDFFQ_M_XD4_XN3_mid1 XD3_XDFFQ_M XD4_XN3_mid1 1.21e-17
* device instance cc_XD3_XDFFQ_M_XD4_XN3_mid2 r0 *1 0,0
Ccc_XD3_XDFFQ_M_XD4_XN3_mid2 XD3_XDFFQ_M XD4_XN3_mid2 1.21e-17
* device instance cc_XD3_XDFFQ_M_XD4_dmodout r0 *1 0,0
Ccc_XD3_XDFFQ_M_XD4_dmodout XD3_XDFFQ_M XD4_dmodout 1.21e-17
* device instance cc_XD3_XDFFQ_M_XD4_dq r0 *1 0,0
Ccc_XD3_XDFFQ_M_XD4_dq XD3_XDFFQ_M XD4_dq 1.8151e-17
* device instance cc_XD3_XDFFQ_M_XD4_nm r0 *1 0,0
Ccc_XD3_XDFFQ_M_XD4_nm XD3_XDFFQ_M XD4_nm 1.21e-17
* device instance cc_XD3_XDFFQ_M_XD4_nt r0 *1 0,0
Ccc_XD3_XDFFQ_M_XD4_nt XD3_XDFFQ_M XD4_nt 1.21e-17
* device instance cc_XD3_XDFFQ_M_XD4_t1 r0 *1 0,0
Ccc_XD3_XDFFQ_M_XD4_t1 XD3_XDFFQ_M XD4_t1 1.21e-17
* device instance cc_XD3_XDFFQ_M_XD5_XDFFM_CLKB r0 *1 0,0
Ccc_XD3_XDFFQ_M_XD5_XDFFM_CLKB XD3_XDFFQ_M XD5_XDFFM_CLKB 1.8151e-17
* device instance cc_XD3_XDFFQ_M_XD5_XDFFM_M r0 *1 0,0
Ccc_XD3_XDFFQ_M_XD5_XDFFM_M XD3_XDFFQ_M XD5_XDFFM_M 2.4201e-17
* device instance cc_XD3_XDFFQ_M_XD5_XDFFM_MB r0 *1 0,0
Ccc_XD3_XDFFQ_M_XD5_XDFFM_MB XD3_XDFFQ_M XD5_XDFFM_MB 1.21e-17
* device instance cc_XD3_XDFFQ_M_XD5_XDFFM_S r0 *1 0,0
Ccc_XD3_XDFFQ_M_XD5_XDFFM_S XD3_XDFFQ_M XD5_XDFFM_S 1.8151e-17
* device instance cc_XD3_XDFFQ_M_XD5_XDFFM_SB r0 *1 0,0
Ccc_XD3_XDFFQ_M_XD5_XDFFM_SB XD3_XDFFQ_M XD5_XDFFM_SB 1.8151e-17
* device instance cc_XD3_XDFFQ_M_XD5_XDFFQ_CLKB r0 *1 0,0
Ccc_XD3_XDFFQ_M_XD5_XDFFQ_CLKB XD3_XDFFQ_M XD5_XDFFQ_CLKB 1.8151e-17
* device instance cc_XD3_XDFFQ_M_XD5_XDFFQ_M r0 *1 0,0
Ccc_XD3_XDFFQ_M_XD5_XDFFQ_M XD3_XDFFQ_M XD5_XDFFQ_M 2.4201e-17
* device instance cc_XD3_XDFFQ_M_XD5_XDFFQ_MB r0 *1 0,0
Ccc_XD3_XDFFQ_M_XD5_XDFFQ_MB XD3_XDFFQ_M XD5_XDFFQ_MB 1.21e-17
* device instance cc_XD3_XDFFQ_M_XD5_XDFFQ_S r0 *1 0,0
Ccc_XD3_XDFFQ_M_XD5_XDFFQ_S XD3_XDFFQ_M XD5_XDFFQ_S 1.8151e-17
* device instance cc_XD3_XDFFQ_M_XD5_XDFFQ_SB r0 *1 0,0
Ccc_XD3_XDFFQ_M_XD5_XDFFQ_SB XD3_XDFFQ_M XD5_XDFFQ_SB 1.8151e-17
* device instance cc_XD3_XDFFQ_M_XD5_XN2_mid1 r0 *1 0,0
Ccc_XD3_XDFFQ_M_XD5_XN2_mid1 XD3_XDFFQ_M XD5_XN2_mid1 1.21e-17
* device instance cc_XD3_XDFFQ_M_XD5_XN3_mid1 r0 *1 0,0
Ccc_XD3_XDFFQ_M_XD5_XN3_mid1 XD3_XDFFQ_M XD5_XN3_mid1 1.21e-17
* device instance cc_XD3_XDFFQ_M_XD5_XN3_mid2 r0 *1 0,0
Ccc_XD3_XDFFQ_M_XD5_XN3_mid2 XD3_XDFFQ_M XD5_XN3_mid2 1.21e-17
* device instance cc_XD3_XDFFQ_M_XD5_dmodout r0 *1 0,0
Ccc_XD3_XDFFQ_M_XD5_dmodout XD3_XDFFQ_M XD5_dmodout 1.21e-17
* device instance cc_XD3_XDFFQ_M_XD5_dq r0 *1 0,0
Ccc_XD3_XDFFQ_M_XD5_dq XD3_XDFFQ_M XD5_dq 1.8151e-17
* device instance cc_XD3_XDFFQ_M_XD5_nm r0 *1 0,0
Ccc_XD3_XDFFQ_M_XD5_nm XD3_XDFFQ_M XD5_nm 1.21e-17
* device instance cc_XD3_XDFFQ_M_XD5_nt r0 *1 0,0
Ccc_XD3_XDFFQ_M_XD5_nt XD3_XDFFQ_M XD5_nt 1.21e-17
* device instance cc_XD3_XDFFQ_M_XD5_t1 r0 *1 0,0
Ccc_XD3_XDFFQ_M_XD5_t1 XD3_XDFFQ_M XD5_t1 1.21e-17
* device instance cc_XD3_XDFFQ_M_XFRT_CLKB r0 *1 0,0
Ccc_XD3_XDFFQ_M_XFRT_CLKB XD3_XDFFQ_M XFRT_CLKB 1.8151e-17
* device instance cc_XD3_XDFFQ_M_XFRT_M r0 *1 0,0
Ccc_XD3_XDFFQ_M_XFRT_M XD3_XDFFQ_M XFRT_M 2.4201e-17
* device instance cc_XD3_XDFFQ_M_XFRT_MB r0 *1 0,0
Ccc_XD3_XDFFQ_M_XFRT_MB XD3_XDFFQ_M XFRT_MB 1.21e-17
* device instance cc_XD3_XDFFQ_M_XFRT_S r0 *1 0,0
Ccc_XD3_XDFFQ_M_XFRT_S XD3_XDFFQ_M XFRT_S 1.8151e-17
* device instance cc_XD3_XDFFQ_M_XFRT_SB r0 *1 0,0
Ccc_XD3_XDFFQ_M_XFRT_SB XD3_XDFFQ_M XFRT_SB 1.8151e-17
* device instance cc_XD3_XDFFQ_M_ck1 r0 *1 0,0
Ccc_XD3_XDFFQ_M_ck1 XD3_XDFFQ_M ck1 5.4452e-17
* device instance cc_XD3_XDFFQ_M_ck2 r0 *1 0,0
Ccc_XD3_XDFFQ_M_ck2 XD3_XDFFQ_M ck2 5.4452e-17
* device instance cc_XD3_XDFFQ_M_ck3 r0 *1 0,0
Ccc_XD3_XDFFQ_M_ck3 XD3_XDFFQ_M ck3 6.0502e-17
* device instance cc_XD3_XDFFQ_M_ck4 r0 *1 0,0
Ccc_XD3_XDFFQ_M_ck4 XD3_XDFFQ_M ck4 5.4452e-17
* device instance cc_XD3_XDFFQ_M_ck5 r0 *1 0,0
Ccc_XD3_XDFFQ_M_ck5 XD3_XDFFQ_M ck5 5.4452e-17
* device instance cc_XD3_XDFFQ_M_mod0 r0 *1 0,0
Ccc_XD3_XDFFQ_M_mod0 XD3_XDFFQ_M mod0 2.4201e-17
* device instance cc_XD3_XDFFQ_M_mod1 r0 *1 0,0
Ccc_XD3_XDFFQ_M_mod1 XD3_XDFFQ_M mod1 2.4201e-17
* device instance cc_XD3_XDFFQ_M_mod2 r0 *1 0,0
Ccc_XD3_XDFFQ_M_mod2 XD3_XDFFQ_M mod2 2.4201e-17
* device instance cc_XD3_XDFFQ_M_mod3 r0 *1 0,0
Ccc_XD3_XDFFQ_M_mod3 XD3_XDFFQ_M mod3 2.4201e-17
* device instance cc_XD3_XDFFQ_M_mod4 r0 *1 0,0
Ccc_XD3_XDFFQ_M_mod4 XD3_XDFFQ_M mod4 2.4201e-17
* device instance cc_XD3_XDFFQ_M_net1 r0 *1 0,0
Ccc_XD3_XDFFQ_M_net1 XD3_XDFFQ_M net1 1.21e-17
* device instance cc_XD3_XDFFQ_MB_XD3_XDFFQ_S r0 *1 0,0
Ccc_XD3_XDFFQ_MB_XD3_XDFFQ_S XD3_XDFFQ_MB XD3_XDFFQ_S 1.8151e-17
* device instance cc_XD3_XDFFQ_MB_XD3_XDFFQ_SB r0 *1 0,0
Ccc_XD3_XDFFQ_MB_XD3_XDFFQ_SB XD3_XDFFQ_MB XD3_XDFFQ_SB 1.8151e-17
* device instance cc_XD3_XDFFQ_MB_XD3_XN2_mid1 r0 *1 0,0
Ccc_XD3_XDFFQ_MB_XD3_XN2_mid1 XD3_XDFFQ_MB XD3_XN2_mid1 1.21e-17
* device instance cc_XD3_XDFFQ_MB_XD3_XNOR_midp r0 *1 0,0
Ccc_XD3_XDFFQ_MB_XD3_XNOR_midp XD3_XDFFQ_MB XD3_XNOR_midp 1.21e-17
* device instance cc_XD3_XDFFQ_MB_XD3_dmodout r0 *1 0,0
Ccc_XD3_XDFFQ_MB_XD3_dmodout XD3_XDFFQ_MB XD3_dmodout 1.21e-17
* device instance cc_XD3_XDFFQ_MB_XD3_dq r0 *1 0,0
Ccc_XD3_XDFFQ_MB_XD3_dq XD3_XDFFQ_MB XD3_dq 1.21e-17
* device instance cc_XD3_XDFFQ_MB_XD3_nm r0 *1 0,0
Ccc_XD3_XDFFQ_MB_XD3_nm XD3_XDFFQ_MB XD3_nm 1.21e-17
* device instance cc_XD3_XDFFQ_MB_XD3_nt r0 *1 0,0
Ccc_XD3_XDFFQ_MB_XD3_nt XD3_XDFFQ_MB XD3_nt 2.4201e-17
* device instance cc_XD3_XDFFQ_MB_XD3_t1 r0 *1 0,0
Ccc_XD3_XDFFQ_MB_XD3_t1 XD3_XDFFQ_MB XD3_t1 1.21e-17
* device instance cc_XD3_XDFFQ_MB_XD4_XDFFM_CLKB r0 *1 0,0
Ccc_XD3_XDFFQ_MB_XD4_XDFFM_CLKB XD3_XDFFQ_MB XD4_XDFFM_CLKB 1.8151e-17
* device instance cc_XD3_XDFFQ_MB_XD4_XDFFM_M r0 *1 0,0
Ccc_XD3_XDFFQ_MB_XD4_XDFFM_M XD3_XDFFQ_MB XD4_XDFFM_M 2.4201e-17
* device instance cc_XD3_XDFFQ_MB_XD4_XDFFM_MB r0 *1 0,0
Ccc_XD3_XDFFQ_MB_XD4_XDFFM_MB XD3_XDFFQ_MB XD4_XDFFM_MB 1.21e-17
* device instance cc_XD3_XDFFQ_MB_XD4_XDFFM_S r0 *1 0,0
Ccc_XD3_XDFFQ_MB_XD4_XDFFM_S XD3_XDFFQ_MB XD4_XDFFM_S 1.8151e-17
* device instance cc_XD3_XDFFQ_MB_XD4_XDFFM_SB r0 *1 0,0
Ccc_XD3_XDFFQ_MB_XD4_XDFFM_SB XD3_XDFFQ_MB XD4_XDFFM_SB 1.8151e-17
* device instance cc_XD3_XDFFQ_MB_XD4_XDFFQ_CLKB r0 *1 0,0
Ccc_XD3_XDFFQ_MB_XD4_XDFFQ_CLKB XD3_XDFFQ_MB XD4_XDFFQ_CLKB 1.8151e-17
* device instance cc_XD3_XDFFQ_MB_XD4_XDFFQ_M r0 *1 0,0
Ccc_XD3_XDFFQ_MB_XD4_XDFFQ_M XD3_XDFFQ_MB XD4_XDFFQ_M 2.4201e-17
* device instance cc_XD3_XDFFQ_MB_XD4_XDFFQ_MB r0 *1 0,0
Ccc_XD3_XDFFQ_MB_XD4_XDFFQ_MB XD3_XDFFQ_MB XD4_XDFFQ_MB 1.21e-17
* device instance cc_XD3_XDFFQ_MB_XD4_XDFFQ_S r0 *1 0,0
Ccc_XD3_XDFFQ_MB_XD4_XDFFQ_S XD3_XDFFQ_MB XD4_XDFFQ_S 1.8151e-17
* device instance cc_XD3_XDFFQ_MB_XD4_XDFFQ_SB r0 *1 0,0
Ccc_XD3_XDFFQ_MB_XD4_XDFFQ_SB XD3_XDFFQ_MB XD4_XDFFQ_SB 1.8151e-17
* device instance cc_XD3_XDFFQ_MB_XD4_XN2_mid1 r0 *1 0,0
Ccc_XD3_XDFFQ_MB_XD4_XN2_mid1 XD3_XDFFQ_MB XD4_XN2_mid1 1.21e-17
* device instance cc_XD3_XDFFQ_MB_XD4_XN3_mid1 r0 *1 0,0
Ccc_XD3_XDFFQ_MB_XD4_XN3_mid1 XD3_XDFFQ_MB XD4_XN3_mid1 1.21e-17
* device instance cc_XD3_XDFFQ_MB_XD4_XN3_mid2 r0 *1 0,0
Ccc_XD3_XDFFQ_MB_XD4_XN3_mid2 XD3_XDFFQ_MB XD4_XN3_mid2 1.21e-17
* device instance cc_XD3_XDFFQ_MB_XD4_dmodout r0 *1 0,0
Ccc_XD3_XDFFQ_MB_XD4_dmodout XD3_XDFFQ_MB XD4_dmodout 1.21e-17
* device instance cc_XD3_XDFFQ_MB_XD4_dq r0 *1 0,0
Ccc_XD3_XDFFQ_MB_XD4_dq XD3_XDFFQ_MB XD4_dq 1.8151e-17
* device instance cc_XD3_XDFFQ_MB_XD4_nm r0 *1 0,0
Ccc_XD3_XDFFQ_MB_XD4_nm XD3_XDFFQ_MB XD4_nm 1.21e-17
* device instance cc_XD3_XDFFQ_MB_XD4_nt r0 *1 0,0
Ccc_XD3_XDFFQ_MB_XD4_nt XD3_XDFFQ_MB XD4_nt 1.21e-17
* device instance cc_XD3_XDFFQ_MB_XD4_t1 r0 *1 0,0
Ccc_XD3_XDFFQ_MB_XD4_t1 XD3_XDFFQ_MB XD4_t1 1.21e-17
* device instance cc_XD3_XDFFQ_MB_XD5_XDFFM_CLKB r0 *1 0,0
Ccc_XD3_XDFFQ_MB_XD5_XDFFM_CLKB XD3_XDFFQ_MB XD5_XDFFM_CLKB 1.8151e-17
* device instance cc_XD3_XDFFQ_MB_XD5_XDFFM_M r0 *1 0,0
Ccc_XD3_XDFFQ_MB_XD5_XDFFM_M XD3_XDFFQ_MB XD5_XDFFM_M 2.4201e-17
* device instance cc_XD3_XDFFQ_MB_XD5_XDFFM_MB r0 *1 0,0
Ccc_XD3_XDFFQ_MB_XD5_XDFFM_MB XD3_XDFFQ_MB XD5_XDFFM_MB 1.21e-17
* device instance cc_XD3_XDFFQ_MB_XD5_XDFFM_S r0 *1 0,0
Ccc_XD3_XDFFQ_MB_XD5_XDFFM_S XD3_XDFFQ_MB XD5_XDFFM_S 1.8151e-17
* device instance cc_XD3_XDFFQ_MB_XD5_XDFFM_SB r0 *1 0,0
Ccc_XD3_XDFFQ_MB_XD5_XDFFM_SB XD3_XDFFQ_MB XD5_XDFFM_SB 1.8151e-17
* device instance cc_XD3_XDFFQ_MB_XD5_XDFFQ_CLKB r0 *1 0,0
Ccc_XD3_XDFFQ_MB_XD5_XDFFQ_CLKB XD3_XDFFQ_MB XD5_XDFFQ_CLKB 1.8151e-17
* device instance cc_XD3_XDFFQ_MB_XD5_XDFFQ_M r0 *1 0,0
Ccc_XD3_XDFFQ_MB_XD5_XDFFQ_M XD3_XDFFQ_MB XD5_XDFFQ_M 2.4201e-17
* device instance cc_XD3_XDFFQ_MB_XD5_XDFFQ_MB r0 *1 0,0
Ccc_XD3_XDFFQ_MB_XD5_XDFFQ_MB XD3_XDFFQ_MB XD5_XDFFQ_MB 1.21e-17
* device instance cc_XD3_XDFFQ_MB_XD5_XDFFQ_S r0 *1 0,0
Ccc_XD3_XDFFQ_MB_XD5_XDFFQ_S XD3_XDFFQ_MB XD5_XDFFQ_S 1.8151e-17
* device instance cc_XD3_XDFFQ_MB_XD5_XDFFQ_SB r0 *1 0,0
Ccc_XD3_XDFFQ_MB_XD5_XDFFQ_SB XD3_XDFFQ_MB XD5_XDFFQ_SB 1.8151e-17
* device instance cc_XD3_XDFFQ_MB_XD5_XN2_mid1 r0 *1 0,0
Ccc_XD3_XDFFQ_MB_XD5_XN2_mid1 XD3_XDFFQ_MB XD5_XN2_mid1 1.21e-17
* device instance cc_XD3_XDFFQ_MB_XD5_XN3_mid1 r0 *1 0,0
Ccc_XD3_XDFFQ_MB_XD5_XN3_mid1 XD3_XDFFQ_MB XD5_XN3_mid1 1.21e-17
* device instance cc_XD3_XDFFQ_MB_XD5_XN3_mid2 r0 *1 0,0
Ccc_XD3_XDFFQ_MB_XD5_XN3_mid2 XD3_XDFFQ_MB XD5_XN3_mid2 1.21e-17
* device instance cc_XD3_XDFFQ_MB_XD5_dmodout r0 *1 0,0
Ccc_XD3_XDFFQ_MB_XD5_dmodout XD3_XDFFQ_MB XD5_dmodout 1.21e-17
* device instance cc_XD3_XDFFQ_MB_XD5_dq r0 *1 0,0
Ccc_XD3_XDFFQ_MB_XD5_dq XD3_XDFFQ_MB XD5_dq 1.8151e-17
* device instance cc_XD3_XDFFQ_MB_XD5_nm r0 *1 0,0
Ccc_XD3_XDFFQ_MB_XD5_nm XD3_XDFFQ_MB XD5_nm 1.21e-17
* device instance cc_XD3_XDFFQ_MB_XD5_nt r0 *1 0,0
Ccc_XD3_XDFFQ_MB_XD5_nt XD3_XDFFQ_MB XD5_nt 1.21e-17
* device instance cc_XD3_XDFFQ_MB_XD5_t1 r0 *1 0,0
Ccc_XD3_XDFFQ_MB_XD5_t1 XD3_XDFFQ_MB XD5_t1 1.21e-17
* device instance cc_XD3_XDFFQ_MB_XFRT_CLKB r0 *1 0,0
Ccc_XD3_XDFFQ_MB_XFRT_CLKB XD3_XDFFQ_MB XFRT_CLKB 1.8151e-17
* device instance cc_XD3_XDFFQ_MB_XFRT_M r0 *1 0,0
Ccc_XD3_XDFFQ_MB_XFRT_M XD3_XDFFQ_MB XFRT_M 2.4201e-17
* device instance cc_XD3_XDFFQ_MB_XFRT_MB r0 *1 0,0
Ccc_XD3_XDFFQ_MB_XFRT_MB XD3_XDFFQ_MB XFRT_MB 1.21e-17
* device instance cc_XD3_XDFFQ_MB_XFRT_S r0 *1 0,0
Ccc_XD3_XDFFQ_MB_XFRT_S XD3_XDFFQ_MB XFRT_S 1.8151e-17
* device instance cc_XD3_XDFFQ_MB_XFRT_SB r0 *1 0,0
Ccc_XD3_XDFFQ_MB_XFRT_SB XD3_XDFFQ_MB XFRT_SB 1.8151e-17
* device instance cc_XD3_XDFFQ_MB_ck1 r0 *1 0,0
Ccc_XD3_XDFFQ_MB_ck1 XD3_XDFFQ_MB ck1 5.4452e-17
* device instance cc_XD3_XDFFQ_MB_ck2 r0 *1 0,0
Ccc_XD3_XDFFQ_MB_ck2 XD3_XDFFQ_MB ck2 5.4452e-17
* device instance cc_XD3_XDFFQ_MB_ck3 r0 *1 0,0
Ccc_XD3_XDFFQ_MB_ck3 XD3_XDFFQ_MB ck3 6.0502e-17
* device instance cc_XD3_XDFFQ_MB_ck4 r0 *1 0,0
Ccc_XD3_XDFFQ_MB_ck4 XD3_XDFFQ_MB ck4 5.4452e-17
* device instance cc_XD3_XDFFQ_MB_ck5 r0 *1 0,0
Ccc_XD3_XDFFQ_MB_ck5 XD3_XDFFQ_MB ck5 5.4452e-17
* device instance cc_XD3_XDFFQ_MB_mod0 r0 *1 0,0
Ccc_XD3_XDFFQ_MB_mod0 XD3_XDFFQ_MB mod0 2.4201e-17
* device instance cc_XD3_XDFFQ_MB_mod1 r0 *1 0,0
Ccc_XD3_XDFFQ_MB_mod1 XD3_XDFFQ_MB mod1 2.4201e-17
* device instance cc_XD3_XDFFQ_MB_mod2 r0 *1 0,0
Ccc_XD3_XDFFQ_MB_mod2 XD3_XDFFQ_MB mod2 2.4201e-17
* device instance cc_XD3_XDFFQ_MB_mod3 r0 *1 0,0
Ccc_XD3_XDFFQ_MB_mod3 XD3_XDFFQ_MB mod3 2.4201e-17
* device instance cc_XD3_XDFFQ_MB_mod4 r0 *1 0,0
Ccc_XD3_XDFFQ_MB_mod4 XD3_XDFFQ_MB mod4 2.4201e-17
* device instance cc_XD3_XDFFQ_MB_net1 r0 *1 0,0
Ccc_XD3_XDFFQ_MB_net1 XD3_XDFFQ_MB net1 1.21e-17
* device instance cc_XD3_XDFFQ_S_XD3_XDFFQ_SB r0 *1 0,0
Ccc_XD3_XDFFQ_S_XD3_XDFFQ_SB XD3_XDFFQ_S XD3_XDFFQ_SB 4.0738e-17
* device instance cc_XD3_XDFFQ_S_XD3_XN2_mid1 r0 *1 0,0
Ccc_XD3_XDFFQ_S_XD3_XN2_mid1 XD3_XDFFQ_S XD3_XN2_mid1 1.21e-17
* device instance cc_XD3_XDFFQ_S_XD3_XNOR_midp r0 *1 0,0
Ccc_XD3_XDFFQ_S_XD3_XNOR_midp XD3_XDFFQ_S XD3_XNOR_midp 1.21e-17
* device instance cc_XD3_XDFFQ_S_XD3_dmodout r0 *1 0,0
Ccc_XD3_XDFFQ_S_XD3_dmodout XD3_XDFFQ_S XD3_dmodout 1.21e-17
* device instance cc_XD3_XDFFQ_S_XD3_dq r0 *1 0,0
Ccc_XD3_XDFFQ_S_XD3_dq XD3_XDFFQ_S XD3_dq 1.21e-17
* device instance cc_XD3_XDFFQ_S_XD3_nm r0 *1 0,0
Ccc_XD3_XDFFQ_S_XD3_nm XD3_XDFFQ_S XD3_nm 1.21e-17
* device instance cc_XD3_XDFFQ_S_XD3_nt r0 *1 0,0
Ccc_XD3_XDFFQ_S_XD3_nt XD3_XDFFQ_S XD3_nt 2.4201e-17
* device instance cc_XD3_XDFFQ_S_XD3_t1 r0 *1 0,0
Ccc_XD3_XDFFQ_S_XD3_t1 XD3_XDFFQ_S XD3_t1 1.21e-17
* device instance cc_XD3_XDFFQ_S_XD4_XDFFM_CLKB r0 *1 0,0
Ccc_XD3_XDFFQ_S_XD4_XDFFM_CLKB XD3_XDFFQ_S XD4_XDFFM_CLKB 1.8151e-17
* device instance cc_XD3_XDFFQ_S_XD4_XDFFM_M r0 *1 0,0
Ccc_XD3_XDFFQ_S_XD4_XDFFM_M XD3_XDFFQ_S XD4_XDFFM_M 2.4201e-17
* device instance cc_XD3_XDFFQ_S_XD4_XDFFM_MB r0 *1 0,0
Ccc_XD3_XDFFQ_S_XD4_XDFFM_MB XD3_XDFFQ_S XD4_XDFFM_MB 1.21e-17
* device instance cc_XD3_XDFFQ_S_XD4_XDFFM_S r0 *1 0,0
Ccc_XD3_XDFFQ_S_XD4_XDFFM_S XD3_XDFFQ_S XD4_XDFFM_S 1.8151e-17
* device instance cc_XD3_XDFFQ_S_XD4_XDFFM_SB r0 *1 0,0
Ccc_XD3_XDFFQ_S_XD4_XDFFM_SB XD3_XDFFQ_S XD4_XDFFM_SB 1.8151e-17
* device instance cc_XD3_XDFFQ_S_XD4_XDFFQ_CLKB r0 *1 0,0
Ccc_XD3_XDFFQ_S_XD4_XDFFQ_CLKB XD3_XDFFQ_S XD4_XDFFQ_CLKB 1.8151e-17
* device instance cc_XD3_XDFFQ_S_XD4_XDFFQ_M r0 *1 0,0
Ccc_XD3_XDFFQ_S_XD4_XDFFQ_M XD3_XDFFQ_S XD4_XDFFQ_M 2.4201e-17
* device instance cc_XD3_XDFFQ_S_XD4_XDFFQ_MB r0 *1 0,0
Ccc_XD3_XDFFQ_S_XD4_XDFFQ_MB XD3_XDFFQ_S XD4_XDFFQ_MB 1.21e-17
* device instance cc_XD3_XDFFQ_S_XD4_XDFFQ_S r0 *1 0,0
Ccc_XD3_XDFFQ_S_XD4_XDFFQ_S XD3_XDFFQ_S XD4_XDFFQ_S 1.8151e-17
* device instance cc_XD3_XDFFQ_S_XD4_XDFFQ_SB r0 *1 0,0
Ccc_XD3_XDFFQ_S_XD4_XDFFQ_SB XD3_XDFFQ_S XD4_XDFFQ_SB 1.8151e-17
* device instance cc_XD3_XDFFQ_S_XD4_XN2_mid1 r0 *1 0,0
Ccc_XD3_XDFFQ_S_XD4_XN2_mid1 XD3_XDFFQ_S XD4_XN2_mid1 1.21e-17
* device instance cc_XD3_XDFFQ_S_XD4_XN3_mid1 r0 *1 0,0
Ccc_XD3_XDFFQ_S_XD4_XN3_mid1 XD3_XDFFQ_S XD4_XN3_mid1 1.21e-17
* device instance cc_XD3_XDFFQ_S_XD4_XN3_mid2 r0 *1 0,0
Ccc_XD3_XDFFQ_S_XD4_XN3_mid2 XD3_XDFFQ_S XD4_XN3_mid2 1.21e-17
* device instance cc_XD3_XDFFQ_S_XD4_dmodout r0 *1 0,0
Ccc_XD3_XDFFQ_S_XD4_dmodout XD3_XDFFQ_S XD4_dmodout 1.21e-17
* device instance cc_XD3_XDFFQ_S_XD4_dq r0 *1 0,0
Ccc_XD3_XDFFQ_S_XD4_dq XD3_XDFFQ_S XD4_dq 1.8151e-17
* device instance cc_XD3_XDFFQ_S_XD4_nm r0 *1 0,0
Ccc_XD3_XDFFQ_S_XD4_nm XD3_XDFFQ_S XD4_nm 1.21e-17
* device instance cc_XD3_XDFFQ_S_XD4_nt r0 *1 0,0
Ccc_XD3_XDFFQ_S_XD4_nt XD3_XDFFQ_S XD4_nt 1.21e-17
* device instance cc_XD3_XDFFQ_S_XD4_t1 r0 *1 0,0
Ccc_XD3_XDFFQ_S_XD4_t1 XD3_XDFFQ_S XD4_t1 1.21e-17
* device instance cc_XD3_XDFFQ_S_XD5_XDFFM_CLKB r0 *1 0,0
Ccc_XD3_XDFFQ_S_XD5_XDFFM_CLKB XD3_XDFFQ_S XD5_XDFFM_CLKB 1.8151e-17
* device instance cc_XD3_XDFFQ_S_XD5_XDFFM_M r0 *1 0,0
Ccc_XD3_XDFFQ_S_XD5_XDFFM_M XD3_XDFFQ_S XD5_XDFFM_M 2.4201e-17
* device instance cc_XD3_XDFFQ_S_XD5_XDFFM_MB r0 *1 0,0
Ccc_XD3_XDFFQ_S_XD5_XDFFM_MB XD3_XDFFQ_S XD5_XDFFM_MB 1.21e-17
* device instance cc_XD3_XDFFQ_S_XD5_XDFFM_S r0 *1 0,0
Ccc_XD3_XDFFQ_S_XD5_XDFFM_S XD3_XDFFQ_S XD5_XDFFM_S 1.8151e-17
* device instance cc_XD3_XDFFQ_S_XD5_XDFFM_SB r0 *1 0,0
Ccc_XD3_XDFFQ_S_XD5_XDFFM_SB XD3_XDFFQ_S XD5_XDFFM_SB 1.8151e-17
* device instance cc_XD3_XDFFQ_S_XD5_XDFFQ_CLKB r0 *1 0,0
Ccc_XD3_XDFFQ_S_XD5_XDFFQ_CLKB XD3_XDFFQ_S XD5_XDFFQ_CLKB 1.8151e-17
* device instance cc_XD3_XDFFQ_S_XD5_XDFFQ_M r0 *1 0,0
Ccc_XD3_XDFFQ_S_XD5_XDFFQ_M XD3_XDFFQ_S XD5_XDFFQ_M 2.4201e-17
* device instance cc_XD3_XDFFQ_S_XD5_XDFFQ_MB r0 *1 0,0
Ccc_XD3_XDFFQ_S_XD5_XDFFQ_MB XD3_XDFFQ_S XD5_XDFFQ_MB 1.21e-17
* device instance cc_XD3_XDFFQ_S_XD5_XDFFQ_S r0 *1 0,0
Ccc_XD3_XDFFQ_S_XD5_XDFFQ_S XD3_XDFFQ_S XD5_XDFFQ_S 1.8151e-17
* device instance cc_XD3_XDFFQ_S_XD5_XDFFQ_SB r0 *1 0,0
Ccc_XD3_XDFFQ_S_XD5_XDFFQ_SB XD3_XDFFQ_S XD5_XDFFQ_SB 1.8151e-17
* device instance cc_XD3_XDFFQ_S_XD5_XN2_mid1 r0 *1 0,0
Ccc_XD3_XDFFQ_S_XD5_XN2_mid1 XD3_XDFFQ_S XD5_XN2_mid1 1.21e-17
* device instance cc_XD3_XDFFQ_S_XD5_XN3_mid1 r0 *1 0,0
Ccc_XD3_XDFFQ_S_XD5_XN3_mid1 XD3_XDFFQ_S XD5_XN3_mid1 1.21e-17
* device instance cc_XD3_XDFFQ_S_XD5_XN3_mid2 r0 *1 0,0
Ccc_XD3_XDFFQ_S_XD5_XN3_mid2 XD3_XDFFQ_S XD5_XN3_mid2 1.21e-17
* device instance cc_XD3_XDFFQ_S_XD5_dmodout r0 *1 0,0
Ccc_XD3_XDFFQ_S_XD5_dmodout XD3_XDFFQ_S XD5_dmodout 1.21e-17
* device instance cc_XD3_XDFFQ_S_XD5_dq r0 *1 0,0
Ccc_XD3_XDFFQ_S_XD5_dq XD3_XDFFQ_S XD5_dq 1.8151e-17
* device instance cc_XD3_XDFFQ_S_XD5_nm r0 *1 0,0
Ccc_XD3_XDFFQ_S_XD5_nm XD3_XDFFQ_S XD5_nm 1.21e-17
* device instance cc_XD3_XDFFQ_S_XD5_nt r0 *1 0,0
Ccc_XD3_XDFFQ_S_XD5_nt XD3_XDFFQ_S XD5_nt 1.21e-17
* device instance cc_XD3_XDFFQ_S_XD5_t1 r0 *1 0,0
Ccc_XD3_XDFFQ_S_XD5_t1 XD3_XDFFQ_S XD5_t1 1.21e-17
* device instance cc_XD3_XDFFQ_S_XFRT_CLKB r0 *1 0,0
Ccc_XD3_XDFFQ_S_XFRT_CLKB XD3_XDFFQ_S XFRT_CLKB 1.8151e-17
* device instance cc_XD3_XDFFQ_S_XFRT_M r0 *1 0,0
Ccc_XD3_XDFFQ_S_XFRT_M XD3_XDFFQ_S XFRT_M 2.4201e-17
* device instance cc_XD3_XDFFQ_S_XFRT_MB r0 *1 0,0
Ccc_XD3_XDFFQ_S_XFRT_MB XD3_XDFFQ_S XFRT_MB 1.21e-17
* device instance cc_XD3_XDFFQ_S_XFRT_S r0 *1 0,0
Ccc_XD3_XDFFQ_S_XFRT_S XD3_XDFFQ_S XFRT_S 1.8151e-17
* device instance cc_XD3_XDFFQ_S_XFRT_SB r0 *1 0,0
Ccc_XD3_XDFFQ_S_XFRT_SB XD3_XDFFQ_S XFRT_SB 1.8151e-17
* device instance cc_XD3_XDFFQ_S_ck1 r0 *1 0,0
Ccc_XD3_XDFFQ_S_ck1 XD3_XDFFQ_S ck1 5.4452e-17
* device instance cc_XD3_XDFFQ_S_ck2 r0 *1 0,0
Ccc_XD3_XDFFQ_S_ck2 XD3_XDFFQ_S ck2 5.4452e-17
* device instance cc_XD3_XDFFQ_S_ck3 r0 *1 0,0
Ccc_XD3_XDFFQ_S_ck3 XD3_XDFFQ_S ck3 5.4452e-17
* device instance cc_XD3_XDFFQ_S_ck4 r0 *1 0,0
Ccc_XD3_XDFFQ_S_ck4 XD3_XDFFQ_S ck4 5.4452e-17
* device instance cc_XD3_XDFFQ_S_ck5 r0 *1 0,0
Ccc_XD3_XDFFQ_S_ck5 XD3_XDFFQ_S ck5 5.4452e-17
* device instance cc_XD3_XDFFQ_S_mod0 r0 *1 0,0
Ccc_XD3_XDFFQ_S_mod0 XD3_XDFFQ_S mod0 2.4201e-17
* device instance cc_XD3_XDFFQ_S_mod1 r0 *1 0,0
Ccc_XD3_XDFFQ_S_mod1 XD3_XDFFQ_S mod1 2.4201e-17
* device instance cc_XD3_XDFFQ_S_mod2 r0 *1 0,0
Ccc_XD3_XDFFQ_S_mod2 XD3_XDFFQ_S mod2 2.4201e-17
* device instance cc_XD3_XDFFQ_S_mod3 r0 *1 0,0
Ccc_XD3_XDFFQ_S_mod3 XD3_XDFFQ_S mod3 2.4201e-17
* device instance cc_XD3_XDFFQ_S_mod4 r0 *1 0,0
Ccc_XD3_XDFFQ_S_mod4 XD3_XDFFQ_S mod4 2.4201e-17
* device instance cc_XD3_XDFFQ_S_net1 r0 *1 0,0
Ccc_XD3_XDFFQ_S_net1 XD3_XDFFQ_S net1 1.21e-17
* device instance cc_XD3_XDFFQ_SB_XD3_XN2_mid1 r0 *1 0,0
Ccc_XD3_XDFFQ_SB_XD3_XN2_mid1 XD3_XDFFQ_SB XD3_XN2_mid1 1.21e-17
* device instance cc_XD3_XDFFQ_SB_XD3_XNOR_midp r0 *1 0,0
Ccc_XD3_XDFFQ_SB_XD3_XNOR_midp XD3_XDFFQ_SB XD3_XNOR_midp 1.21e-17
* device instance cc_XD3_XDFFQ_SB_XD3_dmodout r0 *1 0,0
Ccc_XD3_XDFFQ_SB_XD3_dmodout XD3_XDFFQ_SB XD3_dmodout 1.21e-17
* device instance cc_XD3_XDFFQ_SB_XD3_dq r0 *1 0,0
Ccc_XD3_XDFFQ_SB_XD3_dq XD3_XDFFQ_SB XD3_dq 1.21e-17
* device instance cc_XD3_XDFFQ_SB_XD3_nm r0 *1 0,0
Ccc_XD3_XDFFQ_SB_XD3_nm XD3_XDFFQ_SB XD3_nm 1.21e-17
* device instance cc_XD3_XDFFQ_SB_XD3_nt r0 *1 0,0
Ccc_XD3_XDFFQ_SB_XD3_nt XD3_XDFFQ_SB XD3_nt 2.4201e-17
* device instance cc_XD3_XDFFQ_SB_XD3_t1 r0 *1 0,0
Ccc_XD3_XDFFQ_SB_XD3_t1 XD3_XDFFQ_SB XD3_t1 1.21e-17
* device instance cc_XD3_XDFFQ_SB_XD4_XDFFM_CLKB r0 *1 0,0
Ccc_XD3_XDFFQ_SB_XD4_XDFFM_CLKB XD3_XDFFQ_SB XD4_XDFFM_CLKB 1.8151e-17
* device instance cc_XD3_XDFFQ_SB_XD4_XDFFM_M r0 *1 0,0
Ccc_XD3_XDFFQ_SB_XD4_XDFFM_M XD3_XDFFQ_SB XD4_XDFFM_M 2.4201e-17
* device instance cc_XD3_XDFFQ_SB_XD4_XDFFM_MB r0 *1 0,0
Ccc_XD3_XDFFQ_SB_XD4_XDFFM_MB XD3_XDFFQ_SB XD4_XDFFM_MB 1.21e-17
* device instance cc_XD3_XDFFQ_SB_XD4_XDFFM_S r0 *1 0,0
Ccc_XD3_XDFFQ_SB_XD4_XDFFM_S XD3_XDFFQ_SB XD4_XDFFM_S 1.8151e-17
* device instance cc_XD3_XDFFQ_SB_XD4_XDFFM_SB r0 *1 0,0
Ccc_XD3_XDFFQ_SB_XD4_XDFFM_SB XD3_XDFFQ_SB XD4_XDFFM_SB 1.8151e-17
* device instance cc_XD3_XDFFQ_SB_XD4_XDFFQ_CLKB r0 *1 0,0
Ccc_XD3_XDFFQ_SB_XD4_XDFFQ_CLKB XD3_XDFFQ_SB XD4_XDFFQ_CLKB 1.8151e-17
* device instance cc_XD3_XDFFQ_SB_XD4_XDFFQ_M r0 *1 0,0
Ccc_XD3_XDFFQ_SB_XD4_XDFFQ_M XD3_XDFFQ_SB XD4_XDFFQ_M 2.4201e-17
* device instance cc_XD3_XDFFQ_SB_XD4_XDFFQ_MB r0 *1 0,0
Ccc_XD3_XDFFQ_SB_XD4_XDFFQ_MB XD3_XDFFQ_SB XD4_XDFFQ_MB 1.21e-17
* device instance cc_XD3_XDFFQ_SB_XD4_XDFFQ_S r0 *1 0,0
Ccc_XD3_XDFFQ_SB_XD4_XDFFQ_S XD3_XDFFQ_SB XD4_XDFFQ_S 1.8151e-17
* device instance cc_XD3_XDFFQ_SB_XD4_XDFFQ_SB r0 *1 0,0
Ccc_XD3_XDFFQ_SB_XD4_XDFFQ_SB XD3_XDFFQ_SB XD4_XDFFQ_SB 1.8151e-17
* device instance cc_XD3_XDFFQ_SB_XD4_XN2_mid1 r0 *1 0,0
Ccc_XD3_XDFFQ_SB_XD4_XN2_mid1 XD3_XDFFQ_SB XD4_XN2_mid1 1.21e-17
* device instance cc_XD3_XDFFQ_SB_XD4_XN3_mid1 r0 *1 0,0
Ccc_XD3_XDFFQ_SB_XD4_XN3_mid1 XD3_XDFFQ_SB XD4_XN3_mid1 1.21e-17
* device instance cc_XD3_XDFFQ_SB_XD4_XN3_mid2 r0 *1 0,0
Ccc_XD3_XDFFQ_SB_XD4_XN3_mid2 XD3_XDFFQ_SB XD4_XN3_mid2 1.21e-17
* device instance cc_XD3_XDFFQ_SB_XD4_dmodout r0 *1 0,0
Ccc_XD3_XDFFQ_SB_XD4_dmodout XD3_XDFFQ_SB XD4_dmodout 1.21e-17
* device instance cc_XD3_XDFFQ_SB_XD4_dq r0 *1 0,0
Ccc_XD3_XDFFQ_SB_XD4_dq XD3_XDFFQ_SB XD4_dq 1.8151e-17
* device instance cc_XD3_XDFFQ_SB_XD4_nm r0 *1 0,0
Ccc_XD3_XDFFQ_SB_XD4_nm XD3_XDFFQ_SB XD4_nm 1.21e-17
* device instance cc_XD3_XDFFQ_SB_XD4_nt r0 *1 0,0
Ccc_XD3_XDFFQ_SB_XD4_nt XD3_XDFFQ_SB XD4_nt 1.21e-17
* device instance cc_XD3_XDFFQ_SB_XD4_t1 r0 *1 0,0
Ccc_XD3_XDFFQ_SB_XD4_t1 XD3_XDFFQ_SB XD4_t1 1.21e-17
* device instance cc_XD3_XDFFQ_SB_XD5_XDFFM_CLKB r0 *1 0,0
Ccc_XD3_XDFFQ_SB_XD5_XDFFM_CLKB XD3_XDFFQ_SB XD5_XDFFM_CLKB 1.8151e-17
* device instance cc_XD3_XDFFQ_SB_XD5_XDFFM_M r0 *1 0,0
Ccc_XD3_XDFFQ_SB_XD5_XDFFM_M XD3_XDFFQ_SB XD5_XDFFM_M 2.4201e-17
* device instance cc_XD3_XDFFQ_SB_XD5_XDFFM_MB r0 *1 0,0
Ccc_XD3_XDFFQ_SB_XD5_XDFFM_MB XD3_XDFFQ_SB XD5_XDFFM_MB 1.21e-17
* device instance cc_XD3_XDFFQ_SB_XD5_XDFFM_S r0 *1 0,0
Ccc_XD3_XDFFQ_SB_XD5_XDFFM_S XD3_XDFFQ_SB XD5_XDFFM_S 1.8151e-17
* device instance cc_XD3_XDFFQ_SB_XD5_XDFFM_SB r0 *1 0,0
Ccc_XD3_XDFFQ_SB_XD5_XDFFM_SB XD3_XDFFQ_SB XD5_XDFFM_SB 1.8151e-17
* device instance cc_XD3_XDFFQ_SB_XD5_XDFFQ_CLKB r0 *1 0,0
Ccc_XD3_XDFFQ_SB_XD5_XDFFQ_CLKB XD3_XDFFQ_SB XD5_XDFFQ_CLKB 1.8151e-17
* device instance cc_XD3_XDFFQ_SB_XD5_XDFFQ_M r0 *1 0,0
Ccc_XD3_XDFFQ_SB_XD5_XDFFQ_M XD3_XDFFQ_SB XD5_XDFFQ_M 2.4201e-17
* device instance cc_XD3_XDFFQ_SB_XD5_XDFFQ_MB r0 *1 0,0
Ccc_XD3_XDFFQ_SB_XD5_XDFFQ_MB XD3_XDFFQ_SB XD5_XDFFQ_MB 1.21e-17
* device instance cc_XD3_XDFFQ_SB_XD5_XDFFQ_S r0 *1 0,0
Ccc_XD3_XDFFQ_SB_XD5_XDFFQ_S XD3_XDFFQ_SB XD5_XDFFQ_S 1.8151e-17
* device instance cc_XD3_XDFFQ_SB_XD5_XDFFQ_SB r0 *1 0,0
Ccc_XD3_XDFFQ_SB_XD5_XDFFQ_SB XD3_XDFFQ_SB XD5_XDFFQ_SB 1.8151e-17
* device instance cc_XD3_XDFFQ_SB_XD5_XN2_mid1 r0 *1 0,0
Ccc_XD3_XDFFQ_SB_XD5_XN2_mid1 XD3_XDFFQ_SB XD5_XN2_mid1 1.21e-17
* device instance cc_XD3_XDFFQ_SB_XD5_XN3_mid1 r0 *1 0,0
Ccc_XD3_XDFFQ_SB_XD5_XN3_mid1 XD3_XDFFQ_SB XD5_XN3_mid1 1.21e-17
* device instance cc_XD3_XDFFQ_SB_XD5_XN3_mid2 r0 *1 0,0
Ccc_XD3_XDFFQ_SB_XD5_XN3_mid2 XD3_XDFFQ_SB XD5_XN3_mid2 1.21e-17
* device instance cc_XD3_XDFFQ_SB_XD5_dmodout r0 *1 0,0
Ccc_XD3_XDFFQ_SB_XD5_dmodout XD3_XDFFQ_SB XD5_dmodout 1.21e-17
* device instance cc_XD3_XDFFQ_SB_XD5_dq r0 *1 0,0
Ccc_XD3_XDFFQ_SB_XD5_dq XD3_XDFFQ_SB XD5_dq 1.8151e-17
* device instance cc_XD3_XDFFQ_SB_XD5_nm r0 *1 0,0
Ccc_XD3_XDFFQ_SB_XD5_nm XD3_XDFFQ_SB XD5_nm 1.21e-17
* device instance cc_XD3_XDFFQ_SB_XD5_nt r0 *1 0,0
Ccc_XD3_XDFFQ_SB_XD5_nt XD3_XDFFQ_SB XD5_nt 1.21e-17
* device instance cc_XD3_XDFFQ_SB_XD5_t1 r0 *1 0,0
Ccc_XD3_XDFFQ_SB_XD5_t1 XD3_XDFFQ_SB XD5_t1 1.21e-17
* device instance cc_XD3_XDFFQ_SB_XFRT_CLKB r0 *1 0,0
Ccc_XD3_XDFFQ_SB_XFRT_CLKB XD3_XDFFQ_SB XFRT_CLKB 1.8151e-17
* device instance cc_XD3_XDFFQ_SB_XFRT_M r0 *1 0,0
Ccc_XD3_XDFFQ_SB_XFRT_M XD3_XDFFQ_SB XFRT_M 2.4201e-17
* device instance cc_XD3_XDFFQ_SB_XFRT_MB r0 *1 0,0
Ccc_XD3_XDFFQ_SB_XFRT_MB XD3_XDFFQ_SB XFRT_MB 1.21e-17
* device instance cc_XD3_XDFFQ_SB_XFRT_S r0 *1 0,0
Ccc_XD3_XDFFQ_SB_XFRT_S XD3_XDFFQ_SB XFRT_S 1.8151e-17
* device instance cc_XD3_XDFFQ_SB_XFRT_SB r0 *1 0,0
Ccc_XD3_XDFFQ_SB_XFRT_SB XD3_XDFFQ_SB XFRT_SB 1.8151e-17
* device instance cc_XD3_XDFFQ_SB_ck1 r0 *1 0,0
Ccc_XD3_XDFFQ_SB_ck1 XD3_XDFFQ_SB ck1 5.4452e-17
* device instance cc_XD3_XDFFQ_SB_ck2 r0 *1 0,0
Ccc_XD3_XDFFQ_SB_ck2 XD3_XDFFQ_SB ck2 5.4452e-17
* device instance cc_XD3_XDFFQ_SB_ck3 r0 *1 0,0
Ccc_XD3_XDFFQ_SB_ck3 XD3_XDFFQ_SB ck3 5.4452e-17
* device instance cc_XD3_XDFFQ_SB_ck4 r0 *1 0,0
Ccc_XD3_XDFFQ_SB_ck4 XD3_XDFFQ_SB ck4 5.4452e-17
* device instance cc_XD3_XDFFQ_SB_ck5 r0 *1 0,0
Ccc_XD3_XDFFQ_SB_ck5 XD3_XDFFQ_SB ck5 5.4452e-17
* device instance cc_XD3_XDFFQ_SB_mod0 r0 *1 0,0
Ccc_XD3_XDFFQ_SB_mod0 XD3_XDFFQ_SB mod0 2.4201e-17
* device instance cc_XD3_XDFFQ_SB_mod1 r0 *1 0,0
Ccc_XD3_XDFFQ_SB_mod1 XD3_XDFFQ_SB mod1 2.4201e-17
* device instance cc_XD3_XDFFQ_SB_mod2 r0 *1 0,0
Ccc_XD3_XDFFQ_SB_mod2 XD3_XDFFQ_SB mod2 2.4201e-17
* device instance cc_XD3_XDFFQ_SB_mod3 r0 *1 0,0
Ccc_XD3_XDFFQ_SB_mod3 XD3_XDFFQ_SB mod3 2.4201e-17
* device instance cc_XD3_XDFFQ_SB_mod4 r0 *1 0,0
Ccc_XD3_XDFFQ_SB_mod4 XD3_XDFFQ_SB mod4 2.4201e-17
* device instance cc_XD3_XDFFQ_SB_net1 r0 *1 0,0
Ccc_XD3_XDFFQ_SB_net1 XD3_XDFFQ_SB net1 1.21e-17
* device instance cc_XD3_XN2_mid1_XD3_nm r0 *1 0,0
Ccc_XD3_XN2_mid1_XD3_nm XD3_XN2_mid1 XD3_nm 1.1294e-17
* device instance cc_XD3_XN2_mid1_ck4 r0 *1 0,0
Ccc_XD3_XN2_mid1_ck4 XD3_XN2_mid1 ck4 6.05e-18
* device instance cc_XD3_XN3_mid1_XD3_XN3_mid2 r0 *1 0,0
Ccc_XD3_XN3_mid1_XD3_XN3_mid2 XD3_XN3_mid1 XD3_XN3_mid2 1.1294e-17
* device instance cc_XD3_XN3_mid1_XD3_nt r0 *1 0,0
Ccc_XD3_XN3_mid1_XD3_nt XD3_XN3_mid1 XD3_nt 1.1294e-17
* device instance cc_XD3_XN3_mid2_mod2 r0 *1 0,0
Ccc_XD3_XN3_mid2_mod2 XD3_XN3_mid2 mod2 6.05e-18
* device instance cc_XD3_XNOR_midp_XD3_dq r0 *1 0,0
Ccc_XD3_XNOR_midp_XD3_dq XD3_XNOR_midp XD3_dq 5.244e-18
* device instance cc_XD3_XNOR_midp_XD3_t1 r0 *1 0,0
Ccc_XD3_XNOR_midp_XD3_t1 XD3_XNOR_midp XD3_t1 6.05e-18
* device instance cc_XD3_dmodout_XD3_dq r0 *1 0,0
Ccc_XD3_dmodout_XD3_dq XD3_dmodout XD3_dq 1.21e-17
* device instance cc_XD3_dmodout_XD3_nm r0 *1 0,0
Ccc_XD3_dmodout_XD3_nm XD3_dmodout XD3_nm 1.8151e-17
* device instance cc_XD3_dmodout_XD3_nt r0 *1 0,0
Ccc_XD3_dmodout_XD3_nt XD3_dmodout XD3_nt 2.4201e-17
* device instance cc_XD3_dmodout_XD3_t1 r0 *1 0,0
Ccc_XD3_dmodout_XD3_t1 XD3_dmodout XD3_t1 1.21e-17
* device instance cc_XD3_dmodout_XD4_XDFFM_CLKB r0 *1 0,0
Ccc_XD3_dmodout_XD4_XDFFM_CLKB XD3_dmodout XD4_XDFFM_CLKB 1.8151e-17
* device instance cc_XD3_dmodout_XD4_XDFFM_M r0 *1 0,0
Ccc_XD3_dmodout_XD4_XDFFM_M XD3_dmodout XD4_XDFFM_M 2.4201e-17
* device instance cc_XD3_dmodout_XD4_XDFFM_MB r0 *1 0,0
Ccc_XD3_dmodout_XD4_XDFFM_MB XD3_dmodout XD4_XDFFM_MB 1.21e-17
* device instance cc_XD3_dmodout_XD4_XDFFM_S r0 *1 0,0
Ccc_XD3_dmodout_XD4_XDFFM_S XD3_dmodout XD4_XDFFM_S 1.8151e-17
* device instance cc_XD3_dmodout_XD4_XDFFM_SB r0 *1 0,0
Ccc_XD3_dmodout_XD4_XDFFM_SB XD3_dmodout XD4_XDFFM_SB 1.8151e-17
* device instance cc_XD3_dmodout_XD4_XDFFQ_CLKB r0 *1 0,0
Ccc_XD3_dmodout_XD4_XDFFQ_CLKB XD3_dmodout XD4_XDFFQ_CLKB 1.8151e-17
* device instance cc_XD3_dmodout_XD4_XDFFQ_M r0 *1 0,0
Ccc_XD3_dmodout_XD4_XDFFQ_M XD3_dmodout XD4_XDFFQ_M 2.4201e-17
* device instance cc_XD3_dmodout_XD4_XDFFQ_MB r0 *1 0,0
Ccc_XD3_dmodout_XD4_XDFFQ_MB XD3_dmodout XD4_XDFFQ_MB 1.21e-17
* device instance cc_XD3_dmodout_XD4_XDFFQ_S r0 *1 0,0
Ccc_XD3_dmodout_XD4_XDFFQ_S XD3_dmodout XD4_XDFFQ_S 1.8151e-17
* device instance cc_XD3_dmodout_XD4_XDFFQ_SB r0 *1 0,0
Ccc_XD3_dmodout_XD4_XDFFQ_SB XD3_dmodout XD4_XDFFQ_SB 1.8151e-17
* device instance cc_XD3_dmodout_XD4_XN2_mid1 r0 *1 0,0
Ccc_XD3_dmodout_XD4_XN2_mid1 XD3_dmodout XD4_XN2_mid1 1.21e-17
* device instance cc_XD3_dmodout_XD4_XN3_mid1 r0 *1 0,0
Ccc_XD3_dmodout_XD4_XN3_mid1 XD3_dmodout XD4_XN3_mid1 1.21e-17
* device instance cc_XD3_dmodout_XD4_XN3_mid2 r0 *1 0,0
Ccc_XD3_dmodout_XD4_XN3_mid2 XD3_dmodout XD4_XN3_mid2 1.21e-17
* device instance cc_XD3_dmodout_XD4_dmodout r0 *1 0,0
Ccc_XD3_dmodout_XD4_dmodout XD3_dmodout XD4_dmodout 1.21e-17
* device instance cc_XD3_dmodout_XD4_dq r0 *1 0,0
Ccc_XD3_dmodout_XD4_dq XD3_dmodout XD4_dq 1.8151e-17
* device instance cc_XD3_dmodout_XD4_nm r0 *1 0,0
Ccc_XD3_dmodout_XD4_nm XD3_dmodout XD4_nm 1.21e-17
* device instance cc_XD3_dmodout_XD4_nt r0 *1 0,0
Ccc_XD3_dmodout_XD4_nt XD3_dmodout XD4_nt 1.21e-17
* device instance cc_XD3_dmodout_XD4_t1 r0 *1 0,0
Ccc_XD3_dmodout_XD4_t1 XD3_dmodout XD4_t1 1.21e-17
* device instance cc_XD3_dmodout_XD5_XDFFM_CLKB r0 *1 0,0
Ccc_XD3_dmodout_XD5_XDFFM_CLKB XD3_dmodout XD5_XDFFM_CLKB 1.8151e-17
* device instance cc_XD3_dmodout_XD5_XDFFM_M r0 *1 0,0
Ccc_XD3_dmodout_XD5_XDFFM_M XD3_dmodout XD5_XDFFM_M 2.4201e-17
* device instance cc_XD3_dmodout_XD5_XDFFM_MB r0 *1 0,0
Ccc_XD3_dmodout_XD5_XDFFM_MB XD3_dmodout XD5_XDFFM_MB 1.21e-17
* device instance cc_XD3_dmodout_XD5_XDFFM_S r0 *1 0,0
Ccc_XD3_dmodout_XD5_XDFFM_S XD3_dmodout XD5_XDFFM_S 1.8151e-17
* device instance cc_XD3_dmodout_XD5_XDFFM_SB r0 *1 0,0
Ccc_XD3_dmodout_XD5_XDFFM_SB XD3_dmodout XD5_XDFFM_SB 1.8151e-17
* device instance cc_XD3_dmodout_XD5_XDFFQ_CLKB r0 *1 0,0
Ccc_XD3_dmodout_XD5_XDFFQ_CLKB XD3_dmodout XD5_XDFFQ_CLKB 1.8151e-17
* device instance cc_XD3_dmodout_XD5_XDFFQ_M r0 *1 0,0
Ccc_XD3_dmodout_XD5_XDFFQ_M XD3_dmodout XD5_XDFFQ_M 2.4201e-17
* device instance cc_XD3_dmodout_XD5_XDFFQ_MB r0 *1 0,0
Ccc_XD3_dmodout_XD5_XDFFQ_MB XD3_dmodout XD5_XDFFQ_MB 1.21e-17
* device instance cc_XD3_dmodout_XD5_XDFFQ_S r0 *1 0,0
Ccc_XD3_dmodout_XD5_XDFFQ_S XD3_dmodout XD5_XDFFQ_S 1.8151e-17
* device instance cc_XD3_dmodout_XD5_XDFFQ_SB r0 *1 0,0
Ccc_XD3_dmodout_XD5_XDFFQ_SB XD3_dmodout XD5_XDFFQ_SB 1.8151e-17
* device instance cc_XD3_dmodout_XD5_XN2_mid1 r0 *1 0,0
Ccc_XD3_dmodout_XD5_XN2_mid1 XD3_dmodout XD5_XN2_mid1 1.21e-17
* device instance cc_XD3_dmodout_XD5_XN3_mid1 r0 *1 0,0
Ccc_XD3_dmodout_XD5_XN3_mid1 XD3_dmodout XD5_XN3_mid1 1.21e-17
* device instance cc_XD3_dmodout_XD5_XN3_mid2 r0 *1 0,0
Ccc_XD3_dmodout_XD5_XN3_mid2 XD3_dmodout XD5_XN3_mid2 1.21e-17
* device instance cc_XD3_dmodout_XD5_dmodout r0 *1 0,0
Ccc_XD3_dmodout_XD5_dmodout XD3_dmodout XD5_dmodout 1.21e-17
* device instance cc_XD3_dmodout_XD5_dq r0 *1 0,0
Ccc_XD3_dmodout_XD5_dq XD3_dmodout XD5_dq 1.8151e-17
* device instance cc_XD3_dmodout_XD5_nm r0 *1 0,0
Ccc_XD3_dmodout_XD5_nm XD3_dmodout XD5_nm 1.21e-17
* device instance cc_XD3_dmodout_XD5_nt r0 *1 0,0
Ccc_XD3_dmodout_XD5_nt XD3_dmodout XD5_nt 1.21e-17
* device instance cc_XD3_dmodout_XD5_t1 r0 *1 0,0
Ccc_XD3_dmodout_XD5_t1 XD3_dmodout XD5_t1 1.21e-17
* device instance cc_XD3_dmodout_XFRT_CLKB r0 *1 0,0
Ccc_XD3_dmodout_XFRT_CLKB XD3_dmodout XFRT_CLKB 1.8151e-17
* device instance cc_XD3_dmodout_XFRT_M r0 *1 0,0
Ccc_XD3_dmodout_XFRT_M XD3_dmodout XFRT_M 2.4201e-17
* device instance cc_XD3_dmodout_XFRT_MB r0 *1 0,0
Ccc_XD3_dmodout_XFRT_MB XD3_dmodout XFRT_MB 1.21e-17
* device instance cc_XD3_dmodout_XFRT_S r0 *1 0,0
Ccc_XD3_dmodout_XFRT_S XD3_dmodout XFRT_S 1.8151e-17
* device instance cc_XD3_dmodout_XFRT_SB r0 *1 0,0
Ccc_XD3_dmodout_XFRT_SB XD3_dmodout XFRT_SB 1.8151e-17
* device instance cc_XD3_dmodout_ck1 r0 *1 0,0
Ccc_XD3_dmodout_ck1 XD3_dmodout ck1 5.4452e-17
* device instance cc_XD3_dmodout_ck2 r0 *1 0,0
Ccc_XD3_dmodout_ck2 XD3_dmodout ck2 5.4452e-17
* device instance cc_XD3_dmodout_ck3 r0 *1 0,0
Ccc_XD3_dmodout_ck3 XD3_dmodout ck3 6.6553e-17
* device instance cc_XD3_dmodout_ck4 r0 *1 0,0
Ccc_XD3_dmodout_ck4 XD3_dmodout ck4 5.4452e-17
* device instance cc_XD3_dmodout_ck5 r0 *1 0,0
Ccc_XD3_dmodout_ck5 XD3_dmodout ck5 5.4452e-17
* device instance cc_XD3_dmodout_mod0 r0 *1 0,0
Ccc_XD3_dmodout_mod0 XD3_dmodout mod0 2.4201e-17
* device instance cc_XD3_dmodout_mod1 r0 *1 0,0
Ccc_XD3_dmodout_mod1 XD3_dmodout mod1 2.4201e-17
* device instance cc_XD3_dmodout_mod2 r0 *1 0,0
Ccc_XD3_dmodout_mod2 XD3_dmodout mod2 2.4201e-17
* device instance cc_XD3_dmodout_mod3 r0 *1 0,0
Ccc_XD3_dmodout_mod3 XD3_dmodout mod3 2.4201e-17
* device instance cc_XD3_dmodout_mod4 r0 *1 0,0
Ccc_XD3_dmodout_mod4 XD3_dmodout mod4 2.4201e-17
* device instance cc_XD3_dmodout_net1 r0 *1 0,0
Ccc_XD3_dmodout_net1 XD3_dmodout net1 1.21e-17
* device instance cc_XD3_dq_XD3_nm r0 *1 0,0
Ccc_XD3_dq_XD3_nm XD3_dq XD3_nm 1.21e-17
* device instance cc_XD3_dq_XD3_nt r0 *1 0,0
Ccc_XD3_dq_XD3_nt XD3_dq XD3_nt 2.4201e-17
* device instance cc_XD3_dq_XD3_t1 r0 *1 0,0
Ccc_XD3_dq_XD3_t1 XD3_dq XD3_t1 1.8151e-17
* device instance cc_XD3_dq_XD4_XDFFM_CLKB r0 *1 0,0
Ccc_XD3_dq_XD4_XDFFM_CLKB XD3_dq XD4_XDFFM_CLKB 1.8151e-17
* device instance cc_XD3_dq_XD4_XDFFM_M r0 *1 0,0
Ccc_XD3_dq_XD4_XDFFM_M XD3_dq XD4_XDFFM_M 2.4201e-17
* device instance cc_XD3_dq_XD4_XDFFM_MB r0 *1 0,0
Ccc_XD3_dq_XD4_XDFFM_MB XD3_dq XD4_XDFFM_MB 1.21e-17
* device instance cc_XD3_dq_XD4_XDFFM_S r0 *1 0,0
Ccc_XD3_dq_XD4_XDFFM_S XD3_dq XD4_XDFFM_S 1.8151e-17
* device instance cc_XD3_dq_XD4_XDFFM_SB r0 *1 0,0
Ccc_XD3_dq_XD4_XDFFM_SB XD3_dq XD4_XDFFM_SB 1.8151e-17
* device instance cc_XD3_dq_XD4_XDFFQ_CLKB r0 *1 0,0
Ccc_XD3_dq_XD4_XDFFQ_CLKB XD3_dq XD4_XDFFQ_CLKB 1.8151e-17
* device instance cc_XD3_dq_XD4_XDFFQ_M r0 *1 0,0
Ccc_XD3_dq_XD4_XDFFQ_M XD3_dq XD4_XDFFQ_M 2.4201e-17
* device instance cc_XD3_dq_XD4_XDFFQ_MB r0 *1 0,0
Ccc_XD3_dq_XD4_XDFFQ_MB XD3_dq XD4_XDFFQ_MB 1.21e-17
* device instance cc_XD3_dq_XD4_XDFFQ_S r0 *1 0,0
Ccc_XD3_dq_XD4_XDFFQ_S XD3_dq XD4_XDFFQ_S 1.8151e-17
* device instance cc_XD3_dq_XD4_XDFFQ_SB r0 *1 0,0
Ccc_XD3_dq_XD4_XDFFQ_SB XD3_dq XD4_XDFFQ_SB 1.8151e-17
* device instance cc_XD3_dq_XD4_XN2_mid1 r0 *1 0,0
Ccc_XD3_dq_XD4_XN2_mid1 XD3_dq XD4_XN2_mid1 1.21e-17
* device instance cc_XD3_dq_XD4_XN3_mid1 r0 *1 0,0
Ccc_XD3_dq_XD4_XN3_mid1 XD3_dq XD4_XN3_mid1 1.21e-17
* device instance cc_XD3_dq_XD4_XN3_mid2 r0 *1 0,0
Ccc_XD3_dq_XD4_XN3_mid2 XD3_dq XD4_XN3_mid2 1.21e-17
* device instance cc_XD3_dq_XD4_dmodout r0 *1 0,0
Ccc_XD3_dq_XD4_dmodout XD3_dq XD4_dmodout 1.21e-17
* device instance cc_XD3_dq_XD4_dq r0 *1 0,0
Ccc_XD3_dq_XD4_dq XD3_dq XD4_dq 1.8151e-17
* device instance cc_XD3_dq_XD4_nm r0 *1 0,0
Ccc_XD3_dq_XD4_nm XD3_dq XD4_nm 1.21e-17
* device instance cc_XD3_dq_XD4_nt r0 *1 0,0
Ccc_XD3_dq_XD4_nt XD3_dq XD4_nt 1.21e-17
* device instance cc_XD3_dq_XD4_t1 r0 *1 0,0
Ccc_XD3_dq_XD4_t1 XD3_dq XD4_t1 1.21e-17
* device instance cc_XD3_dq_XD5_XDFFM_CLKB r0 *1 0,0
Ccc_XD3_dq_XD5_XDFFM_CLKB XD3_dq XD5_XDFFM_CLKB 1.8151e-17
* device instance cc_XD3_dq_XD5_XDFFM_M r0 *1 0,0
Ccc_XD3_dq_XD5_XDFFM_M XD3_dq XD5_XDFFM_M 2.4201e-17
* device instance cc_XD3_dq_XD5_XDFFM_MB r0 *1 0,0
Ccc_XD3_dq_XD5_XDFFM_MB XD3_dq XD5_XDFFM_MB 1.21e-17
* device instance cc_XD3_dq_XD5_XDFFM_S r0 *1 0,0
Ccc_XD3_dq_XD5_XDFFM_S XD3_dq XD5_XDFFM_S 1.8151e-17
* device instance cc_XD3_dq_XD5_XDFFM_SB r0 *1 0,0
Ccc_XD3_dq_XD5_XDFFM_SB XD3_dq XD5_XDFFM_SB 1.8151e-17
* device instance cc_XD3_dq_XD5_XDFFQ_CLKB r0 *1 0,0
Ccc_XD3_dq_XD5_XDFFQ_CLKB XD3_dq XD5_XDFFQ_CLKB 1.8151e-17
* device instance cc_XD3_dq_XD5_XDFFQ_M r0 *1 0,0
Ccc_XD3_dq_XD5_XDFFQ_M XD3_dq XD5_XDFFQ_M 2.4201e-17
* device instance cc_XD3_dq_XD5_XDFFQ_MB r0 *1 0,0
Ccc_XD3_dq_XD5_XDFFQ_MB XD3_dq XD5_XDFFQ_MB 1.21e-17
* device instance cc_XD3_dq_XD5_XDFFQ_S r0 *1 0,0
Ccc_XD3_dq_XD5_XDFFQ_S XD3_dq XD5_XDFFQ_S 1.8151e-17
* device instance cc_XD3_dq_XD5_XDFFQ_SB r0 *1 0,0
Ccc_XD3_dq_XD5_XDFFQ_SB XD3_dq XD5_XDFFQ_SB 1.8151e-17
* device instance cc_XD3_dq_XD5_XN2_mid1 r0 *1 0,0
Ccc_XD3_dq_XD5_XN2_mid1 XD3_dq XD5_XN2_mid1 1.21e-17
* device instance cc_XD3_dq_XD5_XN3_mid1 r0 *1 0,0
Ccc_XD3_dq_XD5_XN3_mid1 XD3_dq XD5_XN3_mid1 1.21e-17
* device instance cc_XD3_dq_XD5_XN3_mid2 r0 *1 0,0
Ccc_XD3_dq_XD5_XN3_mid2 XD3_dq XD5_XN3_mid2 1.21e-17
* device instance cc_XD3_dq_XD5_dmodout r0 *1 0,0
Ccc_XD3_dq_XD5_dmodout XD3_dq XD5_dmodout 1.21e-17
* device instance cc_XD3_dq_XD5_dq r0 *1 0,0
Ccc_XD3_dq_XD5_dq XD3_dq XD5_dq 1.8151e-17
* device instance cc_XD3_dq_XD5_nm r0 *1 0,0
Ccc_XD3_dq_XD5_nm XD3_dq XD5_nm 1.21e-17
* device instance cc_XD3_dq_XD5_nt r0 *1 0,0
Ccc_XD3_dq_XD5_nt XD3_dq XD5_nt 1.21e-17
* device instance cc_XD3_dq_XD5_t1 r0 *1 0,0
Ccc_XD3_dq_XD5_t1 XD3_dq XD5_t1 1.21e-17
* device instance cc_XD3_dq_XFRT_CLKB r0 *1 0,0
Ccc_XD3_dq_XFRT_CLKB XD3_dq XFRT_CLKB 1.8151e-17
* device instance cc_XD3_dq_XFRT_M r0 *1 0,0
Ccc_XD3_dq_XFRT_M XD3_dq XFRT_M 2.4201e-17
* device instance cc_XD3_dq_XFRT_MB r0 *1 0,0
Ccc_XD3_dq_XFRT_MB XD3_dq XFRT_MB 1.21e-17
* device instance cc_XD3_dq_XFRT_S r0 *1 0,0
Ccc_XD3_dq_XFRT_S XD3_dq XFRT_S 1.8151e-17
* device instance cc_XD3_dq_XFRT_SB r0 *1 0,0
Ccc_XD3_dq_XFRT_SB XD3_dq XFRT_SB 1.8151e-17
* device instance cc_XD3_dq_ck1 r0 *1 0,0
Ccc_XD3_dq_ck1 XD3_dq ck1 5.4452e-17
* device instance cc_XD3_dq_ck2 r0 *1 0,0
Ccc_XD3_dq_ck2 XD3_dq ck2 5.4452e-17
* device instance cc_XD3_dq_ck3 r0 *1 0,0
Ccc_XD3_dq_ck3 XD3_dq ck3 6.6553e-17
* device instance cc_XD3_dq_ck4 r0 *1 0,0
Ccc_XD3_dq_ck4 XD3_dq ck4 5.4452e-17
* device instance cc_XD3_dq_ck5 r0 *1 0,0
Ccc_XD3_dq_ck5 XD3_dq ck5 5.4452e-17
* device instance cc_XD3_dq_mod0 r0 *1 0,0
Ccc_XD3_dq_mod0 XD3_dq mod0 2.4201e-17
* device instance cc_XD3_dq_mod1 r0 *1 0,0
Ccc_XD3_dq_mod1 XD3_dq mod1 2.4201e-17
* device instance cc_XD3_dq_mod2 r0 *1 0,0
Ccc_XD3_dq_mod2 XD3_dq mod2 2.4201e-17
* device instance cc_XD3_dq_mod3 r0 *1 0,0
Ccc_XD3_dq_mod3 XD3_dq mod3 2.4201e-17
* device instance cc_XD3_dq_mod4 r0 *1 0,0
Ccc_XD3_dq_mod4 XD3_dq mod4 2.4201e-17
* device instance cc_XD3_dq_net1 r0 *1 0,0
Ccc_XD3_dq_net1 XD3_dq net1 1.21e-17
* device instance cc_XD3_nm_XD3_nt r0 *1 0,0
Ccc_XD3_nm_XD3_nt XD3_nm XD3_nt 2.4201e-17
* device instance cc_XD3_nm_XD3_t1 r0 *1 0,0
Ccc_XD3_nm_XD3_t1 XD3_nm XD3_t1 1.21e-17
* device instance cc_XD3_nm_XD4_XDFFM_CLKB r0 *1 0,0
Ccc_XD3_nm_XD4_XDFFM_CLKB XD3_nm XD4_XDFFM_CLKB 1.8151e-17
* device instance cc_XD3_nm_XD4_XDFFM_M r0 *1 0,0
Ccc_XD3_nm_XD4_XDFFM_M XD3_nm XD4_XDFFM_M 2.4201e-17
* device instance cc_XD3_nm_XD4_XDFFM_MB r0 *1 0,0
Ccc_XD3_nm_XD4_XDFFM_MB XD3_nm XD4_XDFFM_MB 1.21e-17
* device instance cc_XD3_nm_XD4_XDFFM_S r0 *1 0,0
Ccc_XD3_nm_XD4_XDFFM_S XD3_nm XD4_XDFFM_S 1.8151e-17
* device instance cc_XD3_nm_XD4_XDFFM_SB r0 *1 0,0
Ccc_XD3_nm_XD4_XDFFM_SB XD3_nm XD4_XDFFM_SB 1.8151e-17
* device instance cc_XD3_nm_XD4_XDFFQ_CLKB r0 *1 0,0
Ccc_XD3_nm_XD4_XDFFQ_CLKB XD3_nm XD4_XDFFQ_CLKB 1.8151e-17
* device instance cc_XD3_nm_XD4_XDFFQ_M r0 *1 0,0
Ccc_XD3_nm_XD4_XDFFQ_M XD3_nm XD4_XDFFQ_M 2.4201e-17
* device instance cc_XD3_nm_XD4_XDFFQ_MB r0 *1 0,0
Ccc_XD3_nm_XD4_XDFFQ_MB XD3_nm XD4_XDFFQ_MB 1.21e-17
* device instance cc_XD3_nm_XD4_XDFFQ_S r0 *1 0,0
Ccc_XD3_nm_XD4_XDFFQ_S XD3_nm XD4_XDFFQ_S 1.8151e-17
* device instance cc_XD3_nm_XD4_XDFFQ_SB r0 *1 0,0
Ccc_XD3_nm_XD4_XDFFQ_SB XD3_nm XD4_XDFFQ_SB 1.8151e-17
* device instance cc_XD3_nm_XD4_XN2_mid1 r0 *1 0,0
Ccc_XD3_nm_XD4_XN2_mid1 XD3_nm XD4_XN2_mid1 1.21e-17
* device instance cc_XD3_nm_XD4_XN3_mid1 r0 *1 0,0
Ccc_XD3_nm_XD4_XN3_mid1 XD3_nm XD4_XN3_mid1 1.21e-17
* device instance cc_XD3_nm_XD4_XN3_mid2 r0 *1 0,0
Ccc_XD3_nm_XD4_XN3_mid2 XD3_nm XD4_XN3_mid2 1.21e-17
* device instance cc_XD3_nm_XD4_dmodout r0 *1 0,0
Ccc_XD3_nm_XD4_dmodout XD3_nm XD4_dmodout 1.21e-17
* device instance cc_XD3_nm_XD4_dq r0 *1 0,0
Ccc_XD3_nm_XD4_dq XD3_nm XD4_dq 1.8151e-17
* device instance cc_XD3_nm_XD4_nm r0 *1 0,0
Ccc_XD3_nm_XD4_nm XD3_nm XD4_nm 1.21e-17
* device instance cc_XD3_nm_XD4_nt r0 *1 0,0
Ccc_XD3_nm_XD4_nt XD3_nm XD4_nt 1.21e-17
* device instance cc_XD3_nm_XD4_t1 r0 *1 0,0
Ccc_XD3_nm_XD4_t1 XD3_nm XD4_t1 1.21e-17
* device instance cc_XD3_nm_XD5_XDFFM_CLKB r0 *1 0,0
Ccc_XD3_nm_XD5_XDFFM_CLKB XD3_nm XD5_XDFFM_CLKB 1.8151e-17
* device instance cc_XD3_nm_XD5_XDFFM_M r0 *1 0,0
Ccc_XD3_nm_XD5_XDFFM_M XD3_nm XD5_XDFFM_M 2.4201e-17
* device instance cc_XD3_nm_XD5_XDFFM_MB r0 *1 0,0
Ccc_XD3_nm_XD5_XDFFM_MB XD3_nm XD5_XDFFM_MB 1.21e-17
* device instance cc_XD3_nm_XD5_XDFFM_S r0 *1 0,0
Ccc_XD3_nm_XD5_XDFFM_S XD3_nm XD5_XDFFM_S 1.8151e-17
* device instance cc_XD3_nm_XD5_XDFFM_SB r0 *1 0,0
Ccc_XD3_nm_XD5_XDFFM_SB XD3_nm XD5_XDFFM_SB 1.8151e-17
* device instance cc_XD3_nm_XD5_XDFFQ_CLKB r0 *1 0,0
Ccc_XD3_nm_XD5_XDFFQ_CLKB XD3_nm XD5_XDFFQ_CLKB 1.8151e-17
* device instance cc_XD3_nm_XD5_XDFFQ_M r0 *1 0,0
Ccc_XD3_nm_XD5_XDFFQ_M XD3_nm XD5_XDFFQ_M 2.4201e-17
* device instance cc_XD3_nm_XD5_XDFFQ_MB r0 *1 0,0
Ccc_XD3_nm_XD5_XDFFQ_MB XD3_nm XD5_XDFFQ_MB 1.21e-17
* device instance cc_XD3_nm_XD5_XDFFQ_S r0 *1 0,0
Ccc_XD3_nm_XD5_XDFFQ_S XD3_nm XD5_XDFFQ_S 1.8151e-17
* device instance cc_XD3_nm_XD5_XDFFQ_SB r0 *1 0,0
Ccc_XD3_nm_XD5_XDFFQ_SB XD3_nm XD5_XDFFQ_SB 1.8151e-17
* device instance cc_XD3_nm_XD5_XN2_mid1 r0 *1 0,0
Ccc_XD3_nm_XD5_XN2_mid1 XD3_nm XD5_XN2_mid1 1.21e-17
* device instance cc_XD3_nm_XD5_XN3_mid1 r0 *1 0,0
Ccc_XD3_nm_XD5_XN3_mid1 XD3_nm XD5_XN3_mid1 1.21e-17
* device instance cc_XD3_nm_XD5_XN3_mid2 r0 *1 0,0
Ccc_XD3_nm_XD5_XN3_mid2 XD3_nm XD5_XN3_mid2 1.21e-17
* device instance cc_XD3_nm_XD5_dmodout r0 *1 0,0
Ccc_XD3_nm_XD5_dmodout XD3_nm XD5_dmodout 1.21e-17
* device instance cc_XD3_nm_XD5_dq r0 *1 0,0
Ccc_XD3_nm_XD5_dq XD3_nm XD5_dq 1.8151e-17
* device instance cc_XD3_nm_XD5_nm r0 *1 0,0
Ccc_XD3_nm_XD5_nm XD3_nm XD5_nm 1.21e-17
* device instance cc_XD3_nm_XD5_nt r0 *1 0,0
Ccc_XD3_nm_XD5_nt XD3_nm XD5_nt 1.21e-17
* device instance cc_XD3_nm_XD5_t1 r0 *1 0,0
Ccc_XD3_nm_XD5_t1 XD3_nm XD5_t1 1.21e-17
* device instance cc_XD3_nm_XFRT_CLKB r0 *1 0,0
Ccc_XD3_nm_XFRT_CLKB XD3_nm XFRT_CLKB 1.8151e-17
* device instance cc_XD3_nm_XFRT_M r0 *1 0,0
Ccc_XD3_nm_XFRT_M XD3_nm XFRT_M 2.4201e-17
* device instance cc_XD3_nm_XFRT_MB r0 *1 0,0
Ccc_XD3_nm_XFRT_MB XD3_nm XFRT_MB 1.21e-17
* device instance cc_XD3_nm_XFRT_S r0 *1 0,0
Ccc_XD3_nm_XFRT_S XD3_nm XFRT_S 1.8151e-17
* device instance cc_XD3_nm_XFRT_SB r0 *1 0,0
Ccc_XD3_nm_XFRT_SB XD3_nm XFRT_SB 1.8151e-17
* device instance cc_XD3_nm_ck1 r0 *1 0,0
Ccc_XD3_nm_ck1 XD3_nm ck1 5.4452e-17
* device instance cc_XD3_nm_ck2 r0 *1 0,0
Ccc_XD3_nm_ck2 XD3_nm ck2 5.4452e-17
* device instance cc_XD3_nm_ck3 r0 *1 0,0
Ccc_XD3_nm_ck3 XD3_nm ck3 5.4452e-17
* device instance cc_XD3_nm_ck4 r0 *1 0,0
Ccc_XD3_nm_ck4 XD3_nm ck4 6.0502e-17
* device instance cc_XD3_nm_ck5 r0 *1 0,0
Ccc_XD3_nm_ck5 XD3_nm ck5 5.4452e-17
* device instance cc_XD3_nm_mod0 r0 *1 0,0
Ccc_XD3_nm_mod0 XD3_nm mod0 2.4201e-17
* device instance cc_XD3_nm_mod1 r0 *1 0,0
Ccc_XD3_nm_mod1 XD3_nm mod1 2.4201e-17
* device instance cc_XD3_nm_mod2 r0 *1 0,0
Ccc_XD3_nm_mod2 XD3_nm mod2 2.4201e-17
* device instance cc_XD3_nm_mod3 r0 *1 0,0
Ccc_XD3_nm_mod3 XD3_nm mod3 2.4201e-17
* device instance cc_XD3_nm_mod4 r0 *1 0,0
Ccc_XD3_nm_mod4 XD3_nm mod4 2.4201e-17
* device instance cc_XD3_nm_net1 r0 *1 0,0
Ccc_XD3_nm_net1 XD3_nm net1 1.21e-17
* device instance cc_XD3_nt_XD3_t1 r0 *1 0,0
Ccc_XD3_nt_XD3_t1 XD3_nt XD3_t1 1.21e-17
* device instance cc_XD3_nt_XD4_XDFFM_CLKB r0 *1 0,0
Ccc_XD3_nt_XD4_XDFFM_CLKB XD3_nt XD4_XDFFM_CLKB 1.8151e-17
* device instance cc_XD3_nt_XD4_XDFFM_M r0 *1 0,0
Ccc_XD3_nt_XD4_XDFFM_M XD3_nt XD4_XDFFM_M 2.4201e-17
* device instance cc_XD3_nt_XD4_XDFFM_MB r0 *1 0,0
Ccc_XD3_nt_XD4_XDFFM_MB XD3_nt XD4_XDFFM_MB 1.21e-17
* device instance cc_XD3_nt_XD4_XDFFM_S r0 *1 0,0
Ccc_XD3_nt_XD4_XDFFM_S XD3_nt XD4_XDFFM_S 1.8151e-17
* device instance cc_XD3_nt_XD4_XDFFM_SB r0 *1 0,0
Ccc_XD3_nt_XD4_XDFFM_SB XD3_nt XD4_XDFFM_SB 1.8151e-17
* device instance cc_XD3_nt_XD4_XDFFQ_CLKB r0 *1 0,0
Ccc_XD3_nt_XD4_XDFFQ_CLKB XD3_nt XD4_XDFFQ_CLKB 1.8151e-17
* device instance cc_XD3_nt_XD4_XDFFQ_M r0 *1 0,0
Ccc_XD3_nt_XD4_XDFFQ_M XD3_nt XD4_XDFFQ_M 2.4201e-17
* device instance cc_XD3_nt_XD4_XDFFQ_MB r0 *1 0,0
Ccc_XD3_nt_XD4_XDFFQ_MB XD3_nt XD4_XDFFQ_MB 1.21e-17
* device instance cc_XD3_nt_XD4_XDFFQ_S r0 *1 0,0
Ccc_XD3_nt_XD4_XDFFQ_S XD3_nt XD4_XDFFQ_S 1.8151e-17
* device instance cc_XD3_nt_XD4_XDFFQ_SB r0 *1 0,0
Ccc_XD3_nt_XD4_XDFFQ_SB XD3_nt XD4_XDFFQ_SB 1.8151e-17
* device instance cc_XD3_nt_XD4_XN2_mid1 r0 *1 0,0
Ccc_XD3_nt_XD4_XN2_mid1 XD3_nt XD4_XN2_mid1 1.21e-17
* device instance cc_XD3_nt_XD4_XN3_mid1 r0 *1 0,0
Ccc_XD3_nt_XD4_XN3_mid1 XD3_nt XD4_XN3_mid1 1.21e-17
* device instance cc_XD3_nt_XD4_XN3_mid2 r0 *1 0,0
Ccc_XD3_nt_XD4_XN3_mid2 XD3_nt XD4_XN3_mid2 1.21e-17
* device instance cc_XD3_nt_XD4_dmodout r0 *1 0,0
Ccc_XD3_nt_XD4_dmodout XD3_nt XD4_dmodout 1.21e-17
* device instance cc_XD3_nt_XD4_dq r0 *1 0,0
Ccc_XD3_nt_XD4_dq XD3_nt XD4_dq 1.8151e-17
* device instance cc_XD3_nt_XD4_nm r0 *1 0,0
Ccc_XD3_nt_XD4_nm XD3_nt XD4_nm 1.21e-17
* device instance cc_XD3_nt_XD4_nt r0 *1 0,0
Ccc_XD3_nt_XD4_nt XD3_nt XD4_nt 1.21e-17
* device instance cc_XD3_nt_XD4_t1 r0 *1 0,0
Ccc_XD3_nt_XD4_t1 XD3_nt XD4_t1 1.21e-17
* device instance cc_XD3_nt_XD5_XDFFM_CLKB r0 *1 0,0
Ccc_XD3_nt_XD5_XDFFM_CLKB XD3_nt XD5_XDFFM_CLKB 1.8151e-17
* device instance cc_XD3_nt_XD5_XDFFM_M r0 *1 0,0
Ccc_XD3_nt_XD5_XDFFM_M XD3_nt XD5_XDFFM_M 2.4201e-17
* device instance cc_XD3_nt_XD5_XDFFM_MB r0 *1 0,0
Ccc_XD3_nt_XD5_XDFFM_MB XD3_nt XD5_XDFFM_MB 1.21e-17
* device instance cc_XD3_nt_XD5_XDFFM_S r0 *1 0,0
Ccc_XD3_nt_XD5_XDFFM_S XD3_nt XD5_XDFFM_S 1.8151e-17
* device instance cc_XD3_nt_XD5_XDFFM_SB r0 *1 0,0
Ccc_XD3_nt_XD5_XDFFM_SB XD3_nt XD5_XDFFM_SB 1.8151e-17
* device instance cc_XD3_nt_XD5_XDFFQ_CLKB r0 *1 0,0
Ccc_XD3_nt_XD5_XDFFQ_CLKB XD3_nt XD5_XDFFQ_CLKB 1.8151e-17
* device instance cc_XD3_nt_XD5_XDFFQ_M r0 *1 0,0
Ccc_XD3_nt_XD5_XDFFQ_M XD3_nt XD5_XDFFQ_M 2.4201e-17
* device instance cc_XD3_nt_XD5_XDFFQ_MB r0 *1 0,0
Ccc_XD3_nt_XD5_XDFFQ_MB XD3_nt XD5_XDFFQ_MB 1.21e-17
* device instance cc_XD3_nt_XD5_XDFFQ_S r0 *1 0,0
Ccc_XD3_nt_XD5_XDFFQ_S XD3_nt XD5_XDFFQ_S 1.8151e-17
* device instance cc_XD3_nt_XD5_XDFFQ_SB r0 *1 0,0
Ccc_XD3_nt_XD5_XDFFQ_SB XD3_nt XD5_XDFFQ_SB 1.8151e-17
* device instance cc_XD3_nt_XD5_XN2_mid1 r0 *1 0,0
Ccc_XD3_nt_XD5_XN2_mid1 XD3_nt XD5_XN2_mid1 1.21e-17
* device instance cc_XD3_nt_XD5_XN3_mid1 r0 *1 0,0
Ccc_XD3_nt_XD5_XN3_mid1 XD3_nt XD5_XN3_mid1 1.21e-17
* device instance cc_XD3_nt_XD5_XN3_mid2 r0 *1 0,0
Ccc_XD3_nt_XD5_XN3_mid2 XD3_nt XD5_XN3_mid2 1.21e-17
* device instance cc_XD3_nt_XD5_dmodout r0 *1 0,0
Ccc_XD3_nt_XD5_dmodout XD3_nt XD5_dmodout 1.21e-17
* device instance cc_XD3_nt_XD5_dq r0 *1 0,0
Ccc_XD3_nt_XD5_dq XD3_nt XD5_dq 1.8151e-17
* device instance cc_XD3_nt_XD5_nm r0 *1 0,0
Ccc_XD3_nt_XD5_nm XD3_nt XD5_nm 1.21e-17
* device instance cc_XD3_nt_XD5_nt r0 *1 0,0
Ccc_XD3_nt_XD5_nt XD3_nt XD5_nt 1.21e-17
* device instance cc_XD3_nt_XD5_t1 r0 *1 0,0
Ccc_XD3_nt_XD5_t1 XD3_nt XD5_t1 1.21e-17
* device instance cc_XD3_nt_XFRT_CLKB r0 *1 0,0
Ccc_XD3_nt_XFRT_CLKB XD3_nt XFRT_CLKB 1.8151e-17
* device instance cc_XD3_nt_XFRT_M r0 *1 0,0
Ccc_XD3_nt_XFRT_M XD3_nt XFRT_M 2.4201e-17
* device instance cc_XD3_nt_XFRT_MB r0 *1 0,0
Ccc_XD3_nt_XFRT_MB XD3_nt XFRT_MB 1.21e-17
* device instance cc_XD3_nt_XFRT_S r0 *1 0,0
Ccc_XD3_nt_XFRT_S XD3_nt XFRT_S 1.8151e-17
* device instance cc_XD3_nt_XFRT_SB r0 *1 0,0
Ccc_XD3_nt_XFRT_SB XD3_nt XFRT_SB 1.8151e-17
* device instance cc_XD3_nt_ck1 r0 *1 0,0
Ccc_XD3_nt_ck1 XD3_nt ck1 5.4452e-17
* device instance cc_XD3_nt_ck2 r0 *1 0,0
Ccc_XD3_nt_ck2 XD3_nt ck2 5.4452e-17
* device instance cc_XD3_nt_ck3 r0 *1 0,0
Ccc_XD3_nt_ck3 XD3_nt ck3 5.4452e-17
* device instance cc_XD3_nt_ck4 r0 *1 0,0
Ccc_XD3_nt_ck4 XD3_nt ck4 5.4452e-17
* device instance cc_XD3_nt_ck5 r0 *1 0,0
Ccc_XD3_nt_ck5 XD3_nt ck5 5.4452e-17
* device instance cc_XD3_nt_mod0 r0 *1 0,0
Ccc_XD3_nt_mod0 XD3_nt mod0 2.4201e-17
* device instance cc_XD3_nt_mod1 r0 *1 0,0
Ccc_XD3_nt_mod1 XD3_nt mod1 2.4201e-17
* device instance cc_XD3_nt_mod2 r0 *1 0,0
Ccc_XD3_nt_mod2 XD3_nt mod2 3.0251e-17
* device instance cc_XD3_nt_mod3 r0 *1 0,0
Ccc_XD3_nt_mod3 XD3_nt mod3 2.4201e-17
* device instance cc_XD3_nt_mod4 r0 *1 0,0
Ccc_XD3_nt_mod4 XD3_nt mod4 2.4201e-17
* device instance cc_XD3_nt_net1 r0 *1 0,0
Ccc_XD3_nt_net1 XD3_nt net1 1.21e-17
* device instance cc_XD3_t1_XD4_XDFFM_CLKB r0 *1 0,0
Ccc_XD3_t1_XD4_XDFFM_CLKB XD3_t1 XD4_XDFFM_CLKB 1.8151e-17
* device instance cc_XD3_t1_XD4_XDFFM_M r0 *1 0,0
Ccc_XD3_t1_XD4_XDFFM_M XD3_t1 XD4_XDFFM_M 2.4201e-17
* device instance cc_XD3_t1_XD4_XDFFM_MB r0 *1 0,0
Ccc_XD3_t1_XD4_XDFFM_MB XD3_t1 XD4_XDFFM_MB 1.21e-17
* device instance cc_XD3_t1_XD4_XDFFM_S r0 *1 0,0
Ccc_XD3_t1_XD4_XDFFM_S XD3_t1 XD4_XDFFM_S 1.8151e-17
* device instance cc_XD3_t1_XD4_XDFFM_SB r0 *1 0,0
Ccc_XD3_t1_XD4_XDFFM_SB XD3_t1 XD4_XDFFM_SB 1.8151e-17
* device instance cc_XD3_t1_XD4_XDFFQ_CLKB r0 *1 0,0
Ccc_XD3_t1_XD4_XDFFQ_CLKB XD3_t1 XD4_XDFFQ_CLKB 1.8151e-17
* device instance cc_XD3_t1_XD4_XDFFQ_M r0 *1 0,0
Ccc_XD3_t1_XD4_XDFFQ_M XD3_t1 XD4_XDFFQ_M 2.4201e-17
* device instance cc_XD3_t1_XD4_XDFFQ_MB r0 *1 0,0
Ccc_XD3_t1_XD4_XDFFQ_MB XD3_t1 XD4_XDFFQ_MB 1.21e-17
* device instance cc_XD3_t1_XD4_XDFFQ_S r0 *1 0,0
Ccc_XD3_t1_XD4_XDFFQ_S XD3_t1 XD4_XDFFQ_S 1.8151e-17
* device instance cc_XD3_t1_XD4_XDFFQ_SB r0 *1 0,0
Ccc_XD3_t1_XD4_XDFFQ_SB XD3_t1 XD4_XDFFQ_SB 1.8151e-17
* device instance cc_XD3_t1_XD4_XN2_mid1 r0 *1 0,0
Ccc_XD3_t1_XD4_XN2_mid1 XD3_t1 XD4_XN2_mid1 1.21e-17
* device instance cc_XD3_t1_XD4_XN3_mid1 r0 *1 0,0
Ccc_XD3_t1_XD4_XN3_mid1 XD3_t1 XD4_XN3_mid1 1.21e-17
* device instance cc_XD3_t1_XD4_XN3_mid2 r0 *1 0,0
Ccc_XD3_t1_XD4_XN3_mid2 XD3_t1 XD4_XN3_mid2 1.21e-17
* device instance cc_XD3_t1_XD4_dmodout r0 *1 0,0
Ccc_XD3_t1_XD4_dmodout XD3_t1 XD4_dmodout 1.21e-17
* device instance cc_XD3_t1_XD4_dq r0 *1 0,0
Ccc_XD3_t1_XD4_dq XD3_t1 XD4_dq 1.8151e-17
* device instance cc_XD3_t1_XD4_nm r0 *1 0,0
Ccc_XD3_t1_XD4_nm XD3_t1 XD4_nm 1.21e-17
* device instance cc_XD3_t1_XD4_nt r0 *1 0,0
Ccc_XD3_t1_XD4_nt XD3_t1 XD4_nt 1.21e-17
* device instance cc_XD3_t1_XD4_t1 r0 *1 0,0
Ccc_XD3_t1_XD4_t1 XD3_t1 XD4_t1 1.21e-17
* device instance cc_XD3_t1_XD5_XDFFM_CLKB r0 *1 0,0
Ccc_XD3_t1_XD5_XDFFM_CLKB XD3_t1 XD5_XDFFM_CLKB 1.8151e-17
* device instance cc_XD3_t1_XD5_XDFFM_M r0 *1 0,0
Ccc_XD3_t1_XD5_XDFFM_M XD3_t1 XD5_XDFFM_M 2.4201e-17
* device instance cc_XD3_t1_XD5_XDFFM_MB r0 *1 0,0
Ccc_XD3_t1_XD5_XDFFM_MB XD3_t1 XD5_XDFFM_MB 1.21e-17
* device instance cc_XD3_t1_XD5_XDFFM_S r0 *1 0,0
Ccc_XD3_t1_XD5_XDFFM_S XD3_t1 XD5_XDFFM_S 1.8151e-17
* device instance cc_XD3_t1_XD5_XDFFM_SB r0 *1 0,0
Ccc_XD3_t1_XD5_XDFFM_SB XD3_t1 XD5_XDFFM_SB 1.8151e-17
* device instance cc_XD3_t1_XD5_XDFFQ_CLKB r0 *1 0,0
Ccc_XD3_t1_XD5_XDFFQ_CLKB XD3_t1 XD5_XDFFQ_CLKB 1.8151e-17
* device instance cc_XD3_t1_XD5_XDFFQ_M r0 *1 0,0
Ccc_XD3_t1_XD5_XDFFQ_M XD3_t1 XD5_XDFFQ_M 2.4201e-17
* device instance cc_XD3_t1_XD5_XDFFQ_MB r0 *1 0,0
Ccc_XD3_t1_XD5_XDFFQ_MB XD3_t1 XD5_XDFFQ_MB 1.21e-17
* device instance cc_XD3_t1_XD5_XDFFQ_S r0 *1 0,0
Ccc_XD3_t1_XD5_XDFFQ_S XD3_t1 XD5_XDFFQ_S 1.8151e-17
* device instance cc_XD3_t1_XD5_XDFFQ_SB r0 *1 0,0
Ccc_XD3_t1_XD5_XDFFQ_SB XD3_t1 XD5_XDFFQ_SB 1.8151e-17
* device instance cc_XD3_t1_XD5_XN2_mid1 r0 *1 0,0
Ccc_XD3_t1_XD5_XN2_mid1 XD3_t1 XD5_XN2_mid1 1.21e-17
* device instance cc_XD3_t1_XD5_XN3_mid1 r0 *1 0,0
Ccc_XD3_t1_XD5_XN3_mid1 XD3_t1 XD5_XN3_mid1 1.21e-17
* device instance cc_XD3_t1_XD5_XN3_mid2 r0 *1 0,0
Ccc_XD3_t1_XD5_XN3_mid2 XD3_t1 XD5_XN3_mid2 1.21e-17
* device instance cc_XD3_t1_XD5_dmodout r0 *1 0,0
Ccc_XD3_t1_XD5_dmodout XD3_t1 XD5_dmodout 1.21e-17
* device instance cc_XD3_t1_XD5_dq r0 *1 0,0
Ccc_XD3_t1_XD5_dq XD3_t1 XD5_dq 1.8151e-17
* device instance cc_XD3_t1_XD5_nm r0 *1 0,0
Ccc_XD3_t1_XD5_nm XD3_t1 XD5_nm 1.21e-17
* device instance cc_XD3_t1_XD5_nt r0 *1 0,0
Ccc_XD3_t1_XD5_nt XD3_t1 XD5_nt 1.21e-17
* device instance cc_XD3_t1_XD5_t1 r0 *1 0,0
Ccc_XD3_t1_XD5_t1 XD3_t1 XD5_t1 1.21e-17
* device instance cc_XD3_t1_XFRT_CLKB r0 *1 0,0
Ccc_XD3_t1_XFRT_CLKB XD3_t1 XFRT_CLKB 1.8151e-17
* device instance cc_XD3_t1_XFRT_M r0 *1 0,0
Ccc_XD3_t1_XFRT_M XD3_t1 XFRT_M 2.4201e-17
* device instance cc_XD3_t1_XFRT_MB r0 *1 0,0
Ccc_XD3_t1_XFRT_MB XD3_t1 XFRT_MB 1.21e-17
* device instance cc_XD3_t1_XFRT_S r0 *1 0,0
Ccc_XD3_t1_XFRT_S XD3_t1 XFRT_S 1.8151e-17
* device instance cc_XD3_t1_XFRT_SB r0 *1 0,0
Ccc_XD3_t1_XFRT_SB XD3_t1 XFRT_SB 1.8151e-17
* device instance cc_XD3_t1_ck1 r0 *1 0,0
Ccc_XD3_t1_ck1 XD3_t1 ck1 5.4452e-17
* device instance cc_XD3_t1_ck2 r0 *1 0,0
Ccc_XD3_t1_ck2 XD3_t1 ck2 5.4452e-17
* device instance cc_XD3_t1_ck3 r0 *1 0,0
Ccc_XD3_t1_ck3 XD3_t1 ck3 5.4452e-17
* device instance cc_XD3_t1_ck4 r0 *1 0,0
Ccc_XD3_t1_ck4 XD3_t1 ck4 6.0502e-17
* device instance cc_XD3_t1_ck5 r0 *1 0,0
Ccc_XD3_t1_ck5 XD3_t1 ck5 5.4452e-17
* device instance cc_XD3_t1_mod0 r0 *1 0,0
Ccc_XD3_t1_mod0 XD3_t1 mod0 2.4201e-17
* device instance cc_XD3_t1_mod1 r0 *1 0,0
Ccc_XD3_t1_mod1 XD3_t1 mod1 2.4201e-17
* device instance cc_XD3_t1_mod2 r0 *1 0,0
Ccc_XD3_t1_mod2 XD3_t1 mod2 2.4201e-17
* device instance cc_XD3_t1_mod3 r0 *1 0,0
Ccc_XD3_t1_mod3 XD3_t1 mod3 2.4201e-17
* device instance cc_XD3_t1_mod4 r0 *1 0,0
Ccc_XD3_t1_mod4 XD3_t1 mod4 2.4201e-17
* device instance cc_XD3_t1_net1 r0 *1 0,0
Ccc_XD3_t1_net1 XD3_t1 net1 1.21e-17
* device instance cc_XD4_XDFFM_CLKB_XD4_XDFFM_M r0 *1 0,0
Ccc_XD4_XDFFM_CLKB_XD4_XDFFM_M XD4_XDFFM_CLKB XD4_XDFFM_M 4.2352e-17
* device instance cc_XD4_XDFFM_CLKB_XD4_XDFFM_MB r0 *1 0,0
Ccc_XD4_XDFFM_CLKB_XD4_XDFFM_MB XD4_XDFFM_CLKB XD4_XDFFM_MB 2.4201e-17
* device instance cc_XD4_XDFFM_CLKB_XD4_XDFFM_S r0 *1 0,0
Ccc_XD4_XDFFM_CLKB_XD4_XDFFM_S XD4_XDFFM_CLKB XD4_XDFFM_S 1.8151e-17
* device instance cc_XD4_XDFFM_CLKB_XD4_XDFFM_SB r0 *1 0,0
Ccc_XD4_XDFFM_CLKB_XD4_XDFFM_SB XD4_XDFFM_CLKB XD4_XDFFM_SB 1.8151e-17
* device instance cc_XD4_XDFFM_CLKB_XD4_XDFFQ_CLKB r0 *1 0,0
Ccc_XD4_XDFFM_CLKB_XD4_XDFFQ_CLKB XD4_XDFFM_CLKB XD4_XDFFQ_CLKB 1.8151e-17
* device instance cc_XD4_XDFFM_CLKB_XD4_XDFFQ_M r0 *1 0,0
Ccc_XD4_XDFFM_CLKB_XD4_XDFFQ_M XD4_XDFFM_CLKB XD4_XDFFQ_M 2.4201e-17
* device instance cc_XD4_XDFFM_CLKB_XD4_XDFFQ_MB r0 *1 0,0
Ccc_XD4_XDFFM_CLKB_XD4_XDFFQ_MB XD4_XDFFM_CLKB XD4_XDFFQ_MB 1.21e-17
* device instance cc_XD4_XDFFM_CLKB_XD4_XDFFQ_S r0 *1 0,0
Ccc_XD4_XDFFM_CLKB_XD4_XDFFQ_S XD4_XDFFM_CLKB XD4_XDFFQ_S 1.8151e-17
* device instance cc_XD4_XDFFM_CLKB_XD4_XDFFQ_SB r0 *1 0,0
Ccc_XD4_XDFFM_CLKB_XD4_XDFFQ_SB XD4_XDFFM_CLKB XD4_XDFFQ_SB 1.8151e-17
* device instance cc_XD4_XDFFM_CLKB_XD4_XNOR_midp r0 *1 0,0
Ccc_XD4_XDFFM_CLKB_XD4_XNOR_midp XD4_XDFFM_CLKB XD4_XNOR_midp 1.21e-17
* device instance cc_XD4_XDFFM_CLKB_XD4_dmodout r0 *1 0,0
Ccc_XD4_XDFFM_CLKB_XD4_dmodout XD4_XDFFM_CLKB XD4_dmodout 1.8151e-17
* device instance cc_XD4_XDFFM_CLKB_XD4_dq r0 *1 0,0
Ccc_XD4_XDFFM_CLKB_XD4_dq XD4_XDFFM_CLKB XD4_dq 1.21e-17
* device instance cc_XD4_XDFFM_CLKB_XD4_nm r0 *1 0,0
Ccc_XD4_XDFFM_CLKB_XD4_nm XD4_XDFFM_CLKB XD4_nm 1.8151e-17
* device instance cc_XD4_XDFFM_CLKB_XD4_nt r0 *1 0,0
Ccc_XD4_XDFFM_CLKB_XD4_nt XD4_XDFFM_CLKB XD4_nt 2.4201e-17
* device instance cc_XD4_XDFFM_CLKB_XD4_t1 r0 *1 0,0
Ccc_XD4_XDFFM_CLKB_XD4_t1 XD4_XDFFM_CLKB XD4_t1 1.21e-17
* device instance cc_XD4_XDFFM_CLKB_XD5_XDFFM_CLKB r0 *1 0,0
Ccc_XD4_XDFFM_CLKB_XD5_XDFFM_CLKB XD4_XDFFM_CLKB XD5_XDFFM_CLKB 1.8151e-17
* device instance cc_XD4_XDFFM_CLKB_XD5_XDFFM_M r0 *1 0,0
Ccc_XD4_XDFFM_CLKB_XD5_XDFFM_M XD4_XDFFM_CLKB XD5_XDFFM_M 2.4201e-17
* device instance cc_XD4_XDFFM_CLKB_XD5_XDFFM_MB r0 *1 0,0
Ccc_XD4_XDFFM_CLKB_XD5_XDFFM_MB XD4_XDFFM_CLKB XD5_XDFFM_MB 1.21e-17
* device instance cc_XD4_XDFFM_CLKB_XD5_XDFFM_S r0 *1 0,0
Ccc_XD4_XDFFM_CLKB_XD5_XDFFM_S XD4_XDFFM_CLKB XD5_XDFFM_S 1.8151e-17
* device instance cc_XD4_XDFFM_CLKB_XD5_XDFFM_SB r0 *1 0,0
Ccc_XD4_XDFFM_CLKB_XD5_XDFFM_SB XD4_XDFFM_CLKB XD5_XDFFM_SB 1.8151e-17
* device instance cc_XD4_XDFFM_CLKB_XD5_XDFFQ_CLKB r0 *1 0,0
Ccc_XD4_XDFFM_CLKB_XD5_XDFFQ_CLKB XD4_XDFFM_CLKB XD5_XDFFQ_CLKB 1.8151e-17
* device instance cc_XD4_XDFFM_CLKB_XD5_XDFFQ_M r0 *1 0,0
Ccc_XD4_XDFFM_CLKB_XD5_XDFFQ_M XD4_XDFFM_CLKB XD5_XDFFQ_M 2.4201e-17
* device instance cc_XD4_XDFFM_CLKB_XD5_XDFFQ_MB r0 *1 0,0
Ccc_XD4_XDFFM_CLKB_XD5_XDFFQ_MB XD4_XDFFM_CLKB XD5_XDFFQ_MB 1.21e-17
* device instance cc_XD4_XDFFM_CLKB_XD5_XDFFQ_S r0 *1 0,0
Ccc_XD4_XDFFM_CLKB_XD5_XDFFQ_S XD4_XDFFM_CLKB XD5_XDFFQ_S 1.8151e-17
* device instance cc_XD4_XDFFM_CLKB_XD5_XDFFQ_SB r0 *1 0,0
Ccc_XD4_XDFFM_CLKB_XD5_XDFFQ_SB XD4_XDFFM_CLKB XD5_XDFFQ_SB 1.8151e-17
* device instance cc_XD4_XDFFM_CLKB_XD5_XN2_mid1 r0 *1 0,0
Ccc_XD4_XDFFM_CLKB_XD5_XN2_mid1 XD4_XDFFM_CLKB XD5_XN2_mid1 1.21e-17
* device instance cc_XD4_XDFFM_CLKB_XD5_XN3_mid1 r0 *1 0,0
Ccc_XD4_XDFFM_CLKB_XD5_XN3_mid1 XD4_XDFFM_CLKB XD5_XN3_mid1 1.21e-17
* device instance cc_XD4_XDFFM_CLKB_XD5_XN3_mid2 r0 *1 0,0
Ccc_XD4_XDFFM_CLKB_XD5_XN3_mid2 XD4_XDFFM_CLKB XD5_XN3_mid2 1.21e-17
* device instance cc_XD4_XDFFM_CLKB_XD5_dmodout r0 *1 0,0
Ccc_XD4_XDFFM_CLKB_XD5_dmodout XD4_XDFFM_CLKB XD5_dmodout 1.21e-17
* device instance cc_XD4_XDFFM_CLKB_XD5_dq r0 *1 0,0
Ccc_XD4_XDFFM_CLKB_XD5_dq XD4_XDFFM_CLKB XD5_dq 1.8151e-17
* device instance cc_XD4_XDFFM_CLKB_XD5_nm r0 *1 0,0
Ccc_XD4_XDFFM_CLKB_XD5_nm XD4_XDFFM_CLKB XD5_nm 1.21e-17
* device instance cc_XD4_XDFFM_CLKB_XD5_nt r0 *1 0,0
Ccc_XD4_XDFFM_CLKB_XD5_nt XD4_XDFFM_CLKB XD5_nt 1.21e-17
* device instance cc_XD4_XDFFM_CLKB_XD5_t1 r0 *1 0,0
Ccc_XD4_XDFFM_CLKB_XD5_t1 XD4_XDFFM_CLKB XD5_t1 1.21e-17
* device instance cc_XD4_XDFFM_CLKB_XFRT_CLKB r0 *1 0,0
Ccc_XD4_XDFFM_CLKB_XFRT_CLKB XD4_XDFFM_CLKB XFRT_CLKB 1.8151e-17
* device instance cc_XD4_XDFFM_CLKB_XFRT_M r0 *1 0,0
Ccc_XD4_XDFFM_CLKB_XFRT_M XD4_XDFFM_CLKB XFRT_M 2.4201e-17
* device instance cc_XD4_XDFFM_CLKB_XFRT_MB r0 *1 0,0
Ccc_XD4_XDFFM_CLKB_XFRT_MB XD4_XDFFM_CLKB XFRT_MB 1.21e-17
* device instance cc_XD4_XDFFM_CLKB_XFRT_S r0 *1 0,0
Ccc_XD4_XDFFM_CLKB_XFRT_S XD4_XDFFM_CLKB XFRT_S 1.8151e-17
* device instance cc_XD4_XDFFM_CLKB_XFRT_SB r0 *1 0,0
Ccc_XD4_XDFFM_CLKB_XFRT_SB XD4_XDFFM_CLKB XFRT_SB 1.8151e-17
* device instance cc_XD4_XDFFM_CLKB_ck1 r0 *1 0,0
Ccc_XD4_XDFFM_CLKB_ck1 XD4_XDFFM_CLKB ck1 5.4452e-17
* device instance cc_XD4_XDFFM_CLKB_ck2 r0 *1 0,0
Ccc_XD4_XDFFM_CLKB_ck2 XD4_XDFFM_CLKB ck2 5.4452e-17
* device instance cc_XD4_XDFFM_CLKB_ck3 r0 *1 0,0
Ccc_XD4_XDFFM_CLKB_ck3 XD4_XDFFM_CLKB ck3 5.4452e-17
* device instance cc_XD4_XDFFM_CLKB_ck4 r0 *1 0,0
Ccc_XD4_XDFFM_CLKB_ck4 XD4_XDFFM_CLKB ck4 6.0502e-17
* device instance cc_XD4_XDFFM_CLKB_ck5 r0 *1 0,0
Ccc_XD4_XDFFM_CLKB_ck5 XD4_XDFFM_CLKB ck5 5.4452e-17
* device instance cc_XD4_XDFFM_CLKB_mod0 r0 *1 0,0
Ccc_XD4_XDFFM_CLKB_mod0 XD4_XDFFM_CLKB mod0 2.4201e-17
* device instance cc_XD4_XDFFM_CLKB_mod1 r0 *1 0,0
Ccc_XD4_XDFFM_CLKB_mod1 XD4_XDFFM_CLKB mod1 2.4201e-17
* device instance cc_XD4_XDFFM_CLKB_mod2 r0 *1 0,0
Ccc_XD4_XDFFM_CLKB_mod2 XD4_XDFFM_CLKB mod2 2.4201e-17
* device instance cc_XD4_XDFFM_CLKB_mod3 r0 *1 0,0
Ccc_XD4_XDFFM_CLKB_mod3 XD4_XDFFM_CLKB mod3 2.4201e-17
* device instance cc_XD4_XDFFM_CLKB_mod4 r0 *1 0,0
Ccc_XD4_XDFFM_CLKB_mod4 XD4_XDFFM_CLKB mod4 2.4201e-17
* device instance cc_XD4_XDFFM_CLKB_net1 r0 *1 0,0
Ccc_XD4_XDFFM_CLKB_net1 XD4_XDFFM_CLKB net1 1.21e-17
* device instance cc_XD4_XDFFM_M_XD4_XDFFM_MB r0 *1 0,0
Ccc_XD4_XDFFM_M_XD4_XDFFM_MB XD4_XDFFM_M XD4_XDFFM_MB 3.4688e-17
* device instance cc_XD4_XDFFM_M_XD4_XDFFM_S r0 *1 0,0
Ccc_XD4_XDFFM_M_XD4_XDFFM_S XD4_XDFFM_M XD4_XDFFM_S 2.8638e-17
* device instance cc_XD4_XDFFM_M_XD4_XDFFM_SB r0 *1 0,0
Ccc_XD4_XDFFM_M_XD4_XDFFM_SB XD4_XDFFM_M XD4_XDFFM_SB 1.8151e-17
* device instance cc_XD4_XDFFM_M_XD4_XDFFQ_CLKB r0 *1 0,0
Ccc_XD4_XDFFM_M_XD4_XDFFQ_CLKB XD4_XDFFM_M XD4_XDFFQ_CLKB 1.8151e-17
* device instance cc_XD4_XDFFM_M_XD4_XDFFQ_M r0 *1 0,0
Ccc_XD4_XDFFM_M_XD4_XDFFQ_M XD4_XDFFM_M XD4_XDFFQ_M 2.4201e-17
* device instance cc_XD4_XDFFM_M_XD4_XDFFQ_MB r0 *1 0,0
Ccc_XD4_XDFFM_M_XD4_XDFFQ_MB XD4_XDFFM_M XD4_XDFFQ_MB 1.21e-17
* device instance cc_XD4_XDFFM_M_XD4_XDFFQ_S r0 *1 0,0
Ccc_XD4_XDFFM_M_XD4_XDFFQ_S XD4_XDFFM_M XD4_XDFFQ_S 1.8151e-17
* device instance cc_XD4_XDFFM_M_XD4_XDFFQ_SB r0 *1 0,0
Ccc_XD4_XDFFM_M_XD4_XDFFQ_SB XD4_XDFFM_M XD4_XDFFQ_SB 1.8151e-17
* device instance cc_XD4_XDFFM_M_XD4_XNOR_midp r0 *1 0,0
Ccc_XD4_XDFFM_M_XD4_XNOR_midp XD4_XDFFM_M XD4_XNOR_midp 1.21e-17
* device instance cc_XD4_XDFFM_M_XD4_dmodout r0 *1 0,0
Ccc_XD4_XDFFM_M_XD4_dmodout XD4_XDFFM_M XD4_dmodout 2.8638e-17
* device instance cc_XD4_XDFFM_M_XD4_dq r0 *1 0,0
Ccc_XD4_XDFFM_M_XD4_dq XD4_XDFFM_M XD4_dq 1.21e-17
* device instance cc_XD4_XDFFM_M_XD4_nm r0 *1 0,0
Ccc_XD4_XDFFM_M_XD4_nm XD4_XDFFM_M XD4_nm 1.8151e-17
* device instance cc_XD4_XDFFM_M_XD4_nt r0 *1 0,0
Ccc_XD4_XDFFM_M_XD4_nt XD4_XDFFM_M XD4_nt 2.4201e-17
* device instance cc_XD4_XDFFM_M_XD4_t1 r0 *1 0,0
Ccc_XD4_XDFFM_M_XD4_t1 XD4_XDFFM_M XD4_t1 1.21e-17
* device instance cc_XD4_XDFFM_M_XD5_XDFFM_CLKB r0 *1 0,0
Ccc_XD4_XDFFM_M_XD5_XDFFM_CLKB XD4_XDFFM_M XD5_XDFFM_CLKB 1.8151e-17
* device instance cc_XD4_XDFFM_M_XD5_XDFFM_M r0 *1 0,0
Ccc_XD4_XDFFM_M_XD5_XDFFM_M XD4_XDFFM_M XD5_XDFFM_M 2.4201e-17
* device instance cc_XD4_XDFFM_M_XD5_XDFFM_MB r0 *1 0,0
Ccc_XD4_XDFFM_M_XD5_XDFFM_MB XD4_XDFFM_M XD5_XDFFM_MB 1.21e-17
* device instance cc_XD4_XDFFM_M_XD5_XDFFM_S r0 *1 0,0
Ccc_XD4_XDFFM_M_XD5_XDFFM_S XD4_XDFFM_M XD5_XDFFM_S 1.8151e-17
* device instance cc_XD4_XDFFM_M_XD5_XDFFM_SB r0 *1 0,0
Ccc_XD4_XDFFM_M_XD5_XDFFM_SB XD4_XDFFM_M XD5_XDFFM_SB 1.8151e-17
* device instance cc_XD4_XDFFM_M_XD5_XDFFQ_CLKB r0 *1 0,0
Ccc_XD4_XDFFM_M_XD5_XDFFQ_CLKB XD4_XDFFM_M XD5_XDFFQ_CLKB 1.8151e-17
* device instance cc_XD4_XDFFM_M_XD5_XDFFQ_M r0 *1 0,0
Ccc_XD4_XDFFM_M_XD5_XDFFQ_M XD4_XDFFM_M XD5_XDFFQ_M 2.4201e-17
* device instance cc_XD4_XDFFM_M_XD5_XDFFQ_MB r0 *1 0,0
Ccc_XD4_XDFFM_M_XD5_XDFFQ_MB XD4_XDFFM_M XD5_XDFFQ_MB 1.21e-17
* device instance cc_XD4_XDFFM_M_XD5_XDFFQ_S r0 *1 0,0
Ccc_XD4_XDFFM_M_XD5_XDFFQ_S XD4_XDFFM_M XD5_XDFFQ_S 1.8151e-17
* device instance cc_XD4_XDFFM_M_XD5_XDFFQ_SB r0 *1 0,0
Ccc_XD4_XDFFM_M_XD5_XDFFQ_SB XD4_XDFFM_M XD5_XDFFQ_SB 1.8151e-17
* device instance cc_XD4_XDFFM_M_XD5_XN2_mid1 r0 *1 0,0
Ccc_XD4_XDFFM_M_XD5_XN2_mid1 XD4_XDFFM_M XD5_XN2_mid1 1.21e-17
* device instance cc_XD4_XDFFM_M_XD5_XN3_mid1 r0 *1 0,0
Ccc_XD4_XDFFM_M_XD5_XN3_mid1 XD4_XDFFM_M XD5_XN3_mid1 1.21e-17
* device instance cc_XD4_XDFFM_M_XD5_XN3_mid2 r0 *1 0,0
Ccc_XD4_XDFFM_M_XD5_XN3_mid2 XD4_XDFFM_M XD5_XN3_mid2 1.21e-17
* device instance cc_XD4_XDFFM_M_XD5_dmodout r0 *1 0,0
Ccc_XD4_XDFFM_M_XD5_dmodout XD4_XDFFM_M XD5_dmodout 1.21e-17
* device instance cc_XD4_XDFFM_M_XD5_dq r0 *1 0,0
Ccc_XD4_XDFFM_M_XD5_dq XD4_XDFFM_M XD5_dq 1.8151e-17
* device instance cc_XD4_XDFFM_M_XD5_nm r0 *1 0,0
Ccc_XD4_XDFFM_M_XD5_nm XD4_XDFFM_M XD5_nm 1.21e-17
* device instance cc_XD4_XDFFM_M_XD5_nt r0 *1 0,0
Ccc_XD4_XDFFM_M_XD5_nt XD4_XDFFM_M XD5_nt 1.21e-17
* device instance cc_XD4_XDFFM_M_XD5_t1 r0 *1 0,0
Ccc_XD4_XDFFM_M_XD5_t1 XD4_XDFFM_M XD5_t1 1.21e-17
* device instance cc_XD4_XDFFM_M_XFRT_CLKB r0 *1 0,0
Ccc_XD4_XDFFM_M_XFRT_CLKB XD4_XDFFM_M XFRT_CLKB 1.8151e-17
* device instance cc_XD4_XDFFM_M_XFRT_M r0 *1 0,0
Ccc_XD4_XDFFM_M_XFRT_M XD4_XDFFM_M XFRT_M 2.4201e-17
* device instance cc_XD4_XDFFM_M_XFRT_MB r0 *1 0,0
Ccc_XD4_XDFFM_M_XFRT_MB XD4_XDFFM_M XFRT_MB 1.21e-17
* device instance cc_XD4_XDFFM_M_XFRT_S r0 *1 0,0
Ccc_XD4_XDFFM_M_XFRT_S XD4_XDFFM_M XFRT_S 1.8151e-17
* device instance cc_XD4_XDFFM_M_XFRT_SB r0 *1 0,0
Ccc_XD4_XDFFM_M_XFRT_SB XD4_XDFFM_M XFRT_SB 1.8151e-17
* device instance cc_XD4_XDFFM_M_ck1 r0 *1 0,0
Ccc_XD4_XDFFM_M_ck1 XD4_XDFFM_M ck1 5.4452e-17
* device instance cc_XD4_XDFFM_M_ck2 r0 *1 0,0
Ccc_XD4_XDFFM_M_ck2 XD4_XDFFM_M ck2 5.4452e-17
* device instance cc_XD4_XDFFM_M_ck3 r0 *1 0,0
Ccc_XD4_XDFFM_M_ck3 XD4_XDFFM_M ck3 5.4452e-17
* device instance cc_XD4_XDFFM_M_ck4 r0 *1 0,0
Ccc_XD4_XDFFM_M_ck4 XD4_XDFFM_M ck4 6.0502e-17
* device instance cc_XD4_XDFFM_M_ck5 r0 *1 0,0
Ccc_XD4_XDFFM_M_ck5 XD4_XDFFM_M ck5 5.4452e-17
* device instance cc_XD4_XDFFM_M_mod0 r0 *1 0,0
Ccc_XD4_XDFFM_M_mod0 XD4_XDFFM_M mod0 2.4201e-17
* device instance cc_XD4_XDFFM_M_mod1 r0 *1 0,0
Ccc_XD4_XDFFM_M_mod1 XD4_XDFFM_M mod1 2.4201e-17
* device instance cc_XD4_XDFFM_M_mod2 r0 *1 0,0
Ccc_XD4_XDFFM_M_mod2 XD4_XDFFM_M mod2 2.4201e-17
* device instance cc_XD4_XDFFM_M_mod3 r0 *1 0,0
Ccc_XD4_XDFFM_M_mod3 XD4_XDFFM_M mod3 2.4201e-17
* device instance cc_XD4_XDFFM_M_mod4 r0 *1 0,0
Ccc_XD4_XDFFM_M_mod4 XD4_XDFFM_M mod4 2.4201e-17
* device instance cc_XD4_XDFFM_M_net1 r0 *1 0,0
Ccc_XD4_XDFFM_M_net1 XD4_XDFFM_M net1 1.21e-17
* device instance cc_XD4_XDFFM_MB_XD4_XDFFM_S r0 *1 0,0
Ccc_XD4_XDFFM_MB_XD4_XDFFM_S XD4_XDFFM_MB XD4_XDFFM_S 1.8151e-17
* device instance cc_XD4_XDFFM_MB_XD4_XDFFM_SB r0 *1 0,0
Ccc_XD4_XDFFM_MB_XD4_XDFFM_SB XD4_XDFFM_MB XD4_XDFFM_SB 1.8151e-17
* device instance cc_XD4_XDFFM_MB_XD4_XDFFQ_CLKB r0 *1 0,0
Ccc_XD4_XDFFM_MB_XD4_XDFFQ_CLKB XD4_XDFFM_MB XD4_XDFFQ_CLKB 1.8151e-17
* device instance cc_XD4_XDFFM_MB_XD4_XDFFQ_M r0 *1 0,0
Ccc_XD4_XDFFM_MB_XD4_XDFFQ_M XD4_XDFFM_MB XD4_XDFFQ_M 2.4201e-17
* device instance cc_XD4_XDFFM_MB_XD4_XDFFQ_MB r0 *1 0,0
Ccc_XD4_XDFFM_MB_XD4_XDFFQ_MB XD4_XDFFM_MB XD4_XDFFQ_MB 1.21e-17
* device instance cc_XD4_XDFFM_MB_XD4_XDFFQ_S r0 *1 0,0
Ccc_XD4_XDFFM_MB_XD4_XDFFQ_S XD4_XDFFM_MB XD4_XDFFQ_S 1.8151e-17
* device instance cc_XD4_XDFFM_MB_XD4_XDFFQ_SB r0 *1 0,0
Ccc_XD4_XDFFM_MB_XD4_XDFFQ_SB XD4_XDFFM_MB XD4_XDFFQ_SB 1.8151e-17
* device instance cc_XD4_XDFFM_MB_XD4_XNOR_midp r0 *1 0,0
Ccc_XD4_XDFFM_MB_XD4_XNOR_midp XD4_XDFFM_MB XD4_XNOR_midp 1.21e-17
* device instance cc_XD4_XDFFM_MB_XD4_dmodout r0 *1 0,0
Ccc_XD4_XDFFM_MB_XD4_dmodout XD4_XDFFM_MB XD4_dmodout 1.21e-17
* device instance cc_XD4_XDFFM_MB_XD4_dq r0 *1 0,0
Ccc_XD4_XDFFM_MB_XD4_dq XD4_XDFFM_MB XD4_dq 1.21e-17
* device instance cc_XD4_XDFFM_MB_XD4_nm r0 *1 0,0
Ccc_XD4_XDFFM_MB_XD4_nm XD4_XDFFM_MB XD4_nm 1.8151e-17
* device instance cc_XD4_XDFFM_MB_XD4_nt r0 *1 0,0
Ccc_XD4_XDFFM_MB_XD4_nt XD4_XDFFM_MB XD4_nt 2.4201e-17
* device instance cc_XD4_XDFFM_MB_XD4_t1 r0 *1 0,0
Ccc_XD4_XDFFM_MB_XD4_t1 XD4_XDFFM_MB XD4_t1 1.21e-17
* device instance cc_XD4_XDFFM_MB_XD5_XDFFM_CLKB r0 *1 0,0
Ccc_XD4_XDFFM_MB_XD5_XDFFM_CLKB XD4_XDFFM_MB XD5_XDFFM_CLKB 1.8151e-17
* device instance cc_XD4_XDFFM_MB_XD5_XDFFM_M r0 *1 0,0
Ccc_XD4_XDFFM_MB_XD5_XDFFM_M XD4_XDFFM_MB XD5_XDFFM_M 2.4201e-17
* device instance cc_XD4_XDFFM_MB_XD5_XDFFM_MB r0 *1 0,0
Ccc_XD4_XDFFM_MB_XD5_XDFFM_MB XD4_XDFFM_MB XD5_XDFFM_MB 1.21e-17
* device instance cc_XD4_XDFFM_MB_XD5_XDFFM_S r0 *1 0,0
Ccc_XD4_XDFFM_MB_XD5_XDFFM_S XD4_XDFFM_MB XD5_XDFFM_S 1.8151e-17
* device instance cc_XD4_XDFFM_MB_XD5_XDFFM_SB r0 *1 0,0
Ccc_XD4_XDFFM_MB_XD5_XDFFM_SB XD4_XDFFM_MB XD5_XDFFM_SB 1.8151e-17
* device instance cc_XD4_XDFFM_MB_XD5_XDFFQ_CLKB r0 *1 0,0
Ccc_XD4_XDFFM_MB_XD5_XDFFQ_CLKB XD4_XDFFM_MB XD5_XDFFQ_CLKB 1.8151e-17
* device instance cc_XD4_XDFFM_MB_XD5_XDFFQ_M r0 *1 0,0
Ccc_XD4_XDFFM_MB_XD5_XDFFQ_M XD4_XDFFM_MB XD5_XDFFQ_M 2.4201e-17
* device instance cc_XD4_XDFFM_MB_XD5_XDFFQ_MB r0 *1 0,0
Ccc_XD4_XDFFM_MB_XD5_XDFFQ_MB XD4_XDFFM_MB XD5_XDFFQ_MB 1.21e-17
* device instance cc_XD4_XDFFM_MB_XD5_XDFFQ_S r0 *1 0,0
Ccc_XD4_XDFFM_MB_XD5_XDFFQ_S XD4_XDFFM_MB XD5_XDFFQ_S 1.8151e-17
* device instance cc_XD4_XDFFM_MB_XD5_XDFFQ_SB r0 *1 0,0
Ccc_XD4_XDFFM_MB_XD5_XDFFQ_SB XD4_XDFFM_MB XD5_XDFFQ_SB 1.8151e-17
* device instance cc_XD4_XDFFM_MB_XD5_XN2_mid1 r0 *1 0,0
Ccc_XD4_XDFFM_MB_XD5_XN2_mid1 XD4_XDFFM_MB XD5_XN2_mid1 1.21e-17
* device instance cc_XD4_XDFFM_MB_XD5_XN3_mid1 r0 *1 0,0
Ccc_XD4_XDFFM_MB_XD5_XN3_mid1 XD4_XDFFM_MB XD5_XN3_mid1 1.21e-17
* device instance cc_XD4_XDFFM_MB_XD5_XN3_mid2 r0 *1 0,0
Ccc_XD4_XDFFM_MB_XD5_XN3_mid2 XD4_XDFFM_MB XD5_XN3_mid2 1.21e-17
* device instance cc_XD4_XDFFM_MB_XD5_dmodout r0 *1 0,0
Ccc_XD4_XDFFM_MB_XD5_dmodout XD4_XDFFM_MB XD5_dmodout 1.21e-17
* device instance cc_XD4_XDFFM_MB_XD5_dq r0 *1 0,0
Ccc_XD4_XDFFM_MB_XD5_dq XD4_XDFFM_MB XD5_dq 1.8151e-17
* device instance cc_XD4_XDFFM_MB_XD5_nm r0 *1 0,0
Ccc_XD4_XDFFM_MB_XD5_nm XD4_XDFFM_MB XD5_nm 1.21e-17
* device instance cc_XD4_XDFFM_MB_XD5_nt r0 *1 0,0
Ccc_XD4_XDFFM_MB_XD5_nt XD4_XDFFM_MB XD5_nt 1.21e-17
* device instance cc_XD4_XDFFM_MB_XD5_t1 r0 *1 0,0
Ccc_XD4_XDFFM_MB_XD5_t1 XD4_XDFFM_MB XD5_t1 1.21e-17
* device instance cc_XD4_XDFFM_MB_XFRT_CLKB r0 *1 0,0
Ccc_XD4_XDFFM_MB_XFRT_CLKB XD4_XDFFM_MB XFRT_CLKB 1.8151e-17
* device instance cc_XD4_XDFFM_MB_XFRT_M r0 *1 0,0
Ccc_XD4_XDFFM_MB_XFRT_M XD4_XDFFM_MB XFRT_M 2.4201e-17
* device instance cc_XD4_XDFFM_MB_XFRT_MB r0 *1 0,0
Ccc_XD4_XDFFM_MB_XFRT_MB XD4_XDFFM_MB XFRT_MB 1.21e-17
* device instance cc_XD4_XDFFM_MB_XFRT_S r0 *1 0,0
Ccc_XD4_XDFFM_MB_XFRT_S XD4_XDFFM_MB XFRT_S 1.8151e-17
* device instance cc_XD4_XDFFM_MB_XFRT_SB r0 *1 0,0
Ccc_XD4_XDFFM_MB_XFRT_SB XD4_XDFFM_MB XFRT_SB 1.8151e-17
* device instance cc_XD4_XDFFM_MB_ck1 r0 *1 0,0
Ccc_XD4_XDFFM_MB_ck1 XD4_XDFFM_MB ck1 5.4452e-17
* device instance cc_XD4_XDFFM_MB_ck2 r0 *1 0,0
Ccc_XD4_XDFFM_MB_ck2 XD4_XDFFM_MB ck2 5.4452e-17
* device instance cc_XD4_XDFFM_MB_ck3 r0 *1 0,0
Ccc_XD4_XDFFM_MB_ck3 XD4_XDFFM_MB ck3 5.4452e-17
* device instance cc_XD4_XDFFM_MB_ck4 r0 *1 0,0
Ccc_XD4_XDFFM_MB_ck4 XD4_XDFFM_MB ck4 6.0502e-17
* device instance cc_XD4_XDFFM_MB_ck5 r0 *1 0,0
Ccc_XD4_XDFFM_MB_ck5 XD4_XDFFM_MB ck5 5.4452e-17
* device instance cc_XD4_XDFFM_MB_mod0 r0 *1 0,0
Ccc_XD4_XDFFM_MB_mod0 XD4_XDFFM_MB mod0 2.4201e-17
* device instance cc_XD4_XDFFM_MB_mod1 r0 *1 0,0
Ccc_XD4_XDFFM_MB_mod1 XD4_XDFFM_MB mod1 2.4201e-17
* device instance cc_XD4_XDFFM_MB_mod2 r0 *1 0,0
Ccc_XD4_XDFFM_MB_mod2 XD4_XDFFM_MB mod2 2.4201e-17
* device instance cc_XD4_XDFFM_MB_mod3 r0 *1 0,0
Ccc_XD4_XDFFM_MB_mod3 XD4_XDFFM_MB mod3 2.4201e-17
* device instance cc_XD4_XDFFM_MB_mod4 r0 *1 0,0
Ccc_XD4_XDFFM_MB_mod4 XD4_XDFFM_MB mod4 2.4201e-17
* device instance cc_XD4_XDFFM_MB_net1 r0 *1 0,0
Ccc_XD4_XDFFM_MB_net1 XD4_XDFFM_MB net1 1.21e-17
* device instance cc_XD4_XDFFM_S_XD4_XDFFM_SB r0 *1 0,0
Ccc_XD4_XDFFM_S_XD4_XDFFM_SB XD4_XDFFM_S XD4_XDFFM_SB 4.0738e-17
* device instance cc_XD4_XDFFM_S_XD4_XDFFQ_CLKB r0 *1 0,0
Ccc_XD4_XDFFM_S_XD4_XDFFQ_CLKB XD4_XDFFM_S XD4_XDFFQ_CLKB 1.8151e-17
* device instance cc_XD4_XDFFM_S_XD4_XDFFQ_M r0 *1 0,0
Ccc_XD4_XDFFM_S_XD4_XDFFQ_M XD4_XDFFM_S XD4_XDFFQ_M 2.4201e-17
* device instance cc_XD4_XDFFM_S_XD4_XDFFQ_MB r0 *1 0,0
Ccc_XD4_XDFFM_S_XD4_XDFFQ_MB XD4_XDFFM_S XD4_XDFFQ_MB 1.21e-17
* device instance cc_XD4_XDFFM_S_XD4_XDFFQ_S r0 *1 0,0
Ccc_XD4_XDFFM_S_XD4_XDFFQ_S XD4_XDFFM_S XD4_XDFFQ_S 1.8151e-17
* device instance cc_XD4_XDFFM_S_XD4_XDFFQ_SB r0 *1 0,0
Ccc_XD4_XDFFM_S_XD4_XDFFQ_SB XD4_XDFFM_S XD4_XDFFQ_SB 1.8151e-17
* device instance cc_XD4_XDFFM_S_XD4_XNOR_midp r0 *1 0,0
Ccc_XD4_XDFFM_S_XD4_XNOR_midp XD4_XDFFM_S XD4_XNOR_midp 1.21e-17
* device instance cc_XD4_XDFFM_S_XD4_dmodout r0 *1 0,0
Ccc_XD4_XDFFM_S_XD4_dmodout XD4_XDFFM_S XD4_dmodout 1.21e-17
* device instance cc_XD4_XDFFM_S_XD4_dq r0 *1 0,0
Ccc_XD4_XDFFM_S_XD4_dq XD4_XDFFM_S XD4_dq 1.21e-17
* device instance cc_XD4_XDFFM_S_XD4_nm r0 *1 0,0
Ccc_XD4_XDFFM_S_XD4_nm XD4_XDFFM_S XD4_nm 1.8151e-17
* device instance cc_XD4_XDFFM_S_XD4_nt r0 *1 0,0
Ccc_XD4_XDFFM_S_XD4_nt XD4_XDFFM_S XD4_nt 2.4201e-17
* device instance cc_XD4_XDFFM_S_XD4_t1 r0 *1 0,0
Ccc_XD4_XDFFM_S_XD4_t1 XD4_XDFFM_S XD4_t1 1.21e-17
* device instance cc_XD4_XDFFM_S_XD5_XDFFM_CLKB r0 *1 0,0
Ccc_XD4_XDFFM_S_XD5_XDFFM_CLKB XD4_XDFFM_S XD5_XDFFM_CLKB 1.8151e-17
* device instance cc_XD4_XDFFM_S_XD5_XDFFM_M r0 *1 0,0
Ccc_XD4_XDFFM_S_XD5_XDFFM_M XD4_XDFFM_S XD5_XDFFM_M 2.4201e-17
* device instance cc_XD4_XDFFM_S_XD5_XDFFM_MB r0 *1 0,0
Ccc_XD4_XDFFM_S_XD5_XDFFM_MB XD4_XDFFM_S XD5_XDFFM_MB 1.21e-17
* device instance cc_XD4_XDFFM_S_XD5_XDFFM_S r0 *1 0,0
Ccc_XD4_XDFFM_S_XD5_XDFFM_S XD4_XDFFM_S XD5_XDFFM_S 1.8151e-17
* device instance cc_XD4_XDFFM_S_XD5_XDFFM_SB r0 *1 0,0
Ccc_XD4_XDFFM_S_XD5_XDFFM_SB XD4_XDFFM_S XD5_XDFFM_SB 1.8151e-17
* device instance cc_XD4_XDFFM_S_XD5_XDFFQ_CLKB r0 *1 0,0
Ccc_XD4_XDFFM_S_XD5_XDFFQ_CLKB XD4_XDFFM_S XD5_XDFFQ_CLKB 1.8151e-17
* device instance cc_XD4_XDFFM_S_XD5_XDFFQ_M r0 *1 0,0
Ccc_XD4_XDFFM_S_XD5_XDFFQ_M XD4_XDFFM_S XD5_XDFFQ_M 2.4201e-17
* device instance cc_XD4_XDFFM_S_XD5_XDFFQ_MB r0 *1 0,0
Ccc_XD4_XDFFM_S_XD5_XDFFQ_MB XD4_XDFFM_S XD5_XDFFQ_MB 1.21e-17
* device instance cc_XD4_XDFFM_S_XD5_XDFFQ_S r0 *1 0,0
Ccc_XD4_XDFFM_S_XD5_XDFFQ_S XD4_XDFFM_S XD5_XDFFQ_S 1.8151e-17
* device instance cc_XD4_XDFFM_S_XD5_XDFFQ_SB r0 *1 0,0
Ccc_XD4_XDFFM_S_XD5_XDFFQ_SB XD4_XDFFM_S XD5_XDFFQ_SB 1.8151e-17
* device instance cc_XD4_XDFFM_S_XD5_XN2_mid1 r0 *1 0,0
Ccc_XD4_XDFFM_S_XD5_XN2_mid1 XD4_XDFFM_S XD5_XN2_mid1 1.21e-17
* device instance cc_XD4_XDFFM_S_XD5_XN3_mid1 r0 *1 0,0
Ccc_XD4_XDFFM_S_XD5_XN3_mid1 XD4_XDFFM_S XD5_XN3_mid1 1.21e-17
* device instance cc_XD4_XDFFM_S_XD5_XN3_mid2 r0 *1 0,0
Ccc_XD4_XDFFM_S_XD5_XN3_mid2 XD4_XDFFM_S XD5_XN3_mid2 1.21e-17
* device instance cc_XD4_XDFFM_S_XD5_dmodout r0 *1 0,0
Ccc_XD4_XDFFM_S_XD5_dmodout XD4_XDFFM_S XD5_dmodout 1.21e-17
* device instance cc_XD4_XDFFM_S_XD5_dq r0 *1 0,0
Ccc_XD4_XDFFM_S_XD5_dq XD4_XDFFM_S XD5_dq 1.8151e-17
* device instance cc_XD4_XDFFM_S_XD5_nm r0 *1 0,0
Ccc_XD4_XDFFM_S_XD5_nm XD4_XDFFM_S XD5_nm 1.21e-17
* device instance cc_XD4_XDFFM_S_XD5_nt r0 *1 0,0
Ccc_XD4_XDFFM_S_XD5_nt XD4_XDFFM_S XD5_nt 1.21e-17
* device instance cc_XD4_XDFFM_S_XD5_t1 r0 *1 0,0
Ccc_XD4_XDFFM_S_XD5_t1 XD4_XDFFM_S XD5_t1 1.21e-17
* device instance cc_XD4_XDFFM_S_XFRT_CLKB r0 *1 0,0
Ccc_XD4_XDFFM_S_XFRT_CLKB XD4_XDFFM_S XFRT_CLKB 1.8151e-17
* device instance cc_XD4_XDFFM_S_XFRT_M r0 *1 0,0
Ccc_XD4_XDFFM_S_XFRT_M XD4_XDFFM_S XFRT_M 2.4201e-17
* device instance cc_XD4_XDFFM_S_XFRT_MB r0 *1 0,0
Ccc_XD4_XDFFM_S_XFRT_MB XD4_XDFFM_S XFRT_MB 1.21e-17
* device instance cc_XD4_XDFFM_S_XFRT_S r0 *1 0,0
Ccc_XD4_XDFFM_S_XFRT_S XD4_XDFFM_S XFRT_S 1.8151e-17
* device instance cc_XD4_XDFFM_S_XFRT_SB r0 *1 0,0
Ccc_XD4_XDFFM_S_XFRT_SB XD4_XDFFM_S XFRT_SB 1.8151e-17
* device instance cc_XD4_XDFFM_S_ck1 r0 *1 0,0
Ccc_XD4_XDFFM_S_ck1 XD4_XDFFM_S ck1 5.4452e-17
* device instance cc_XD4_XDFFM_S_ck2 r0 *1 0,0
Ccc_XD4_XDFFM_S_ck2 XD4_XDFFM_S ck2 5.4452e-17
* device instance cc_XD4_XDFFM_S_ck3 r0 *1 0,0
Ccc_XD4_XDFFM_S_ck3 XD4_XDFFM_S ck3 5.4452e-17
* device instance cc_XD4_XDFFM_S_ck4 r0 *1 0,0
Ccc_XD4_XDFFM_S_ck4 XD4_XDFFM_S ck4 5.4452e-17
* device instance cc_XD4_XDFFM_S_ck5 r0 *1 0,0
Ccc_XD4_XDFFM_S_ck5 XD4_XDFFM_S ck5 5.4452e-17
* device instance cc_XD4_XDFFM_S_mod0 r0 *1 0,0
Ccc_XD4_XDFFM_S_mod0 XD4_XDFFM_S mod0 2.4201e-17
* device instance cc_XD4_XDFFM_S_mod1 r0 *1 0,0
Ccc_XD4_XDFFM_S_mod1 XD4_XDFFM_S mod1 2.4201e-17
* device instance cc_XD4_XDFFM_S_mod2 r0 *1 0,0
Ccc_XD4_XDFFM_S_mod2 XD4_XDFFM_S mod2 2.4201e-17
* device instance cc_XD4_XDFFM_S_mod3 r0 *1 0,0
Ccc_XD4_XDFFM_S_mod3 XD4_XDFFM_S mod3 2.4201e-17
* device instance cc_XD4_XDFFM_S_mod4 r0 *1 0,0
Ccc_XD4_XDFFM_S_mod4 XD4_XDFFM_S mod4 2.4201e-17
* device instance cc_XD4_XDFFM_S_net1 r0 *1 0,0
Ccc_XD4_XDFFM_S_net1 XD4_XDFFM_S net1 1.21e-17
* device instance cc_XD4_XDFFM_SB_XD4_XDFFQ_CLKB r0 *1 0,0
Ccc_XD4_XDFFM_SB_XD4_XDFFQ_CLKB XD4_XDFFM_SB XD4_XDFFQ_CLKB 1.8151e-17
* device instance cc_XD4_XDFFM_SB_XD4_XDFFQ_M r0 *1 0,0
Ccc_XD4_XDFFM_SB_XD4_XDFFQ_M XD4_XDFFM_SB XD4_XDFFQ_M 2.4201e-17
* device instance cc_XD4_XDFFM_SB_XD4_XDFFQ_MB r0 *1 0,0
Ccc_XD4_XDFFM_SB_XD4_XDFFQ_MB XD4_XDFFM_SB XD4_XDFFQ_MB 1.21e-17
* device instance cc_XD4_XDFFM_SB_XD4_XDFFQ_S r0 *1 0,0
Ccc_XD4_XDFFM_SB_XD4_XDFFQ_S XD4_XDFFM_SB XD4_XDFFQ_S 1.8151e-17
* device instance cc_XD4_XDFFM_SB_XD4_XDFFQ_SB r0 *1 0,0
Ccc_XD4_XDFFM_SB_XD4_XDFFQ_SB XD4_XDFFM_SB XD4_XDFFQ_SB 1.8151e-17
* device instance cc_XD4_XDFFM_SB_XD4_XNOR_midp r0 *1 0,0
Ccc_XD4_XDFFM_SB_XD4_XNOR_midp XD4_XDFFM_SB XD4_XNOR_midp 1.21e-17
* device instance cc_XD4_XDFFM_SB_XD4_dmodout r0 *1 0,0
Ccc_XD4_XDFFM_SB_XD4_dmodout XD4_XDFFM_SB XD4_dmodout 1.21e-17
* device instance cc_XD4_XDFFM_SB_XD4_dq r0 *1 0,0
Ccc_XD4_XDFFM_SB_XD4_dq XD4_XDFFM_SB XD4_dq 1.21e-17
* device instance cc_XD4_XDFFM_SB_XD4_nm r0 *1 0,0
Ccc_XD4_XDFFM_SB_XD4_nm XD4_XDFFM_SB XD4_nm 1.8151e-17
* device instance cc_XD4_XDFFM_SB_XD4_nt r0 *1 0,0
Ccc_XD4_XDFFM_SB_XD4_nt XD4_XDFFM_SB XD4_nt 2.4201e-17
* device instance cc_XD4_XDFFM_SB_XD4_t1 r0 *1 0,0
Ccc_XD4_XDFFM_SB_XD4_t1 XD4_XDFFM_SB XD4_t1 1.21e-17
* device instance cc_XD4_XDFFM_SB_XD5_XDFFM_CLKB r0 *1 0,0
Ccc_XD4_XDFFM_SB_XD5_XDFFM_CLKB XD4_XDFFM_SB XD5_XDFFM_CLKB 1.8151e-17
* device instance cc_XD4_XDFFM_SB_XD5_XDFFM_M r0 *1 0,0
Ccc_XD4_XDFFM_SB_XD5_XDFFM_M XD4_XDFFM_SB XD5_XDFFM_M 2.4201e-17
* device instance cc_XD4_XDFFM_SB_XD5_XDFFM_MB r0 *1 0,0
Ccc_XD4_XDFFM_SB_XD5_XDFFM_MB XD4_XDFFM_SB XD5_XDFFM_MB 1.21e-17
* device instance cc_XD4_XDFFM_SB_XD5_XDFFM_S r0 *1 0,0
Ccc_XD4_XDFFM_SB_XD5_XDFFM_S XD4_XDFFM_SB XD5_XDFFM_S 1.8151e-17
* device instance cc_XD4_XDFFM_SB_XD5_XDFFM_SB r0 *1 0,0
Ccc_XD4_XDFFM_SB_XD5_XDFFM_SB XD4_XDFFM_SB XD5_XDFFM_SB 1.8151e-17
* device instance cc_XD4_XDFFM_SB_XD5_XDFFQ_CLKB r0 *1 0,0
Ccc_XD4_XDFFM_SB_XD5_XDFFQ_CLKB XD4_XDFFM_SB XD5_XDFFQ_CLKB 1.8151e-17
* device instance cc_XD4_XDFFM_SB_XD5_XDFFQ_M r0 *1 0,0
Ccc_XD4_XDFFM_SB_XD5_XDFFQ_M XD4_XDFFM_SB XD5_XDFFQ_M 2.4201e-17
* device instance cc_XD4_XDFFM_SB_XD5_XDFFQ_MB r0 *1 0,0
Ccc_XD4_XDFFM_SB_XD5_XDFFQ_MB XD4_XDFFM_SB XD5_XDFFQ_MB 1.21e-17
* device instance cc_XD4_XDFFM_SB_XD5_XDFFQ_S r0 *1 0,0
Ccc_XD4_XDFFM_SB_XD5_XDFFQ_S XD4_XDFFM_SB XD5_XDFFQ_S 1.8151e-17
* device instance cc_XD4_XDFFM_SB_XD5_XDFFQ_SB r0 *1 0,0
Ccc_XD4_XDFFM_SB_XD5_XDFFQ_SB XD4_XDFFM_SB XD5_XDFFQ_SB 1.8151e-17
* device instance cc_XD4_XDFFM_SB_XD5_XN2_mid1 r0 *1 0,0
Ccc_XD4_XDFFM_SB_XD5_XN2_mid1 XD4_XDFFM_SB XD5_XN2_mid1 1.21e-17
* device instance cc_XD4_XDFFM_SB_XD5_XN3_mid1 r0 *1 0,0
Ccc_XD4_XDFFM_SB_XD5_XN3_mid1 XD4_XDFFM_SB XD5_XN3_mid1 1.21e-17
* device instance cc_XD4_XDFFM_SB_XD5_XN3_mid2 r0 *1 0,0
Ccc_XD4_XDFFM_SB_XD5_XN3_mid2 XD4_XDFFM_SB XD5_XN3_mid2 1.21e-17
* device instance cc_XD4_XDFFM_SB_XD5_dmodout r0 *1 0,0
Ccc_XD4_XDFFM_SB_XD5_dmodout XD4_XDFFM_SB XD5_dmodout 1.21e-17
* device instance cc_XD4_XDFFM_SB_XD5_dq r0 *1 0,0
Ccc_XD4_XDFFM_SB_XD5_dq XD4_XDFFM_SB XD5_dq 1.8151e-17
* device instance cc_XD4_XDFFM_SB_XD5_nm r0 *1 0,0
Ccc_XD4_XDFFM_SB_XD5_nm XD4_XDFFM_SB XD5_nm 1.21e-17
* device instance cc_XD4_XDFFM_SB_XD5_nt r0 *1 0,0
Ccc_XD4_XDFFM_SB_XD5_nt XD4_XDFFM_SB XD5_nt 1.21e-17
* device instance cc_XD4_XDFFM_SB_XD5_t1 r0 *1 0,0
Ccc_XD4_XDFFM_SB_XD5_t1 XD4_XDFFM_SB XD5_t1 1.21e-17
* device instance cc_XD4_XDFFM_SB_XFRT_CLKB r0 *1 0,0
Ccc_XD4_XDFFM_SB_XFRT_CLKB XD4_XDFFM_SB XFRT_CLKB 1.8151e-17
* device instance cc_XD4_XDFFM_SB_XFRT_M r0 *1 0,0
Ccc_XD4_XDFFM_SB_XFRT_M XD4_XDFFM_SB XFRT_M 2.4201e-17
* device instance cc_XD4_XDFFM_SB_XFRT_MB r0 *1 0,0
Ccc_XD4_XDFFM_SB_XFRT_MB XD4_XDFFM_SB XFRT_MB 1.21e-17
* device instance cc_XD4_XDFFM_SB_XFRT_S r0 *1 0,0
Ccc_XD4_XDFFM_SB_XFRT_S XD4_XDFFM_SB XFRT_S 1.8151e-17
* device instance cc_XD4_XDFFM_SB_XFRT_SB r0 *1 0,0
Ccc_XD4_XDFFM_SB_XFRT_SB XD4_XDFFM_SB XFRT_SB 1.8151e-17
* device instance cc_XD4_XDFFM_SB_ck1 r0 *1 0,0
Ccc_XD4_XDFFM_SB_ck1 XD4_XDFFM_SB ck1 5.4452e-17
* device instance cc_XD4_XDFFM_SB_ck2 r0 *1 0,0
Ccc_XD4_XDFFM_SB_ck2 XD4_XDFFM_SB ck2 5.4452e-17
* device instance cc_XD4_XDFFM_SB_ck3 r0 *1 0,0
Ccc_XD4_XDFFM_SB_ck3 XD4_XDFFM_SB ck3 5.4452e-17
* device instance cc_XD4_XDFFM_SB_ck4 r0 *1 0,0
Ccc_XD4_XDFFM_SB_ck4 XD4_XDFFM_SB ck4 5.4452e-17
* device instance cc_XD4_XDFFM_SB_ck5 r0 *1 0,0
Ccc_XD4_XDFFM_SB_ck5 XD4_XDFFM_SB ck5 5.4452e-17
* device instance cc_XD4_XDFFM_SB_mod0 r0 *1 0,0
Ccc_XD4_XDFFM_SB_mod0 XD4_XDFFM_SB mod0 2.4201e-17
* device instance cc_XD4_XDFFM_SB_mod1 r0 *1 0,0
Ccc_XD4_XDFFM_SB_mod1 XD4_XDFFM_SB mod1 2.4201e-17
* device instance cc_XD4_XDFFM_SB_mod2 r0 *1 0,0
Ccc_XD4_XDFFM_SB_mod2 XD4_XDFFM_SB mod2 2.4201e-17
* device instance cc_XD4_XDFFM_SB_mod3 r0 *1 0,0
Ccc_XD4_XDFFM_SB_mod3 XD4_XDFFM_SB mod3 2.4201e-17
* device instance cc_XD4_XDFFM_SB_mod4 r0 *1 0,0
Ccc_XD4_XDFFM_SB_mod4 XD4_XDFFM_SB mod4 2.4201e-17
* device instance cc_XD4_XDFFM_SB_net1 r0 *1 0,0
Ccc_XD4_XDFFM_SB_net1 XD4_XDFFM_SB net1 1.21e-17
* device instance cc_XD4_XDFFQ_CLKB_XD4_XDFFQ_M r0 *1 0,0
Ccc_XD4_XDFFQ_CLKB_XD4_XDFFQ_M XD4_XDFFQ_CLKB XD4_XDFFQ_M 4.2352e-17
* device instance cc_XD4_XDFFQ_CLKB_XD4_XDFFQ_MB r0 *1 0,0
Ccc_XD4_XDFFQ_CLKB_XD4_XDFFQ_MB XD4_XDFFQ_CLKB XD4_XDFFQ_MB 2.4201e-17
* device instance cc_XD4_XDFFQ_CLKB_XD4_XDFFQ_S r0 *1 0,0
Ccc_XD4_XDFFQ_CLKB_XD4_XDFFQ_S XD4_XDFFQ_CLKB XD4_XDFFQ_S 1.8151e-17
* device instance cc_XD4_XDFFQ_CLKB_XD4_XDFFQ_SB r0 *1 0,0
Ccc_XD4_XDFFQ_CLKB_XD4_XDFFQ_SB XD4_XDFFQ_CLKB XD4_XDFFQ_SB 1.8151e-17
* device instance cc_XD4_XDFFQ_CLKB_XD4_XN2_mid1 r0 *1 0,0
Ccc_XD4_XDFFQ_CLKB_XD4_XN2_mid1 XD4_XDFFQ_CLKB XD4_XN2_mid1 1.21e-17
* device instance cc_XD4_XDFFQ_CLKB_XD4_XNOR_midp r0 *1 0,0
Ccc_XD4_XDFFQ_CLKB_XD4_XNOR_midp XD4_XDFFQ_CLKB XD4_XNOR_midp 1.21e-17
* device instance cc_XD4_XDFFQ_CLKB_XD4_dmodout r0 *1 0,0
Ccc_XD4_XDFFQ_CLKB_XD4_dmodout XD4_XDFFQ_CLKB XD4_dmodout 1.21e-17
* device instance cc_XD4_XDFFQ_CLKB_XD4_dq r0 *1 0,0
Ccc_XD4_XDFFQ_CLKB_XD4_dq XD4_XDFFQ_CLKB XD4_dq 1.8151e-17
* device instance cc_XD4_XDFFQ_CLKB_XD4_nm r0 *1 0,0
Ccc_XD4_XDFFQ_CLKB_XD4_nm XD4_XDFFQ_CLKB XD4_nm 1.21e-17
* device instance cc_XD4_XDFFQ_CLKB_XD4_nt r0 *1 0,0
Ccc_XD4_XDFFQ_CLKB_XD4_nt XD4_XDFFQ_CLKB XD4_nt 2.4201e-17
* device instance cc_XD4_XDFFQ_CLKB_XD4_t1 r0 *1 0,0
Ccc_XD4_XDFFQ_CLKB_XD4_t1 XD4_XDFFQ_CLKB XD4_t1 1.21e-17
* device instance cc_XD4_XDFFQ_CLKB_XD5_XDFFM_CLKB r0 *1 0,0
Ccc_XD4_XDFFQ_CLKB_XD5_XDFFM_CLKB XD4_XDFFQ_CLKB XD5_XDFFM_CLKB 1.8151e-17
* device instance cc_XD4_XDFFQ_CLKB_XD5_XDFFM_M r0 *1 0,0
Ccc_XD4_XDFFQ_CLKB_XD5_XDFFM_M XD4_XDFFQ_CLKB XD5_XDFFM_M 2.4201e-17
* device instance cc_XD4_XDFFQ_CLKB_XD5_XDFFM_MB r0 *1 0,0
Ccc_XD4_XDFFQ_CLKB_XD5_XDFFM_MB XD4_XDFFQ_CLKB XD5_XDFFM_MB 1.21e-17
* device instance cc_XD4_XDFFQ_CLKB_XD5_XDFFM_S r0 *1 0,0
Ccc_XD4_XDFFQ_CLKB_XD5_XDFFM_S XD4_XDFFQ_CLKB XD5_XDFFM_S 1.8151e-17
* device instance cc_XD4_XDFFQ_CLKB_XD5_XDFFM_SB r0 *1 0,0
Ccc_XD4_XDFFQ_CLKB_XD5_XDFFM_SB XD4_XDFFQ_CLKB XD5_XDFFM_SB 1.8151e-17
* device instance cc_XD4_XDFFQ_CLKB_XD5_XDFFQ_CLKB r0 *1 0,0
Ccc_XD4_XDFFQ_CLKB_XD5_XDFFQ_CLKB XD4_XDFFQ_CLKB XD5_XDFFQ_CLKB 1.8151e-17
* device instance cc_XD4_XDFFQ_CLKB_XD5_XDFFQ_M r0 *1 0,0
Ccc_XD4_XDFFQ_CLKB_XD5_XDFFQ_M XD4_XDFFQ_CLKB XD5_XDFFQ_M 2.4201e-17
* device instance cc_XD4_XDFFQ_CLKB_XD5_XDFFQ_MB r0 *1 0,0
Ccc_XD4_XDFFQ_CLKB_XD5_XDFFQ_MB XD4_XDFFQ_CLKB XD5_XDFFQ_MB 1.21e-17
* device instance cc_XD4_XDFFQ_CLKB_XD5_XDFFQ_S r0 *1 0,0
Ccc_XD4_XDFFQ_CLKB_XD5_XDFFQ_S XD4_XDFFQ_CLKB XD5_XDFFQ_S 1.8151e-17
* device instance cc_XD4_XDFFQ_CLKB_XD5_XDFFQ_SB r0 *1 0,0
Ccc_XD4_XDFFQ_CLKB_XD5_XDFFQ_SB XD4_XDFFQ_CLKB XD5_XDFFQ_SB 1.8151e-17
* device instance cc_XD4_XDFFQ_CLKB_XD5_XN2_mid1 r0 *1 0,0
Ccc_XD4_XDFFQ_CLKB_XD5_XN2_mid1 XD4_XDFFQ_CLKB XD5_XN2_mid1 1.21e-17
* device instance cc_XD4_XDFFQ_CLKB_XD5_XN3_mid1 r0 *1 0,0
Ccc_XD4_XDFFQ_CLKB_XD5_XN3_mid1 XD4_XDFFQ_CLKB XD5_XN3_mid1 1.21e-17
* device instance cc_XD4_XDFFQ_CLKB_XD5_XN3_mid2 r0 *1 0,0
Ccc_XD4_XDFFQ_CLKB_XD5_XN3_mid2 XD4_XDFFQ_CLKB XD5_XN3_mid2 1.21e-17
* device instance cc_XD4_XDFFQ_CLKB_XD5_dmodout r0 *1 0,0
Ccc_XD4_XDFFQ_CLKB_XD5_dmodout XD4_XDFFQ_CLKB XD5_dmodout 1.21e-17
* device instance cc_XD4_XDFFQ_CLKB_XD5_dq r0 *1 0,0
Ccc_XD4_XDFFQ_CLKB_XD5_dq XD4_XDFFQ_CLKB XD5_dq 1.8151e-17
* device instance cc_XD4_XDFFQ_CLKB_XD5_nm r0 *1 0,0
Ccc_XD4_XDFFQ_CLKB_XD5_nm XD4_XDFFQ_CLKB XD5_nm 1.21e-17
* device instance cc_XD4_XDFFQ_CLKB_XD5_nt r0 *1 0,0
Ccc_XD4_XDFFQ_CLKB_XD5_nt XD4_XDFFQ_CLKB XD5_nt 1.21e-17
* device instance cc_XD4_XDFFQ_CLKB_XD5_t1 r0 *1 0,0
Ccc_XD4_XDFFQ_CLKB_XD5_t1 XD4_XDFFQ_CLKB XD5_t1 1.21e-17
* device instance cc_XD4_XDFFQ_CLKB_XFRT_CLKB r0 *1 0,0
Ccc_XD4_XDFFQ_CLKB_XFRT_CLKB XD4_XDFFQ_CLKB XFRT_CLKB 1.8151e-17
* device instance cc_XD4_XDFFQ_CLKB_XFRT_M r0 *1 0,0
Ccc_XD4_XDFFQ_CLKB_XFRT_M XD4_XDFFQ_CLKB XFRT_M 2.4201e-17
* device instance cc_XD4_XDFFQ_CLKB_XFRT_MB r0 *1 0,0
Ccc_XD4_XDFFQ_CLKB_XFRT_MB XD4_XDFFQ_CLKB XFRT_MB 1.21e-17
* device instance cc_XD4_XDFFQ_CLKB_XFRT_S r0 *1 0,0
Ccc_XD4_XDFFQ_CLKB_XFRT_S XD4_XDFFQ_CLKB XFRT_S 1.8151e-17
* device instance cc_XD4_XDFFQ_CLKB_XFRT_SB r0 *1 0,0
Ccc_XD4_XDFFQ_CLKB_XFRT_SB XD4_XDFFQ_CLKB XFRT_SB 1.8151e-17
* device instance cc_XD4_XDFFQ_CLKB_ck1 r0 *1 0,0
Ccc_XD4_XDFFQ_CLKB_ck1 XD4_XDFFQ_CLKB ck1 5.4452e-17
* device instance cc_XD4_XDFFQ_CLKB_ck2 r0 *1 0,0
Ccc_XD4_XDFFQ_CLKB_ck2 XD4_XDFFQ_CLKB ck2 5.4452e-17
* device instance cc_XD4_XDFFQ_CLKB_ck3 r0 *1 0,0
Ccc_XD4_XDFFQ_CLKB_ck3 XD4_XDFFQ_CLKB ck3 5.4452e-17
* device instance cc_XD4_XDFFQ_CLKB_ck4 r0 *1 0,0
Ccc_XD4_XDFFQ_CLKB_ck4 XD4_XDFFQ_CLKB ck4 6.0502e-17
* device instance cc_XD4_XDFFQ_CLKB_ck5 r0 *1 0,0
Ccc_XD4_XDFFQ_CLKB_ck5 XD4_XDFFQ_CLKB ck5 5.4452e-17
* device instance cc_XD4_XDFFQ_CLKB_mod0 r0 *1 0,0
Ccc_XD4_XDFFQ_CLKB_mod0 XD4_XDFFQ_CLKB mod0 2.4201e-17
* device instance cc_XD4_XDFFQ_CLKB_mod1 r0 *1 0,0
Ccc_XD4_XDFFQ_CLKB_mod1 XD4_XDFFQ_CLKB mod1 2.4201e-17
* device instance cc_XD4_XDFFQ_CLKB_mod2 r0 *1 0,0
Ccc_XD4_XDFFQ_CLKB_mod2 XD4_XDFFQ_CLKB mod2 2.4201e-17
* device instance cc_XD4_XDFFQ_CLKB_mod3 r0 *1 0,0
Ccc_XD4_XDFFQ_CLKB_mod3 XD4_XDFFQ_CLKB mod3 2.4201e-17
* device instance cc_XD4_XDFFQ_CLKB_mod4 r0 *1 0,0
Ccc_XD4_XDFFQ_CLKB_mod4 XD4_XDFFQ_CLKB mod4 2.4201e-17
* device instance cc_XD4_XDFFQ_CLKB_net1 r0 *1 0,0
Ccc_XD4_XDFFQ_CLKB_net1 XD4_XDFFQ_CLKB net1 1.21e-17
* device instance cc_XD4_XDFFQ_M_XD4_XDFFQ_MB r0 *1 0,0
Ccc_XD4_XDFFQ_M_XD4_XDFFQ_MB XD4_XDFFQ_M XD4_XDFFQ_MB 3.4688e-17
* device instance cc_XD4_XDFFQ_M_XD4_XDFFQ_S r0 *1 0,0
Ccc_XD4_XDFFQ_M_XD4_XDFFQ_S XD4_XDFFQ_M XD4_XDFFQ_S 2.8638e-17
* device instance cc_XD4_XDFFQ_M_XD4_XDFFQ_SB r0 *1 0,0
Ccc_XD4_XDFFQ_M_XD4_XDFFQ_SB XD4_XDFFQ_M XD4_XDFFQ_SB 1.8151e-17
* device instance cc_XD4_XDFFQ_M_XD4_XN2_mid1 r0 *1 0,0
Ccc_XD4_XDFFQ_M_XD4_XN2_mid1 XD4_XDFFQ_M XD4_XN2_mid1 1.21e-17
* device instance cc_XD4_XDFFQ_M_XD4_XNOR_midp r0 *1 0,0
Ccc_XD4_XDFFQ_M_XD4_XNOR_midp XD4_XDFFQ_M XD4_XNOR_midp 1.21e-17
* device instance cc_XD4_XDFFQ_M_XD4_dmodout r0 *1 0,0
Ccc_XD4_XDFFQ_M_XD4_dmodout XD4_XDFFQ_M XD4_dmodout 1.21e-17
* device instance cc_XD4_XDFFQ_M_XD4_dq r0 *1 0,0
Ccc_XD4_XDFFQ_M_XD4_dq XD4_XDFFQ_M XD4_dq 2.8638e-17
* device instance cc_XD4_XDFFQ_M_XD4_nm r0 *1 0,0
Ccc_XD4_XDFFQ_M_XD4_nm XD4_XDFFQ_M XD4_nm 1.21e-17
* device instance cc_XD4_XDFFQ_M_XD4_nt r0 *1 0,0
Ccc_XD4_XDFFQ_M_XD4_nt XD4_XDFFQ_M XD4_nt 2.4201e-17
* device instance cc_XD4_XDFFQ_M_XD4_t1 r0 *1 0,0
Ccc_XD4_XDFFQ_M_XD4_t1 XD4_XDFFQ_M XD4_t1 1.21e-17
* device instance cc_XD4_XDFFQ_M_XD5_XDFFM_CLKB r0 *1 0,0
Ccc_XD4_XDFFQ_M_XD5_XDFFM_CLKB XD4_XDFFQ_M XD5_XDFFM_CLKB 1.8151e-17
* device instance cc_XD4_XDFFQ_M_XD5_XDFFM_M r0 *1 0,0
Ccc_XD4_XDFFQ_M_XD5_XDFFM_M XD4_XDFFQ_M XD5_XDFFM_M 2.4201e-17
* device instance cc_XD4_XDFFQ_M_XD5_XDFFM_MB r0 *1 0,0
Ccc_XD4_XDFFQ_M_XD5_XDFFM_MB XD4_XDFFQ_M XD5_XDFFM_MB 1.21e-17
* device instance cc_XD4_XDFFQ_M_XD5_XDFFM_S r0 *1 0,0
Ccc_XD4_XDFFQ_M_XD5_XDFFM_S XD4_XDFFQ_M XD5_XDFFM_S 1.8151e-17
* device instance cc_XD4_XDFFQ_M_XD5_XDFFM_SB r0 *1 0,0
Ccc_XD4_XDFFQ_M_XD5_XDFFM_SB XD4_XDFFQ_M XD5_XDFFM_SB 1.8151e-17
* device instance cc_XD4_XDFFQ_M_XD5_XDFFQ_CLKB r0 *1 0,0
Ccc_XD4_XDFFQ_M_XD5_XDFFQ_CLKB XD4_XDFFQ_M XD5_XDFFQ_CLKB 1.8151e-17
* device instance cc_XD4_XDFFQ_M_XD5_XDFFQ_M r0 *1 0,0
Ccc_XD4_XDFFQ_M_XD5_XDFFQ_M XD4_XDFFQ_M XD5_XDFFQ_M 2.4201e-17
* device instance cc_XD4_XDFFQ_M_XD5_XDFFQ_MB r0 *1 0,0
Ccc_XD4_XDFFQ_M_XD5_XDFFQ_MB XD4_XDFFQ_M XD5_XDFFQ_MB 1.21e-17
* device instance cc_XD4_XDFFQ_M_XD5_XDFFQ_S r0 *1 0,0
Ccc_XD4_XDFFQ_M_XD5_XDFFQ_S XD4_XDFFQ_M XD5_XDFFQ_S 1.8151e-17
* device instance cc_XD4_XDFFQ_M_XD5_XDFFQ_SB r0 *1 0,0
Ccc_XD4_XDFFQ_M_XD5_XDFFQ_SB XD4_XDFFQ_M XD5_XDFFQ_SB 1.8151e-17
* device instance cc_XD4_XDFFQ_M_XD5_XN2_mid1 r0 *1 0,0
Ccc_XD4_XDFFQ_M_XD5_XN2_mid1 XD4_XDFFQ_M XD5_XN2_mid1 1.21e-17
* device instance cc_XD4_XDFFQ_M_XD5_XN3_mid1 r0 *1 0,0
Ccc_XD4_XDFFQ_M_XD5_XN3_mid1 XD4_XDFFQ_M XD5_XN3_mid1 1.21e-17
* device instance cc_XD4_XDFFQ_M_XD5_XN3_mid2 r0 *1 0,0
Ccc_XD4_XDFFQ_M_XD5_XN3_mid2 XD4_XDFFQ_M XD5_XN3_mid2 1.21e-17
* device instance cc_XD4_XDFFQ_M_XD5_dmodout r0 *1 0,0
Ccc_XD4_XDFFQ_M_XD5_dmodout XD4_XDFFQ_M XD5_dmodout 1.21e-17
* device instance cc_XD4_XDFFQ_M_XD5_dq r0 *1 0,0
Ccc_XD4_XDFFQ_M_XD5_dq XD4_XDFFQ_M XD5_dq 1.8151e-17
* device instance cc_XD4_XDFFQ_M_XD5_nm r0 *1 0,0
Ccc_XD4_XDFFQ_M_XD5_nm XD4_XDFFQ_M XD5_nm 1.21e-17
* device instance cc_XD4_XDFFQ_M_XD5_nt r0 *1 0,0
Ccc_XD4_XDFFQ_M_XD5_nt XD4_XDFFQ_M XD5_nt 1.21e-17
* device instance cc_XD4_XDFFQ_M_XD5_t1 r0 *1 0,0
Ccc_XD4_XDFFQ_M_XD5_t1 XD4_XDFFQ_M XD5_t1 1.21e-17
* device instance cc_XD4_XDFFQ_M_XFRT_CLKB r0 *1 0,0
Ccc_XD4_XDFFQ_M_XFRT_CLKB XD4_XDFFQ_M XFRT_CLKB 1.8151e-17
* device instance cc_XD4_XDFFQ_M_XFRT_M r0 *1 0,0
Ccc_XD4_XDFFQ_M_XFRT_M XD4_XDFFQ_M XFRT_M 2.4201e-17
* device instance cc_XD4_XDFFQ_M_XFRT_MB r0 *1 0,0
Ccc_XD4_XDFFQ_M_XFRT_MB XD4_XDFFQ_M XFRT_MB 1.21e-17
* device instance cc_XD4_XDFFQ_M_XFRT_S r0 *1 0,0
Ccc_XD4_XDFFQ_M_XFRT_S XD4_XDFFQ_M XFRT_S 1.8151e-17
* device instance cc_XD4_XDFFQ_M_XFRT_SB r0 *1 0,0
Ccc_XD4_XDFFQ_M_XFRT_SB XD4_XDFFQ_M XFRT_SB 1.8151e-17
* device instance cc_XD4_XDFFQ_M_ck1 r0 *1 0,0
Ccc_XD4_XDFFQ_M_ck1 XD4_XDFFQ_M ck1 5.4452e-17
* device instance cc_XD4_XDFFQ_M_ck2 r0 *1 0,0
Ccc_XD4_XDFFQ_M_ck2 XD4_XDFFQ_M ck2 5.4452e-17
* device instance cc_XD4_XDFFQ_M_ck3 r0 *1 0,0
Ccc_XD4_XDFFQ_M_ck3 XD4_XDFFQ_M ck3 5.4452e-17
* device instance cc_XD4_XDFFQ_M_ck4 r0 *1 0,0
Ccc_XD4_XDFFQ_M_ck4 XD4_XDFFQ_M ck4 6.0502e-17
* device instance cc_XD4_XDFFQ_M_ck5 r0 *1 0,0
Ccc_XD4_XDFFQ_M_ck5 XD4_XDFFQ_M ck5 5.4452e-17
* device instance cc_XD4_XDFFQ_M_mod0 r0 *1 0,0
Ccc_XD4_XDFFQ_M_mod0 XD4_XDFFQ_M mod0 2.4201e-17
* device instance cc_XD4_XDFFQ_M_mod1 r0 *1 0,0
Ccc_XD4_XDFFQ_M_mod1 XD4_XDFFQ_M mod1 2.4201e-17
* device instance cc_XD4_XDFFQ_M_mod2 r0 *1 0,0
Ccc_XD4_XDFFQ_M_mod2 XD4_XDFFQ_M mod2 2.4201e-17
* device instance cc_XD4_XDFFQ_M_mod3 r0 *1 0,0
Ccc_XD4_XDFFQ_M_mod3 XD4_XDFFQ_M mod3 2.4201e-17
* device instance cc_XD4_XDFFQ_M_mod4 r0 *1 0,0
Ccc_XD4_XDFFQ_M_mod4 XD4_XDFFQ_M mod4 2.4201e-17
* device instance cc_XD4_XDFFQ_M_net1 r0 *1 0,0
Ccc_XD4_XDFFQ_M_net1 XD4_XDFFQ_M net1 1.21e-17
* device instance cc_XD4_XDFFQ_MB_XD4_XDFFQ_S r0 *1 0,0
Ccc_XD4_XDFFQ_MB_XD4_XDFFQ_S XD4_XDFFQ_MB XD4_XDFFQ_S 1.8151e-17
* device instance cc_XD4_XDFFQ_MB_XD4_XDFFQ_SB r0 *1 0,0
Ccc_XD4_XDFFQ_MB_XD4_XDFFQ_SB XD4_XDFFQ_MB XD4_XDFFQ_SB 1.8151e-17
* device instance cc_XD4_XDFFQ_MB_XD4_XN2_mid1 r0 *1 0,0
Ccc_XD4_XDFFQ_MB_XD4_XN2_mid1 XD4_XDFFQ_MB XD4_XN2_mid1 1.21e-17
* device instance cc_XD4_XDFFQ_MB_XD4_XNOR_midp r0 *1 0,0
Ccc_XD4_XDFFQ_MB_XD4_XNOR_midp XD4_XDFFQ_MB XD4_XNOR_midp 1.21e-17
* device instance cc_XD4_XDFFQ_MB_XD4_dmodout r0 *1 0,0
Ccc_XD4_XDFFQ_MB_XD4_dmodout XD4_XDFFQ_MB XD4_dmodout 1.21e-17
* device instance cc_XD4_XDFFQ_MB_XD4_dq r0 *1 0,0
Ccc_XD4_XDFFQ_MB_XD4_dq XD4_XDFFQ_MB XD4_dq 1.21e-17
* device instance cc_XD4_XDFFQ_MB_XD4_nm r0 *1 0,0
Ccc_XD4_XDFFQ_MB_XD4_nm XD4_XDFFQ_MB XD4_nm 1.21e-17
* device instance cc_XD4_XDFFQ_MB_XD4_nt r0 *1 0,0
Ccc_XD4_XDFFQ_MB_XD4_nt XD4_XDFFQ_MB XD4_nt 2.4201e-17
* device instance cc_XD4_XDFFQ_MB_XD4_t1 r0 *1 0,0
Ccc_XD4_XDFFQ_MB_XD4_t1 XD4_XDFFQ_MB XD4_t1 1.21e-17
* device instance cc_XD4_XDFFQ_MB_XD5_XDFFM_CLKB r0 *1 0,0
Ccc_XD4_XDFFQ_MB_XD5_XDFFM_CLKB XD4_XDFFQ_MB XD5_XDFFM_CLKB 1.8151e-17
* device instance cc_XD4_XDFFQ_MB_XD5_XDFFM_M r0 *1 0,0
Ccc_XD4_XDFFQ_MB_XD5_XDFFM_M XD4_XDFFQ_MB XD5_XDFFM_M 2.4201e-17
* device instance cc_XD4_XDFFQ_MB_XD5_XDFFM_MB r0 *1 0,0
Ccc_XD4_XDFFQ_MB_XD5_XDFFM_MB XD4_XDFFQ_MB XD5_XDFFM_MB 1.21e-17
* device instance cc_XD4_XDFFQ_MB_XD5_XDFFM_S r0 *1 0,0
Ccc_XD4_XDFFQ_MB_XD5_XDFFM_S XD4_XDFFQ_MB XD5_XDFFM_S 1.8151e-17
* device instance cc_XD4_XDFFQ_MB_XD5_XDFFM_SB r0 *1 0,0
Ccc_XD4_XDFFQ_MB_XD5_XDFFM_SB XD4_XDFFQ_MB XD5_XDFFM_SB 1.8151e-17
* device instance cc_XD4_XDFFQ_MB_XD5_XDFFQ_CLKB r0 *1 0,0
Ccc_XD4_XDFFQ_MB_XD5_XDFFQ_CLKB XD4_XDFFQ_MB XD5_XDFFQ_CLKB 1.8151e-17
* device instance cc_XD4_XDFFQ_MB_XD5_XDFFQ_M r0 *1 0,0
Ccc_XD4_XDFFQ_MB_XD5_XDFFQ_M XD4_XDFFQ_MB XD5_XDFFQ_M 2.4201e-17
* device instance cc_XD4_XDFFQ_MB_XD5_XDFFQ_MB r0 *1 0,0
Ccc_XD4_XDFFQ_MB_XD5_XDFFQ_MB XD4_XDFFQ_MB XD5_XDFFQ_MB 1.21e-17
* device instance cc_XD4_XDFFQ_MB_XD5_XDFFQ_S r0 *1 0,0
Ccc_XD4_XDFFQ_MB_XD5_XDFFQ_S XD4_XDFFQ_MB XD5_XDFFQ_S 1.8151e-17
* device instance cc_XD4_XDFFQ_MB_XD5_XDFFQ_SB r0 *1 0,0
Ccc_XD4_XDFFQ_MB_XD5_XDFFQ_SB XD4_XDFFQ_MB XD5_XDFFQ_SB 1.8151e-17
* device instance cc_XD4_XDFFQ_MB_XD5_XN2_mid1 r0 *1 0,0
Ccc_XD4_XDFFQ_MB_XD5_XN2_mid1 XD4_XDFFQ_MB XD5_XN2_mid1 1.21e-17
* device instance cc_XD4_XDFFQ_MB_XD5_XN3_mid1 r0 *1 0,0
Ccc_XD4_XDFFQ_MB_XD5_XN3_mid1 XD4_XDFFQ_MB XD5_XN3_mid1 1.21e-17
* device instance cc_XD4_XDFFQ_MB_XD5_XN3_mid2 r0 *1 0,0
Ccc_XD4_XDFFQ_MB_XD5_XN3_mid2 XD4_XDFFQ_MB XD5_XN3_mid2 1.21e-17
* device instance cc_XD4_XDFFQ_MB_XD5_dmodout r0 *1 0,0
Ccc_XD4_XDFFQ_MB_XD5_dmodout XD4_XDFFQ_MB XD5_dmodout 1.21e-17
* device instance cc_XD4_XDFFQ_MB_XD5_dq r0 *1 0,0
Ccc_XD4_XDFFQ_MB_XD5_dq XD4_XDFFQ_MB XD5_dq 1.8151e-17
* device instance cc_XD4_XDFFQ_MB_XD5_nm r0 *1 0,0
Ccc_XD4_XDFFQ_MB_XD5_nm XD4_XDFFQ_MB XD5_nm 1.21e-17
* device instance cc_XD4_XDFFQ_MB_XD5_nt r0 *1 0,0
Ccc_XD4_XDFFQ_MB_XD5_nt XD4_XDFFQ_MB XD5_nt 1.21e-17
* device instance cc_XD4_XDFFQ_MB_XD5_t1 r0 *1 0,0
Ccc_XD4_XDFFQ_MB_XD5_t1 XD4_XDFFQ_MB XD5_t1 1.21e-17
* device instance cc_XD4_XDFFQ_MB_XFRT_CLKB r0 *1 0,0
Ccc_XD4_XDFFQ_MB_XFRT_CLKB XD4_XDFFQ_MB XFRT_CLKB 1.8151e-17
* device instance cc_XD4_XDFFQ_MB_XFRT_M r0 *1 0,0
Ccc_XD4_XDFFQ_MB_XFRT_M XD4_XDFFQ_MB XFRT_M 2.4201e-17
* device instance cc_XD4_XDFFQ_MB_XFRT_MB r0 *1 0,0
Ccc_XD4_XDFFQ_MB_XFRT_MB XD4_XDFFQ_MB XFRT_MB 1.21e-17
* device instance cc_XD4_XDFFQ_MB_XFRT_S r0 *1 0,0
Ccc_XD4_XDFFQ_MB_XFRT_S XD4_XDFFQ_MB XFRT_S 1.8151e-17
* device instance cc_XD4_XDFFQ_MB_XFRT_SB r0 *1 0,0
Ccc_XD4_XDFFQ_MB_XFRT_SB XD4_XDFFQ_MB XFRT_SB 1.8151e-17
* device instance cc_XD4_XDFFQ_MB_ck1 r0 *1 0,0
Ccc_XD4_XDFFQ_MB_ck1 XD4_XDFFQ_MB ck1 5.4452e-17
* device instance cc_XD4_XDFFQ_MB_ck2 r0 *1 0,0
Ccc_XD4_XDFFQ_MB_ck2 XD4_XDFFQ_MB ck2 5.4452e-17
* device instance cc_XD4_XDFFQ_MB_ck3 r0 *1 0,0
Ccc_XD4_XDFFQ_MB_ck3 XD4_XDFFQ_MB ck3 5.4452e-17
* device instance cc_XD4_XDFFQ_MB_ck4 r0 *1 0,0
Ccc_XD4_XDFFQ_MB_ck4 XD4_XDFFQ_MB ck4 6.0502e-17
* device instance cc_XD4_XDFFQ_MB_ck5 r0 *1 0,0
Ccc_XD4_XDFFQ_MB_ck5 XD4_XDFFQ_MB ck5 5.4452e-17
* device instance cc_XD4_XDFFQ_MB_mod0 r0 *1 0,0
Ccc_XD4_XDFFQ_MB_mod0 XD4_XDFFQ_MB mod0 2.4201e-17
* device instance cc_XD4_XDFFQ_MB_mod1 r0 *1 0,0
Ccc_XD4_XDFFQ_MB_mod1 XD4_XDFFQ_MB mod1 2.4201e-17
* device instance cc_XD4_XDFFQ_MB_mod2 r0 *1 0,0
Ccc_XD4_XDFFQ_MB_mod2 XD4_XDFFQ_MB mod2 2.4201e-17
* device instance cc_XD4_XDFFQ_MB_mod3 r0 *1 0,0
Ccc_XD4_XDFFQ_MB_mod3 XD4_XDFFQ_MB mod3 2.4201e-17
* device instance cc_XD4_XDFFQ_MB_mod4 r0 *1 0,0
Ccc_XD4_XDFFQ_MB_mod4 XD4_XDFFQ_MB mod4 2.4201e-17
* device instance cc_XD4_XDFFQ_MB_net1 r0 *1 0,0
Ccc_XD4_XDFFQ_MB_net1 XD4_XDFFQ_MB net1 1.21e-17
* device instance cc_XD4_XDFFQ_S_XD4_XDFFQ_SB r0 *1 0,0
Ccc_XD4_XDFFQ_S_XD4_XDFFQ_SB XD4_XDFFQ_S XD4_XDFFQ_SB 4.0738e-17
* device instance cc_XD4_XDFFQ_S_XD4_XN2_mid1 r0 *1 0,0
Ccc_XD4_XDFFQ_S_XD4_XN2_mid1 XD4_XDFFQ_S XD4_XN2_mid1 1.21e-17
* device instance cc_XD4_XDFFQ_S_XD4_XNOR_midp r0 *1 0,0
Ccc_XD4_XDFFQ_S_XD4_XNOR_midp XD4_XDFFQ_S XD4_XNOR_midp 1.21e-17
* device instance cc_XD4_XDFFQ_S_XD4_dmodout r0 *1 0,0
Ccc_XD4_XDFFQ_S_XD4_dmodout XD4_XDFFQ_S XD4_dmodout 1.21e-17
* device instance cc_XD4_XDFFQ_S_XD4_dq r0 *1 0,0
Ccc_XD4_XDFFQ_S_XD4_dq XD4_XDFFQ_S XD4_dq 1.21e-17
* device instance cc_XD4_XDFFQ_S_XD4_nm r0 *1 0,0
Ccc_XD4_XDFFQ_S_XD4_nm XD4_XDFFQ_S XD4_nm 1.21e-17
* device instance cc_XD4_XDFFQ_S_XD4_nt r0 *1 0,0
Ccc_XD4_XDFFQ_S_XD4_nt XD4_XDFFQ_S XD4_nt 2.4201e-17
* device instance cc_XD4_XDFFQ_S_XD4_t1 r0 *1 0,0
Ccc_XD4_XDFFQ_S_XD4_t1 XD4_XDFFQ_S XD4_t1 1.21e-17
* device instance cc_XD4_XDFFQ_S_XD5_XDFFM_CLKB r0 *1 0,0
Ccc_XD4_XDFFQ_S_XD5_XDFFM_CLKB XD4_XDFFQ_S XD5_XDFFM_CLKB 1.8151e-17
* device instance cc_XD4_XDFFQ_S_XD5_XDFFM_M r0 *1 0,0
Ccc_XD4_XDFFQ_S_XD5_XDFFM_M XD4_XDFFQ_S XD5_XDFFM_M 2.4201e-17
* device instance cc_XD4_XDFFQ_S_XD5_XDFFM_MB r0 *1 0,0
Ccc_XD4_XDFFQ_S_XD5_XDFFM_MB XD4_XDFFQ_S XD5_XDFFM_MB 1.21e-17
* device instance cc_XD4_XDFFQ_S_XD5_XDFFM_S r0 *1 0,0
Ccc_XD4_XDFFQ_S_XD5_XDFFM_S XD4_XDFFQ_S XD5_XDFFM_S 1.8151e-17
* device instance cc_XD4_XDFFQ_S_XD5_XDFFM_SB r0 *1 0,0
Ccc_XD4_XDFFQ_S_XD5_XDFFM_SB XD4_XDFFQ_S XD5_XDFFM_SB 1.8151e-17
* device instance cc_XD4_XDFFQ_S_XD5_XDFFQ_CLKB r0 *1 0,0
Ccc_XD4_XDFFQ_S_XD5_XDFFQ_CLKB XD4_XDFFQ_S XD5_XDFFQ_CLKB 1.8151e-17
* device instance cc_XD4_XDFFQ_S_XD5_XDFFQ_M r0 *1 0,0
Ccc_XD4_XDFFQ_S_XD5_XDFFQ_M XD4_XDFFQ_S XD5_XDFFQ_M 2.4201e-17
* device instance cc_XD4_XDFFQ_S_XD5_XDFFQ_MB r0 *1 0,0
Ccc_XD4_XDFFQ_S_XD5_XDFFQ_MB XD4_XDFFQ_S XD5_XDFFQ_MB 1.21e-17
* device instance cc_XD4_XDFFQ_S_XD5_XDFFQ_S r0 *1 0,0
Ccc_XD4_XDFFQ_S_XD5_XDFFQ_S XD4_XDFFQ_S XD5_XDFFQ_S 1.8151e-17
* device instance cc_XD4_XDFFQ_S_XD5_XDFFQ_SB r0 *1 0,0
Ccc_XD4_XDFFQ_S_XD5_XDFFQ_SB XD4_XDFFQ_S XD5_XDFFQ_SB 1.8151e-17
* device instance cc_XD4_XDFFQ_S_XD5_XN2_mid1 r0 *1 0,0
Ccc_XD4_XDFFQ_S_XD5_XN2_mid1 XD4_XDFFQ_S XD5_XN2_mid1 1.21e-17
* device instance cc_XD4_XDFFQ_S_XD5_XN3_mid1 r0 *1 0,0
Ccc_XD4_XDFFQ_S_XD5_XN3_mid1 XD4_XDFFQ_S XD5_XN3_mid1 1.21e-17
* device instance cc_XD4_XDFFQ_S_XD5_XN3_mid2 r0 *1 0,0
Ccc_XD4_XDFFQ_S_XD5_XN3_mid2 XD4_XDFFQ_S XD5_XN3_mid2 1.21e-17
* device instance cc_XD4_XDFFQ_S_XD5_dmodout r0 *1 0,0
Ccc_XD4_XDFFQ_S_XD5_dmodout XD4_XDFFQ_S XD5_dmodout 1.21e-17
* device instance cc_XD4_XDFFQ_S_XD5_dq r0 *1 0,0
Ccc_XD4_XDFFQ_S_XD5_dq XD4_XDFFQ_S XD5_dq 1.8151e-17
* device instance cc_XD4_XDFFQ_S_XD5_nm r0 *1 0,0
Ccc_XD4_XDFFQ_S_XD5_nm XD4_XDFFQ_S XD5_nm 1.21e-17
* device instance cc_XD4_XDFFQ_S_XD5_nt r0 *1 0,0
Ccc_XD4_XDFFQ_S_XD5_nt XD4_XDFFQ_S XD5_nt 1.21e-17
* device instance cc_XD4_XDFFQ_S_XD5_t1 r0 *1 0,0
Ccc_XD4_XDFFQ_S_XD5_t1 XD4_XDFFQ_S XD5_t1 1.21e-17
* device instance cc_XD4_XDFFQ_S_XFRT_CLKB r0 *1 0,0
Ccc_XD4_XDFFQ_S_XFRT_CLKB XD4_XDFFQ_S XFRT_CLKB 1.8151e-17
* device instance cc_XD4_XDFFQ_S_XFRT_M r0 *1 0,0
Ccc_XD4_XDFFQ_S_XFRT_M XD4_XDFFQ_S XFRT_M 2.4201e-17
* device instance cc_XD4_XDFFQ_S_XFRT_MB r0 *1 0,0
Ccc_XD4_XDFFQ_S_XFRT_MB XD4_XDFFQ_S XFRT_MB 1.21e-17
* device instance cc_XD4_XDFFQ_S_XFRT_S r0 *1 0,0
Ccc_XD4_XDFFQ_S_XFRT_S XD4_XDFFQ_S XFRT_S 1.8151e-17
* device instance cc_XD4_XDFFQ_S_XFRT_SB r0 *1 0,0
Ccc_XD4_XDFFQ_S_XFRT_SB XD4_XDFFQ_S XFRT_SB 1.8151e-17
* device instance cc_XD4_XDFFQ_S_ck1 r0 *1 0,0
Ccc_XD4_XDFFQ_S_ck1 XD4_XDFFQ_S ck1 5.4452e-17
* device instance cc_XD4_XDFFQ_S_ck2 r0 *1 0,0
Ccc_XD4_XDFFQ_S_ck2 XD4_XDFFQ_S ck2 5.4452e-17
* device instance cc_XD4_XDFFQ_S_ck3 r0 *1 0,0
Ccc_XD4_XDFFQ_S_ck3 XD4_XDFFQ_S ck3 5.4452e-17
* device instance cc_XD4_XDFFQ_S_ck4 r0 *1 0,0
Ccc_XD4_XDFFQ_S_ck4 XD4_XDFFQ_S ck4 5.4452e-17
* device instance cc_XD4_XDFFQ_S_ck5 r0 *1 0,0
Ccc_XD4_XDFFQ_S_ck5 XD4_XDFFQ_S ck5 5.4452e-17
* device instance cc_XD4_XDFFQ_S_mod0 r0 *1 0,0
Ccc_XD4_XDFFQ_S_mod0 XD4_XDFFQ_S mod0 2.4201e-17
* device instance cc_XD4_XDFFQ_S_mod1 r0 *1 0,0
Ccc_XD4_XDFFQ_S_mod1 XD4_XDFFQ_S mod1 2.4201e-17
* device instance cc_XD4_XDFFQ_S_mod2 r0 *1 0,0
Ccc_XD4_XDFFQ_S_mod2 XD4_XDFFQ_S mod2 2.4201e-17
* device instance cc_XD4_XDFFQ_S_mod3 r0 *1 0,0
Ccc_XD4_XDFFQ_S_mod3 XD4_XDFFQ_S mod3 2.4201e-17
* device instance cc_XD4_XDFFQ_S_mod4 r0 *1 0,0
Ccc_XD4_XDFFQ_S_mod4 XD4_XDFFQ_S mod4 2.4201e-17
* device instance cc_XD4_XDFFQ_S_net1 r0 *1 0,0
Ccc_XD4_XDFFQ_S_net1 XD4_XDFFQ_S net1 1.21e-17
* device instance cc_XD4_XDFFQ_SB_XD4_XN2_mid1 r0 *1 0,0
Ccc_XD4_XDFFQ_SB_XD4_XN2_mid1 XD4_XDFFQ_SB XD4_XN2_mid1 1.21e-17
* device instance cc_XD4_XDFFQ_SB_XD4_XNOR_midp r0 *1 0,0
Ccc_XD4_XDFFQ_SB_XD4_XNOR_midp XD4_XDFFQ_SB XD4_XNOR_midp 1.21e-17
* device instance cc_XD4_XDFFQ_SB_XD4_dmodout r0 *1 0,0
Ccc_XD4_XDFFQ_SB_XD4_dmodout XD4_XDFFQ_SB XD4_dmodout 1.21e-17
* device instance cc_XD4_XDFFQ_SB_XD4_dq r0 *1 0,0
Ccc_XD4_XDFFQ_SB_XD4_dq XD4_XDFFQ_SB XD4_dq 1.21e-17
* device instance cc_XD4_XDFFQ_SB_XD4_nm r0 *1 0,0
Ccc_XD4_XDFFQ_SB_XD4_nm XD4_XDFFQ_SB XD4_nm 1.21e-17
* device instance cc_XD4_XDFFQ_SB_XD4_nt r0 *1 0,0
Ccc_XD4_XDFFQ_SB_XD4_nt XD4_XDFFQ_SB XD4_nt 2.4201e-17
* device instance cc_XD4_XDFFQ_SB_XD4_t1 r0 *1 0,0
Ccc_XD4_XDFFQ_SB_XD4_t1 XD4_XDFFQ_SB XD4_t1 1.21e-17
* device instance cc_XD4_XDFFQ_SB_XD5_XDFFM_CLKB r0 *1 0,0
Ccc_XD4_XDFFQ_SB_XD5_XDFFM_CLKB XD4_XDFFQ_SB XD5_XDFFM_CLKB 1.8151e-17
* device instance cc_XD4_XDFFQ_SB_XD5_XDFFM_M r0 *1 0,0
Ccc_XD4_XDFFQ_SB_XD5_XDFFM_M XD4_XDFFQ_SB XD5_XDFFM_M 2.4201e-17
* device instance cc_XD4_XDFFQ_SB_XD5_XDFFM_MB r0 *1 0,0
Ccc_XD4_XDFFQ_SB_XD5_XDFFM_MB XD4_XDFFQ_SB XD5_XDFFM_MB 1.21e-17
* device instance cc_XD4_XDFFQ_SB_XD5_XDFFM_S r0 *1 0,0
Ccc_XD4_XDFFQ_SB_XD5_XDFFM_S XD4_XDFFQ_SB XD5_XDFFM_S 1.8151e-17
* device instance cc_XD4_XDFFQ_SB_XD5_XDFFM_SB r0 *1 0,0
Ccc_XD4_XDFFQ_SB_XD5_XDFFM_SB XD4_XDFFQ_SB XD5_XDFFM_SB 1.8151e-17
* device instance cc_XD4_XDFFQ_SB_XD5_XDFFQ_CLKB r0 *1 0,0
Ccc_XD4_XDFFQ_SB_XD5_XDFFQ_CLKB XD4_XDFFQ_SB XD5_XDFFQ_CLKB 1.8151e-17
* device instance cc_XD4_XDFFQ_SB_XD5_XDFFQ_M r0 *1 0,0
Ccc_XD4_XDFFQ_SB_XD5_XDFFQ_M XD4_XDFFQ_SB XD5_XDFFQ_M 2.4201e-17
* device instance cc_XD4_XDFFQ_SB_XD5_XDFFQ_MB r0 *1 0,0
Ccc_XD4_XDFFQ_SB_XD5_XDFFQ_MB XD4_XDFFQ_SB XD5_XDFFQ_MB 1.21e-17
* device instance cc_XD4_XDFFQ_SB_XD5_XDFFQ_S r0 *1 0,0
Ccc_XD4_XDFFQ_SB_XD5_XDFFQ_S XD4_XDFFQ_SB XD5_XDFFQ_S 1.8151e-17
* device instance cc_XD4_XDFFQ_SB_XD5_XDFFQ_SB r0 *1 0,0
Ccc_XD4_XDFFQ_SB_XD5_XDFFQ_SB XD4_XDFFQ_SB XD5_XDFFQ_SB 1.8151e-17
* device instance cc_XD4_XDFFQ_SB_XD5_XN2_mid1 r0 *1 0,0
Ccc_XD4_XDFFQ_SB_XD5_XN2_mid1 XD4_XDFFQ_SB XD5_XN2_mid1 1.21e-17
* device instance cc_XD4_XDFFQ_SB_XD5_XN3_mid1 r0 *1 0,0
Ccc_XD4_XDFFQ_SB_XD5_XN3_mid1 XD4_XDFFQ_SB XD5_XN3_mid1 1.21e-17
* device instance cc_XD4_XDFFQ_SB_XD5_XN3_mid2 r0 *1 0,0
Ccc_XD4_XDFFQ_SB_XD5_XN3_mid2 XD4_XDFFQ_SB XD5_XN3_mid2 1.21e-17
* device instance cc_XD4_XDFFQ_SB_XD5_dmodout r0 *1 0,0
Ccc_XD4_XDFFQ_SB_XD5_dmodout XD4_XDFFQ_SB XD5_dmodout 1.21e-17
* device instance cc_XD4_XDFFQ_SB_XD5_dq r0 *1 0,0
Ccc_XD4_XDFFQ_SB_XD5_dq XD4_XDFFQ_SB XD5_dq 1.8151e-17
* device instance cc_XD4_XDFFQ_SB_XD5_nm r0 *1 0,0
Ccc_XD4_XDFFQ_SB_XD5_nm XD4_XDFFQ_SB XD5_nm 1.21e-17
* device instance cc_XD4_XDFFQ_SB_XD5_nt r0 *1 0,0
Ccc_XD4_XDFFQ_SB_XD5_nt XD4_XDFFQ_SB XD5_nt 1.21e-17
* device instance cc_XD4_XDFFQ_SB_XD5_t1 r0 *1 0,0
Ccc_XD4_XDFFQ_SB_XD5_t1 XD4_XDFFQ_SB XD5_t1 1.21e-17
* device instance cc_XD4_XDFFQ_SB_XFRT_CLKB r0 *1 0,0
Ccc_XD4_XDFFQ_SB_XFRT_CLKB XD4_XDFFQ_SB XFRT_CLKB 1.8151e-17
* device instance cc_XD4_XDFFQ_SB_XFRT_M r0 *1 0,0
Ccc_XD4_XDFFQ_SB_XFRT_M XD4_XDFFQ_SB XFRT_M 2.4201e-17
* device instance cc_XD4_XDFFQ_SB_XFRT_MB r0 *1 0,0
Ccc_XD4_XDFFQ_SB_XFRT_MB XD4_XDFFQ_SB XFRT_MB 1.21e-17
* device instance cc_XD4_XDFFQ_SB_XFRT_S r0 *1 0,0
Ccc_XD4_XDFFQ_SB_XFRT_S XD4_XDFFQ_SB XFRT_S 1.8151e-17
* device instance cc_XD4_XDFFQ_SB_XFRT_SB r0 *1 0,0
Ccc_XD4_XDFFQ_SB_XFRT_SB XD4_XDFFQ_SB XFRT_SB 1.8151e-17
* device instance cc_XD4_XDFFQ_SB_ck1 r0 *1 0,0
Ccc_XD4_XDFFQ_SB_ck1 XD4_XDFFQ_SB ck1 5.4452e-17
* device instance cc_XD4_XDFFQ_SB_ck2 r0 *1 0,0
Ccc_XD4_XDFFQ_SB_ck2 XD4_XDFFQ_SB ck2 5.4452e-17
* device instance cc_XD4_XDFFQ_SB_ck3 r0 *1 0,0
Ccc_XD4_XDFFQ_SB_ck3 XD4_XDFFQ_SB ck3 5.4452e-17
* device instance cc_XD4_XDFFQ_SB_ck4 r0 *1 0,0
Ccc_XD4_XDFFQ_SB_ck4 XD4_XDFFQ_SB ck4 5.4452e-17
* device instance cc_XD4_XDFFQ_SB_ck5 r0 *1 0,0
Ccc_XD4_XDFFQ_SB_ck5 XD4_XDFFQ_SB ck5 5.4452e-17
* device instance cc_XD4_XDFFQ_SB_mod0 r0 *1 0,0
Ccc_XD4_XDFFQ_SB_mod0 XD4_XDFFQ_SB mod0 2.4201e-17
* device instance cc_XD4_XDFFQ_SB_mod1 r0 *1 0,0
Ccc_XD4_XDFFQ_SB_mod1 XD4_XDFFQ_SB mod1 2.4201e-17
* device instance cc_XD4_XDFFQ_SB_mod2 r0 *1 0,0
Ccc_XD4_XDFFQ_SB_mod2 XD4_XDFFQ_SB mod2 2.4201e-17
* device instance cc_XD4_XDFFQ_SB_mod3 r0 *1 0,0
Ccc_XD4_XDFFQ_SB_mod3 XD4_XDFFQ_SB mod3 2.4201e-17
* device instance cc_XD4_XDFFQ_SB_mod4 r0 *1 0,0
Ccc_XD4_XDFFQ_SB_mod4 XD4_XDFFQ_SB mod4 2.4201e-17
* device instance cc_XD4_XDFFQ_SB_net1 r0 *1 0,0
Ccc_XD4_XDFFQ_SB_net1 XD4_XDFFQ_SB net1 1.21e-17
* device instance cc_XD4_XN2_mid1_XD4_nm r0 *1 0,0
Ccc_XD4_XN2_mid1_XD4_nm XD4_XN2_mid1 XD4_nm 1.1294e-17
* device instance cc_XD4_XN2_mid1_ck5 r0 *1 0,0
Ccc_XD4_XN2_mid1_ck5 XD4_XN2_mid1 ck5 6.05e-18
* device instance cc_XD4_XN3_mid1_XD4_XN3_mid2 r0 *1 0,0
Ccc_XD4_XN3_mid1_XD4_XN3_mid2 XD4_XN3_mid1 XD4_XN3_mid2 1.1294e-17
* device instance cc_XD4_XN3_mid1_XD4_nt r0 *1 0,0
Ccc_XD4_XN3_mid1_XD4_nt XD4_XN3_mid1 XD4_nt 1.1294e-17
* device instance cc_XD4_XN3_mid2_mod3 r0 *1 0,0
Ccc_XD4_XN3_mid2_mod3 XD4_XN3_mid2 mod3 6.05e-18
* device instance cc_XD4_XNOR_midp_XD4_dq r0 *1 0,0
Ccc_XD4_XNOR_midp_XD4_dq XD4_XNOR_midp XD4_dq 5.244e-18
* device instance cc_XD4_XNOR_midp_XD4_t1 r0 *1 0,0
Ccc_XD4_XNOR_midp_XD4_t1 XD4_XNOR_midp XD4_t1 6.05e-18
* device instance cc_XD4_dmodout_XD4_dq r0 *1 0,0
Ccc_XD4_dmodout_XD4_dq XD4_dmodout XD4_dq 1.21e-17
* device instance cc_XD4_dmodout_XD4_nm r0 *1 0,0
Ccc_XD4_dmodout_XD4_nm XD4_dmodout XD4_nm 1.8151e-17
* device instance cc_XD4_dmodout_XD4_nt r0 *1 0,0
Ccc_XD4_dmodout_XD4_nt XD4_dmodout XD4_nt 2.4201e-17
* device instance cc_XD4_dmodout_XD4_t1 r0 *1 0,0
Ccc_XD4_dmodout_XD4_t1 XD4_dmodout XD4_t1 1.21e-17
* device instance cc_XD4_dmodout_XD5_XDFFM_CLKB r0 *1 0,0
Ccc_XD4_dmodout_XD5_XDFFM_CLKB XD4_dmodout XD5_XDFFM_CLKB 1.8151e-17
* device instance cc_XD4_dmodout_XD5_XDFFM_M r0 *1 0,0
Ccc_XD4_dmodout_XD5_XDFFM_M XD4_dmodout XD5_XDFFM_M 2.4201e-17
* device instance cc_XD4_dmodout_XD5_XDFFM_MB r0 *1 0,0
Ccc_XD4_dmodout_XD5_XDFFM_MB XD4_dmodout XD5_XDFFM_MB 1.21e-17
* device instance cc_XD4_dmodout_XD5_XDFFM_S r0 *1 0,0
Ccc_XD4_dmodout_XD5_XDFFM_S XD4_dmodout XD5_XDFFM_S 1.8151e-17
* device instance cc_XD4_dmodout_XD5_XDFFM_SB r0 *1 0,0
Ccc_XD4_dmodout_XD5_XDFFM_SB XD4_dmodout XD5_XDFFM_SB 1.8151e-17
* device instance cc_XD4_dmodout_XD5_XDFFQ_CLKB r0 *1 0,0
Ccc_XD4_dmodout_XD5_XDFFQ_CLKB XD4_dmodout XD5_XDFFQ_CLKB 1.8151e-17
* device instance cc_XD4_dmodout_XD5_XDFFQ_M r0 *1 0,0
Ccc_XD4_dmodout_XD5_XDFFQ_M XD4_dmodout XD5_XDFFQ_M 2.4201e-17
* device instance cc_XD4_dmodout_XD5_XDFFQ_MB r0 *1 0,0
Ccc_XD4_dmodout_XD5_XDFFQ_MB XD4_dmodout XD5_XDFFQ_MB 1.21e-17
* device instance cc_XD4_dmodout_XD5_XDFFQ_S r0 *1 0,0
Ccc_XD4_dmodout_XD5_XDFFQ_S XD4_dmodout XD5_XDFFQ_S 1.8151e-17
* device instance cc_XD4_dmodout_XD5_XDFFQ_SB r0 *1 0,0
Ccc_XD4_dmodout_XD5_XDFFQ_SB XD4_dmodout XD5_XDFFQ_SB 1.8151e-17
* device instance cc_XD4_dmodout_XD5_XN2_mid1 r0 *1 0,0
Ccc_XD4_dmodout_XD5_XN2_mid1 XD4_dmodout XD5_XN2_mid1 1.21e-17
* device instance cc_XD4_dmodout_XD5_XN3_mid1 r0 *1 0,0
Ccc_XD4_dmodout_XD5_XN3_mid1 XD4_dmodout XD5_XN3_mid1 1.21e-17
* device instance cc_XD4_dmodout_XD5_XN3_mid2 r0 *1 0,0
Ccc_XD4_dmodout_XD5_XN3_mid2 XD4_dmodout XD5_XN3_mid2 1.21e-17
* device instance cc_XD4_dmodout_XD5_dmodout r0 *1 0,0
Ccc_XD4_dmodout_XD5_dmodout XD4_dmodout XD5_dmodout 1.21e-17
* device instance cc_XD4_dmodout_XD5_dq r0 *1 0,0
Ccc_XD4_dmodout_XD5_dq XD4_dmodout XD5_dq 1.8151e-17
* device instance cc_XD4_dmodout_XD5_nm r0 *1 0,0
Ccc_XD4_dmodout_XD5_nm XD4_dmodout XD5_nm 1.21e-17
* device instance cc_XD4_dmodout_XD5_nt r0 *1 0,0
Ccc_XD4_dmodout_XD5_nt XD4_dmodout XD5_nt 1.21e-17
* device instance cc_XD4_dmodout_XD5_t1 r0 *1 0,0
Ccc_XD4_dmodout_XD5_t1 XD4_dmodout XD5_t1 1.21e-17
* device instance cc_XD4_dmodout_XFRT_CLKB r0 *1 0,0
Ccc_XD4_dmodout_XFRT_CLKB XD4_dmodout XFRT_CLKB 1.8151e-17
* device instance cc_XD4_dmodout_XFRT_M r0 *1 0,0
Ccc_XD4_dmodout_XFRT_M XD4_dmodout XFRT_M 2.4201e-17
* device instance cc_XD4_dmodout_XFRT_MB r0 *1 0,0
Ccc_XD4_dmodout_XFRT_MB XD4_dmodout XFRT_MB 1.21e-17
* device instance cc_XD4_dmodout_XFRT_S r0 *1 0,0
Ccc_XD4_dmodout_XFRT_S XD4_dmodout XFRT_S 1.8151e-17
* device instance cc_XD4_dmodout_XFRT_SB r0 *1 0,0
Ccc_XD4_dmodout_XFRT_SB XD4_dmodout XFRT_SB 1.8151e-17
* device instance cc_XD4_dmodout_ck1 r0 *1 0,0
Ccc_XD4_dmodout_ck1 XD4_dmodout ck1 5.4452e-17
* device instance cc_XD4_dmodout_ck2 r0 *1 0,0
Ccc_XD4_dmodout_ck2 XD4_dmodout ck2 5.4452e-17
* device instance cc_XD4_dmodout_ck3 r0 *1 0,0
Ccc_XD4_dmodout_ck3 XD4_dmodout ck3 5.4452e-17
* device instance cc_XD4_dmodout_ck4 r0 *1 0,0
Ccc_XD4_dmodout_ck4 XD4_dmodout ck4 6.6553e-17
* device instance cc_XD4_dmodout_ck5 r0 *1 0,0
Ccc_XD4_dmodout_ck5 XD4_dmodout ck5 5.4452e-17
* device instance cc_XD4_dmodout_mod0 r0 *1 0,0
Ccc_XD4_dmodout_mod0 XD4_dmodout mod0 2.4201e-17
* device instance cc_XD4_dmodout_mod1 r0 *1 0,0
Ccc_XD4_dmodout_mod1 XD4_dmodout mod1 2.4201e-17
* device instance cc_XD4_dmodout_mod2 r0 *1 0,0
Ccc_XD4_dmodout_mod2 XD4_dmodout mod2 2.4201e-17
* device instance cc_XD4_dmodout_mod3 r0 *1 0,0
Ccc_XD4_dmodout_mod3 XD4_dmodout mod3 2.4201e-17
* device instance cc_XD4_dmodout_mod4 r0 *1 0,0
Ccc_XD4_dmodout_mod4 XD4_dmodout mod4 2.4201e-17
* device instance cc_XD4_dmodout_net1 r0 *1 0,0
Ccc_XD4_dmodout_net1 XD4_dmodout net1 1.21e-17
* device instance cc_XD4_dq_XD4_nm r0 *1 0,0
Ccc_XD4_dq_XD4_nm XD4_dq XD4_nm 1.21e-17
* device instance cc_XD4_dq_XD4_nt r0 *1 0,0
Ccc_XD4_dq_XD4_nt XD4_dq XD4_nt 2.4201e-17
* device instance cc_XD4_dq_XD4_t1 r0 *1 0,0
Ccc_XD4_dq_XD4_t1 XD4_dq XD4_t1 1.8151e-17
* device instance cc_XD4_dq_XD5_XDFFM_CLKB r0 *1 0,0
Ccc_XD4_dq_XD5_XDFFM_CLKB XD4_dq XD5_XDFFM_CLKB 1.8151e-17
* device instance cc_XD4_dq_XD5_XDFFM_M r0 *1 0,0
Ccc_XD4_dq_XD5_XDFFM_M XD4_dq XD5_XDFFM_M 2.4201e-17
* device instance cc_XD4_dq_XD5_XDFFM_MB r0 *1 0,0
Ccc_XD4_dq_XD5_XDFFM_MB XD4_dq XD5_XDFFM_MB 1.21e-17
* device instance cc_XD4_dq_XD5_XDFFM_S r0 *1 0,0
Ccc_XD4_dq_XD5_XDFFM_S XD4_dq XD5_XDFFM_S 1.8151e-17
* device instance cc_XD4_dq_XD5_XDFFM_SB r0 *1 0,0
Ccc_XD4_dq_XD5_XDFFM_SB XD4_dq XD5_XDFFM_SB 1.8151e-17
* device instance cc_XD4_dq_XD5_XDFFQ_CLKB r0 *1 0,0
Ccc_XD4_dq_XD5_XDFFQ_CLKB XD4_dq XD5_XDFFQ_CLKB 1.8151e-17
* device instance cc_XD4_dq_XD5_XDFFQ_M r0 *1 0,0
Ccc_XD4_dq_XD5_XDFFQ_M XD4_dq XD5_XDFFQ_M 2.4201e-17
* device instance cc_XD4_dq_XD5_XDFFQ_MB r0 *1 0,0
Ccc_XD4_dq_XD5_XDFFQ_MB XD4_dq XD5_XDFFQ_MB 1.21e-17
* device instance cc_XD4_dq_XD5_XDFFQ_S r0 *1 0,0
Ccc_XD4_dq_XD5_XDFFQ_S XD4_dq XD5_XDFFQ_S 1.8151e-17
* device instance cc_XD4_dq_XD5_XDFFQ_SB r0 *1 0,0
Ccc_XD4_dq_XD5_XDFFQ_SB XD4_dq XD5_XDFFQ_SB 1.8151e-17
* device instance cc_XD4_dq_XD5_XN2_mid1 r0 *1 0,0
Ccc_XD4_dq_XD5_XN2_mid1 XD4_dq XD5_XN2_mid1 1.21e-17
* device instance cc_XD4_dq_XD5_XN3_mid1 r0 *1 0,0
Ccc_XD4_dq_XD5_XN3_mid1 XD4_dq XD5_XN3_mid1 1.21e-17
* device instance cc_XD4_dq_XD5_XN3_mid2 r0 *1 0,0
Ccc_XD4_dq_XD5_XN3_mid2 XD4_dq XD5_XN3_mid2 1.21e-17
* device instance cc_XD4_dq_XD5_dmodout r0 *1 0,0
Ccc_XD4_dq_XD5_dmodout XD4_dq XD5_dmodout 1.21e-17
* device instance cc_XD4_dq_XD5_dq r0 *1 0,0
Ccc_XD4_dq_XD5_dq XD4_dq XD5_dq 1.8151e-17
* device instance cc_XD4_dq_XD5_nm r0 *1 0,0
Ccc_XD4_dq_XD5_nm XD4_dq XD5_nm 1.21e-17
* device instance cc_XD4_dq_XD5_nt r0 *1 0,0
Ccc_XD4_dq_XD5_nt XD4_dq XD5_nt 1.21e-17
* device instance cc_XD4_dq_XD5_t1 r0 *1 0,0
Ccc_XD4_dq_XD5_t1 XD4_dq XD5_t1 1.21e-17
* device instance cc_XD4_dq_XFRT_CLKB r0 *1 0,0
Ccc_XD4_dq_XFRT_CLKB XD4_dq XFRT_CLKB 1.8151e-17
* device instance cc_XD4_dq_XFRT_M r0 *1 0,0
Ccc_XD4_dq_XFRT_M XD4_dq XFRT_M 2.4201e-17
* device instance cc_XD4_dq_XFRT_MB r0 *1 0,0
Ccc_XD4_dq_XFRT_MB XD4_dq XFRT_MB 1.21e-17
* device instance cc_XD4_dq_XFRT_S r0 *1 0,0
Ccc_XD4_dq_XFRT_S XD4_dq XFRT_S 1.8151e-17
* device instance cc_XD4_dq_XFRT_SB r0 *1 0,0
Ccc_XD4_dq_XFRT_SB XD4_dq XFRT_SB 1.8151e-17
* device instance cc_XD4_dq_ck1 r0 *1 0,0
Ccc_XD4_dq_ck1 XD4_dq ck1 5.4452e-17
* device instance cc_XD4_dq_ck2 r0 *1 0,0
Ccc_XD4_dq_ck2 XD4_dq ck2 5.4452e-17
* device instance cc_XD4_dq_ck3 r0 *1 0,0
Ccc_XD4_dq_ck3 XD4_dq ck3 5.4452e-17
* device instance cc_XD4_dq_ck4 r0 *1 0,0
Ccc_XD4_dq_ck4 XD4_dq ck4 6.6553e-17
* device instance cc_XD4_dq_ck5 r0 *1 0,0
Ccc_XD4_dq_ck5 XD4_dq ck5 5.4452e-17
* device instance cc_XD4_dq_mod0 r0 *1 0,0
Ccc_XD4_dq_mod0 XD4_dq mod0 2.4201e-17
* device instance cc_XD4_dq_mod1 r0 *1 0,0
Ccc_XD4_dq_mod1 XD4_dq mod1 2.4201e-17
* device instance cc_XD4_dq_mod2 r0 *1 0,0
Ccc_XD4_dq_mod2 XD4_dq mod2 2.4201e-17
* device instance cc_XD4_dq_mod3 r0 *1 0,0
Ccc_XD4_dq_mod3 XD4_dq mod3 2.4201e-17
* device instance cc_XD4_dq_mod4 r0 *1 0,0
Ccc_XD4_dq_mod4 XD4_dq mod4 2.4201e-17
* device instance cc_XD4_dq_net1 r0 *1 0,0
Ccc_XD4_dq_net1 XD4_dq net1 1.21e-17
* device instance cc_XD4_nm_XD4_nt r0 *1 0,0
Ccc_XD4_nm_XD4_nt XD4_nm XD4_nt 2.4201e-17
* device instance cc_XD4_nm_XD4_t1 r0 *1 0,0
Ccc_XD4_nm_XD4_t1 XD4_nm XD4_t1 1.21e-17
* device instance cc_XD4_nm_XD5_XDFFM_CLKB r0 *1 0,0
Ccc_XD4_nm_XD5_XDFFM_CLKB XD4_nm XD5_XDFFM_CLKB 1.8151e-17
* device instance cc_XD4_nm_XD5_XDFFM_M r0 *1 0,0
Ccc_XD4_nm_XD5_XDFFM_M XD4_nm XD5_XDFFM_M 2.4201e-17
* device instance cc_XD4_nm_XD5_XDFFM_MB r0 *1 0,0
Ccc_XD4_nm_XD5_XDFFM_MB XD4_nm XD5_XDFFM_MB 1.21e-17
* device instance cc_XD4_nm_XD5_XDFFM_S r0 *1 0,0
Ccc_XD4_nm_XD5_XDFFM_S XD4_nm XD5_XDFFM_S 1.8151e-17
* device instance cc_XD4_nm_XD5_XDFFM_SB r0 *1 0,0
Ccc_XD4_nm_XD5_XDFFM_SB XD4_nm XD5_XDFFM_SB 1.8151e-17
* device instance cc_XD4_nm_XD5_XDFFQ_CLKB r0 *1 0,0
Ccc_XD4_nm_XD5_XDFFQ_CLKB XD4_nm XD5_XDFFQ_CLKB 1.8151e-17
* device instance cc_XD4_nm_XD5_XDFFQ_M r0 *1 0,0
Ccc_XD4_nm_XD5_XDFFQ_M XD4_nm XD5_XDFFQ_M 2.4201e-17
* device instance cc_XD4_nm_XD5_XDFFQ_MB r0 *1 0,0
Ccc_XD4_nm_XD5_XDFFQ_MB XD4_nm XD5_XDFFQ_MB 1.21e-17
* device instance cc_XD4_nm_XD5_XDFFQ_S r0 *1 0,0
Ccc_XD4_nm_XD5_XDFFQ_S XD4_nm XD5_XDFFQ_S 1.8151e-17
* device instance cc_XD4_nm_XD5_XDFFQ_SB r0 *1 0,0
Ccc_XD4_nm_XD5_XDFFQ_SB XD4_nm XD5_XDFFQ_SB 1.8151e-17
* device instance cc_XD4_nm_XD5_XN2_mid1 r0 *1 0,0
Ccc_XD4_nm_XD5_XN2_mid1 XD4_nm XD5_XN2_mid1 1.21e-17
* device instance cc_XD4_nm_XD5_XN3_mid1 r0 *1 0,0
Ccc_XD4_nm_XD5_XN3_mid1 XD4_nm XD5_XN3_mid1 1.21e-17
* device instance cc_XD4_nm_XD5_XN3_mid2 r0 *1 0,0
Ccc_XD4_nm_XD5_XN3_mid2 XD4_nm XD5_XN3_mid2 1.21e-17
* device instance cc_XD4_nm_XD5_dmodout r0 *1 0,0
Ccc_XD4_nm_XD5_dmodout XD4_nm XD5_dmodout 1.21e-17
* device instance cc_XD4_nm_XD5_dq r0 *1 0,0
Ccc_XD4_nm_XD5_dq XD4_nm XD5_dq 1.8151e-17
* device instance cc_XD4_nm_XD5_nm r0 *1 0,0
Ccc_XD4_nm_XD5_nm XD4_nm XD5_nm 1.21e-17
* device instance cc_XD4_nm_XD5_nt r0 *1 0,0
Ccc_XD4_nm_XD5_nt XD4_nm XD5_nt 1.21e-17
* device instance cc_XD4_nm_XD5_t1 r0 *1 0,0
Ccc_XD4_nm_XD5_t1 XD4_nm XD5_t1 1.21e-17
* device instance cc_XD4_nm_XFRT_CLKB r0 *1 0,0
Ccc_XD4_nm_XFRT_CLKB XD4_nm XFRT_CLKB 1.8151e-17
* device instance cc_XD4_nm_XFRT_M r0 *1 0,0
Ccc_XD4_nm_XFRT_M XD4_nm XFRT_M 2.4201e-17
* device instance cc_XD4_nm_XFRT_MB r0 *1 0,0
Ccc_XD4_nm_XFRT_MB XD4_nm XFRT_MB 1.21e-17
* device instance cc_XD4_nm_XFRT_S r0 *1 0,0
Ccc_XD4_nm_XFRT_S XD4_nm XFRT_S 1.8151e-17
* device instance cc_XD4_nm_XFRT_SB r0 *1 0,0
Ccc_XD4_nm_XFRT_SB XD4_nm XFRT_SB 1.8151e-17
* device instance cc_XD4_nm_ck1 r0 *1 0,0
Ccc_XD4_nm_ck1 XD4_nm ck1 5.4452e-17
* device instance cc_XD4_nm_ck2 r0 *1 0,0
Ccc_XD4_nm_ck2 XD4_nm ck2 5.4452e-17
* device instance cc_XD4_nm_ck3 r0 *1 0,0
Ccc_XD4_nm_ck3 XD4_nm ck3 5.4452e-17
* device instance cc_XD4_nm_ck4 r0 *1 0,0
Ccc_XD4_nm_ck4 XD4_nm ck4 5.4452e-17
* device instance cc_XD4_nm_ck5 r0 *1 0,0
Ccc_XD4_nm_ck5 XD4_nm ck5 6.0502e-17
* device instance cc_XD4_nm_mod0 r0 *1 0,0
Ccc_XD4_nm_mod0 XD4_nm mod0 2.4201e-17
* device instance cc_XD4_nm_mod1 r0 *1 0,0
Ccc_XD4_nm_mod1 XD4_nm mod1 2.4201e-17
* device instance cc_XD4_nm_mod2 r0 *1 0,0
Ccc_XD4_nm_mod2 XD4_nm mod2 2.4201e-17
* device instance cc_XD4_nm_mod3 r0 *1 0,0
Ccc_XD4_nm_mod3 XD4_nm mod3 2.4201e-17
* device instance cc_XD4_nm_mod4 r0 *1 0,0
Ccc_XD4_nm_mod4 XD4_nm mod4 2.4201e-17
* device instance cc_XD4_nm_net1 r0 *1 0,0
Ccc_XD4_nm_net1 XD4_nm net1 1.21e-17
* device instance cc_XD4_nt_XD4_t1 r0 *1 0,0
Ccc_XD4_nt_XD4_t1 XD4_nt XD4_t1 1.21e-17
* device instance cc_XD4_nt_XD5_XDFFM_CLKB r0 *1 0,0
Ccc_XD4_nt_XD5_XDFFM_CLKB XD4_nt XD5_XDFFM_CLKB 1.8151e-17
* device instance cc_XD4_nt_XD5_XDFFM_M r0 *1 0,0
Ccc_XD4_nt_XD5_XDFFM_M XD4_nt XD5_XDFFM_M 2.4201e-17
* device instance cc_XD4_nt_XD5_XDFFM_MB r0 *1 0,0
Ccc_XD4_nt_XD5_XDFFM_MB XD4_nt XD5_XDFFM_MB 1.21e-17
* device instance cc_XD4_nt_XD5_XDFFM_S r0 *1 0,0
Ccc_XD4_nt_XD5_XDFFM_S XD4_nt XD5_XDFFM_S 1.8151e-17
* device instance cc_XD4_nt_XD5_XDFFM_SB r0 *1 0,0
Ccc_XD4_nt_XD5_XDFFM_SB XD4_nt XD5_XDFFM_SB 1.8151e-17
* device instance cc_XD4_nt_XD5_XDFFQ_CLKB r0 *1 0,0
Ccc_XD4_nt_XD5_XDFFQ_CLKB XD4_nt XD5_XDFFQ_CLKB 1.8151e-17
* device instance cc_XD4_nt_XD5_XDFFQ_M r0 *1 0,0
Ccc_XD4_nt_XD5_XDFFQ_M XD4_nt XD5_XDFFQ_M 2.4201e-17
* device instance cc_XD4_nt_XD5_XDFFQ_MB r0 *1 0,0
Ccc_XD4_nt_XD5_XDFFQ_MB XD4_nt XD5_XDFFQ_MB 1.21e-17
* device instance cc_XD4_nt_XD5_XDFFQ_S r0 *1 0,0
Ccc_XD4_nt_XD5_XDFFQ_S XD4_nt XD5_XDFFQ_S 1.8151e-17
* device instance cc_XD4_nt_XD5_XDFFQ_SB r0 *1 0,0
Ccc_XD4_nt_XD5_XDFFQ_SB XD4_nt XD5_XDFFQ_SB 1.8151e-17
* device instance cc_XD4_nt_XD5_XN2_mid1 r0 *1 0,0
Ccc_XD4_nt_XD5_XN2_mid1 XD4_nt XD5_XN2_mid1 1.21e-17
* device instance cc_XD4_nt_XD5_XN3_mid1 r0 *1 0,0
Ccc_XD4_nt_XD5_XN3_mid1 XD4_nt XD5_XN3_mid1 1.21e-17
* device instance cc_XD4_nt_XD5_XN3_mid2 r0 *1 0,0
Ccc_XD4_nt_XD5_XN3_mid2 XD4_nt XD5_XN3_mid2 1.21e-17
* device instance cc_XD4_nt_XD5_dmodout r0 *1 0,0
Ccc_XD4_nt_XD5_dmodout XD4_nt XD5_dmodout 1.21e-17
* device instance cc_XD4_nt_XD5_dq r0 *1 0,0
Ccc_XD4_nt_XD5_dq XD4_nt XD5_dq 1.8151e-17
* device instance cc_XD4_nt_XD5_nm r0 *1 0,0
Ccc_XD4_nt_XD5_nm XD4_nt XD5_nm 1.21e-17
* device instance cc_XD4_nt_XD5_nt r0 *1 0,0
Ccc_XD4_nt_XD5_nt XD4_nt XD5_nt 1.21e-17
* device instance cc_XD4_nt_XD5_t1 r0 *1 0,0
Ccc_XD4_nt_XD5_t1 XD4_nt XD5_t1 1.21e-17
* device instance cc_XD4_nt_XFRT_CLKB r0 *1 0,0
Ccc_XD4_nt_XFRT_CLKB XD4_nt XFRT_CLKB 1.8151e-17
* device instance cc_XD4_nt_XFRT_M r0 *1 0,0
Ccc_XD4_nt_XFRT_M XD4_nt XFRT_M 2.4201e-17
* device instance cc_XD4_nt_XFRT_MB r0 *1 0,0
Ccc_XD4_nt_XFRT_MB XD4_nt XFRT_MB 1.21e-17
* device instance cc_XD4_nt_XFRT_S r0 *1 0,0
Ccc_XD4_nt_XFRT_S XD4_nt XFRT_S 1.8151e-17
* device instance cc_XD4_nt_XFRT_SB r0 *1 0,0
Ccc_XD4_nt_XFRT_SB XD4_nt XFRT_SB 1.8151e-17
* device instance cc_XD4_nt_ck1 r0 *1 0,0
Ccc_XD4_nt_ck1 XD4_nt ck1 5.4452e-17
* device instance cc_XD4_nt_ck2 r0 *1 0,0
Ccc_XD4_nt_ck2 XD4_nt ck2 5.4452e-17
* device instance cc_XD4_nt_ck3 r0 *1 0,0
Ccc_XD4_nt_ck3 XD4_nt ck3 5.4452e-17
* device instance cc_XD4_nt_ck4 r0 *1 0,0
Ccc_XD4_nt_ck4 XD4_nt ck4 5.4452e-17
* device instance cc_XD4_nt_ck5 r0 *1 0,0
Ccc_XD4_nt_ck5 XD4_nt ck5 5.4452e-17
* device instance cc_XD4_nt_mod0 r0 *1 0,0
Ccc_XD4_nt_mod0 XD4_nt mod0 2.4201e-17
* device instance cc_XD4_nt_mod1 r0 *1 0,0
Ccc_XD4_nt_mod1 XD4_nt mod1 2.4201e-17
* device instance cc_XD4_nt_mod2 r0 *1 0,0
Ccc_XD4_nt_mod2 XD4_nt mod2 2.4201e-17
* device instance cc_XD4_nt_mod3 r0 *1 0,0
Ccc_XD4_nt_mod3 XD4_nt mod3 3.0251e-17
* device instance cc_XD4_nt_mod4 r0 *1 0,0
Ccc_XD4_nt_mod4 XD4_nt mod4 2.4201e-17
* device instance cc_XD4_nt_net1 r0 *1 0,0
Ccc_XD4_nt_net1 XD4_nt net1 1.21e-17
* device instance cc_XD4_t1_XD5_XDFFM_CLKB r0 *1 0,0
Ccc_XD4_t1_XD5_XDFFM_CLKB XD4_t1 XD5_XDFFM_CLKB 1.8151e-17
* device instance cc_XD4_t1_XD5_XDFFM_M r0 *1 0,0
Ccc_XD4_t1_XD5_XDFFM_M XD4_t1 XD5_XDFFM_M 2.4201e-17
* device instance cc_XD4_t1_XD5_XDFFM_MB r0 *1 0,0
Ccc_XD4_t1_XD5_XDFFM_MB XD4_t1 XD5_XDFFM_MB 1.21e-17
* device instance cc_XD4_t1_XD5_XDFFM_S r0 *1 0,0
Ccc_XD4_t1_XD5_XDFFM_S XD4_t1 XD5_XDFFM_S 1.8151e-17
* device instance cc_XD4_t1_XD5_XDFFM_SB r0 *1 0,0
Ccc_XD4_t1_XD5_XDFFM_SB XD4_t1 XD5_XDFFM_SB 1.8151e-17
* device instance cc_XD4_t1_XD5_XDFFQ_CLKB r0 *1 0,0
Ccc_XD4_t1_XD5_XDFFQ_CLKB XD4_t1 XD5_XDFFQ_CLKB 1.8151e-17
* device instance cc_XD4_t1_XD5_XDFFQ_M r0 *1 0,0
Ccc_XD4_t1_XD5_XDFFQ_M XD4_t1 XD5_XDFFQ_M 2.4201e-17
* device instance cc_XD4_t1_XD5_XDFFQ_MB r0 *1 0,0
Ccc_XD4_t1_XD5_XDFFQ_MB XD4_t1 XD5_XDFFQ_MB 1.21e-17
* device instance cc_XD4_t1_XD5_XDFFQ_S r0 *1 0,0
Ccc_XD4_t1_XD5_XDFFQ_S XD4_t1 XD5_XDFFQ_S 1.8151e-17
* device instance cc_XD4_t1_XD5_XDFFQ_SB r0 *1 0,0
Ccc_XD4_t1_XD5_XDFFQ_SB XD4_t1 XD5_XDFFQ_SB 1.8151e-17
* device instance cc_XD4_t1_XD5_XN2_mid1 r0 *1 0,0
Ccc_XD4_t1_XD5_XN2_mid1 XD4_t1 XD5_XN2_mid1 1.21e-17
* device instance cc_XD4_t1_XD5_XN3_mid1 r0 *1 0,0
Ccc_XD4_t1_XD5_XN3_mid1 XD4_t1 XD5_XN3_mid1 1.21e-17
* device instance cc_XD4_t1_XD5_XN3_mid2 r0 *1 0,0
Ccc_XD4_t1_XD5_XN3_mid2 XD4_t1 XD5_XN3_mid2 1.21e-17
* device instance cc_XD4_t1_XD5_dmodout r0 *1 0,0
Ccc_XD4_t1_XD5_dmodout XD4_t1 XD5_dmodout 1.21e-17
* device instance cc_XD4_t1_XD5_dq r0 *1 0,0
Ccc_XD4_t1_XD5_dq XD4_t1 XD5_dq 1.8151e-17
* device instance cc_XD4_t1_XD5_nm r0 *1 0,0
Ccc_XD4_t1_XD5_nm XD4_t1 XD5_nm 1.21e-17
* device instance cc_XD4_t1_XD5_nt r0 *1 0,0
Ccc_XD4_t1_XD5_nt XD4_t1 XD5_nt 1.21e-17
* device instance cc_XD4_t1_XD5_t1 r0 *1 0,0
Ccc_XD4_t1_XD5_t1 XD4_t1 XD5_t1 1.21e-17
* device instance cc_XD4_t1_XFRT_CLKB r0 *1 0,0
Ccc_XD4_t1_XFRT_CLKB XD4_t1 XFRT_CLKB 1.8151e-17
* device instance cc_XD4_t1_XFRT_M r0 *1 0,0
Ccc_XD4_t1_XFRT_M XD4_t1 XFRT_M 2.4201e-17
* device instance cc_XD4_t1_XFRT_MB r0 *1 0,0
Ccc_XD4_t1_XFRT_MB XD4_t1 XFRT_MB 1.21e-17
* device instance cc_XD4_t1_XFRT_S r0 *1 0,0
Ccc_XD4_t1_XFRT_S XD4_t1 XFRT_S 1.8151e-17
* device instance cc_XD4_t1_XFRT_SB r0 *1 0,0
Ccc_XD4_t1_XFRT_SB XD4_t1 XFRT_SB 1.8151e-17
* device instance cc_XD4_t1_ck1 r0 *1 0,0
Ccc_XD4_t1_ck1 XD4_t1 ck1 5.4452e-17
* device instance cc_XD4_t1_ck2 r0 *1 0,0
Ccc_XD4_t1_ck2 XD4_t1 ck2 5.4452e-17
* device instance cc_XD4_t1_ck3 r0 *1 0,0
Ccc_XD4_t1_ck3 XD4_t1 ck3 5.4452e-17
* device instance cc_XD4_t1_ck4 r0 *1 0,0
Ccc_XD4_t1_ck4 XD4_t1 ck4 5.4452e-17
* device instance cc_XD4_t1_ck5 r0 *1 0,0
Ccc_XD4_t1_ck5 XD4_t1 ck5 6.0502e-17
* device instance cc_XD4_t1_mod0 r0 *1 0,0
Ccc_XD4_t1_mod0 XD4_t1 mod0 2.4201e-17
* device instance cc_XD4_t1_mod1 r0 *1 0,0
Ccc_XD4_t1_mod1 XD4_t1 mod1 2.4201e-17
* device instance cc_XD4_t1_mod2 r0 *1 0,0
Ccc_XD4_t1_mod2 XD4_t1 mod2 2.4201e-17
* device instance cc_XD4_t1_mod3 r0 *1 0,0
Ccc_XD4_t1_mod3 XD4_t1 mod3 2.4201e-17
* device instance cc_XD4_t1_mod4 r0 *1 0,0
Ccc_XD4_t1_mod4 XD4_t1 mod4 2.4201e-17
* device instance cc_XD4_t1_net1 r0 *1 0,0
Ccc_XD4_t1_net1 XD4_t1 net1 1.21e-17
* device instance cc_XD5_XDFFM_CLKB_XD5_XDFFM_M r0 *1 0,0
Ccc_XD5_XDFFM_CLKB_XD5_XDFFM_M XD5_XDFFM_CLKB XD5_XDFFM_M 4.2352e-17
* device instance cc_XD5_XDFFM_CLKB_XD5_XDFFM_MB r0 *1 0,0
Ccc_XD5_XDFFM_CLKB_XD5_XDFFM_MB XD5_XDFFM_CLKB XD5_XDFFM_MB 2.4201e-17
* device instance cc_XD5_XDFFM_CLKB_XD5_XDFFM_S r0 *1 0,0
Ccc_XD5_XDFFM_CLKB_XD5_XDFFM_S XD5_XDFFM_CLKB XD5_XDFFM_S 1.8151e-17
* device instance cc_XD5_XDFFM_CLKB_XD5_XDFFM_SB r0 *1 0,0
Ccc_XD5_XDFFM_CLKB_XD5_XDFFM_SB XD5_XDFFM_CLKB XD5_XDFFM_SB 1.8151e-17
* device instance cc_XD5_XDFFM_CLKB_XD5_XDFFQ_CLKB r0 *1 0,0
Ccc_XD5_XDFFM_CLKB_XD5_XDFFQ_CLKB XD5_XDFFM_CLKB XD5_XDFFQ_CLKB 1.8151e-17
* device instance cc_XD5_XDFFM_CLKB_XD5_XDFFQ_M r0 *1 0,0
Ccc_XD5_XDFFM_CLKB_XD5_XDFFQ_M XD5_XDFFM_CLKB XD5_XDFFQ_M 2.4201e-17
* device instance cc_XD5_XDFFM_CLKB_XD5_XDFFQ_MB r0 *1 0,0
Ccc_XD5_XDFFM_CLKB_XD5_XDFFQ_MB XD5_XDFFM_CLKB XD5_XDFFQ_MB 1.21e-17
* device instance cc_XD5_XDFFM_CLKB_XD5_XDFFQ_S r0 *1 0,0
Ccc_XD5_XDFFM_CLKB_XD5_XDFFQ_S XD5_XDFFM_CLKB XD5_XDFFQ_S 1.8151e-17
* device instance cc_XD5_XDFFM_CLKB_XD5_XDFFQ_SB r0 *1 0,0
Ccc_XD5_XDFFM_CLKB_XD5_XDFFQ_SB XD5_XDFFM_CLKB XD5_XDFFQ_SB 1.8151e-17
* device instance cc_XD5_XDFFM_CLKB_XD5_XNOR_midp r0 *1 0,0
Ccc_XD5_XDFFM_CLKB_XD5_XNOR_midp XD5_XDFFM_CLKB XD5_XNOR_midp 1.21e-17
* device instance cc_XD5_XDFFM_CLKB_XD5_dmodout r0 *1 0,0
Ccc_XD5_XDFFM_CLKB_XD5_dmodout XD5_XDFFM_CLKB XD5_dmodout 1.8151e-17
* device instance cc_XD5_XDFFM_CLKB_XD5_dq r0 *1 0,0
Ccc_XD5_XDFFM_CLKB_XD5_dq XD5_XDFFM_CLKB XD5_dq 1.21e-17
* device instance cc_XD5_XDFFM_CLKB_XD5_nm r0 *1 0,0
Ccc_XD5_XDFFM_CLKB_XD5_nm XD5_XDFFM_CLKB XD5_nm 1.8151e-17
* device instance cc_XD5_XDFFM_CLKB_XD5_nt r0 *1 0,0
Ccc_XD5_XDFFM_CLKB_XD5_nt XD5_XDFFM_CLKB XD5_nt 2.4201e-17
* device instance cc_XD5_XDFFM_CLKB_XD5_t1 r0 *1 0,0
Ccc_XD5_XDFFM_CLKB_XD5_t1 XD5_XDFFM_CLKB XD5_t1 1.21e-17
* device instance cc_XD5_XDFFM_CLKB_XFRT_CLKB r0 *1 0,0
Ccc_XD5_XDFFM_CLKB_XFRT_CLKB XD5_XDFFM_CLKB XFRT_CLKB 1.8151e-17
* device instance cc_XD5_XDFFM_CLKB_XFRT_M r0 *1 0,0
Ccc_XD5_XDFFM_CLKB_XFRT_M XD5_XDFFM_CLKB XFRT_M 2.4201e-17
* device instance cc_XD5_XDFFM_CLKB_XFRT_MB r0 *1 0,0
Ccc_XD5_XDFFM_CLKB_XFRT_MB XD5_XDFFM_CLKB XFRT_MB 1.21e-17
* device instance cc_XD5_XDFFM_CLKB_XFRT_S r0 *1 0,0
Ccc_XD5_XDFFM_CLKB_XFRT_S XD5_XDFFM_CLKB XFRT_S 1.8151e-17
* device instance cc_XD5_XDFFM_CLKB_XFRT_SB r0 *1 0,0
Ccc_XD5_XDFFM_CLKB_XFRT_SB XD5_XDFFM_CLKB XFRT_SB 1.8151e-17
* device instance cc_XD5_XDFFM_CLKB_ck1 r0 *1 0,0
Ccc_XD5_XDFFM_CLKB_ck1 XD5_XDFFM_CLKB ck1 5.4452e-17
* device instance cc_XD5_XDFFM_CLKB_ck2 r0 *1 0,0
Ccc_XD5_XDFFM_CLKB_ck2 XD5_XDFFM_CLKB ck2 5.4452e-17
* device instance cc_XD5_XDFFM_CLKB_ck3 r0 *1 0,0
Ccc_XD5_XDFFM_CLKB_ck3 XD5_XDFFM_CLKB ck3 5.4452e-17
* device instance cc_XD5_XDFFM_CLKB_ck4 r0 *1 0,0
Ccc_XD5_XDFFM_CLKB_ck4 XD5_XDFFM_CLKB ck4 5.4452e-17
* device instance cc_XD5_XDFFM_CLKB_ck5 r0 *1 0,0
Ccc_XD5_XDFFM_CLKB_ck5 XD5_XDFFM_CLKB ck5 6.0502e-17
* device instance cc_XD5_XDFFM_CLKB_mod0 r0 *1 0,0
Ccc_XD5_XDFFM_CLKB_mod0 XD5_XDFFM_CLKB mod0 2.4201e-17
* device instance cc_XD5_XDFFM_CLKB_mod1 r0 *1 0,0
Ccc_XD5_XDFFM_CLKB_mod1 XD5_XDFFM_CLKB mod1 2.4201e-17
* device instance cc_XD5_XDFFM_CLKB_mod2 r0 *1 0,0
Ccc_XD5_XDFFM_CLKB_mod2 XD5_XDFFM_CLKB mod2 2.4201e-17
* device instance cc_XD5_XDFFM_CLKB_mod3 r0 *1 0,0
Ccc_XD5_XDFFM_CLKB_mod3 XD5_XDFFM_CLKB mod3 2.4201e-17
* device instance cc_XD5_XDFFM_CLKB_mod4 r0 *1 0,0
Ccc_XD5_XDFFM_CLKB_mod4 XD5_XDFFM_CLKB mod4 2.4201e-17
* device instance cc_XD5_XDFFM_CLKB_net1 r0 *1 0,0
Ccc_XD5_XDFFM_CLKB_net1 XD5_XDFFM_CLKB net1 1.21e-17
* device instance cc_XD5_XDFFM_M_XD5_XDFFM_MB r0 *1 0,0
Ccc_XD5_XDFFM_M_XD5_XDFFM_MB XD5_XDFFM_M XD5_XDFFM_MB 3.4688e-17
* device instance cc_XD5_XDFFM_M_XD5_XDFFM_S r0 *1 0,0
Ccc_XD5_XDFFM_M_XD5_XDFFM_S XD5_XDFFM_M XD5_XDFFM_S 2.8638e-17
* device instance cc_XD5_XDFFM_M_XD5_XDFFM_SB r0 *1 0,0
Ccc_XD5_XDFFM_M_XD5_XDFFM_SB XD5_XDFFM_M XD5_XDFFM_SB 1.8151e-17
* device instance cc_XD5_XDFFM_M_XD5_XDFFQ_CLKB r0 *1 0,0
Ccc_XD5_XDFFM_M_XD5_XDFFQ_CLKB XD5_XDFFM_M XD5_XDFFQ_CLKB 1.8151e-17
* device instance cc_XD5_XDFFM_M_XD5_XDFFQ_M r0 *1 0,0
Ccc_XD5_XDFFM_M_XD5_XDFFQ_M XD5_XDFFM_M XD5_XDFFQ_M 2.4201e-17
* device instance cc_XD5_XDFFM_M_XD5_XDFFQ_MB r0 *1 0,0
Ccc_XD5_XDFFM_M_XD5_XDFFQ_MB XD5_XDFFM_M XD5_XDFFQ_MB 1.21e-17
* device instance cc_XD5_XDFFM_M_XD5_XDFFQ_S r0 *1 0,0
Ccc_XD5_XDFFM_M_XD5_XDFFQ_S XD5_XDFFM_M XD5_XDFFQ_S 1.8151e-17
* device instance cc_XD5_XDFFM_M_XD5_XDFFQ_SB r0 *1 0,0
Ccc_XD5_XDFFM_M_XD5_XDFFQ_SB XD5_XDFFM_M XD5_XDFFQ_SB 1.8151e-17
* device instance cc_XD5_XDFFM_M_XD5_XNOR_midp r0 *1 0,0
Ccc_XD5_XDFFM_M_XD5_XNOR_midp XD5_XDFFM_M XD5_XNOR_midp 1.21e-17
* device instance cc_XD5_XDFFM_M_XD5_dmodout r0 *1 0,0
Ccc_XD5_XDFFM_M_XD5_dmodout XD5_XDFFM_M XD5_dmodout 2.8638e-17
* device instance cc_XD5_XDFFM_M_XD5_dq r0 *1 0,0
Ccc_XD5_XDFFM_M_XD5_dq XD5_XDFFM_M XD5_dq 1.21e-17
* device instance cc_XD5_XDFFM_M_XD5_nm r0 *1 0,0
Ccc_XD5_XDFFM_M_XD5_nm XD5_XDFFM_M XD5_nm 1.8151e-17
* device instance cc_XD5_XDFFM_M_XD5_nt r0 *1 0,0
Ccc_XD5_XDFFM_M_XD5_nt XD5_XDFFM_M XD5_nt 2.4201e-17
* device instance cc_XD5_XDFFM_M_XD5_t1 r0 *1 0,0
Ccc_XD5_XDFFM_M_XD5_t1 XD5_XDFFM_M XD5_t1 1.21e-17
* device instance cc_XD5_XDFFM_M_XFRT_CLKB r0 *1 0,0
Ccc_XD5_XDFFM_M_XFRT_CLKB XD5_XDFFM_M XFRT_CLKB 1.8151e-17
* device instance cc_XD5_XDFFM_M_XFRT_M r0 *1 0,0
Ccc_XD5_XDFFM_M_XFRT_M XD5_XDFFM_M XFRT_M 2.4201e-17
* device instance cc_XD5_XDFFM_M_XFRT_MB r0 *1 0,0
Ccc_XD5_XDFFM_M_XFRT_MB XD5_XDFFM_M XFRT_MB 1.21e-17
* device instance cc_XD5_XDFFM_M_XFRT_S r0 *1 0,0
Ccc_XD5_XDFFM_M_XFRT_S XD5_XDFFM_M XFRT_S 1.8151e-17
* device instance cc_XD5_XDFFM_M_XFRT_SB r0 *1 0,0
Ccc_XD5_XDFFM_M_XFRT_SB XD5_XDFFM_M XFRT_SB 1.8151e-17
* device instance cc_XD5_XDFFM_M_ck1 r0 *1 0,0
Ccc_XD5_XDFFM_M_ck1 XD5_XDFFM_M ck1 5.4452e-17
* device instance cc_XD5_XDFFM_M_ck2 r0 *1 0,0
Ccc_XD5_XDFFM_M_ck2 XD5_XDFFM_M ck2 5.4452e-17
* device instance cc_XD5_XDFFM_M_ck3 r0 *1 0,0
Ccc_XD5_XDFFM_M_ck3 XD5_XDFFM_M ck3 5.4452e-17
* device instance cc_XD5_XDFFM_M_ck4 r0 *1 0,0
Ccc_XD5_XDFFM_M_ck4 XD5_XDFFM_M ck4 5.4452e-17
* device instance cc_XD5_XDFFM_M_ck5 r0 *1 0,0
Ccc_XD5_XDFFM_M_ck5 XD5_XDFFM_M ck5 6.0502e-17
* device instance cc_XD5_XDFFM_M_mod0 r0 *1 0,0
Ccc_XD5_XDFFM_M_mod0 XD5_XDFFM_M mod0 2.4201e-17
* device instance cc_XD5_XDFFM_M_mod1 r0 *1 0,0
Ccc_XD5_XDFFM_M_mod1 XD5_XDFFM_M mod1 2.4201e-17
* device instance cc_XD5_XDFFM_M_mod2 r0 *1 0,0
Ccc_XD5_XDFFM_M_mod2 XD5_XDFFM_M mod2 2.4201e-17
* device instance cc_XD5_XDFFM_M_mod3 r0 *1 0,0
Ccc_XD5_XDFFM_M_mod3 XD5_XDFFM_M mod3 2.4201e-17
* device instance cc_XD5_XDFFM_M_mod4 r0 *1 0,0
Ccc_XD5_XDFFM_M_mod4 XD5_XDFFM_M mod4 2.4201e-17
* device instance cc_XD5_XDFFM_M_net1 r0 *1 0,0
Ccc_XD5_XDFFM_M_net1 XD5_XDFFM_M net1 1.21e-17
* device instance cc_XD5_XDFFM_MB_XD5_XDFFM_S r0 *1 0,0
Ccc_XD5_XDFFM_MB_XD5_XDFFM_S XD5_XDFFM_MB XD5_XDFFM_S 1.8151e-17
* device instance cc_XD5_XDFFM_MB_XD5_XDFFM_SB r0 *1 0,0
Ccc_XD5_XDFFM_MB_XD5_XDFFM_SB XD5_XDFFM_MB XD5_XDFFM_SB 1.8151e-17
* device instance cc_XD5_XDFFM_MB_XD5_XDFFQ_CLKB r0 *1 0,0
Ccc_XD5_XDFFM_MB_XD5_XDFFQ_CLKB XD5_XDFFM_MB XD5_XDFFQ_CLKB 1.8151e-17
* device instance cc_XD5_XDFFM_MB_XD5_XDFFQ_M r0 *1 0,0
Ccc_XD5_XDFFM_MB_XD5_XDFFQ_M XD5_XDFFM_MB XD5_XDFFQ_M 2.4201e-17
* device instance cc_XD5_XDFFM_MB_XD5_XDFFQ_MB r0 *1 0,0
Ccc_XD5_XDFFM_MB_XD5_XDFFQ_MB XD5_XDFFM_MB XD5_XDFFQ_MB 1.21e-17
* device instance cc_XD5_XDFFM_MB_XD5_XDFFQ_S r0 *1 0,0
Ccc_XD5_XDFFM_MB_XD5_XDFFQ_S XD5_XDFFM_MB XD5_XDFFQ_S 1.8151e-17
* device instance cc_XD5_XDFFM_MB_XD5_XDFFQ_SB r0 *1 0,0
Ccc_XD5_XDFFM_MB_XD5_XDFFQ_SB XD5_XDFFM_MB XD5_XDFFQ_SB 1.8151e-17
* device instance cc_XD5_XDFFM_MB_XD5_XNOR_midp r0 *1 0,0
Ccc_XD5_XDFFM_MB_XD5_XNOR_midp XD5_XDFFM_MB XD5_XNOR_midp 1.21e-17
* device instance cc_XD5_XDFFM_MB_XD5_dmodout r0 *1 0,0
Ccc_XD5_XDFFM_MB_XD5_dmodout XD5_XDFFM_MB XD5_dmodout 1.21e-17
* device instance cc_XD5_XDFFM_MB_XD5_dq r0 *1 0,0
Ccc_XD5_XDFFM_MB_XD5_dq XD5_XDFFM_MB XD5_dq 1.21e-17
* device instance cc_XD5_XDFFM_MB_XD5_nm r0 *1 0,0
Ccc_XD5_XDFFM_MB_XD5_nm XD5_XDFFM_MB XD5_nm 1.8151e-17
* device instance cc_XD5_XDFFM_MB_XD5_nt r0 *1 0,0
Ccc_XD5_XDFFM_MB_XD5_nt XD5_XDFFM_MB XD5_nt 2.4201e-17
* device instance cc_XD5_XDFFM_MB_XD5_t1 r0 *1 0,0
Ccc_XD5_XDFFM_MB_XD5_t1 XD5_XDFFM_MB XD5_t1 1.21e-17
* device instance cc_XD5_XDFFM_MB_XFRT_CLKB r0 *1 0,0
Ccc_XD5_XDFFM_MB_XFRT_CLKB XD5_XDFFM_MB XFRT_CLKB 1.8151e-17
* device instance cc_XD5_XDFFM_MB_XFRT_M r0 *1 0,0
Ccc_XD5_XDFFM_MB_XFRT_M XD5_XDFFM_MB XFRT_M 2.4201e-17
* device instance cc_XD5_XDFFM_MB_XFRT_MB r0 *1 0,0
Ccc_XD5_XDFFM_MB_XFRT_MB XD5_XDFFM_MB XFRT_MB 1.21e-17
* device instance cc_XD5_XDFFM_MB_XFRT_S r0 *1 0,0
Ccc_XD5_XDFFM_MB_XFRT_S XD5_XDFFM_MB XFRT_S 1.8151e-17
* device instance cc_XD5_XDFFM_MB_XFRT_SB r0 *1 0,0
Ccc_XD5_XDFFM_MB_XFRT_SB XD5_XDFFM_MB XFRT_SB 1.8151e-17
* device instance cc_XD5_XDFFM_MB_ck1 r0 *1 0,0
Ccc_XD5_XDFFM_MB_ck1 XD5_XDFFM_MB ck1 5.4452e-17
* device instance cc_XD5_XDFFM_MB_ck2 r0 *1 0,0
Ccc_XD5_XDFFM_MB_ck2 XD5_XDFFM_MB ck2 5.4452e-17
* device instance cc_XD5_XDFFM_MB_ck3 r0 *1 0,0
Ccc_XD5_XDFFM_MB_ck3 XD5_XDFFM_MB ck3 5.4452e-17
* device instance cc_XD5_XDFFM_MB_ck4 r0 *1 0,0
Ccc_XD5_XDFFM_MB_ck4 XD5_XDFFM_MB ck4 5.4452e-17
* device instance cc_XD5_XDFFM_MB_ck5 r0 *1 0,0
Ccc_XD5_XDFFM_MB_ck5 XD5_XDFFM_MB ck5 6.0502e-17
* device instance cc_XD5_XDFFM_MB_mod0 r0 *1 0,0
Ccc_XD5_XDFFM_MB_mod0 XD5_XDFFM_MB mod0 2.4201e-17
* device instance cc_XD5_XDFFM_MB_mod1 r0 *1 0,0
Ccc_XD5_XDFFM_MB_mod1 XD5_XDFFM_MB mod1 2.4201e-17
* device instance cc_XD5_XDFFM_MB_mod2 r0 *1 0,0
Ccc_XD5_XDFFM_MB_mod2 XD5_XDFFM_MB mod2 2.4201e-17
* device instance cc_XD5_XDFFM_MB_mod3 r0 *1 0,0
Ccc_XD5_XDFFM_MB_mod3 XD5_XDFFM_MB mod3 2.4201e-17
* device instance cc_XD5_XDFFM_MB_mod4 r0 *1 0,0
Ccc_XD5_XDFFM_MB_mod4 XD5_XDFFM_MB mod4 2.4201e-17
* device instance cc_XD5_XDFFM_MB_net1 r0 *1 0,0
Ccc_XD5_XDFFM_MB_net1 XD5_XDFFM_MB net1 1.21e-17
* device instance cc_XD5_XDFFM_S_XD5_XDFFM_SB r0 *1 0,0
Ccc_XD5_XDFFM_S_XD5_XDFFM_SB XD5_XDFFM_S XD5_XDFFM_SB 4.0738e-17
* device instance cc_XD5_XDFFM_S_XD5_XDFFQ_CLKB r0 *1 0,0
Ccc_XD5_XDFFM_S_XD5_XDFFQ_CLKB XD5_XDFFM_S XD5_XDFFQ_CLKB 1.8151e-17
* device instance cc_XD5_XDFFM_S_XD5_XDFFQ_M r0 *1 0,0
Ccc_XD5_XDFFM_S_XD5_XDFFQ_M XD5_XDFFM_S XD5_XDFFQ_M 2.4201e-17
* device instance cc_XD5_XDFFM_S_XD5_XDFFQ_MB r0 *1 0,0
Ccc_XD5_XDFFM_S_XD5_XDFFQ_MB XD5_XDFFM_S XD5_XDFFQ_MB 1.21e-17
* device instance cc_XD5_XDFFM_S_XD5_XDFFQ_S r0 *1 0,0
Ccc_XD5_XDFFM_S_XD5_XDFFQ_S XD5_XDFFM_S XD5_XDFFQ_S 1.8151e-17
* device instance cc_XD5_XDFFM_S_XD5_XDFFQ_SB r0 *1 0,0
Ccc_XD5_XDFFM_S_XD5_XDFFQ_SB XD5_XDFFM_S XD5_XDFFQ_SB 1.8151e-17
* device instance cc_XD5_XDFFM_S_XD5_XNOR_midp r0 *1 0,0
Ccc_XD5_XDFFM_S_XD5_XNOR_midp XD5_XDFFM_S XD5_XNOR_midp 1.21e-17
* device instance cc_XD5_XDFFM_S_XD5_dmodout r0 *1 0,0
Ccc_XD5_XDFFM_S_XD5_dmodout XD5_XDFFM_S XD5_dmodout 1.21e-17
* device instance cc_XD5_XDFFM_S_XD5_dq r0 *1 0,0
Ccc_XD5_XDFFM_S_XD5_dq XD5_XDFFM_S XD5_dq 1.21e-17
* device instance cc_XD5_XDFFM_S_XD5_nm r0 *1 0,0
Ccc_XD5_XDFFM_S_XD5_nm XD5_XDFFM_S XD5_nm 1.8151e-17
* device instance cc_XD5_XDFFM_S_XD5_nt r0 *1 0,0
Ccc_XD5_XDFFM_S_XD5_nt XD5_XDFFM_S XD5_nt 2.4201e-17
* device instance cc_XD5_XDFFM_S_XD5_t1 r0 *1 0,0
Ccc_XD5_XDFFM_S_XD5_t1 XD5_XDFFM_S XD5_t1 1.21e-17
* device instance cc_XD5_XDFFM_S_XFRT_CLKB r0 *1 0,0
Ccc_XD5_XDFFM_S_XFRT_CLKB XD5_XDFFM_S XFRT_CLKB 1.8151e-17
* device instance cc_XD5_XDFFM_S_XFRT_M r0 *1 0,0
Ccc_XD5_XDFFM_S_XFRT_M XD5_XDFFM_S XFRT_M 2.4201e-17
* device instance cc_XD5_XDFFM_S_XFRT_MB r0 *1 0,0
Ccc_XD5_XDFFM_S_XFRT_MB XD5_XDFFM_S XFRT_MB 1.21e-17
* device instance cc_XD5_XDFFM_S_XFRT_S r0 *1 0,0
Ccc_XD5_XDFFM_S_XFRT_S XD5_XDFFM_S XFRT_S 1.8151e-17
* device instance cc_XD5_XDFFM_S_XFRT_SB r0 *1 0,0
Ccc_XD5_XDFFM_S_XFRT_SB XD5_XDFFM_S XFRT_SB 1.8151e-17
* device instance cc_XD5_XDFFM_S_ck1 r0 *1 0,0
Ccc_XD5_XDFFM_S_ck1 XD5_XDFFM_S ck1 5.4452e-17
* device instance cc_XD5_XDFFM_S_ck2 r0 *1 0,0
Ccc_XD5_XDFFM_S_ck2 XD5_XDFFM_S ck2 5.4452e-17
* device instance cc_XD5_XDFFM_S_ck3 r0 *1 0,0
Ccc_XD5_XDFFM_S_ck3 XD5_XDFFM_S ck3 5.4452e-17
* device instance cc_XD5_XDFFM_S_ck4 r0 *1 0,0
Ccc_XD5_XDFFM_S_ck4 XD5_XDFFM_S ck4 5.4452e-17
* device instance cc_XD5_XDFFM_S_ck5 r0 *1 0,0
Ccc_XD5_XDFFM_S_ck5 XD5_XDFFM_S ck5 5.4452e-17
* device instance cc_XD5_XDFFM_S_mod0 r0 *1 0,0
Ccc_XD5_XDFFM_S_mod0 XD5_XDFFM_S mod0 2.4201e-17
* device instance cc_XD5_XDFFM_S_mod1 r0 *1 0,0
Ccc_XD5_XDFFM_S_mod1 XD5_XDFFM_S mod1 2.4201e-17
* device instance cc_XD5_XDFFM_S_mod2 r0 *1 0,0
Ccc_XD5_XDFFM_S_mod2 XD5_XDFFM_S mod2 2.4201e-17
* device instance cc_XD5_XDFFM_S_mod3 r0 *1 0,0
Ccc_XD5_XDFFM_S_mod3 XD5_XDFFM_S mod3 2.4201e-17
* device instance cc_XD5_XDFFM_S_mod4 r0 *1 0,0
Ccc_XD5_XDFFM_S_mod4 XD5_XDFFM_S mod4 2.4201e-17
* device instance cc_XD5_XDFFM_S_net1 r0 *1 0,0
Ccc_XD5_XDFFM_S_net1 XD5_XDFFM_S net1 1.21e-17
* device instance cc_XD5_XDFFM_SB_XD5_XDFFQ_CLKB r0 *1 0,0
Ccc_XD5_XDFFM_SB_XD5_XDFFQ_CLKB XD5_XDFFM_SB XD5_XDFFQ_CLKB 1.8151e-17
* device instance cc_XD5_XDFFM_SB_XD5_XDFFQ_M r0 *1 0,0
Ccc_XD5_XDFFM_SB_XD5_XDFFQ_M XD5_XDFFM_SB XD5_XDFFQ_M 2.4201e-17
* device instance cc_XD5_XDFFM_SB_XD5_XDFFQ_MB r0 *1 0,0
Ccc_XD5_XDFFM_SB_XD5_XDFFQ_MB XD5_XDFFM_SB XD5_XDFFQ_MB 1.21e-17
* device instance cc_XD5_XDFFM_SB_XD5_XDFFQ_S r0 *1 0,0
Ccc_XD5_XDFFM_SB_XD5_XDFFQ_S XD5_XDFFM_SB XD5_XDFFQ_S 1.8151e-17
* device instance cc_XD5_XDFFM_SB_XD5_XDFFQ_SB r0 *1 0,0
Ccc_XD5_XDFFM_SB_XD5_XDFFQ_SB XD5_XDFFM_SB XD5_XDFFQ_SB 1.8151e-17
* device instance cc_XD5_XDFFM_SB_XD5_XNOR_midp r0 *1 0,0
Ccc_XD5_XDFFM_SB_XD5_XNOR_midp XD5_XDFFM_SB XD5_XNOR_midp 1.21e-17
* device instance cc_XD5_XDFFM_SB_XD5_dmodout r0 *1 0,0
Ccc_XD5_XDFFM_SB_XD5_dmodout XD5_XDFFM_SB XD5_dmodout 1.21e-17
* device instance cc_XD5_XDFFM_SB_XD5_dq r0 *1 0,0
Ccc_XD5_XDFFM_SB_XD5_dq XD5_XDFFM_SB XD5_dq 1.21e-17
* device instance cc_XD5_XDFFM_SB_XD5_nm r0 *1 0,0
Ccc_XD5_XDFFM_SB_XD5_nm XD5_XDFFM_SB XD5_nm 1.8151e-17
* device instance cc_XD5_XDFFM_SB_XD5_nt r0 *1 0,0
Ccc_XD5_XDFFM_SB_XD5_nt XD5_XDFFM_SB XD5_nt 2.4201e-17
* device instance cc_XD5_XDFFM_SB_XD5_t1 r0 *1 0,0
Ccc_XD5_XDFFM_SB_XD5_t1 XD5_XDFFM_SB XD5_t1 1.21e-17
* device instance cc_XD5_XDFFM_SB_XFRT_CLKB r0 *1 0,0
Ccc_XD5_XDFFM_SB_XFRT_CLKB XD5_XDFFM_SB XFRT_CLKB 1.8151e-17
* device instance cc_XD5_XDFFM_SB_XFRT_M r0 *1 0,0
Ccc_XD5_XDFFM_SB_XFRT_M XD5_XDFFM_SB XFRT_M 2.4201e-17
* device instance cc_XD5_XDFFM_SB_XFRT_MB r0 *1 0,0
Ccc_XD5_XDFFM_SB_XFRT_MB XD5_XDFFM_SB XFRT_MB 1.21e-17
* device instance cc_XD5_XDFFM_SB_XFRT_S r0 *1 0,0
Ccc_XD5_XDFFM_SB_XFRT_S XD5_XDFFM_SB XFRT_S 1.8151e-17
* device instance cc_XD5_XDFFM_SB_XFRT_SB r0 *1 0,0
Ccc_XD5_XDFFM_SB_XFRT_SB XD5_XDFFM_SB XFRT_SB 1.8151e-17
* device instance cc_XD5_XDFFM_SB_ck1 r0 *1 0,0
Ccc_XD5_XDFFM_SB_ck1 XD5_XDFFM_SB ck1 5.4452e-17
* device instance cc_XD5_XDFFM_SB_ck2 r0 *1 0,0
Ccc_XD5_XDFFM_SB_ck2 XD5_XDFFM_SB ck2 5.4452e-17
* device instance cc_XD5_XDFFM_SB_ck3 r0 *1 0,0
Ccc_XD5_XDFFM_SB_ck3 XD5_XDFFM_SB ck3 5.4452e-17
* device instance cc_XD5_XDFFM_SB_ck4 r0 *1 0,0
Ccc_XD5_XDFFM_SB_ck4 XD5_XDFFM_SB ck4 5.4452e-17
* device instance cc_XD5_XDFFM_SB_ck5 r0 *1 0,0
Ccc_XD5_XDFFM_SB_ck5 XD5_XDFFM_SB ck5 5.4452e-17
* device instance cc_XD5_XDFFM_SB_mod0 r0 *1 0,0
Ccc_XD5_XDFFM_SB_mod0 XD5_XDFFM_SB mod0 2.4201e-17
* device instance cc_XD5_XDFFM_SB_mod1 r0 *1 0,0
Ccc_XD5_XDFFM_SB_mod1 XD5_XDFFM_SB mod1 2.4201e-17
* device instance cc_XD5_XDFFM_SB_mod2 r0 *1 0,0
Ccc_XD5_XDFFM_SB_mod2 XD5_XDFFM_SB mod2 2.4201e-17
* device instance cc_XD5_XDFFM_SB_mod3 r0 *1 0,0
Ccc_XD5_XDFFM_SB_mod3 XD5_XDFFM_SB mod3 2.4201e-17
* device instance cc_XD5_XDFFM_SB_mod4 r0 *1 0,0
Ccc_XD5_XDFFM_SB_mod4 XD5_XDFFM_SB mod4 2.4201e-17
* device instance cc_XD5_XDFFM_SB_net1 r0 *1 0,0
Ccc_XD5_XDFFM_SB_net1 XD5_XDFFM_SB net1 1.21e-17
* device instance cc_XD5_XDFFQ_CLKB_XD5_XDFFQ_M r0 *1 0,0
Ccc_XD5_XDFFQ_CLKB_XD5_XDFFQ_M XD5_XDFFQ_CLKB XD5_XDFFQ_M 4.2352e-17
* device instance cc_XD5_XDFFQ_CLKB_XD5_XDFFQ_MB r0 *1 0,0
Ccc_XD5_XDFFQ_CLKB_XD5_XDFFQ_MB XD5_XDFFQ_CLKB XD5_XDFFQ_MB 2.4201e-17
* device instance cc_XD5_XDFFQ_CLKB_XD5_XDFFQ_S r0 *1 0,0
Ccc_XD5_XDFFQ_CLKB_XD5_XDFFQ_S XD5_XDFFQ_CLKB XD5_XDFFQ_S 1.8151e-17
* device instance cc_XD5_XDFFQ_CLKB_XD5_XDFFQ_SB r0 *1 0,0
Ccc_XD5_XDFFQ_CLKB_XD5_XDFFQ_SB XD5_XDFFQ_CLKB XD5_XDFFQ_SB 1.8151e-17
* device instance cc_XD5_XDFFQ_CLKB_XD5_XN2_mid1 r0 *1 0,0
Ccc_XD5_XDFFQ_CLKB_XD5_XN2_mid1 XD5_XDFFQ_CLKB XD5_XN2_mid1 1.21e-17
* device instance cc_XD5_XDFFQ_CLKB_XD5_XNOR_midp r0 *1 0,0
Ccc_XD5_XDFFQ_CLKB_XD5_XNOR_midp XD5_XDFFQ_CLKB XD5_XNOR_midp 1.21e-17
* device instance cc_XD5_XDFFQ_CLKB_XD5_dmodout r0 *1 0,0
Ccc_XD5_XDFFQ_CLKB_XD5_dmodout XD5_XDFFQ_CLKB XD5_dmodout 1.21e-17
* device instance cc_XD5_XDFFQ_CLKB_XD5_dq r0 *1 0,0
Ccc_XD5_XDFFQ_CLKB_XD5_dq XD5_XDFFQ_CLKB XD5_dq 1.8151e-17
* device instance cc_XD5_XDFFQ_CLKB_XD5_nm r0 *1 0,0
Ccc_XD5_XDFFQ_CLKB_XD5_nm XD5_XDFFQ_CLKB XD5_nm 1.21e-17
* device instance cc_XD5_XDFFQ_CLKB_XD5_nt r0 *1 0,0
Ccc_XD5_XDFFQ_CLKB_XD5_nt XD5_XDFFQ_CLKB XD5_nt 2.4201e-17
* device instance cc_XD5_XDFFQ_CLKB_XD5_t1 r0 *1 0,0
Ccc_XD5_XDFFQ_CLKB_XD5_t1 XD5_XDFFQ_CLKB XD5_t1 1.21e-17
* device instance cc_XD5_XDFFQ_CLKB_XFRT_CLKB r0 *1 0,0
Ccc_XD5_XDFFQ_CLKB_XFRT_CLKB XD5_XDFFQ_CLKB XFRT_CLKB 1.8151e-17
* device instance cc_XD5_XDFFQ_CLKB_XFRT_M r0 *1 0,0
Ccc_XD5_XDFFQ_CLKB_XFRT_M XD5_XDFFQ_CLKB XFRT_M 2.4201e-17
* device instance cc_XD5_XDFFQ_CLKB_XFRT_MB r0 *1 0,0
Ccc_XD5_XDFFQ_CLKB_XFRT_MB XD5_XDFFQ_CLKB XFRT_MB 1.21e-17
* device instance cc_XD5_XDFFQ_CLKB_XFRT_S r0 *1 0,0
Ccc_XD5_XDFFQ_CLKB_XFRT_S XD5_XDFFQ_CLKB XFRT_S 1.8151e-17
* device instance cc_XD5_XDFFQ_CLKB_XFRT_SB r0 *1 0,0
Ccc_XD5_XDFFQ_CLKB_XFRT_SB XD5_XDFFQ_CLKB XFRT_SB 1.8151e-17
* device instance cc_XD5_XDFFQ_CLKB_ck1 r0 *1 0,0
Ccc_XD5_XDFFQ_CLKB_ck1 XD5_XDFFQ_CLKB ck1 5.4452e-17
* device instance cc_XD5_XDFFQ_CLKB_ck2 r0 *1 0,0
Ccc_XD5_XDFFQ_CLKB_ck2 XD5_XDFFQ_CLKB ck2 5.4452e-17
* device instance cc_XD5_XDFFQ_CLKB_ck3 r0 *1 0,0
Ccc_XD5_XDFFQ_CLKB_ck3 XD5_XDFFQ_CLKB ck3 5.4452e-17
* device instance cc_XD5_XDFFQ_CLKB_ck4 r0 *1 0,0
Ccc_XD5_XDFFQ_CLKB_ck4 XD5_XDFFQ_CLKB ck4 5.4452e-17
* device instance cc_XD5_XDFFQ_CLKB_ck5 r0 *1 0,0
Ccc_XD5_XDFFQ_CLKB_ck5 XD5_XDFFQ_CLKB ck5 6.0502e-17
* device instance cc_XD5_XDFFQ_CLKB_mod0 r0 *1 0,0
Ccc_XD5_XDFFQ_CLKB_mod0 XD5_XDFFQ_CLKB mod0 2.4201e-17
* device instance cc_XD5_XDFFQ_CLKB_mod1 r0 *1 0,0
Ccc_XD5_XDFFQ_CLKB_mod1 XD5_XDFFQ_CLKB mod1 2.4201e-17
* device instance cc_XD5_XDFFQ_CLKB_mod2 r0 *1 0,0
Ccc_XD5_XDFFQ_CLKB_mod2 XD5_XDFFQ_CLKB mod2 2.4201e-17
* device instance cc_XD5_XDFFQ_CLKB_mod3 r0 *1 0,0
Ccc_XD5_XDFFQ_CLKB_mod3 XD5_XDFFQ_CLKB mod3 2.4201e-17
* device instance cc_XD5_XDFFQ_CLKB_mod4 r0 *1 0,0
Ccc_XD5_XDFFQ_CLKB_mod4 XD5_XDFFQ_CLKB mod4 2.4201e-17
* device instance cc_XD5_XDFFQ_CLKB_net1 r0 *1 0,0
Ccc_XD5_XDFFQ_CLKB_net1 XD5_XDFFQ_CLKB net1 1.21e-17
* device instance cc_XD5_XDFFQ_M_XD5_XDFFQ_MB r0 *1 0,0
Ccc_XD5_XDFFQ_M_XD5_XDFFQ_MB XD5_XDFFQ_M XD5_XDFFQ_MB 3.4688e-17
* device instance cc_XD5_XDFFQ_M_XD5_XDFFQ_S r0 *1 0,0
Ccc_XD5_XDFFQ_M_XD5_XDFFQ_S XD5_XDFFQ_M XD5_XDFFQ_S 2.8638e-17
* device instance cc_XD5_XDFFQ_M_XD5_XDFFQ_SB r0 *1 0,0
Ccc_XD5_XDFFQ_M_XD5_XDFFQ_SB XD5_XDFFQ_M XD5_XDFFQ_SB 1.8151e-17
* device instance cc_XD5_XDFFQ_M_XD5_XN2_mid1 r0 *1 0,0
Ccc_XD5_XDFFQ_M_XD5_XN2_mid1 XD5_XDFFQ_M XD5_XN2_mid1 1.21e-17
* device instance cc_XD5_XDFFQ_M_XD5_XNOR_midp r0 *1 0,0
Ccc_XD5_XDFFQ_M_XD5_XNOR_midp XD5_XDFFQ_M XD5_XNOR_midp 1.21e-17
* device instance cc_XD5_XDFFQ_M_XD5_dmodout r0 *1 0,0
Ccc_XD5_XDFFQ_M_XD5_dmodout XD5_XDFFQ_M XD5_dmodout 1.21e-17
* device instance cc_XD5_XDFFQ_M_XD5_dq r0 *1 0,0
Ccc_XD5_XDFFQ_M_XD5_dq XD5_XDFFQ_M XD5_dq 2.8638e-17
* device instance cc_XD5_XDFFQ_M_XD5_nm r0 *1 0,0
Ccc_XD5_XDFFQ_M_XD5_nm XD5_XDFFQ_M XD5_nm 1.21e-17
* device instance cc_XD5_XDFFQ_M_XD5_nt r0 *1 0,0
Ccc_XD5_XDFFQ_M_XD5_nt XD5_XDFFQ_M XD5_nt 2.4201e-17
* device instance cc_XD5_XDFFQ_M_XD5_t1 r0 *1 0,0
Ccc_XD5_XDFFQ_M_XD5_t1 XD5_XDFFQ_M XD5_t1 1.21e-17
* device instance cc_XD5_XDFFQ_M_XFRT_CLKB r0 *1 0,0
Ccc_XD5_XDFFQ_M_XFRT_CLKB XD5_XDFFQ_M XFRT_CLKB 1.8151e-17
* device instance cc_XD5_XDFFQ_M_XFRT_M r0 *1 0,0
Ccc_XD5_XDFFQ_M_XFRT_M XD5_XDFFQ_M XFRT_M 2.4201e-17
* device instance cc_XD5_XDFFQ_M_XFRT_MB r0 *1 0,0
Ccc_XD5_XDFFQ_M_XFRT_MB XD5_XDFFQ_M XFRT_MB 1.21e-17
* device instance cc_XD5_XDFFQ_M_XFRT_S r0 *1 0,0
Ccc_XD5_XDFFQ_M_XFRT_S XD5_XDFFQ_M XFRT_S 1.8151e-17
* device instance cc_XD5_XDFFQ_M_XFRT_SB r0 *1 0,0
Ccc_XD5_XDFFQ_M_XFRT_SB XD5_XDFFQ_M XFRT_SB 1.8151e-17
* device instance cc_XD5_XDFFQ_M_ck1 r0 *1 0,0
Ccc_XD5_XDFFQ_M_ck1 XD5_XDFFQ_M ck1 5.4452e-17
* device instance cc_XD5_XDFFQ_M_ck2 r0 *1 0,0
Ccc_XD5_XDFFQ_M_ck2 XD5_XDFFQ_M ck2 5.4452e-17
* device instance cc_XD5_XDFFQ_M_ck3 r0 *1 0,0
Ccc_XD5_XDFFQ_M_ck3 XD5_XDFFQ_M ck3 5.4452e-17
* device instance cc_XD5_XDFFQ_M_ck4 r0 *1 0,0
Ccc_XD5_XDFFQ_M_ck4 XD5_XDFFQ_M ck4 5.4452e-17
* device instance cc_XD5_XDFFQ_M_ck5 r0 *1 0,0
Ccc_XD5_XDFFQ_M_ck5 XD5_XDFFQ_M ck5 6.0502e-17
* device instance cc_XD5_XDFFQ_M_mod0 r0 *1 0,0
Ccc_XD5_XDFFQ_M_mod0 XD5_XDFFQ_M mod0 2.4201e-17
* device instance cc_XD5_XDFFQ_M_mod1 r0 *1 0,0
Ccc_XD5_XDFFQ_M_mod1 XD5_XDFFQ_M mod1 2.4201e-17
* device instance cc_XD5_XDFFQ_M_mod2 r0 *1 0,0
Ccc_XD5_XDFFQ_M_mod2 XD5_XDFFQ_M mod2 2.4201e-17
* device instance cc_XD5_XDFFQ_M_mod3 r0 *1 0,0
Ccc_XD5_XDFFQ_M_mod3 XD5_XDFFQ_M mod3 2.4201e-17
* device instance cc_XD5_XDFFQ_M_mod4 r0 *1 0,0
Ccc_XD5_XDFFQ_M_mod4 XD5_XDFFQ_M mod4 2.4201e-17
* device instance cc_XD5_XDFFQ_M_net1 r0 *1 0,0
Ccc_XD5_XDFFQ_M_net1 XD5_XDFFQ_M net1 1.21e-17
* device instance cc_XD5_XDFFQ_MB_XD5_XDFFQ_S r0 *1 0,0
Ccc_XD5_XDFFQ_MB_XD5_XDFFQ_S XD5_XDFFQ_MB XD5_XDFFQ_S 1.8151e-17
* device instance cc_XD5_XDFFQ_MB_XD5_XDFFQ_SB r0 *1 0,0
Ccc_XD5_XDFFQ_MB_XD5_XDFFQ_SB XD5_XDFFQ_MB XD5_XDFFQ_SB 1.8151e-17
* device instance cc_XD5_XDFFQ_MB_XD5_XN2_mid1 r0 *1 0,0
Ccc_XD5_XDFFQ_MB_XD5_XN2_mid1 XD5_XDFFQ_MB XD5_XN2_mid1 1.21e-17
* device instance cc_XD5_XDFFQ_MB_XD5_XNOR_midp r0 *1 0,0
Ccc_XD5_XDFFQ_MB_XD5_XNOR_midp XD5_XDFFQ_MB XD5_XNOR_midp 1.21e-17
* device instance cc_XD5_XDFFQ_MB_XD5_dmodout r0 *1 0,0
Ccc_XD5_XDFFQ_MB_XD5_dmodout XD5_XDFFQ_MB XD5_dmodout 1.21e-17
* device instance cc_XD5_XDFFQ_MB_XD5_dq r0 *1 0,0
Ccc_XD5_XDFFQ_MB_XD5_dq XD5_XDFFQ_MB XD5_dq 1.21e-17
* device instance cc_XD5_XDFFQ_MB_XD5_nm r0 *1 0,0
Ccc_XD5_XDFFQ_MB_XD5_nm XD5_XDFFQ_MB XD5_nm 1.21e-17
* device instance cc_XD5_XDFFQ_MB_XD5_nt r0 *1 0,0
Ccc_XD5_XDFFQ_MB_XD5_nt XD5_XDFFQ_MB XD5_nt 2.4201e-17
* device instance cc_XD5_XDFFQ_MB_XD5_t1 r0 *1 0,0
Ccc_XD5_XDFFQ_MB_XD5_t1 XD5_XDFFQ_MB XD5_t1 1.21e-17
* device instance cc_XD5_XDFFQ_MB_XFRT_CLKB r0 *1 0,0
Ccc_XD5_XDFFQ_MB_XFRT_CLKB XD5_XDFFQ_MB XFRT_CLKB 1.8151e-17
* device instance cc_XD5_XDFFQ_MB_XFRT_M r0 *1 0,0
Ccc_XD5_XDFFQ_MB_XFRT_M XD5_XDFFQ_MB XFRT_M 2.4201e-17
* device instance cc_XD5_XDFFQ_MB_XFRT_MB r0 *1 0,0
Ccc_XD5_XDFFQ_MB_XFRT_MB XD5_XDFFQ_MB XFRT_MB 1.21e-17
* device instance cc_XD5_XDFFQ_MB_XFRT_S r0 *1 0,0
Ccc_XD5_XDFFQ_MB_XFRT_S XD5_XDFFQ_MB XFRT_S 1.8151e-17
* device instance cc_XD5_XDFFQ_MB_XFRT_SB r0 *1 0,0
Ccc_XD5_XDFFQ_MB_XFRT_SB XD5_XDFFQ_MB XFRT_SB 1.8151e-17
* device instance cc_XD5_XDFFQ_MB_ck1 r0 *1 0,0
Ccc_XD5_XDFFQ_MB_ck1 XD5_XDFFQ_MB ck1 5.4452e-17
* device instance cc_XD5_XDFFQ_MB_ck2 r0 *1 0,0
Ccc_XD5_XDFFQ_MB_ck2 XD5_XDFFQ_MB ck2 5.4452e-17
* device instance cc_XD5_XDFFQ_MB_ck3 r0 *1 0,0
Ccc_XD5_XDFFQ_MB_ck3 XD5_XDFFQ_MB ck3 5.4452e-17
* device instance cc_XD5_XDFFQ_MB_ck4 r0 *1 0,0
Ccc_XD5_XDFFQ_MB_ck4 XD5_XDFFQ_MB ck4 5.4452e-17
* device instance cc_XD5_XDFFQ_MB_ck5 r0 *1 0,0
Ccc_XD5_XDFFQ_MB_ck5 XD5_XDFFQ_MB ck5 6.0502e-17
* device instance cc_XD5_XDFFQ_MB_mod0 r0 *1 0,0
Ccc_XD5_XDFFQ_MB_mod0 XD5_XDFFQ_MB mod0 2.4201e-17
* device instance cc_XD5_XDFFQ_MB_mod1 r0 *1 0,0
Ccc_XD5_XDFFQ_MB_mod1 XD5_XDFFQ_MB mod1 2.4201e-17
* device instance cc_XD5_XDFFQ_MB_mod2 r0 *1 0,0
Ccc_XD5_XDFFQ_MB_mod2 XD5_XDFFQ_MB mod2 2.4201e-17
* device instance cc_XD5_XDFFQ_MB_mod3 r0 *1 0,0
Ccc_XD5_XDFFQ_MB_mod3 XD5_XDFFQ_MB mod3 2.4201e-17
* device instance cc_XD5_XDFFQ_MB_mod4 r0 *1 0,0
Ccc_XD5_XDFFQ_MB_mod4 XD5_XDFFQ_MB mod4 2.4201e-17
* device instance cc_XD5_XDFFQ_MB_net1 r0 *1 0,0
Ccc_XD5_XDFFQ_MB_net1 XD5_XDFFQ_MB net1 1.21e-17
* device instance cc_XD5_XDFFQ_S_XD5_XDFFQ_SB r0 *1 0,0
Ccc_XD5_XDFFQ_S_XD5_XDFFQ_SB XD5_XDFFQ_S XD5_XDFFQ_SB 4.0738e-17
* device instance cc_XD5_XDFFQ_S_XD5_XN2_mid1 r0 *1 0,0
Ccc_XD5_XDFFQ_S_XD5_XN2_mid1 XD5_XDFFQ_S XD5_XN2_mid1 1.21e-17
* device instance cc_XD5_XDFFQ_S_XD5_XNOR_midp r0 *1 0,0
Ccc_XD5_XDFFQ_S_XD5_XNOR_midp XD5_XDFFQ_S XD5_XNOR_midp 1.21e-17
* device instance cc_XD5_XDFFQ_S_XD5_dmodout r0 *1 0,0
Ccc_XD5_XDFFQ_S_XD5_dmodout XD5_XDFFQ_S XD5_dmodout 1.21e-17
* device instance cc_XD5_XDFFQ_S_XD5_dq r0 *1 0,0
Ccc_XD5_XDFFQ_S_XD5_dq XD5_XDFFQ_S XD5_dq 1.21e-17
* device instance cc_XD5_XDFFQ_S_XD5_nm r0 *1 0,0
Ccc_XD5_XDFFQ_S_XD5_nm XD5_XDFFQ_S XD5_nm 1.21e-17
* device instance cc_XD5_XDFFQ_S_XD5_nt r0 *1 0,0
Ccc_XD5_XDFFQ_S_XD5_nt XD5_XDFFQ_S XD5_nt 2.4201e-17
* device instance cc_XD5_XDFFQ_S_XD5_t1 r0 *1 0,0
Ccc_XD5_XDFFQ_S_XD5_t1 XD5_XDFFQ_S XD5_t1 1.21e-17
* device instance cc_XD5_XDFFQ_S_XFRT_CLKB r0 *1 0,0
Ccc_XD5_XDFFQ_S_XFRT_CLKB XD5_XDFFQ_S XFRT_CLKB 1.8151e-17
* device instance cc_XD5_XDFFQ_S_XFRT_M r0 *1 0,0
Ccc_XD5_XDFFQ_S_XFRT_M XD5_XDFFQ_S XFRT_M 2.4201e-17
* device instance cc_XD5_XDFFQ_S_XFRT_MB r0 *1 0,0
Ccc_XD5_XDFFQ_S_XFRT_MB XD5_XDFFQ_S XFRT_MB 1.21e-17
* device instance cc_XD5_XDFFQ_S_XFRT_S r0 *1 0,0
Ccc_XD5_XDFFQ_S_XFRT_S XD5_XDFFQ_S XFRT_S 1.8151e-17
* device instance cc_XD5_XDFFQ_S_XFRT_SB r0 *1 0,0
Ccc_XD5_XDFFQ_S_XFRT_SB XD5_XDFFQ_S XFRT_SB 1.8151e-17
* device instance cc_XD5_XDFFQ_S_ck1 r0 *1 0,0
Ccc_XD5_XDFFQ_S_ck1 XD5_XDFFQ_S ck1 5.4452e-17
* device instance cc_XD5_XDFFQ_S_ck2 r0 *1 0,0
Ccc_XD5_XDFFQ_S_ck2 XD5_XDFFQ_S ck2 5.4452e-17
* device instance cc_XD5_XDFFQ_S_ck3 r0 *1 0,0
Ccc_XD5_XDFFQ_S_ck3 XD5_XDFFQ_S ck3 5.4452e-17
* device instance cc_XD5_XDFFQ_S_ck4 r0 *1 0,0
Ccc_XD5_XDFFQ_S_ck4 XD5_XDFFQ_S ck4 5.4452e-17
* device instance cc_XD5_XDFFQ_S_ck5 r0 *1 0,0
Ccc_XD5_XDFFQ_S_ck5 XD5_XDFFQ_S ck5 5.4452e-17
* device instance cc_XD5_XDFFQ_S_mod0 r0 *1 0,0
Ccc_XD5_XDFFQ_S_mod0 XD5_XDFFQ_S mod0 2.4201e-17
* device instance cc_XD5_XDFFQ_S_mod1 r0 *1 0,0
Ccc_XD5_XDFFQ_S_mod1 XD5_XDFFQ_S mod1 2.4201e-17
* device instance cc_XD5_XDFFQ_S_mod2 r0 *1 0,0
Ccc_XD5_XDFFQ_S_mod2 XD5_XDFFQ_S mod2 2.4201e-17
* device instance cc_XD5_XDFFQ_S_mod3 r0 *1 0,0
Ccc_XD5_XDFFQ_S_mod3 XD5_XDFFQ_S mod3 2.4201e-17
* device instance cc_XD5_XDFFQ_S_mod4 r0 *1 0,0
Ccc_XD5_XDFFQ_S_mod4 XD5_XDFFQ_S mod4 2.4201e-17
* device instance cc_XD5_XDFFQ_S_net1 r0 *1 0,0
Ccc_XD5_XDFFQ_S_net1 XD5_XDFFQ_S net1 1.21e-17
* device instance cc_XD5_XDFFQ_SB_XD5_XN2_mid1 r0 *1 0,0
Ccc_XD5_XDFFQ_SB_XD5_XN2_mid1 XD5_XDFFQ_SB XD5_XN2_mid1 1.21e-17
* device instance cc_XD5_XDFFQ_SB_XD5_XNOR_midp r0 *1 0,0
Ccc_XD5_XDFFQ_SB_XD5_XNOR_midp XD5_XDFFQ_SB XD5_XNOR_midp 1.21e-17
* device instance cc_XD5_XDFFQ_SB_XD5_dmodout r0 *1 0,0
Ccc_XD5_XDFFQ_SB_XD5_dmodout XD5_XDFFQ_SB XD5_dmodout 1.21e-17
* device instance cc_XD5_XDFFQ_SB_XD5_dq r0 *1 0,0
Ccc_XD5_XDFFQ_SB_XD5_dq XD5_XDFFQ_SB XD5_dq 1.21e-17
* device instance cc_XD5_XDFFQ_SB_XD5_nm r0 *1 0,0
Ccc_XD5_XDFFQ_SB_XD5_nm XD5_XDFFQ_SB XD5_nm 1.21e-17
* device instance cc_XD5_XDFFQ_SB_XD5_nt r0 *1 0,0
Ccc_XD5_XDFFQ_SB_XD5_nt XD5_XDFFQ_SB XD5_nt 2.4201e-17
* device instance cc_XD5_XDFFQ_SB_XD5_t1 r0 *1 0,0
Ccc_XD5_XDFFQ_SB_XD5_t1 XD5_XDFFQ_SB XD5_t1 1.21e-17
* device instance cc_XD5_XDFFQ_SB_XFRT_CLKB r0 *1 0,0
Ccc_XD5_XDFFQ_SB_XFRT_CLKB XD5_XDFFQ_SB XFRT_CLKB 1.8151e-17
* device instance cc_XD5_XDFFQ_SB_XFRT_M r0 *1 0,0
Ccc_XD5_XDFFQ_SB_XFRT_M XD5_XDFFQ_SB XFRT_M 2.4201e-17
* device instance cc_XD5_XDFFQ_SB_XFRT_MB r0 *1 0,0
Ccc_XD5_XDFFQ_SB_XFRT_MB XD5_XDFFQ_SB XFRT_MB 1.21e-17
* device instance cc_XD5_XDFFQ_SB_XFRT_S r0 *1 0,0
Ccc_XD5_XDFFQ_SB_XFRT_S XD5_XDFFQ_SB XFRT_S 1.8151e-17
* device instance cc_XD5_XDFFQ_SB_XFRT_SB r0 *1 0,0
Ccc_XD5_XDFFQ_SB_XFRT_SB XD5_XDFFQ_SB XFRT_SB 1.8151e-17
* device instance cc_XD5_XDFFQ_SB_ck1 r0 *1 0,0
Ccc_XD5_XDFFQ_SB_ck1 XD5_XDFFQ_SB ck1 5.4452e-17
* device instance cc_XD5_XDFFQ_SB_ck2 r0 *1 0,0
Ccc_XD5_XDFFQ_SB_ck2 XD5_XDFFQ_SB ck2 5.4452e-17
* device instance cc_XD5_XDFFQ_SB_ck3 r0 *1 0,0
Ccc_XD5_XDFFQ_SB_ck3 XD5_XDFFQ_SB ck3 5.4452e-17
* device instance cc_XD5_XDFFQ_SB_ck4 r0 *1 0,0
Ccc_XD5_XDFFQ_SB_ck4 XD5_XDFFQ_SB ck4 5.4452e-17
* device instance cc_XD5_XDFFQ_SB_ck5 r0 *1 0,0
Ccc_XD5_XDFFQ_SB_ck5 XD5_XDFFQ_SB ck5 5.4452e-17
* device instance cc_XD5_XDFFQ_SB_mod0 r0 *1 0,0
Ccc_XD5_XDFFQ_SB_mod0 XD5_XDFFQ_SB mod0 2.4201e-17
* device instance cc_XD5_XDFFQ_SB_mod1 r0 *1 0,0
Ccc_XD5_XDFFQ_SB_mod1 XD5_XDFFQ_SB mod1 2.4201e-17
* device instance cc_XD5_XDFFQ_SB_mod2 r0 *1 0,0
Ccc_XD5_XDFFQ_SB_mod2 XD5_XDFFQ_SB mod2 2.4201e-17
* device instance cc_XD5_XDFFQ_SB_mod3 r0 *1 0,0
Ccc_XD5_XDFFQ_SB_mod3 XD5_XDFFQ_SB mod3 2.4201e-17
* device instance cc_XD5_XDFFQ_SB_mod4 r0 *1 0,0
Ccc_XD5_XDFFQ_SB_mod4 XD5_XDFFQ_SB mod4 2.4201e-17
* device instance cc_XD5_XDFFQ_SB_net1 r0 *1 0,0
Ccc_XD5_XDFFQ_SB_net1 XD5_XDFFQ_SB net1 1.21e-17
* device instance cc_XD5_XN2_mid1_XD5_nm r0 *1 0,0
Ccc_XD5_XN2_mid1_XD5_nm XD5_XN2_mid1 XD5_nm 1.1294e-17
* device instance cc_XD5_XN3_mid1_XD5_XN3_mid2 r0 *1 0,0
Ccc_XD5_XN3_mid1_XD5_XN3_mid2 XD5_XN3_mid1 XD5_XN3_mid2 1.1294e-17
* device instance cc_XD5_XN3_mid1_XD5_nt r0 *1 0,0
Ccc_XD5_XN3_mid1_XD5_nt XD5_XN3_mid1 XD5_nt 1.1294e-17
* device instance cc_XD5_XN3_mid2_mod4 r0 *1 0,0
Ccc_XD5_XN3_mid2_mod4 XD5_XN3_mid2 mod4 6.05e-18
* device instance cc_XD5_XNOR_midp_XD5_dq r0 *1 0,0
Ccc_XD5_XNOR_midp_XD5_dq XD5_XNOR_midp XD5_dq 5.244e-18
* device instance cc_XD5_XNOR_midp_XD5_t1 r0 *1 0,0
Ccc_XD5_XNOR_midp_XD5_t1 XD5_XNOR_midp XD5_t1 6.05e-18
* device instance cc_XD5_dmodout_XD5_dq r0 *1 0,0
Ccc_XD5_dmodout_XD5_dq XD5_dmodout XD5_dq 1.21e-17
* device instance cc_XD5_dmodout_XD5_nm r0 *1 0,0
Ccc_XD5_dmodout_XD5_nm XD5_dmodout XD5_nm 1.8151e-17
* device instance cc_XD5_dmodout_XD5_nt r0 *1 0,0
Ccc_XD5_dmodout_XD5_nt XD5_dmodout XD5_nt 2.4201e-17
* device instance cc_XD5_dmodout_XD5_t1 r0 *1 0,0
Ccc_XD5_dmodout_XD5_t1 XD5_dmodout XD5_t1 1.21e-17
* device instance cc_XD5_dmodout_XFRT_CLKB r0 *1 0,0
Ccc_XD5_dmodout_XFRT_CLKB XD5_dmodout XFRT_CLKB 1.8151e-17
* device instance cc_XD5_dmodout_XFRT_M r0 *1 0,0
Ccc_XD5_dmodout_XFRT_M XD5_dmodout XFRT_M 2.4201e-17
* device instance cc_XD5_dmodout_XFRT_MB r0 *1 0,0
Ccc_XD5_dmodout_XFRT_MB XD5_dmodout XFRT_MB 1.21e-17
* device instance cc_XD5_dmodout_XFRT_S r0 *1 0,0
Ccc_XD5_dmodout_XFRT_S XD5_dmodout XFRT_S 1.8151e-17
* device instance cc_XD5_dmodout_XFRT_SB r0 *1 0,0
Ccc_XD5_dmodout_XFRT_SB XD5_dmodout XFRT_SB 1.8151e-17
* device instance cc_XD5_dmodout_ck1 r0 *1 0,0
Ccc_XD5_dmodout_ck1 XD5_dmodout ck1 5.4452e-17
* device instance cc_XD5_dmodout_ck2 r0 *1 0,0
Ccc_XD5_dmodout_ck2 XD5_dmodout ck2 5.4452e-17
* device instance cc_XD5_dmodout_ck3 r0 *1 0,0
Ccc_XD5_dmodout_ck3 XD5_dmodout ck3 5.4452e-17
* device instance cc_XD5_dmodout_ck4 r0 *1 0,0
Ccc_XD5_dmodout_ck4 XD5_dmodout ck4 5.4452e-17
* device instance cc_XD5_dmodout_ck5 r0 *1 0,0
Ccc_XD5_dmodout_ck5 XD5_dmodout ck5 6.6553e-17
* device instance cc_XD5_dmodout_mod0 r0 *1 0,0
Ccc_XD5_dmodout_mod0 XD5_dmodout mod0 2.4201e-17
* device instance cc_XD5_dmodout_mod1 r0 *1 0,0
Ccc_XD5_dmodout_mod1 XD5_dmodout mod1 2.4201e-17
* device instance cc_XD5_dmodout_mod2 r0 *1 0,0
Ccc_XD5_dmodout_mod2 XD5_dmodout mod2 2.4201e-17
* device instance cc_XD5_dmodout_mod3 r0 *1 0,0
Ccc_XD5_dmodout_mod3 XD5_dmodout mod3 2.4201e-17
* device instance cc_XD5_dmodout_mod4 r0 *1 0,0
Ccc_XD5_dmodout_mod4 XD5_dmodout mod4 2.4201e-17
* device instance cc_XD5_dmodout_net1 r0 *1 0,0
Ccc_XD5_dmodout_net1 XD5_dmodout net1 1.21e-17
* device instance cc_XD5_dq_XD5_nm r0 *1 0,0
Ccc_XD5_dq_XD5_nm XD5_dq XD5_nm 1.21e-17
* device instance cc_XD5_dq_XD5_nt r0 *1 0,0
Ccc_XD5_dq_XD5_nt XD5_dq XD5_nt 2.4201e-17
* device instance cc_XD5_dq_XD5_t1 r0 *1 0,0
Ccc_XD5_dq_XD5_t1 XD5_dq XD5_t1 1.8151e-17
* device instance cc_XD5_dq_XFRT_CLKB r0 *1 0,0
Ccc_XD5_dq_XFRT_CLKB XD5_dq XFRT_CLKB 1.8151e-17
* device instance cc_XD5_dq_XFRT_M r0 *1 0,0
Ccc_XD5_dq_XFRT_M XD5_dq XFRT_M 2.4201e-17
* device instance cc_XD5_dq_XFRT_MB r0 *1 0,0
Ccc_XD5_dq_XFRT_MB XD5_dq XFRT_MB 1.21e-17
* device instance cc_XD5_dq_XFRT_S r0 *1 0,0
Ccc_XD5_dq_XFRT_S XD5_dq XFRT_S 1.8151e-17
* device instance cc_XD5_dq_XFRT_SB r0 *1 0,0
Ccc_XD5_dq_XFRT_SB XD5_dq XFRT_SB 1.8151e-17
* device instance cc_XD5_dq_ck1 r0 *1 0,0
Ccc_XD5_dq_ck1 XD5_dq ck1 5.4452e-17
* device instance cc_XD5_dq_ck2 r0 *1 0,0
Ccc_XD5_dq_ck2 XD5_dq ck2 5.4452e-17
* device instance cc_XD5_dq_ck3 r0 *1 0,0
Ccc_XD5_dq_ck3 XD5_dq ck3 5.4452e-17
* device instance cc_XD5_dq_ck4 r0 *1 0,0
Ccc_XD5_dq_ck4 XD5_dq ck4 5.4452e-17
* device instance cc_XD5_dq_ck5 r0 *1 0,0
Ccc_XD5_dq_ck5 XD5_dq ck5 6.6553e-17
* device instance cc_XD5_dq_mod0 r0 *1 0,0
Ccc_XD5_dq_mod0 XD5_dq mod0 2.4201e-17
* device instance cc_XD5_dq_mod1 r0 *1 0,0
Ccc_XD5_dq_mod1 XD5_dq mod1 2.4201e-17
* device instance cc_XD5_dq_mod2 r0 *1 0,0
Ccc_XD5_dq_mod2 XD5_dq mod2 2.4201e-17
* device instance cc_XD5_dq_mod3 r0 *1 0,0
Ccc_XD5_dq_mod3 XD5_dq mod3 2.4201e-17
* device instance cc_XD5_dq_mod4 r0 *1 0,0
Ccc_XD5_dq_mod4 XD5_dq mod4 2.4201e-17
* device instance cc_XD5_dq_net1 r0 *1 0,0
Ccc_XD5_dq_net1 XD5_dq net1 1.21e-17
* device instance cc_XD5_nm_XD5_nt r0 *1 0,0
Ccc_XD5_nm_XD5_nt XD5_nm XD5_nt 2.4201e-17
* device instance cc_XD5_nm_XD5_t1 r0 *1 0,0
Ccc_XD5_nm_XD5_t1 XD5_nm XD5_t1 1.21e-17
* device instance cc_XD5_nm_XFRT_CLKB r0 *1 0,0
Ccc_XD5_nm_XFRT_CLKB XD5_nm XFRT_CLKB 1.8151e-17
* device instance cc_XD5_nm_XFRT_M r0 *1 0,0
Ccc_XD5_nm_XFRT_M XD5_nm XFRT_M 2.4201e-17
* device instance cc_XD5_nm_XFRT_MB r0 *1 0,0
Ccc_XD5_nm_XFRT_MB XD5_nm XFRT_MB 1.21e-17
* device instance cc_XD5_nm_XFRT_S r0 *1 0,0
Ccc_XD5_nm_XFRT_S XD5_nm XFRT_S 1.8151e-17
* device instance cc_XD5_nm_XFRT_SB r0 *1 0,0
Ccc_XD5_nm_XFRT_SB XD5_nm XFRT_SB 1.8151e-17
* device instance cc_XD5_nm_ck1 r0 *1 0,0
Ccc_XD5_nm_ck1 XD5_nm ck1 5.4452e-17
* device instance cc_XD5_nm_ck2 r0 *1 0,0
Ccc_XD5_nm_ck2 XD5_nm ck2 5.4452e-17
* device instance cc_XD5_nm_ck3 r0 *1 0,0
Ccc_XD5_nm_ck3 XD5_nm ck3 5.4452e-17
* device instance cc_XD5_nm_ck4 r0 *1 0,0
Ccc_XD5_nm_ck4 XD5_nm ck4 5.4452e-17
* device instance cc_XD5_nm_ck5 r0 *1 0,0
Ccc_XD5_nm_ck5 XD5_nm ck5 5.4452e-17
* device instance cc_XD5_nm_mod0 r0 *1 0,0
Ccc_XD5_nm_mod0 XD5_nm mod0 2.4201e-17
* device instance cc_XD5_nm_mod1 r0 *1 0,0
Ccc_XD5_nm_mod1 XD5_nm mod1 2.4201e-17
* device instance cc_XD5_nm_mod2 r0 *1 0,0
Ccc_XD5_nm_mod2 XD5_nm mod2 2.4201e-17
* device instance cc_XD5_nm_mod3 r0 *1 0,0
Ccc_XD5_nm_mod3 XD5_nm mod3 2.4201e-17
* device instance cc_XD5_nm_mod4 r0 *1 0,0
Ccc_XD5_nm_mod4 XD5_nm mod4 2.4201e-17
* device instance cc_XD5_nm_net1 r0 *1 0,0
Ccc_XD5_nm_net1 XD5_nm net1 1.21e-17
* device instance cc_XD5_nt_XD5_t1 r0 *1 0,0
Ccc_XD5_nt_XD5_t1 XD5_nt XD5_t1 1.21e-17
* device instance cc_XD5_nt_XFRT_CLKB r0 *1 0,0
Ccc_XD5_nt_XFRT_CLKB XD5_nt XFRT_CLKB 1.8151e-17
* device instance cc_XD5_nt_XFRT_M r0 *1 0,0
Ccc_XD5_nt_XFRT_M XD5_nt XFRT_M 2.4201e-17
* device instance cc_XD5_nt_XFRT_MB r0 *1 0,0
Ccc_XD5_nt_XFRT_MB XD5_nt XFRT_MB 1.21e-17
* device instance cc_XD5_nt_XFRT_S r0 *1 0,0
Ccc_XD5_nt_XFRT_S XD5_nt XFRT_S 1.8151e-17
* device instance cc_XD5_nt_XFRT_SB r0 *1 0,0
Ccc_XD5_nt_XFRT_SB XD5_nt XFRT_SB 1.8151e-17
* device instance cc_XD5_nt_ck1 r0 *1 0,0
Ccc_XD5_nt_ck1 XD5_nt ck1 5.4452e-17
* device instance cc_XD5_nt_ck2 r0 *1 0,0
Ccc_XD5_nt_ck2 XD5_nt ck2 5.4452e-17
* device instance cc_XD5_nt_ck3 r0 *1 0,0
Ccc_XD5_nt_ck3 XD5_nt ck3 5.4452e-17
* device instance cc_XD5_nt_ck4 r0 *1 0,0
Ccc_XD5_nt_ck4 XD5_nt ck4 5.4452e-17
* device instance cc_XD5_nt_ck5 r0 *1 0,0
Ccc_XD5_nt_ck5 XD5_nt ck5 5.4452e-17
* device instance cc_XD5_nt_mod0 r0 *1 0,0
Ccc_XD5_nt_mod0 XD5_nt mod0 2.4201e-17
* device instance cc_XD5_nt_mod1 r0 *1 0,0
Ccc_XD5_nt_mod1 XD5_nt mod1 2.4201e-17
* device instance cc_XD5_nt_mod2 r0 *1 0,0
Ccc_XD5_nt_mod2 XD5_nt mod2 2.4201e-17
* device instance cc_XD5_nt_mod3 r0 *1 0,0
Ccc_XD5_nt_mod3 XD5_nt mod3 2.4201e-17
* device instance cc_XD5_nt_mod4 r0 *1 0,0
Ccc_XD5_nt_mod4 XD5_nt mod4 3.0251e-17
* device instance cc_XD5_nt_net1 r0 *1 0,0
Ccc_XD5_nt_net1 XD5_nt net1 1.21e-17
* device instance cc_XD5_t1_XFRT_CLKB r0 *1 0,0
Ccc_XD5_t1_XFRT_CLKB XD5_t1 XFRT_CLKB 1.8151e-17
* device instance cc_XD5_t1_XFRT_M r0 *1 0,0
Ccc_XD5_t1_XFRT_M XD5_t1 XFRT_M 2.4201e-17
* device instance cc_XD5_t1_XFRT_MB r0 *1 0,0
Ccc_XD5_t1_XFRT_MB XD5_t1 XFRT_MB 1.21e-17
* device instance cc_XD5_t1_XFRT_S r0 *1 0,0
Ccc_XD5_t1_XFRT_S XD5_t1 XFRT_S 1.8151e-17
* device instance cc_XD5_t1_XFRT_SB r0 *1 0,0
Ccc_XD5_t1_XFRT_SB XD5_t1 XFRT_SB 1.8151e-17
* device instance cc_XD5_t1_ck1 r0 *1 0,0
Ccc_XD5_t1_ck1 XD5_t1 ck1 5.4452e-17
* device instance cc_XD5_t1_ck2 r0 *1 0,0
Ccc_XD5_t1_ck2 XD5_t1 ck2 5.4452e-17
* device instance cc_XD5_t1_ck3 r0 *1 0,0
Ccc_XD5_t1_ck3 XD5_t1 ck3 5.4452e-17
* device instance cc_XD5_t1_ck4 r0 *1 0,0
Ccc_XD5_t1_ck4 XD5_t1 ck4 5.4452e-17
* device instance cc_XD5_t1_ck5 r0 *1 0,0
Ccc_XD5_t1_ck5 XD5_t1 ck5 5.4452e-17
* device instance cc_XD5_t1_mod0 r0 *1 0,0
Ccc_XD5_t1_mod0 XD5_t1 mod0 2.4201e-17
* device instance cc_XD5_t1_mod1 r0 *1 0,0
Ccc_XD5_t1_mod1 XD5_t1 mod1 2.4201e-17
* device instance cc_XD5_t1_mod2 r0 *1 0,0
Ccc_XD5_t1_mod2 XD5_t1 mod2 2.4201e-17
* device instance cc_XD5_t1_mod3 r0 *1 0,0
Ccc_XD5_t1_mod3 XD5_t1 mod3 2.4201e-17
* device instance cc_XD5_t1_mod4 r0 *1 0,0
Ccc_XD5_t1_mod4 XD5_t1 mod4 2.4201e-17
* device instance cc_XD5_t1_net1 r0 *1 0,0
Ccc_XD5_t1_net1 XD5_t1 net1 1.21e-17
* device instance cc_XFRT_CLKB_XFRT_M r0 *1 0,0
Ccc_XFRT_CLKB_XFRT_M XFRT_CLKB XFRT_M 4.2352e-17
* device instance cc_XFRT_CLKB_XFRT_MB r0 *1 0,0
Ccc_XFRT_CLKB_XFRT_MB XFRT_CLKB XFRT_MB 2.4201e-17
* device instance cc_XFRT_CLKB_XFRT_S r0 *1 0,0
Ccc_XFRT_CLKB_XFRT_S XFRT_CLKB XFRT_S 1.8151e-17
* device instance cc_XFRT_CLKB_XFRT_SB r0 *1 0,0
Ccc_XFRT_CLKB_XFRT_SB XFRT_CLKB XFRT_SB 1.8151e-17
* device instance cc_XFRT_CLKB_ck1 r0 *1 0,0
Ccc_XFRT_CLKB_ck1 XFRT_CLKB ck1 5.4452e-17
* device instance cc_XFRT_CLKB_ck2 r0 *1 0,0
Ccc_XFRT_CLKB_ck2 XFRT_CLKB ck2 5.4452e-17
* device instance cc_XFRT_CLKB_ck3 r0 *1 0,0
Ccc_XFRT_CLKB_ck3 XFRT_CLKB ck3 5.4452e-17
* device instance cc_XFRT_CLKB_ck4 r0 *1 0,0
Ccc_XFRT_CLKB_ck4 XFRT_CLKB ck4 5.4452e-17
* device instance cc_XFRT_CLKB_ck5 r0 *1 0,0
Ccc_XFRT_CLKB_ck5 XFRT_CLKB ck5 5.4452e-17
* device instance cc_XFRT_CLKB_mod0 r0 *1 0,0
Ccc_XFRT_CLKB_mod0 XFRT_CLKB mod0 2.4201e-17
* device instance cc_XFRT_CLKB_mod1 r0 *1 0,0
Ccc_XFRT_CLKB_mod1 XFRT_CLKB mod1 2.4201e-17
* device instance cc_XFRT_CLKB_mod2 r0 *1 0,0
Ccc_XFRT_CLKB_mod2 XFRT_CLKB mod2 2.4201e-17
* device instance cc_XFRT_CLKB_mod3 r0 *1 0,0
Ccc_XFRT_CLKB_mod3 XFRT_CLKB mod3 2.4201e-17
* device instance cc_XFRT_CLKB_mod4 r0 *1 0,0
Ccc_XFRT_CLKB_mod4 XFRT_CLKB mod4 2.4201e-17
* device instance cc_XFRT_CLKB_net1 r0 *1 0,0
Ccc_XFRT_CLKB_net1 XFRT_CLKB net1 1.21e-17
* device instance cc_XFRT_M_XFRT_MB r0 *1 0,0
Ccc_XFRT_M_XFRT_MB XFRT_M XFRT_MB 3.4688e-17
* device instance cc_XFRT_M_XFRT_S r0 *1 0,0
Ccc_XFRT_M_XFRT_S XFRT_M XFRT_S 2.8638e-17
* device instance cc_XFRT_M_XFRT_SB r0 *1 0,0
Ccc_XFRT_M_XFRT_SB XFRT_M XFRT_SB 1.8151e-17
* device instance cc_XFRT_M_ck1 r0 *1 0,0
Ccc_XFRT_M_ck1 XFRT_M ck1 5.4452e-17
* device instance cc_XFRT_M_ck2 r0 *1 0,0
Ccc_XFRT_M_ck2 XFRT_M ck2 5.4452e-17
* device instance cc_XFRT_M_ck3 r0 *1 0,0
Ccc_XFRT_M_ck3 XFRT_M ck3 5.4452e-17
* device instance cc_XFRT_M_ck4 r0 *1 0,0
Ccc_XFRT_M_ck4 XFRT_M ck4 5.4452e-17
* device instance cc_XFRT_M_ck5 r0 *1 0,0
Ccc_XFRT_M_ck5 XFRT_M ck5 5.4452e-17
* device instance cc_XFRT_M_mod0 r0 *1 0,0
Ccc_XFRT_M_mod0 XFRT_M mod0 2.4201e-17
* device instance cc_XFRT_M_mod1 r0 *1 0,0
Ccc_XFRT_M_mod1 XFRT_M mod1 2.4201e-17
* device instance cc_XFRT_M_mod2 r0 *1 0,0
Ccc_XFRT_M_mod2 XFRT_M mod2 2.4201e-17
* device instance cc_XFRT_M_mod3 r0 *1 0,0
Ccc_XFRT_M_mod3 XFRT_M mod3 2.4201e-17
* device instance cc_XFRT_M_mod4 r0 *1 0,0
Ccc_XFRT_M_mod4 XFRT_M mod4 2.4201e-17
* device instance cc_XFRT_M_net1 r0 *1 0,0
Ccc_XFRT_M_net1 XFRT_M net1 1.21e-17
* device instance cc_XFRT_MB_XFRT_S r0 *1 0,0
Ccc_XFRT_MB_XFRT_S XFRT_MB XFRT_S 1.8151e-17
* device instance cc_XFRT_MB_XFRT_SB r0 *1 0,0
Ccc_XFRT_MB_XFRT_SB XFRT_MB XFRT_SB 1.8151e-17
* device instance cc_XFRT_MB_ck1 r0 *1 0,0
Ccc_XFRT_MB_ck1 XFRT_MB ck1 5.4452e-17
* device instance cc_XFRT_MB_ck2 r0 *1 0,0
Ccc_XFRT_MB_ck2 XFRT_MB ck2 5.4452e-17
* device instance cc_XFRT_MB_ck3 r0 *1 0,0
Ccc_XFRT_MB_ck3 XFRT_MB ck3 5.4452e-17
* device instance cc_XFRT_MB_ck4 r0 *1 0,0
Ccc_XFRT_MB_ck4 XFRT_MB ck4 5.4452e-17
* device instance cc_XFRT_MB_ck5 r0 *1 0,0
Ccc_XFRT_MB_ck5 XFRT_MB ck5 5.4452e-17
* device instance cc_XFRT_MB_mod0 r0 *1 0,0
Ccc_XFRT_MB_mod0 XFRT_MB mod0 2.4201e-17
* device instance cc_XFRT_MB_mod1 r0 *1 0,0
Ccc_XFRT_MB_mod1 XFRT_MB mod1 2.4201e-17
* device instance cc_XFRT_MB_mod2 r0 *1 0,0
Ccc_XFRT_MB_mod2 XFRT_MB mod2 2.4201e-17
* device instance cc_XFRT_MB_mod3 r0 *1 0,0
Ccc_XFRT_MB_mod3 XFRT_MB mod3 2.4201e-17
* device instance cc_XFRT_MB_mod4 r0 *1 0,0
Ccc_XFRT_MB_mod4 XFRT_MB mod4 2.4201e-17
* device instance cc_XFRT_MB_net1 r0 *1 0,0
Ccc_XFRT_MB_net1 XFRT_MB net1 1.21e-17
* device instance cc_XFRT_S_XFRT_SB r0 *1 0,0
Ccc_XFRT_S_XFRT_SB XFRT_S XFRT_SB 4.0738e-17
* device instance cc_XFRT_S_ck1 r0 *1 0,0
Ccc_XFRT_S_ck1 XFRT_S ck1 5.4452e-17
* device instance cc_XFRT_S_ck2 r0 *1 0,0
Ccc_XFRT_S_ck2 XFRT_S ck2 5.4452e-17
* device instance cc_XFRT_S_ck3 r0 *1 0,0
Ccc_XFRT_S_ck3 XFRT_S ck3 5.4452e-17
* device instance cc_XFRT_S_ck4 r0 *1 0,0
Ccc_XFRT_S_ck4 XFRT_S ck4 5.4452e-17
* device instance cc_XFRT_S_ck5 r0 *1 0,0
Ccc_XFRT_S_ck5 XFRT_S ck5 5.4452e-17
* device instance cc_XFRT_S_mod0 r0 *1 0,0
Ccc_XFRT_S_mod0 XFRT_S mod0 2.4201e-17
* device instance cc_XFRT_S_mod1 r0 *1 0,0
Ccc_XFRT_S_mod1 XFRT_S mod1 2.4201e-17
* device instance cc_XFRT_S_mod2 r0 *1 0,0
Ccc_XFRT_S_mod2 XFRT_S mod2 2.4201e-17
* device instance cc_XFRT_S_mod3 r0 *1 0,0
Ccc_XFRT_S_mod3 XFRT_S mod3 2.4201e-17
* device instance cc_XFRT_S_mod4 r0 *1 0,0
Ccc_XFRT_S_mod4 XFRT_S mod4 2.4201e-17
* device instance cc_XFRT_S_net1 r0 *1 0,0
Ccc_XFRT_S_net1 XFRT_S net1 1.21e-17
* device instance cc_XFRT_SB_ck1 r0 *1 0,0
Ccc_XFRT_SB_ck1 XFRT_SB ck1 5.4452e-17
* device instance cc_XFRT_SB_ck2 r0 *1 0,0
Ccc_XFRT_SB_ck2 XFRT_SB ck2 5.4452e-17
* device instance cc_XFRT_SB_ck3 r0 *1 0,0
Ccc_XFRT_SB_ck3 XFRT_SB ck3 5.4452e-17
* device instance cc_XFRT_SB_ck4 r0 *1 0,0
Ccc_XFRT_SB_ck4 XFRT_SB ck4 5.4452e-17
* device instance cc_XFRT_SB_ck5 r0 *1 0,0
Ccc_XFRT_SB_ck5 XFRT_SB ck5 5.4452e-17
* device instance cc_XFRT_SB_mod0 r0 *1 0,0
Ccc_XFRT_SB_mod0 XFRT_SB mod0 2.4201e-17
* device instance cc_XFRT_SB_mod1 r0 *1 0,0
Ccc_XFRT_SB_mod1 XFRT_SB mod1 2.4201e-17
* device instance cc_XFRT_SB_mod2 r0 *1 0,0
Ccc_XFRT_SB_mod2 XFRT_SB mod2 2.4201e-17
* device instance cc_XFRT_SB_mod3 r0 *1 0,0
Ccc_XFRT_SB_mod3 XFRT_SB mod3 2.4201e-17
* device instance cc_XFRT_SB_mod4 r0 *1 0,0
Ccc_XFRT_SB_mod4 XFRT_SB mod4 2.4201e-17
* device instance cc_XFRT_SB_net1 r0 *1 0,0
Ccc_XFRT_SB_net1 XFRT_SB net1 1.21e-17
* device instance cc_ck1_ck2 r0 *1 0,0
Ccc_ck1_ck2 ck1 ck2 7.2603e-17
* device instance cc_ck1_ck3 r0 *1 0,0
Ccc_ck1_ck3 ck1 ck3 5.4452e-17
* device instance cc_ck1_ck4 r0 *1 0,0
Ccc_ck1_ck4 ck1 ck4 5.4452e-17
* device instance cc_ck1_ck5 r0 *1 0,0
Ccc_ck1_ck5 ck1 ck5 5.4452e-17
* device instance cc_ck1_mod0 r0 *1 0,0
Ccc_ck1_mod0 ck1 mod0 3.6302e-17
* device instance cc_ck1_mod1 r0 *1 0,0
Ccc_ck1_mod1 ck1 mod1 3.6302e-17
* device instance cc_ck1_mod2 r0 *1 0,0
Ccc_ck1_mod2 ck1 mod2 2.4201e-17
* device instance cc_ck1_mod3 r0 *1 0,0
Ccc_ck1_mod3 ck1 mod3 2.4201e-17
* device instance cc_ck1_mod4 r0 *1 0,0
Ccc_ck1_mod4 ck1 mod4 2.4201e-17
* device instance cc_ck1_net1 r0 *1 0,0
Ccc_ck1_net1 ck1 net1 1.8151e-17
* device instance cc_ck2_ck3 r0 *1 0,0
Ccc_ck2_ck3 ck2 ck3 7.2603e-17
* device instance cc_ck2_ck4 r0 *1 0,0
Ccc_ck2_ck4 ck2 ck4 5.4452e-17
* device instance cc_ck2_ck5 r0 *1 0,0
Ccc_ck2_ck5 ck2 ck5 5.4452e-17
* device instance cc_ck2_mod0 r0 *1 0,0
Ccc_ck2_mod0 ck2 mod0 3.0251e-17
* device instance cc_ck2_mod1 r0 *1 0,0
Ccc_ck2_mod1 ck2 mod1 3.6302e-17
* device instance cc_ck2_mod2 r0 *1 0,0
Ccc_ck2_mod2 ck2 mod2 3.6302e-17
* device instance cc_ck2_mod3 r0 *1 0,0
Ccc_ck2_mod3 ck2 mod3 2.4201e-17
* device instance cc_ck2_mod4 r0 *1 0,0
Ccc_ck2_mod4 ck2 mod4 2.4201e-17
* device instance cc_ck2_net1 r0 *1 0,0
Ccc_ck2_net1 ck2 net1 1.21e-17
* device instance cc_ck3_ck4 r0 *1 0,0
Ccc_ck3_ck4 ck3 ck4 7.2603e-17
* device instance cc_ck3_ck5 r0 *1 0,0
Ccc_ck3_ck5 ck3 ck5 5.4452e-17
* device instance cc_ck3_mod0 r0 *1 0,0
Ccc_ck3_mod0 ck3 mod0 2.4201e-17
* device instance cc_ck3_mod1 r0 *1 0,0
Ccc_ck3_mod1 ck3 mod1 3.0251e-17
* device instance cc_ck3_mod2 r0 *1 0,0
Ccc_ck3_mod2 ck3 mod2 3.6302e-17
* device instance cc_ck3_mod3 r0 *1 0,0
Ccc_ck3_mod3 ck3 mod3 3.6302e-17
* device instance cc_ck3_mod4 r0 *1 0,0
Ccc_ck3_mod4 ck3 mod4 2.4201e-17
* device instance cc_ck3_net1 r0 *1 0,0
Ccc_ck3_net1 ck3 net1 1.21e-17
* device instance cc_ck4_ck5 r0 *1 0,0
Ccc_ck4_ck5 ck4 ck5 7.2603e-17
* device instance cc_ck4_mod0 r0 *1 0,0
Ccc_ck4_mod0 ck4 mod0 2.4201e-17
* device instance cc_ck4_mod1 r0 *1 0,0
Ccc_ck4_mod1 ck4 mod1 2.4201e-17
* device instance cc_ck4_mod2 r0 *1 0,0
Ccc_ck4_mod2 ck4 mod2 3.0251e-17
* device instance cc_ck4_mod3 r0 *1 0,0
Ccc_ck4_mod3 ck4 mod3 3.6302e-17
* device instance cc_ck4_mod4 r0 *1 0,0
Ccc_ck4_mod4 ck4 mod4 3.6302e-17
* device instance cc_ck4_net1 r0 *1 0,0
Ccc_ck4_net1 ck4 net1 1.21e-17
* device instance cc_ck5_mod0 r0 *1 0,0
Ccc_ck5_mod0 ck5 mod0 2.4201e-17
* device instance cc_ck5_mod1 r0 *1 0,0
Ccc_ck5_mod1 ck5 mod1 2.4201e-17
* device instance cc_ck5_mod2 r0 *1 0,0
Ccc_ck5_mod2 ck5 mod2 2.4201e-17
* device instance cc_ck5_mod3 r0 *1 0,0
Ccc_ck5_mod3 ck5 mod3 3.0251e-17
* device instance cc_ck5_mod4 r0 *1 0,0
Ccc_ck5_mod4 ck5 mod4 3.6302e-17
* device instance cc_ck5_net1 r0 *1 0,0
Ccc_ck5_net1 ck5 net1 1.21e-17
* device instance cc_mod0_mod1 r0 *1 0,0
Ccc_mod0_mod1 mod0 mod1 3.6302e-17
* device instance cc_mod0_mod2 r0 *1 0,0
Ccc_mod0_mod2 mod0 mod2 2.4201e-17
* device instance cc_mod0_mod3 r0 *1 0,0
Ccc_mod0_mod3 mod0 mod3 2.4201e-17
* device instance cc_mod0_mod4 r0 *1 0,0
Ccc_mod0_mod4 mod0 mod4 2.4201e-17
* device instance cc_mod0_net1 r0 *1 0,0
Ccc_mod0_net1 mod0 net1 2.4201e-17
* device instance cc_mod1_mod2 r0 *1 0,0
Ccc_mod1_mod2 mod1 mod2 3.6302e-17
* device instance cc_mod1_mod3 r0 *1 0,0
Ccc_mod1_mod3 mod1 mod3 2.4201e-17
* device instance cc_mod1_mod4 r0 *1 0,0
Ccc_mod1_mod4 mod1 mod4 2.4201e-17
* device instance cc_mod1_net1 r0 *1 0,0
Ccc_mod1_net1 mod1 net1 1.21e-17
* device instance cc_mod2_mod3 r0 *1 0,0
Ccc_mod2_mod3 mod2 mod3 3.6302e-17
* device instance cc_mod2_mod4 r0 *1 0,0
Ccc_mod2_mod4 mod2 mod4 2.4201e-17
* device instance cc_mod2_net1 r0 *1 0,0
Ccc_mod2_net1 mod2 net1 1.21e-17
* device instance cc_mod3_mod4 r0 *1 0,0
Ccc_mod3_mod4 mod3 mod4 3.6302e-17
* device instance cc_mod3_net1 r0 *1 0,0
Ccc_mod3_net1 mod3 net1 1.21e-17
* device instance cc_mod4_net1 r0 *1 0,0
Ccc_mod4_net1 mod4 net1 1.21e-17
* device instance vsubs_dctie r0 *1 0,0
Rvsubs_dctie vsubs 0 1e+12
.ENDS pll_divider_chain
