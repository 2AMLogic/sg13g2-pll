* extracted by klt extract --deck sg13cmos5l
* parasitic model (--parasitics):
* - capacitance: net-to-ground for every net's own (non-coupled) area/perimeter, plus net-to-net for the vertical-overlap coupling `coupling` describes below -- a coupled net pair gets a direct capacitor between their two hub nodes, not just capacitors to the deck's ground/substrate net
* - coupling: vertical overlap (crossover) unconditionally -- where one net's conductor on an adjacent metal level sits directly over another *distinct* net's conductor, that overlap area is charged between the two nets instead of to ground (issue #760) -- plus lateral (same-layer, sidewall) coupling, but only for a net pair naming one of the caller's declared `--critical-net` nets (issue #976): facing-edge length within that layer's own minimum-spacing lookback is charged between the two nets, *additively* (not deducted from either net's substrate fringe term, unlike the vertical case -- a known simplification). Any same-layer pair with neither side named `--critical-net`, and fringe shielding in general, are still not modelled
* - resistance: single lumped series resistance per net, distributed as a star across that net's device terminals (issue #592) -- not a per-segment, distributed RC ladder, *unless* `--distributed-rc` names this net via `--critical-net` (issue #977, Epic #709 Phase 2b): then the net's terminals are ordered along their approximate physical spread and its total R/C is broken into a chain of per-segment resistors (segment length proportional to inter-terminal distance) with a ground capacitor at each terminal node (proportional to its adjacent segment length/2), instead of one star hub -- still an approximation (terminal position is a device-placement proxy, not true per-segment routing geometry), but a strictly finer-grained one than the single-hub star
* - frequency: quasi-static -- one frequency-independent R and C per net; no skin effect, no distributed transmission-line behavior
* - substrate tie: 1e+12 ohm to ground -- the substrate is capacitively floating in transient analysis (DC reference only); see --substrate-tie-ohms
.GLOBAL vsubs

* cell pll_pfd
* pin DN
* pin FB
* pin REF
* pin UP
* pin VDD
* pin VSS
* pin XED_DN_XD5
* pin XED_DN_XN1_mid1
* pin XED_DN_d1
* pin XED_DN_d2
* pin XED_DN_d3
* pin XED_DN_d4
* pin XED_DN_ntmp
* pin XED_UP_XD5
* pin XED_UP_XN1_mid1
* pin XED_UP_d1
* pin XED_UP_d2
* pin XED_UP_d3
* pin XED_UP_d4
* pin XED_UP_ntmp
* pin XLD_RB
* pin XLD_SB
* pin XLD_XNQ_mid1
* pin XLD_XNQB_mid1
* pin XLU_RB
* pin XLU_SB
* pin XLU_XNQ_mid1
* pin XLU_XNQB_mid1
* pin XNR_mid1
* pin net1
* pin net2
* pin reset
* pin reset_d1
* pin reset_d2
* pin reset_raw
* pin set_dn
* pin set_up
.SUBCKT pll_pfd DN FB REF UP VDD VSS XED_DN_XD5 XED_DN_XN1_mid1 XED_DN_d1
+ XED_DN_d2 XED_DN_d3 XED_DN_d4 XED_DN_ntmp XED_UP_XD5 XED_UP_XN1_mid1
+ XED_UP_d1 XED_UP_d2 XED_UP_d3 XED_UP_d4 XED_UP_ntmp XLD_RB XLD_SB
+ XLD_XNQ_mid1 XLD_XNQB_mid1 XLU_RB XLU_SB XLU_XNQ_mid1 XLU_XNQB_mid1 XNR_mid1
+ net1 net2 reset reset_d1 reset_d2 reset_raw set_dn set_up
* device instance $1 r0 *1 2.3,3.11 nfet
X$1 XED_UP_d1__t3 REF__t0 VSS__t0 VSS__t26 sg13_hv_nmos L=0.5U W=2U AS=0.8P
+ AD=0.8P PS=4.8U PD=4.8U
* device instance $2 r0 *1 6.26,3.11 nfet
X$2 XED_UP_d2__t3 XED_UP_d1__t2 VSS__t19 VSS__t27 sg13_hv_nmos L=0.5U W=2U
+ AS=0.8P AD=0.8P PS=4.8U PD=4.8U
* device instance $3 r0 *1 10.22,3.11 nfet
X$3 XED_UP_d3__t3 XED_UP_d2__t2 VSS__t12 VSS__t28 sg13_hv_nmos L=0.5U W=2U
+ AS=0.8P AD=0.8P PS=4.8U PD=4.8U
* device instance $4 r0 *1 14.18,3.11 nfet
X$4 XED_UP_d4__t3 XED_UP_d3__t2 VSS__t11 VSS__t29 sg13_hv_nmos L=0.5U W=2U
+ AS=0.8P AD=0.8P PS=4.8U PD=4.8U
* device instance $5 r0 *1 18.14,3.11 nfet
X$5 XED_UP_XD5__t3 XED_UP_d4__t2 VSS__t10 VSS__t30 sg13_hv_nmos L=0.5U W=2U
+ AS=0.8P AD=0.8P PS=4.8U PD=4.8U
* device instance $6 r0 *1 22.1,3.11 nfet
X$6 XED_UP_ntmp__t4 REF__t3 XED_UP_XN1_mid1__t1 VSS__t31 sg13_hv_nmos L=0.5U
+ W=2U AS=0.8P AD=0.8P PS=4.8U PD=4.8U
* device instance $7 r0 *1 26.06,3.11 nfet
X$7 XED_UP_XN1_mid1__t0 XED_UP_XD5__t2 VSS__t9 VSS__t32 sg13_hv_nmos L=0.5U
+ W=2U AS=0.8P AD=0.8P PS=4.8U PD=4.8U
* device instance $8 r0 *1 30.02,3.11 nfet
X$8 set_up__t3 XED_UP_ntmp__t3 VSS__t8 VSS__t33 sg13_hv_nmos L=0.5U W=2U
+ AS=0.8P AD=0.8P PS=4.8U PD=4.8U
* device instance $9 r0 *1 33.98,3.11 nfet
X$9 XED_DN_d1__t3 FB__t3 VSS__t7 VSS__t34 sg13_hv_nmos L=0.5U W=2U AS=0.8P
+ AD=0.8P PS=4.8U PD=4.8U
* device instance $10 r0 *1 37.94,3.11 nfet
X$10 XED_DN_d2__t3 XED_DN_d1__t2 VSS__t6 VSS__t35 sg13_hv_nmos L=0.5U W=2U
+ AS=0.8P AD=0.8P PS=4.8U PD=4.8U
* device instance $11 r0 *1 41.9,3.11 nfet
X$11 XED_DN_d3__t3 XED_DN_d2__t2 VSS__t5 VSS__t36 sg13_hv_nmos L=0.5U W=2U
+ AS=0.8P AD=0.8P PS=4.8U PD=4.8U
* device instance $12 r0 *1 45.86,3.11 nfet
X$12 XED_DN_d4__t3 XED_DN_d3__t2 VSS__t4 VSS__t37 sg13_hv_nmos L=0.5U W=2U
+ AS=0.8P AD=0.8P PS=4.8U PD=4.8U
* device instance $13 r0 *1 49.82,3.11 nfet
X$13 XED_DN_XD5__t3 XED_DN_d4__t2 VSS__t3 VSS__t38 sg13_hv_nmos L=0.5U W=2U
+ AS=0.8P AD=0.8P PS=4.8U PD=4.8U
* device instance $14 r0 *1 53.78,3.11 nfet
X$14 XED_DN_ntmp__t4 FB__t2 XED_DN_XN1_mid1__t1 VSS__t39 sg13_hv_nmos L=0.5U
+ W=2U AS=0.8P AD=0.8P PS=4.8U PD=4.8U
* device instance $15 r0 *1 57.74,3.11 nfet
X$15 XED_DN_XN1_mid1__t0 XED_DN_XD5__t2 VSS__t2 VSS__t40 sg13_hv_nmos L=0.5U
+ W=2U AS=0.8P AD=0.8P PS=4.8U PD=4.8U
* device instance $16 r0 *1 61.7,3.11 nfet
X$16 set_dn__t3 XED_DN_ntmp__t3 VSS__t14 VSS__t41 sg13_hv_nmos L=0.5U W=2U
+ AS=0.8P AD=0.8P PS=4.8U PD=4.8U
* device instance $17 r0 *1 65.66,3.11 nfet
X$17 XLU_SB__t3 set_up__t2 VSS__t13 VSS__t42 sg13_hv_nmos L=0.5U W=2U AS=0.8P
+ AD=0.8P PS=4.8U PD=4.8U
* device instance $18 r0 *1 69.62,3.11 nfet
X$18 XLU_RB__t3 reset__t5 VSS__t24 VSS__t43 sg13_hv_nmos L=0.5U W=2U AS=0.8P
+ AD=0.8P PS=4.8U PD=4.8U
* device instance $19 r0 *1 73.58,3.11 nfet
X$19 UP__t6 XLU_SB__t2 XLU_XNQ_mid1__t1 VSS__t44 sg13_hv_nmos L=0.5U W=2U
+ AS=0.8P AD=0.8P PS=4.8U PD=4.8U
* device instance $20 r0 *1 77.54,3.11 nfet
X$20 XLU_XNQ_mid1__t0 net1__t3 VSS__t23 VSS__t45 sg13_hv_nmos L=0.5U W=2U
+ AS=0.8P AD=0.8P PS=4.8U PD=4.8U
* device instance $21 r0 *1 81.5,3.11 nfet
X$21 net1__t4 XLU_RB__t2 XLU_XNQB_mid1__t1 VSS__t46 sg13_hv_nmos L=0.5U W=2U
+ AS=0.8P AD=0.8P PS=4.8U PD=4.8U
* device instance $22 r0 *1 85.46,3.11 nfet
X$22 XLU_XNQB_mid1__t0 UP__t5 VSS__t22 VSS__t47 sg13_hv_nmos L=0.5U W=2U
+ AS=0.8P AD=0.8P PS=4.8U PD=4.8U
* device instance $23 r0 *1 89.42,3.11 nfet
X$23 XLD_SB__t3 set_dn__t2 VSS__t21 VSS__t48 sg13_hv_nmos L=0.5U W=2U AS=0.8P
+ AD=0.8P PS=4.8U PD=4.8U
* device instance $24 r0 *1 93.38,3.11 nfet
X$24 XLD_RB__t3 reset__t4 VSS__t20 VSS__t49 sg13_hv_nmos L=0.5U W=2U AS=0.8P
+ AD=0.8P PS=4.8U PD=4.8U
* device instance $25 r0 *1 97.34,3.11 nfet
X$25 DN__t6 XLD_SB__t2 XLD_XNQ_mid1__t1 VSS__t50 sg13_hv_nmos L=0.5U W=2U
+ AS=0.8P AD=0.8P PS=4.8U PD=4.8U
* device instance $26 r0 *1 101.3,3.11 nfet
X$26 XLD_XNQ_mid1__t0 net2__t3 VSS__t25 VSS__t51 sg13_hv_nmos L=0.5U W=2U
+ AS=0.8P AD=0.8P PS=4.8U PD=4.8U
* device instance $27 r0 *1 105.26,3.11 nfet
X$27 net2__t4 XLD_RB__t2 XLD_XNQB_mid1__t1 VSS__t52 sg13_hv_nmos L=0.5U W=2U
+ AS=0.8P AD=0.8P PS=4.8U PD=4.8U
* device instance $28 r0 *1 109.22,3.11 nfet
X$28 XLD_XNQB_mid1__t0 DN__t5 VSS__t18 VSS__t53 sg13_hv_nmos L=0.5U W=2U
+ AS=0.8P AD=0.8P PS=4.8U PD=4.8U
* device instance $29 r0 *1 113.18,3.11 nfet
X$29 reset_raw__t4 UP__t4 XNR_mid1__t1 VSS__t54 sg13_hv_nmos L=0.5U W=2U
+ AS=0.8P AD=0.8P PS=4.8U PD=4.8U
* device instance $30 r0 *1 117.14,3.11 nfet
X$30 XNR_mid1__t0 DN__t4 VSS__t17 VSS__t55 sg13_hv_nmos L=0.5U W=2U AS=0.8P
+ AD=0.8P PS=4.8U PD=4.8U
* device instance $31 r0 *1 121.1,3.11 nfet
X$31 reset_d1__t3 reset_raw__t3 VSS__t16 VSS__t56 sg13_hv_nmos L=0.5U W=2U
+ AS=0.8P AD=0.8P PS=4.8U PD=4.8U
* device instance $32 r0 *1 125.06,3.11 nfet
X$32 reset_d2__t3 reset_d1__t2 VSS__t15 VSS__t57 sg13_hv_nmos L=0.5U W=2U
+ AS=0.8P AD=0.8P PS=4.8U PD=4.8U
* device instance $33 r0 *1 136.66,3.11 nfet
X$33 reset__t0 reset_d2__t0 VSS__t1 VSS__t58 sg13_hv_nmos L=0.5U W=4U AS=1.6P
+ AD=1.6P PS=8.8U PD=8.8U
* device instance $34 r0 *1 149.76,3.11 pfet
X$34 XED_UP_d1__t0 REF__t1 VDD__t1 VDD__t0 sg13_hv_pmos L=0.5U W=5U AS=2P AD=2P
+ PS=10.8U PD=10.8U
* device instance $35 r0 *1 156.72,3.11 pfet
X$35 XED_UP_d2__t0 XED_UP_d1__t1 VDD__t18 VDD__t49 sg13_hv_pmos L=0.5U W=5U
+ AS=2P AD=2P PS=10.8U PD=10.8U
* device instance $36 r0 *1 163.68,3.11 pfet
X$36 XED_UP_d3__t0 XED_UP_d2__t1 VDD__t17 VDD__t48 sg13_hv_pmos L=0.5U W=5U
+ AS=2P AD=2P PS=10.8U PD=10.8U
* device instance $37 r0 *1 170.64,3.11 pfet
X$37 XED_UP_d4__t0 XED_UP_d3__t1 VDD__t16 VDD__t47 sg13_hv_pmos L=0.5U W=5U
+ AS=2P AD=2P PS=10.8U PD=10.8U
* device instance $38 r0 *1 177.6,3.11 pfet
X$38 XED_UP_XD5__t0 XED_UP_d4__t1 VDD__t15 VDD__t46 sg13_hv_pmos L=0.5U W=5U
+ AS=2P AD=2P PS=10.8U PD=10.8U
* device instance $39 r0 *1 184.56,3.11 pfet
X$39 XED_UP_ntmp__t1 REF__t2 VDD__t14 VDD__t45 sg13_hv_pmos L=0.5U W=5U AS=2P
+ AD=2P PS=10.8U PD=10.8U
* device instance $40 r0 *1 191.52,3.11 pfet
X$40 XED_UP_ntmp__t0 XED_UP_XD5__t1 VDD__t13 VDD__t44 sg13_hv_pmos L=0.5U W=5U
+ AS=2P AD=2P PS=10.8U PD=10.8U
* device instance $41 r0 *1 198.48,3.11 pfet
X$41 set_up__t0 XED_UP_ntmp__t2 VDD__t12 VDD__t43 sg13_hv_pmos L=0.5U W=5U
+ AS=2P AD=2P PS=10.8U PD=10.8U
* device instance $42 r0 *1 205.44,3.11 pfet
X$42 XED_DN_d1__t0 FB__t1 VDD__t11 VDD__t42 sg13_hv_pmos L=0.5U W=5U AS=2P
+ AD=2P PS=10.8U PD=10.8U
* device instance $43 r0 *1 212.4,3.11 pfet
X$43 XED_DN_d2__t0 XED_DN_d1__t1 VDD__t10 VDD__t41 sg13_hv_pmos L=0.5U W=5U
+ AS=2P AD=2P PS=10.8U PD=10.8U
* device instance $44 r0 *1 219.36,3.11 pfet
X$44 XED_DN_d3__t0 XED_DN_d2__t1 VDD__t9 VDD__t40 sg13_hv_pmos L=0.5U W=5U
+ AS=2P AD=2P PS=10.8U PD=10.8U
* device instance $45 r0 *1 226.32,3.11 pfet
X$45 XED_DN_d4__t0 XED_DN_d3__t1 VDD__t8 VDD__t39 sg13_hv_pmos L=0.5U W=5U
+ AS=2P AD=2P PS=10.8U PD=10.8U
* device instance $46 r0 *1 233.28,3.11 pfet
X$46 XED_DN_XD5__t0 XED_DN_d4__t1 VDD__t7 VDD__t38 sg13_hv_pmos L=0.5U W=5U
+ AS=2P AD=2P PS=10.8U PD=10.8U
* device instance $47 r0 *1 240.24,3.11 pfet
X$47 XED_DN_ntmp__t1 FB__t0 VDD__t6 VDD__t37 sg13_hv_pmos L=0.5U W=5U AS=2P
+ AD=2P PS=10.8U PD=10.8U
* device instance $48 r0 *1 247.2,3.11 pfet
X$48 XED_DN_ntmp__t0 XED_DN_XD5__t1 VDD__t5 VDD__t36 sg13_hv_pmos L=0.5U W=5U
+ AS=2P AD=2P PS=10.8U PD=10.8U
* device instance $49 r0 *1 254.16,3.11 pfet
X$49 set_dn__t0 XED_DN_ntmp__t2 VDD__t19 VDD__t50 sg13_hv_pmos L=0.5U W=5U
+ AS=2P AD=2P PS=10.8U PD=10.8U
* device instance $50 r0 *1 261.12,3.11 pfet
X$50 XLU_SB__t0 set_up__t1 VDD__t4 VDD__t35 sg13_hv_pmos L=0.5U W=5U AS=2P
+ AD=2P PS=10.8U PD=10.8U
* device instance $51 r0 *1 268.08,3.11 pfet
X$51 XLU_RB__t0 reset__t3 VDD__t34 VDD__t65 sg13_hv_pmos L=0.5U W=5U AS=2P
+ AD=2P PS=10.8U PD=10.8U
* device instance $52 r0 *1 275.04,3.11 pfet
X$52 UP__t1 XLU_SB__t1 VDD__t33 VDD__t64 sg13_hv_pmos L=0.5U W=5U AS=2P AD=2P
+ PS=10.8U PD=10.8U
* device instance $53 r0 *1 282,3.11 pfet
X$53 UP__t0 net1__t2 VDD__t32 VDD__t63 sg13_hv_pmos L=0.5U W=5U AS=2P AD=2P
+ PS=10.8U PD=10.8U
* device instance $54 r0 *1 288.96,3.11 pfet
X$54 net1__t1 XLU_RB__t1 VDD__t31 VDD__t62 sg13_hv_pmos L=0.5U W=5U AS=2P AD=2P
+ PS=10.8U PD=10.8U
* device instance $55 r0 *1 295.92,3.11 pfet
X$55 net1__t0 UP__t3 VDD__t30 VDD__t61 sg13_hv_pmos L=0.5U W=5U AS=2P AD=2P
+ PS=10.8U PD=10.8U
* device instance $56 r0 *1 302.88,3.11 pfet
X$56 XLD_SB__t0 set_dn__t1 VDD__t29 VDD__t60 sg13_hv_pmos L=0.5U W=5U AS=2P
+ AD=2P PS=10.8U PD=10.8U
* device instance $57 r0 *1 309.84,3.11 pfet
X$57 XLD_RB__t0 reset__t2 VDD__t28 VDD__t59 sg13_hv_pmos L=0.5U W=5U AS=2P
+ AD=2P PS=10.8U PD=10.8U
* device instance $58 r0 *1 316.8,3.11 pfet
X$58 DN__t1 XLD_SB__t1 VDD__t27 VDD__t58 sg13_hv_pmos L=0.5U W=5U AS=2P AD=2P
+ PS=10.8U PD=10.8U
* device instance $59 r0 *1 323.76,3.11 pfet
X$59 DN__t0 net2__t2 VDD__t26 VDD__t57 sg13_hv_pmos L=0.5U W=5U AS=2P AD=2P
+ PS=10.8U PD=10.8U
* device instance $60 r0 *1 330.72,3.11 pfet
X$60 net2__t1 XLD_RB__t1 VDD__t25 VDD__t56 sg13_hv_pmos L=0.5U W=5U AS=2P AD=2P
+ PS=10.8U PD=10.8U
* device instance $61 r0 *1 337.68,3.11 pfet
X$61 net2__t0 DN__t3 VDD__t24 VDD__t55 sg13_hv_pmos L=0.5U W=5U AS=2P AD=2P
+ PS=10.8U PD=10.8U
* device instance $62 r0 *1 344.64,3.11 pfet
X$62 reset_raw__t1 UP__t2 VDD__t23 VDD__t54 sg13_hv_pmos L=0.5U W=5U AS=2P
+ AD=2P PS=10.8U PD=10.8U
* device instance $63 r0 *1 351.6,3.11 pfet
X$63 reset_raw__t0 DN__t2 VDD__t22 VDD__t53 sg13_hv_pmos L=0.5U W=5U AS=2P
+ AD=2P PS=10.8U PD=10.8U
* device instance $64 r0 *1 358.56,3.11 pfet
X$64 reset_d1__t0 reset_raw__t2 VDD__t21 VDD__t52 sg13_hv_pmos L=0.5U W=5U
+ AS=2P AD=2P PS=10.8U PD=10.8U
* device instance $65 r0 *1 365.52,3.11 pfet
X$65 reset_d2__t2 reset_d1__t1 VDD__t20 VDD__t51 sg13_hv_pmos L=0.5U W=5U AS=2P
+ AD=2P PS=10.8U PD=10.8U
* device instance $66 r0 *1 381.62,3.11 pfet
X$66 reset__t1 reset_d2__t1 VDD__t3 VDD__t2 sg13_hv_pmos L=0.5U W=10U AS=4P
+ AD=4P PS=20.8U PD=20.8U
* device instance DN_t0 r0 *1 0,0
RDN_t0 DN__t0 DN 9.8788012235
* device instance DN_t1 r0 *1 0,0
RDN_t1 DN__t1 DN 9.09337220231
* device instance DN_t2 r0 *1 0,0
RDN_t2 DN__t2 DN 13.0205173083
* device instance DN_t3 r0 *1 0,0
RDN_t3 DN__t3 DN 11.4496592659
* device instance DN_t4 r0 *1 0,0
RDN_t4 DN__t4 DN 13.4380585983
* device instance DN_t5 r0 *1 0,0
RDN_t5 DN__t5 DN 14.3318226569
* device instance DN_t6 r0 *1 0,0
RDN_t6 DN__t6 DN 15.6724687448
* device instance DN r0 *1 0,0
CDN DN vsubs 1.9742534e-14
* device instance FB_t0 r0 *1 0,0
RFB_t0 FB__t0 FB 19.6735107734
* device instance FB_t1 r0 *1 0,0
RFB_t1 FB__t1 FB 13.2678392266
* device instance FB_t2 r0 *1 0,0
RFB_t2 FB__t2 FB 14.6483718876
* device instance FB_t3 r0 *1 0,0
RFB_t3 FB__t3 FB 18.2929781124
* device instance FB r0 *1 0,0
CFB FB vsubs 1.4948379e-14
* device instance REF_t0 r0 *1 0,0
RREF_t0 REF__t0 REF 16.7888185532
* device instance REF_t1 r0 *1 0,0
RREF_t1 REF__t1 REF 11.5435136035
* device instance REF_t2 r0 *1 0,0
RREF_t2 REF__t2 REF 18.2298363965
* device instance REF_t3 r0 *1 0,0
RREF_t3 REF__t3 REF 12.9845314468
* device instance REF r0 *1 0,0
CREF REF vsubs 1.3573054e-14
* device instance UP_t0 r0 *1 0,0
RUP_t0 UP__t0 UP 9.61563795289
* device instance UP_t1 r0 *1 0,0
RUP_t1 UP__t1 UP 8.68645813405
* device instance UP_t2 r0 *1 0,0
RUP_t2 UP__t2 UP 17.9782563225
* device instance UP_t3 r0 *1 0,0
RUP_t3 UP__t3 UP 11.4739975906
* device instance UP_t4 r0 *1 0,0
RUP_t4 UP__t4 UP 12.922312768
* device instance UP_t5 r0 *1 0,0
RUP_t5 UP__t5 UP 16.6230117017
* device instance UP_t6 r0 *1 0,0
RUP_t6 UP__t6 UP 18.2090255304
* device instance UP r0 *1 0,0
CUP UP vsubs 2.1773992e-14
* device instance VDD_t0 r0 *1 0,0
RVDD_t0 VDD__t0 VDD 7.69300787707
* device instance VDD_t1 r0 *1 0,0
RVDD_t1 VDD__t1 VDD 7.69300787707
* device instance VDD_t2 r0 *1 0,0
RVDD_t2 VDD__t2 VDD 8.28468133484
* device instance VDD_t3 r0 *1 0,0
RVDD_t3 VDD__t3 VDD 8.28468133484
* device instance VDD_t4 r0 *1 0,0
RVDD_t4 VDD__t4 VDD 0.0190862405732
* device instance VDD_t5 r0 *1 0,0
RVDD_t5 VDD__t5 VDD 0.978326445136
* device instance VDD_t6 r0 *1 0,0
RVDD_t6 VDD__t6 VDD 1.45794654742
* device instance VDD_t7 r0 *1 0,0
RVDD_t7 VDD__t7 VDD 1.9375666497
* device instance VDD_t8 r0 *1 0,0
RVDD_t8 VDD__t8 VDD 2.41718675198
* device instance VDD_t9 r0 *1 0,0
RVDD_t9 VDD__t9 VDD 2.89680685426
* device instance VDD_t10 r0 *1 0,0
RVDD_t10 VDD__t10 VDD 3.37642695654
* device instance VDD_t11 r0 *1 0,0
RVDD_t11 VDD__t11 VDD 3.85604705882
* device instance VDD_t12 r0 *1 0,0
RVDD_t12 VDD__t12 VDD 4.3356671611
* device instance VDD_t13 r0 *1 0,0
RVDD_t13 VDD__t13 VDD 4.81528726339
* device instance VDD_t14 r0 *1 0,0
RVDD_t14 VDD__t14 VDD 5.29490736567
* device instance VDD_t15 r0 *1 0,0
RVDD_t15 VDD__t15 VDD 5.77452746795
* device instance VDD_t16 r0 *1 0,0
RVDD_t16 VDD__t16 VDD 6.25414757023
* device instance VDD_t17 r0 *1 0,0
RVDD_t17 VDD__t17 VDD 6.73376767251
* device instance VDD_t18 r0 *1 0,0
RVDD_t18 VDD__t18 VDD 7.21338777479
* device instance VDD_t19 r0 *1 0,0
RVDD_t19 VDD__t19 VDD 0.498706342854
* device instance VDD_t20 r0 *1 0,0
RVDD_t20 VDD__t20 VDD 7.17521529365
* device instance VDD_t21 r0 *1 0,0
RVDD_t21 VDD__t21 VDD 6.69559519136
* device instance VDD_t22 r0 *1 0,0
RVDD_t22 VDD__t22 VDD 6.21597508908
* device instance VDD_t23 r0 *1 0,0
RVDD_t23 VDD__t23 VDD 5.7363549868
* device instance VDD_t24 r0 *1 0,0
RVDD_t24 VDD__t24 VDD 5.25673488452
* device instance VDD_t25 r0 *1 0,0
RVDD_t25 VDD__t25 VDD 4.77711478224
* device instance VDD_t26 r0 *1 0,0
RVDD_t26 VDD__t26 VDD 4.29749467996
* device instance VDD_t27 r0 *1 0,0
RVDD_t27 VDD__t27 VDD 3.81787457768
* device instance VDD_t28 r0 *1 0,0
RVDD_t28 VDD__t28 VDD 3.3382544754
* device instance VDD_t29 r0 *1 0,0
RVDD_t29 VDD__t29 VDD 2.85863437311
* device instance VDD_t30 r0 *1 0,0
RVDD_t30 VDD__t30 VDD 2.37901427083
* device instance VDD_t31 r0 *1 0,0
RVDD_t31 VDD__t31 VDD 1.89939416855
* device instance VDD_t32 r0 *1 0,0
RVDD_t32 VDD__t32 VDD 1.41977406627
* device instance VDD_t33 r0 *1 0,0
RVDD_t33 VDD__t33 VDD 0.940153963989
* device instance VDD_t34 r0 *1 0,0
RVDD_t34 VDD__t34 VDD 0.460533861708
* device instance VDD_t35 r0 *1 0,0
RVDD_t35 VDD__t35 VDD 0.0190862405732
* device instance VDD_t36 r0 *1 0,0
RVDD_t36 VDD__t36 VDD 0.978326445136
* device instance VDD_t37 r0 *1 0,0
RVDD_t37 VDD__t37 VDD 1.45794654742
* device instance VDD_t38 r0 *1 0,0
RVDD_t38 VDD__t38 VDD 1.9375666497
* device instance VDD_t39 r0 *1 0,0
RVDD_t39 VDD__t39 VDD 2.41718675198
* device instance VDD_t40 r0 *1 0,0
RVDD_t40 VDD__t40 VDD 2.89680685426
* device instance VDD_t41 r0 *1 0,0
RVDD_t41 VDD__t41 VDD 3.37642695654
* device instance VDD_t42 r0 *1 0,0
RVDD_t42 VDD__t42 VDD 3.85604705882
* device instance VDD_t43 r0 *1 0,0
RVDD_t43 VDD__t43 VDD 4.3356671611
* device instance VDD_t44 r0 *1 0,0
RVDD_t44 VDD__t44 VDD 4.81528726339
* device instance VDD_t45 r0 *1 0,0
RVDD_t45 VDD__t45 VDD 5.29490736567
* device instance VDD_t46 r0 *1 0,0
RVDD_t46 VDD__t46 VDD 5.77452746795
* device instance VDD_t47 r0 *1 0,0
RVDD_t47 VDD__t47 VDD 6.25414757023
* device instance VDD_t48 r0 *1 0,0
RVDD_t48 VDD__t48 VDD 6.73376767251
* device instance VDD_t49 r0 *1 0,0
RVDD_t49 VDD__t49 VDD 7.21338777479
* device instance VDD_t50 r0 *1 0,0
RVDD_t50 VDD__t50 VDD 0.498706342854
* device instance VDD_t51 r0 *1 0,0
RVDD_t51 VDD__t51 VDD 7.17521529365
* device instance VDD_t52 r0 *1 0,0
RVDD_t52 VDD__t52 VDD 6.69559519136
* device instance VDD_t53 r0 *1 0,0
RVDD_t53 VDD__t53 VDD 6.21597508908
* device instance VDD_t54 r0 *1 0,0
RVDD_t54 VDD__t54 VDD 5.7363549868
* device instance VDD_t55 r0 *1 0,0
RVDD_t55 VDD__t55 VDD 5.25673488452
* device instance VDD_t56 r0 *1 0,0
RVDD_t56 VDD__t56 VDD 4.77711478224
* device instance VDD_t57 r0 *1 0,0
RVDD_t57 VDD__t57 VDD 4.29749467996
* device instance VDD_t58 r0 *1 0,0
RVDD_t58 VDD__t58 VDD 3.81787457768
* device instance VDD_t59 r0 *1 0,0
RVDD_t59 VDD__t59 VDD 3.3382544754
* device instance VDD_t60 r0 *1 0,0
RVDD_t60 VDD__t60 VDD 2.85863437311
* device instance VDD_t61 r0 *1 0,0
RVDD_t61 VDD__t61 VDD 2.37901427083
* device instance VDD_t62 r0 *1 0,0
RVDD_t62 VDD__t62 VDD 1.89939416855
* device instance VDD_t63 r0 *1 0,0
RVDD_t63 VDD__t63 VDD 1.41977406627
* device instance VDD_t64 r0 *1 0,0
RVDD_t64 VDD__t64 VDD 0.940153963989
* device instance VDD_t65 r0 *1 0,0
RVDD_t65 VDD__t65 VDD 0.460533861708
* device instance VDD r0 *1 0,0
CVDD VDD vsubs 7.2244129e-14
* device instance VSS_t0 r0 *1 0,0
RVSS_t0 VSS__t0 VSS 4.84063995546
* device instance VSS_t1 r0 *1 0,0
RVSS_t1 VSS__t1 VSS 5.62546158298
* device instance VSS_t2 r0 *1 0,0
RVSS_t2 VSS__t2 VSS 0.522087787472
* device instance VSS_t3 r0 *1 0,0
RVSS_t3 VSS__t3 VSS 1.13902381147
* device instance VSS_t4 r0 *1 0,0
RVSS_t4 VSS__t4 VSS 1.44749182347
* device instance VSS_t5 r0 *1 0,0
RVSS_t5 VSS__t5 VSS 1.75595983547
* device instance VSS_t6 r0 *1 0,0
RVSS_t6 VSS__t6 VSS 2.06442784747
* device instance VSS_t7 r0 *1 0,0
RVSS_t7 VSS__t7 VSS 2.37289585947
* device instance VSS_t8 r0 *1 0,0
RVSS_t8 VSS__t8 VSS 2.68136387147
* device instance VSS_t9 r0 *1 0,0
RVSS_t9 VSS__t9 VSS 2.98983188347
* device instance VSS_t10 r0 *1 0,0
RVSS_t10 VSS__t10 VSS 3.60676790746
* device instance VSS_t11 r0 *1 0,0
RVSS_t11 VSS__t11 VSS 3.91523591946
* device instance VSS_t12 r0 *1 0,0
RVSS_t12 VSS__t12 VSS 4.22370393146
* device instance VSS_t13 r0 *1 0,0
RVSS_t13 VSS__t13 VSS 0.0948482365264
* device instance VSS_t14 r0 *1 0,0
RVSS_t14 VSS__t14 VSS 0.213619775473
* device instance VSS_t15 r0 *1 0,0
RVSS_t15 VSS__t15 VSS 4.72186841651
* device instance VSS_t16 r0 *1 0,0
RVSS_t16 VSS__t16 VSS 4.41340040452
* device instance VSS_t17 r0 *1 0,0
RVSS_t17 VSS__t17 VSS 4.10493239252
* device instance VSS_t18 r0 *1 0,0
RVSS_t18 VSS__t18 VSS 3.48799636852
* device instance VSS_t19 r0 *1 0,0
RVSS_t19 VSS__t19 VSS 4.53217194346
* device instance VSS_t20 r0 *1 0,0
RVSS_t20 VSS__t20 VSS 2.25412432052
* device instance VSS_t21 r0 *1 0,0
RVSS_t21 VSS__t21 VSS 1.94565630852
* device instance VSS_t22 r0 *1 0,0
RVSS_t22 VSS__t22 VSS 1.63718829652
* device instance VSS_t23 r0 *1 0,0
RVSS_t23 VSS__t23 VSS 1.02025227252
* device instance VSS_t24 r0 *1 0,0
RVSS_t24 VSS__t24 VSS 0.403316248526
* device instance VSS_t25 r0 *1 0,0
RVSS_t25 VSS__t25 VSS 2.87106034452
* device instance VSS_t26 r0 *1 0,0
RVSS_t26 VSS__t26 VSS 4.84063995546
* device instance VSS_t27 r0 *1 0,0
RVSS_t27 VSS__t27 VSS 4.53217194346
* device instance VSS_t28 r0 *1 0,0
RVSS_t28 VSS__t28 VSS 4.22370393146
* device instance VSS_t29 r0 *1 0,0
RVSS_t29 VSS__t29 VSS 3.91523591946
* device instance VSS_t30 r0 *1 0,0
RVSS_t30 VSS__t30 VSS 3.60676790746
* device instance VSS_t31 r0 *1 0,0
RVSS_t31 VSS__t31 VSS 3.29829989546
* device instance VSS_t32 r0 *1 0,0
RVSS_t32 VSS__t32 VSS 2.98983188347
* device instance VSS_t33 r0 *1 0,0
RVSS_t33 VSS__t33 VSS 2.68136387147
* device instance VSS_t34 r0 *1 0,0
RVSS_t34 VSS__t34 VSS 2.37289585947
* device instance VSS_t35 r0 *1 0,0
RVSS_t35 VSS__t35 VSS 2.06442784747
* device instance VSS_t36 r0 *1 0,0
RVSS_t36 VSS__t36 VSS 1.75595983547
* device instance VSS_t37 r0 *1 0,0
RVSS_t37 VSS__t37 VSS 1.44749182347
* device instance VSS_t38 r0 *1 0,0
RVSS_t38 VSS__t38 VSS 1.13902381147
* device instance VSS_t39 r0 *1 0,0
RVSS_t39 VSS__t39 VSS 0.830555799471
* device instance VSS_t40 r0 *1 0,0
RVSS_t40 VSS__t40 VSS 0.522087787472
* device instance VSS_t41 r0 *1 0,0
RVSS_t41 VSS__t41 VSS 0.213619775473
* device instance VSS_t42 r0 *1 0,0
RVSS_t42 VSS__t42 VSS 0.0948482365264
* device instance VSS_t43 r0 *1 0,0
RVSS_t43 VSS__t43 VSS 0.403316248526
* device instance VSS_t44 r0 *1 0,0
RVSS_t44 VSS__t44 VSS 0.711784260525
* device instance VSS_t45 r0 *1 0,0
RVSS_t45 VSS__t45 VSS 1.02025227252
* device instance VSS_t46 r0 *1 0,0
RVSS_t46 VSS__t46 VSS 1.32872028452
* device instance VSS_t47 r0 *1 0,0
RVSS_t47 VSS__t47 VSS 1.63718829652
* device instance VSS_t48 r0 *1 0,0
RVSS_t48 VSS__t48 VSS 1.94565630852
* device instance VSS_t49 r0 *1 0,0
RVSS_t49 VSS__t49 VSS 2.25412432052
* device instance VSS_t50 r0 *1 0,0
RVSS_t50 VSS__t50 VSS 2.56259233252
* device instance VSS_t51 r0 *1 0,0
RVSS_t51 VSS__t51 VSS 2.87106034452
* device instance VSS_t52 r0 *1 0,0
RVSS_t52 VSS__t52 VSS 3.17952835652
* device instance VSS_t53 r0 *1 0,0
RVSS_t53 VSS__t53 VSS 3.48799636852
* device instance VSS_t54 r0 *1 0,0
RVSS_t54 VSS__t54 VSS 3.79646438052
* device instance VSS_t55 r0 *1 0,0
RVSS_t55 VSS__t55 VSS 4.10493239252
* device instance VSS_t56 r0 *1 0,0
RVSS_t56 VSS__t56 VSS 4.41340040452
* device instance VSS_t57 r0 *1 0,0
RVSS_t57 VSS__t57 VSS 4.72186841651
* device instance VSS_t58 r0 *1 0,0
RVSS_t58 VSS__t58 VSS 5.62546158298
* device instance VSS r0 *1 0,0
CVSS VSS vsubs 4.3310767e-14
* device instance XED_DN_XD5_t0 r0 *1 0,0
RXED_DN_XD5_t0 XED_DN_XD5__t0 XED_DN_XD5 15.9159960689
* device instance XED_DN_XD5_t1 r0 *1 0,0
RXED_DN_XD5_t1 XED_DN_XD5__t1 XED_DN_XD5 18.4841039311
* device instance XED_DN_XD5_t2 r0 *1 0,0
RXED_DN_XD5_t2 XED_DN_XD5__t2 XED_DN_XD5 16.4694675909
* device instance XED_DN_XD5_t3 r0 *1 0,0
RXED_DN_XD5_t3 XED_DN_XD5__t3 XED_DN_XD5 17.9306324091
* device instance XED_DN_XD5 r0 *1 0,0
CXED_DN_XD5 XED_DN_XD5 vsubs 1.5664195e-14
* device instance XED_DN_XN1_mid1_t0 r0 *1 0,0
RXED_DN_XN1_mid1_t0 XED_DN_XN1_mid1__t0 XED_DN_XN1_mid1 3.9379
* device instance XED_DN_XN1_mid1_t1 r0 *1 0,0
RXED_DN_XN1_mid1_t1 XED_DN_XN1_mid1__t1 XED_DN_XN1_mid1 3.9379
* device instance XED_DN_XN1_mid1 r0 *1 0,0
CXED_DN_XN1_mid1 XED_DN_XN1_mid1 vsubs 1.992966e-15
* device instance XED_DN_d1_t0 r0 *1 0,0
RXED_DN_d1_t0 XED_DN_d1__t0 XED_DN_d1 15.5112968316
* device instance XED_DN_d1_t1 r0 *1 0,0
RXED_DN_d1_t1 XED_DN_d1__t1 XED_DN_d1 16.8120031684
* device instance XED_DN_d1_t2 r0 *1 0,0
RXED_DN_d1_t2 XED_DN_d1__t2 XED_DN_d1 15.7916214732
* device instance XED_DN_d1_t3 r0 *1 0,0
RXED_DN_d1_t3 XED_DN_d1__t3 XED_DN_d1 16.5316785268
* device instance XED_DN_d1 r0 *1 0,0
CXED_DN_d1 XED_DN_d1 vsubs 1.4801311e-14
* device instance XED_DN_d2_t0 r0 *1 0,0
RXED_DN_d2_t0 XED_DN_d2__t0 XED_DN_d2 15.9027213571
* device instance XED_DN_d2_t1 r0 *1 0,0
RXED_DN_d2_t1 XED_DN_d2__t1 XED_DN_d2 17.2125786429
* device instance XED_DN_d2_t2 r0 *1 0,0
RXED_DN_d2_t2 XED_DN_d2__t2 XED_DN_d2 16.185018186
* device instance XED_DN_d2_t3 r0 *1 0,0
RXED_DN_d2_t3 XED_DN_d2__t3 XED_DN_d2 16.930281814
* device instance XED_DN_d2 r0 *1 0,0
CXED_DN_d2 XED_DN_d2 vsubs 1.5178616e-14
* device instance XED_DN_d3_t0 r0 *1 0,0
RXED_DN_d3_t0 XED_DN_d3__t0 XED_DN_d3 16.2942992848
* device instance XED_DN_d3_t1 r0 *1 0,0
RXED_DN_d3_t1 XED_DN_d3__t1 XED_DN_d3 17.6130007152
* device instance XED_DN_d3_t2 r0 *1 0,0
RXED_DN_d3_t2 XED_DN_d3__t2 XED_DN_d3 16.5785021793
* device instance XED_DN_d3_t3 r0 *1 0,0
RXED_DN_d3_t3 XED_DN_d3__t3 XED_DN_d3 17.3287978207
* device instance XED_DN_d3 r0 *1 0,0
CXED_DN_d3 XED_DN_d3 vsubs 1.5555921e-14
* device instance XED_DN_d4_t0 r0 *1 0,0
RXED_DN_d4_t0 XED_DN_d4__t0 XED_DN_d4 16.686023027
* device instance XED_DN_d4_t1 r0 *1 0,0
RXED_DN_d4_t1 XED_DN_d4__t1 XED_DN_d4 18.013276973
* device instance XED_DN_d4_t2 r0 *1 0,0
RXED_DN_d4_t2 XED_DN_d4__t2 XED_DN_d4 16.9720691361
* device instance XED_DN_d4_t3 r0 *1 0,0
RXED_DN_d4_t3 XED_DN_d4__t3 XED_DN_d4 17.7272308639
* device instance XED_DN_d4 r0 *1 0,0
CXED_DN_d4 XED_DN_d4 vsubs 1.5933226e-14
* device instance XED_DN_ntmp_t0 r0 *1 0,0
RXED_DN_ntmp_t0 XED_DN_ntmp__t0 XED_DN_ntmp 13.1876666667
* device instance XED_DN_ntmp_t1 r0 *1 0,0
RXED_DN_ntmp_t1 XED_DN_ntmp__t1 XED_DN_ntmp 11.9765118055
* device instance XED_DN_ntmp_t2 r0 *1 0,0
RXED_DN_ntmp_t2 XED_DN_ntmp__t2 XED_DN_ntmp 14.3988215279
* device instance XED_DN_ntmp_t3 r0 *1 0,0
RXED_DN_ntmp_t3 XED_DN_ntmp__t3 XED_DN_ntmp 19.0923946479
* device instance XED_DN_ntmp_t4 r0 *1 0,0
RXED_DN_ntmp_t4 XED_DN_ntmp__t4 XED_DN_ntmp 20.4706053521
* device instance XED_DN_ntmp r0 *1 0,0
CXED_DN_ntmp XED_DN_ntmp vsubs 1.8242168e-14
* device instance XED_UP_XD5_t0 r0 *1 0,0
RXED_UP_XD5_t0 XED_UP_XD5__t0 XED_UP_XD5 15.2435449157
* device instance XED_UP_XD5_t1 r0 *1 0,0
RXED_UP_XD5_t1 XED_UP_XD5__t1 XED_UP_XD5 18.1005550843
* device instance XED_UP_XD5_t2 r0 *1 0,0
RXED_UP_XD5_t2 XED_UP_XD5__t2 XED_UP_XD5 15.8592798658
* device instance XED_UP_XD5_t3 r0 *1 0,0
RXED_UP_XD5_t3 XED_UP_XD5__t3 XED_UP_XD5 17.4848201342
* device instance XED_UP_XD5 r0 *1 0,0
CXED_UP_XD5 XED_UP_XD5 vsubs 1.5386472e-14
* device instance XED_UP_XN1_mid1_t0 r0 *1 0,0
RXED_UP_XN1_mid1_t0 XED_UP_XN1_mid1__t0 XED_UP_XN1_mid1 5.1699
* device instance XED_UP_XN1_mid1_t1 r0 *1 0,0
RXED_UP_XN1_mid1_t1 XED_UP_XN1_mid1__t1 XED_UP_XN1_mid1 5.1699
* device instance XED_UP_XN1_mid1 r0 *1 0,0
CXED_UP_XN1_mid1 XED_UP_XN1_mid1 vsubs 2.639124e-15
* device instance XED_UP_d1_t0 r0 *1 0,0
RXED_UP_d1_t0 XED_UP_d1__t0 XED_UP_d1 14.9031840763
* device instance XED_UP_d1_t1 r0 *1 0,0
RXED_UP_d1_t1 XED_UP_d1__t1 XED_UP_d1 16.3641159237
* device instance XED_UP_d1_t2 r0 *1 0,0
RXED_UP_d1_t2 XED_UP_d1__t2 XED_UP_d1 15.2180400779
* device instance XED_UP_d1_t3 r0 *1 0,0
RXED_UP_d1_t3 XED_UP_d1__t3 XED_UP_d1 16.0492599221
* device instance XED_UP_d1 r0 *1 0,0
CXED_UP_d1 XED_UP_d1 vsubs 1.4523588e-14
* device instance XED_UP_d2_t0 r0 *1 0,0
RXED_UP_d2_t0 XED_UP_d2__t0 XED_UP_d2 15.2954675573
* device instance XED_UP_d2_t1 r0 *1 0,0
RXED_UP_d2_t1 XED_UP_d2__t1 XED_UP_d2 16.7638324427
* device instance XED_UP_d2_t2 r0 *1 0,0
RXED_UP_d2_t2 XED_UP_d2__t2 XED_UP_d2 15.6119255067
* device instance XED_UP_d2_t3 r0 *1 0,0
RXED_UP_d2_t3 XED_UP_d2__t3 XED_UP_d2 16.4473744933
* device instance XED_UP_d2 r0 *1 0,0
CXED_UP_d2 XED_UP_d2 vsubs 1.4900893e-14
* device instance XED_UP_d3_t0 r0 *1 0,0
RXED_UP_d3_t0 XED_UP_d3__t0 XED_UP_d3 15.6878949406
* device instance XED_UP_d3_t1 r0 *1 0,0
RXED_UP_d3_t1 XED_UP_d3__t1 XED_UP_d3 17.1634050594
* device instance XED_UP_d3_t2 r0 *1 0,0
RXED_UP_d3_t2 XED_UP_d3__t2 XED_UP_d3 16.005892811
* device instance XED_UP_d3_t3 r0 *1 0,0
RXED_UP_d3_t3 XED_UP_d3__t3 XED_UP_d3 16.845407189
* device instance XED_UP_d3 r0 *1 0,0
CXED_UP_d3 XED_UP_d3 vsubs 1.5278198e-14
* device instance XED_UP_d4_t0 r0 *1 0,0
RXED_UP_d4_t0 XED_UP_d4__t0 XED_UP_d4 16.0804580273
* device instance XED_UP_d4_t1 r0 *1 0,0
RXED_UP_d4_t1 XED_UP_d4__t1 XED_UP_d4 17.5628419727
* device instance XED_UP_d4_t2 r0 *1 0,0
RXED_UP_d4_t2 XED_UP_d4__t2 XED_UP_d4 16.3999373259
* device instance XED_UP_d4_t3 r0 *1 0,0
RXED_UP_d4_t3 XED_UP_d4__t3 XED_UP_d4 17.2433626741
* device instance XED_UP_d4 r0 *1 0,0
CXED_UP_d4 XED_UP_d4 vsubs 1.5655502e-14
* device instance XED_UP_ntmp_t0 r0 *1 0,0
RXED_UP_ntmp_t0 XED_UP_ntmp__t0 XED_UP_ntmp 13.041
* device instance XED_UP_ntmp_t1 r0 *1 0,0
RXED_UP_ntmp_t1 XED_UP_ntmp__t1 XED_UP_ntmp 11.6695905959
* device instance XED_UP_ntmp_t2 r0 *1 0,0
RXED_UP_ntmp_t2 XED_UP_ntmp__t2 XED_UP_ntmp 14.4124094041
* device instance XED_UP_ntmp_t3 r0 *1 0,0
RXED_UP_ntmp_t3 XED_UP_ntmp__t3 XED_UP_ntmp 18.7812153391
* device instance XED_UP_ntmp_t4 r0 *1 0,0
RXED_UP_ntmp_t4 XED_UP_ntmp__t4 XED_UP_ntmp 20.3417846609
* device instance XED_UP_ntmp r0 *1 0,0
CXED_UP_ntmp XED_UP_ntmp vsubs 1.8274435e-14
* device instance XLD_RB_t0 r0 *1 0,0
RXLD_RB_t0 XLD_RB__t0 XLD_RB 20.4593480992
* device instance XLD_RB_t1 r0 *1 0,0
RXLD_RB_t1 XLD_RB__t1 XLD_RB 24.7295519008
* device instance XLD_RB_t2 r0 *1 0,0
RXLD_RB_t2 XLD_RB__t2 XLD_RB 21.3796506427
* device instance XLD_RB_t3 r0 *1 0,0
RXLD_RB_t3 XLD_RB__t3 XLD_RB 23.8092493573
* device instance XLD_RB r0 *1 0,0
CXLD_RB XLD_RB vsubs 2.0818392e-14
* device instance XLD_SB_t0 r0 *1 0,0
RXLD_SB_t0 XLD_SB__t0 XLD_SB 20.6227096323
* device instance XLD_SB_t1 r0 *1 0,0
RXLD_SB_t1 XLD_SB__t1 XLD_SB 23.4573903677
* device instance XLD_SB_t2 r0 *1 0,0
RXLD_SB_t2 XLD_SB__t2 XLD_SB 21.2336322046
* device instance XLD_SB_t3 r0 *1 0,0
RXLD_SB_t3 XLD_SB__t3 XLD_SB 22.8464677954
* device instance XLD_SB r0 *1 0,0
CXLD_SB XLD_SB vsubs 2.0355514e-14
* device instance XLD_XNQB_mid1_t0 r0 *1 0,0
RXLD_XNQB_mid1_t0 XLD_XNQB_mid1__t0 XLD_XNQB_mid1 6.7539
* device instance XLD_XNQB_mid1_t1 r0 *1 0,0
RXLD_XNQB_mid1_t1 XLD_XNQB_mid1__t1 XLD_XNQB_mid1 6.7539
* device instance XLD_XNQB_mid1 r0 *1 0,0
CXLD_XNQB_mid1 XLD_XNQB_mid1 vsubs 3.413333e-15
* device instance XLD_XNQ_mid1_t0 r0 *1 0,0
RXLD_XNQ_mid1_t0 XLD_XNQ_mid1__t0 XLD_XNQ_mid1 6.5779
* device instance XLD_XNQ_mid1_t1 r0 *1 0,0
RXLD_XNQ_mid1_t1 XLD_XNQ_mid1__t1 XLD_XNQ_mid1 6.5779
* device instance XLD_XNQ_mid1 r0 *1 0,0
CXLD_XNQ_mid1 XLD_XNQ_mid1 vsubs 3.323128e-15
* device instance XLU_RB_t0 r0 *1 0,0
RXLU_RB_t0 XLU_RB__t0 XLU_RB 19.7173638944
* device instance XLU_RB_t1 r0 *1 0,0
RXLU_RB_t1 XLU_RB__t1 XLU_RB 24.2395361056
* device instance XLU_RB_t2 r0 *1 0,0
RXLU_RB_t2 XLU_RB__t2 XLU_RB 20.6919699744
* device instance XLU_RB_t3 r0 *1 0,0
RXLU_RB_t3 XLU_RB__t3 XLU_RB 23.2649300256
* device instance XLU_RB r0 *1 0,0
CXLU_RB XLU_RB vsubs 2.0386824e-14
* device instance XLU_SB_t0 r0 *1 0,0
RXLU_SB_t0 XLU_SB__t0 XLU_SB 19.921365449
* device instance XLU_SB_t1 r0 *1 0,0
RXLU_SB_t1 XLU_SB__t1 XLU_SB 22.926734551
* device instance XLU_SB_t2 r0 *1 0,0
RXLU_SB_t2 XLU_SB__t2 XLU_SB 20.5690743072
* device instance XLU_SB_t3 r0 *1 0,0
RXLU_SB_t3 XLU_SB__t3 XLU_SB 22.2790256928
* device instance XLU_SB r0 *1 0,0
CXLU_SB XLU_SB vsubs 1.9923946e-14
* device instance XLU_XNQB_mid1_t0 r0 *1 0,0
RXLU_XNQB_mid1_t0 XLU_XNQB_mid1__t0 XLU_XNQB_mid1 7.4579
* device instance XLU_XNQB_mid1_t1 r0 *1 0,0
RXLU_XNQB_mid1_t1 XLU_XNQB_mid1__t1 XLU_XNQB_mid1 7.4579
* device instance XLU_XNQB_mid1 r0 *1 0,0
CXLU_XNQB_mid1 XLU_XNQB_mid1 vsubs 3.783968e-15
* device instance XLU_XNQ_mid1_t0 r0 *1 0,0
RXLU_XNQ_mid1_t0 XLU_XNQ_mid1__t0 XLU_XNQ_mid1 7.2819
* device instance XLU_XNQ_mid1_t1 r0 *1 0,0
RXLU_XNQ_mid1_t1 XLU_XNQ_mid1__t1 XLU_XNQ_mid1 7.2819
* device instance XLU_XNQ_mid1 r0 *1 0,0
CXLU_XNQ_mid1 XLU_XNQ_mid1 vsubs 3.693764e-15
* device instance XNR_mid1_t0 r0 *1 0,0
RXNR_mid1_t0 XNR_mid1__t0 XNR_mid1 7.6339
* device instance XNR_mid1_t1 r0 *1 0,0
RXNR_mid1_t1 XNR_mid1__t1 XNR_mid1 7.6339
* device instance XNR_mid1 r0 *1 0,0
CXNR_mid1 XNR_mid1 vsubs 3.865992e-15
* device instance net1_t0 r0 *1 0,0
Rnet1_t0 net1__t0 net1 18.0936056564
* device instance net1_t1 r0 *1 0,0
Rnet1_t1 net1__t1 net1 16.7057166667
* device instance net1_t2 r0 *1 0,0
Rnet1_t2 net1__t2 net1 15.317827677
* device instance net1_t3 r0 *1 0,0
Rnet1_t3 net1__t3 net1 25.4534054884
* device instance net1_t4 r0 *1 0,0
Rnet1_t4 net1__t4 net1 24.6637445116
* device instance net1 r0 *1 0,0
Cnet1 net1 vsubs 2.3497407e-14
* device instance net2_t0 r0 *1 0,0
Rnet2_t0 net2__t0 net2 19.088976149
* device instance net2_t1 r0 *1 0,0
Rnet2_t1 net2__t1 net2 17.7323833333
* device instance net2_t2 r0 *1 0,0
Rnet2_t2 net2__t2 net2 16.3757905176
* device instance net2_t3 r0 *1 0,0
Rnet2_t3 net2__t3 net2 26.9845022665
* device instance net2_t4 r0 *1 0,0
Rnet2_t4 net2__t4 net2 26.2126477335
* device instance net2 r0 *1 0,0
Cnet2 net2 vsubs 2.4894315e-14
* device instance reset_t0 r0 *1 0,0
Rreset_t0 reset__t0 reset 15.1481487179
* device instance reset_t1 r0 *1 0,0
Rreset_t1 reset__t1 reset 35.5397282051
* device instance reset_t2 r0 *1 0,0
Rreset_t2 reset__t2 reset 20.6867897436
* device instance reset_t3 r0 *1 0,0
Rreset_t3 reset__t3 reset 12.0456820513
* device instance reset_t4 r0 *1 0,0
Rreset_t4 reset__t4 reset 24.1037794872
* device instance reset_t5 r0 *1 0,0
Rreset_t5 reset__t5 reset 29.0202717949
* device instance reset r0 *1 0,0
Creset reset vsubs 3.191691e-14
* device instance reset_d1_t0 r0 *1 0,0
Rreset_d1_t0 reset_d1__t0 reset_d1 24.4909223301
* device instance reset_d1_t1 r0 *1 0,0
Rreset_d1_t1 reset_d1__t1 reset_d1 25.9603776699
* device instance reset_d1_t2 r0 *1 0,0
Rreset_d1_t2 reset_d1__t2 reset_d1 24.8076152913
* device instance reset_d1_t3 r0 *1 0,0
Rreset_d1_t3 reset_d1__t3 reset_d1 25.6436847087
* device instance reset_d1 r0 *1 0,0
Creset_d1 reset_d1 vsubs 2.3485706e-14
* device instance reset_d2_t0 r0 *1 0,0
Rreset_d2_t0 reset_d2__t0 reset_d2 24.8607505593
* device instance reset_d2_t1 r0 *1 0,0
Rreset_d2_t1 reset_d2__t1 reset_d2 27.8404692668
* device instance reset_d2_t2 r0 *1 0,0
Rreset_d2_t2 reset_d2__t2 reset_d2 24.3766807332
* device instance reset_d2_t3 r0 *1 0,0
Rreset_d2_t3 reset_d2__t3 reset_d2 27.3563994407
* device instance reset_d2 r0 *1 0,0
Creset_d2 reset_d2 vsubs 2.4294028e-14
* device instance reset_raw_t0 r0 *1 0,0
Rreset_raw_t0 reset_raw__t0 reset_raw 18.6143333333
* device instance reset_raw_t1 r0 *1 0,0
Rreset_raw_t1 reset_raw__t1 reset_raw 17.2329062242
* device instance reset_raw_t2 r0 *1 0,0
Rreset_raw_t2 reset_raw__t2 reset_raw 19.9957604424
* device instance reset_raw_t3 r0 *1 0,0
Rreset_raw_t3 reset_raw__t3 reset_raw 27.1355156103
* device instance reset_raw_t4 r0 *1 0,0
Rreset_raw_t4 reset_raw__t4 reset_raw 28.7074843897
* device instance reset_raw r0 *1 0,0
Creset_raw reset_raw vsubs 2.6204691e-14
* device instance set_dn_t0 r0 *1 0,0
Rset_dn_t0 set_dn__t0 set_dn 19.3909910918
* device instance set_dn_t1 r0 *1 0,0
Rset_dn_t1 set_dn__t1 set_dn 31.6411089082
* device instance set_dn_t2 r0 *1 0,0
Rset_dn_t2 set_dn__t2 set_dn 22.0311026902
* device instance set_dn_t3 r0 *1 0,0
Rset_dn_t3 set_dn__t3 set_dn 29.0009973098
* device instance set_dn r0 *1 0,0
Cset_dn set_dn vsubs 2.3823095e-14
* device instance set_up_t0 r0 *1 0,0
Rset_up_t0 set_up__t0 set_up 16.3627943614
* device instance set_up_t1 r0 *1 0,0
Rset_up_t1 set_up__t1 set_up 33.5429056386
* device instance set_up_t2 r0 *1 0,0
Rset_up_t2 set_up__t2 set_up 20.0654045505
* device instance set_up_t3 r0 *1 0,0
Rset_up_t3 set_up__t3 set_up 29.8402954495
* device instance set_up r0 *1 0,0
Cset_up set_up vsubs 2.3354064e-14
* device instance cc_DN_FB r0 *1 0,0
Ccc_DN_FB DN FB 1.21e-17
* device instance cc_DN_REF r0 *1 0,0
Ccc_DN_REF DN REF 1.21e-17
* device instance cc_DN_UP r0 *1 0,0
Ccc_DN_UP DN UP 3.0251e-17
* device instance cc_DN_VDD r0 *1 0,0
Ccc_DN_VDD DN VDD 1.91995e-16
* device instance cc_DN_VSS r0 *1 0,0
Ccc_DN_VSS DN VSS 4.2352e-17
* device instance cc_DN_XED_DN_XD5 r0 *1 0,0
Ccc_DN_XED_DN_XD5 DN XED_DN_XD5 1.21e-17
* device instance cc_DN_XED_DN_d1 r0 *1 0,0
Ccc_DN_XED_DN_d1 DN XED_DN_d1 1.21e-17
* device instance cc_DN_XED_DN_d2 r0 *1 0,0
Ccc_DN_XED_DN_d2 DN XED_DN_d2 1.21e-17
* device instance cc_DN_XED_DN_d3 r0 *1 0,0
Ccc_DN_XED_DN_d3 DN XED_DN_d3 1.21e-17
* device instance cc_DN_XED_DN_d4 r0 *1 0,0
Ccc_DN_XED_DN_d4 DN XED_DN_d4 1.21e-17
* device instance cc_DN_XED_DN_ntmp r0 *1 0,0
Ccc_DN_XED_DN_ntmp DN XED_DN_ntmp 1.8151e-17
* device instance cc_DN_XED_UP_XD5 r0 *1 0,0
Ccc_DN_XED_UP_XD5 DN XED_UP_XD5 1.21e-17
* device instance cc_DN_XED_UP_d1 r0 *1 0,0
Ccc_DN_XED_UP_d1 DN XED_UP_d1 1.21e-17
* device instance cc_DN_XED_UP_d2 r0 *1 0,0
Ccc_DN_XED_UP_d2 DN XED_UP_d2 1.21e-17
* device instance cc_DN_XED_UP_d3 r0 *1 0,0
Ccc_DN_XED_UP_d3 DN XED_UP_d3 1.21e-17
* device instance cc_DN_XED_UP_d4 r0 *1 0,0
Ccc_DN_XED_UP_d4 DN XED_UP_d4 1.21e-17
* device instance cc_DN_XED_UP_ntmp r0 *1 0,0
Ccc_DN_XED_UP_ntmp DN XED_UP_ntmp 1.8151e-17
* device instance cc_DN_XLD_RB r0 *1 0,0
Ccc_DN_XLD_RB DN XLD_RB 1.8151e-17
* device instance cc_DN_XLD_SB r0 *1 0,0
Ccc_DN_XLD_SB DN XLD_SB 1.21e-17
* device instance cc_DN_XLD_XNQB_mid1 r0 *1 0,0
Ccc_DN_XLD_XNQB_mid1 DN XLD_XNQB_mid1 1.21e-17
* device instance cc_DN_XLD_XNQ_mid1 r0 *1 0,0
Ccc_DN_XLD_XNQ_mid1 DN XLD_XNQ_mid1 1.1294e-17
* device instance cc_DN_XLU_RB r0 *1 0,0
Ccc_DN_XLU_RB DN XLU_RB 1.21e-17
* device instance cc_DN_XLU_SB r0 *1 0,0
Ccc_DN_XLU_SB DN XLU_SB 1.21e-17
* device instance cc_DN_XNR_mid1 r0 *1 0,0
Ccc_DN_XNR_mid1 DN XNR_mid1 1.21e-17
* device instance cc_DN_net1 r0 *1 0,0
Ccc_DN_net1 DN net1 1.8151e-17
* device instance cc_DN_net2 r0 *1 0,0
Ccc_DN_net2 DN net2 3.0251e-17
* device instance cc_DN_reset r0 *1 0,0
Ccc_DN_reset DN reset 1.8151e-17
* device instance cc_DN_reset_d1 r0 *1 0,0
Ccc_DN_reset_d1 DN reset_d1 1.21e-17
* device instance cc_DN_reset_d2 r0 *1 0,0
Ccc_DN_reset_d2 DN reset_d2 1.21e-17
* device instance cc_DN_reset_raw r0 *1 0,0
Ccc_DN_reset_raw DN reset_raw 1.8151e-17
* device instance cc_DN_set_dn r0 *1 0,0
Ccc_DN_set_dn DN set_dn 1.21e-17
* device instance cc_DN_set_up r0 *1 0,0
Ccc_DN_set_up DN set_up 1.21e-17
* device instance cc_FB_REF r0 *1 0,0
Ccc_FB_REF FB REF 1.21e-17
* device instance cc_FB_UP r0 *1 0,0
Ccc_FB_UP FB UP 1.8151e-17
* device instance cc_FB_VDD r0 *1 0,0
Ccc_FB_VDD FB VDD 8.4703e-17
* device instance cc_FB_VSS r0 *1 0,0
Ccc_FB_VSS FB VSS 1.21005e-16
* device instance cc_FB_XED_DN_XD5 r0 *1 0,0
Ccc_FB_XED_DN_XD5 FB XED_DN_XD5 1.8151e-17
* device instance cc_FB_XED_DN_XN1_mid1 r0 *1 0,0
Ccc_FB_XED_DN_XN1_mid1 FB XED_DN_XN1_mid1 1.21e-17
* device instance cc_FB_XED_DN_d1 r0 *1 0,0
Ccc_FB_XED_DN_d1 FB XED_DN_d1 2.4201e-17
* device instance cc_FB_XED_DN_d2 r0 *1 0,0
Ccc_FB_XED_DN_d2 FB XED_DN_d2 2.4201e-17
* device instance cc_FB_XED_DN_d3 r0 *1 0,0
Ccc_FB_XED_DN_d3 FB XED_DN_d3 2.4201e-17
* device instance cc_FB_XED_DN_d4 r0 *1 0,0
Ccc_FB_XED_DN_d4 FB XED_DN_d4 2.4201e-17
* device instance cc_FB_XED_DN_ntmp r0 *1 0,0
Ccc_FB_XED_DN_ntmp FB XED_DN_ntmp 1.21e-17
* device instance cc_FB_XED_UP_XD5 r0 *1 0,0
Ccc_FB_XED_UP_XD5 FB XED_UP_XD5 1.21e-17
* device instance cc_FB_XED_UP_d1 r0 *1 0,0
Ccc_FB_XED_UP_d1 FB XED_UP_d1 1.21e-17
* device instance cc_FB_XED_UP_d2 r0 *1 0,0
Ccc_FB_XED_UP_d2 FB XED_UP_d2 1.21e-17
* device instance cc_FB_XED_UP_d3 r0 *1 0,0
Ccc_FB_XED_UP_d3 FB XED_UP_d3 1.21e-17
* device instance cc_FB_XED_UP_d4 r0 *1 0,0
Ccc_FB_XED_UP_d4 FB XED_UP_d4 1.21e-17
* device instance cc_FB_XED_UP_ntmp r0 *1 0,0
Ccc_FB_XED_UP_ntmp FB XED_UP_ntmp 1.8151e-17
* device instance cc_FB_XLD_RB r0 *1 0,0
Ccc_FB_XLD_RB FB XLD_RB 1.21e-17
* device instance cc_FB_XLD_SB r0 *1 0,0
Ccc_FB_XLD_SB FB XLD_SB 1.21e-17
* device instance cc_FB_XLD_XNQB_mid1 r0 *1 0,0
Ccc_FB_XLD_XNQB_mid1 FB XLD_XNQB_mid1 1.21e-17
* device instance cc_FB_XLD_XNQ_mid1 r0 *1 0,0
Ccc_FB_XLD_XNQ_mid1 FB XLD_XNQ_mid1 1.21e-17
* device instance cc_FB_XLU_RB r0 *1 0,0
Ccc_FB_XLU_RB FB XLU_RB 1.21e-17
* device instance cc_FB_XLU_SB r0 *1 0,0
Ccc_FB_XLU_SB FB XLU_SB 1.21e-17
* device instance cc_FB_XLU_XNQB_mid1 r0 *1 0,0
Ccc_FB_XLU_XNQB_mid1 FB XLU_XNQB_mid1 1.21e-17
* device instance cc_FB_XLU_XNQ_mid1 r0 *1 0,0
Ccc_FB_XLU_XNQ_mid1 FB XLU_XNQ_mid1 1.21e-17
* device instance cc_FB_XNR_mid1 r0 *1 0,0
Ccc_FB_XNR_mid1 FB XNR_mid1 1.21e-17
* device instance cc_FB_net1 r0 *1 0,0
Ccc_FB_net1 FB net1 1.21e-17
* device instance cc_FB_net2 r0 *1 0,0
Ccc_FB_net2 FB net2 1.21e-17
* device instance cc_FB_reset r0 *1 0,0
Ccc_FB_reset FB reset 1.8151e-17
* device instance cc_FB_reset_d1 r0 *1 0,0
Ccc_FB_reset_d1 FB reset_d1 1.21e-17
* device instance cc_FB_reset_d2 r0 *1 0,0
Ccc_FB_reset_d2 FB reset_d2 1.21e-17
* device instance cc_FB_reset_raw r0 *1 0,0
Ccc_FB_reset_raw FB reset_raw 1.21e-17
* device instance cc_FB_set_dn r0 *1 0,0
Ccc_FB_set_dn FB set_dn 1.21e-17
* device instance cc_FB_set_up r0 *1 0,0
Ccc_FB_set_up FB set_up 1.21e-17
* device instance cc_REF_UP r0 *1 0,0
Ccc_REF_UP REF UP 1.8151e-17
* device instance cc_REF_VDD r0 *1 0,0
Ccc_REF_VDD REF VDD 3.6302e-17
* device instance cc_REF_VSS r0 *1 0,0
Ccc_REF_VSS REF VSS 1.63357e-16
* device instance cc_REF_XED_DN_XD5 r0 *1 0,0
Ccc_REF_XED_DN_XD5 REF XED_DN_XD5 1.21e-17
* device instance cc_REF_XED_DN_XN1_mid1 r0 *1 0,0
Ccc_REF_XED_DN_XN1_mid1 REF XED_DN_XN1_mid1 1.21e-17
* device instance cc_REF_XED_DN_d1 r0 *1 0,0
Ccc_REF_XED_DN_d1 REF XED_DN_d1 1.21e-17
* device instance cc_REF_XED_DN_d2 r0 *1 0,0
Ccc_REF_XED_DN_d2 REF XED_DN_d2 1.21e-17
* device instance cc_REF_XED_DN_d3 r0 *1 0,0
Ccc_REF_XED_DN_d3 REF XED_DN_d3 1.21e-17
* device instance cc_REF_XED_DN_d4 r0 *1 0,0
Ccc_REF_XED_DN_d4 REF XED_DN_d4 1.21e-17
* device instance cc_REF_XED_DN_ntmp r0 *1 0,0
Ccc_REF_XED_DN_ntmp REF XED_DN_ntmp 1.21e-17
* device instance cc_REF_XED_UP_XD5 r0 *1 0,0
Ccc_REF_XED_UP_XD5 REF XED_UP_XD5 1.8151e-17
* device instance cc_REF_XED_UP_XN1_mid1 r0 *1 0,0
Ccc_REF_XED_UP_XN1_mid1 REF XED_UP_XN1_mid1 1.21e-17
* device instance cc_REF_XED_UP_d1 r0 *1 0,0
Ccc_REF_XED_UP_d1 REF XED_UP_d1 2.4201e-17
* device instance cc_REF_XED_UP_d2 r0 *1 0,0
Ccc_REF_XED_UP_d2 REF XED_UP_d2 2.4201e-17
* device instance cc_REF_XED_UP_d3 r0 *1 0,0
Ccc_REF_XED_UP_d3 REF XED_UP_d3 2.4201e-17
* device instance cc_REF_XED_UP_d4 r0 *1 0,0
Ccc_REF_XED_UP_d4 REF XED_UP_d4 2.4201e-17
* device instance cc_REF_XED_UP_ntmp r0 *1 0,0
Ccc_REF_XED_UP_ntmp REF XED_UP_ntmp 1.21e-17
* device instance cc_REF_XLD_RB r0 *1 0,0
Ccc_REF_XLD_RB REF XLD_RB 1.21e-17
* device instance cc_REF_XLD_SB r0 *1 0,0
Ccc_REF_XLD_SB REF XLD_SB 1.21e-17
* device instance cc_REF_XLD_XNQB_mid1 r0 *1 0,0
Ccc_REF_XLD_XNQB_mid1 REF XLD_XNQB_mid1 1.21e-17
* device instance cc_REF_XLD_XNQ_mid1 r0 *1 0,0
Ccc_REF_XLD_XNQ_mid1 REF XLD_XNQ_mid1 1.21e-17
* device instance cc_REF_XLU_RB r0 *1 0,0
Ccc_REF_XLU_RB REF XLU_RB 1.21e-17
* device instance cc_REF_XLU_SB r0 *1 0,0
Ccc_REF_XLU_SB REF XLU_SB 1.21e-17
* device instance cc_REF_XLU_XNQB_mid1 r0 *1 0,0
Ccc_REF_XLU_XNQB_mid1 REF XLU_XNQB_mid1 1.21e-17
* device instance cc_REF_XLU_XNQ_mid1 r0 *1 0,0
Ccc_REF_XLU_XNQ_mid1 REF XLU_XNQ_mid1 1.21e-17
* device instance cc_REF_XNR_mid1 r0 *1 0,0
Ccc_REF_XNR_mid1 REF XNR_mid1 1.21e-17
* device instance cc_REF_net1 r0 *1 0,0
Ccc_REF_net1 REF net1 1.21e-17
* device instance cc_REF_net2 r0 *1 0,0
Ccc_REF_net2 REF net2 1.21e-17
* device instance cc_REF_reset r0 *1 0,0
Ccc_REF_reset REF reset 1.8151e-17
* device instance cc_REF_reset_d1 r0 *1 0,0
Ccc_REF_reset_d1 REF reset_d1 1.21e-17
* device instance cc_REF_reset_d2 r0 *1 0,0
Ccc_REF_reset_d2 REF reset_d2 1.21e-17
* device instance cc_REF_reset_raw r0 *1 0,0
Ccc_REF_reset_raw REF reset_raw 1.21e-17
* device instance cc_REF_set_dn r0 *1 0,0
Ccc_REF_set_dn REF set_dn 1.21e-17
* device instance cc_REF_set_up r0 *1 0,0
Ccc_REF_set_up REF set_up 1.21e-17
* device instance cc_UP_VDD r0 *1 0,0
Ccc_UP_VDD UP VDD 1.85944e-16
* device instance cc_UP_VSS r0 *1 0,0
Ccc_UP_VSS UP VSS 6.6553e-17
* device instance cc_UP_XED_DN_XD5 r0 *1 0,0
Ccc_UP_XED_DN_XD5 UP XED_DN_XD5 1.21e-17
* device instance cc_UP_XED_DN_d1 r0 *1 0,0
Ccc_UP_XED_DN_d1 UP XED_DN_d1 1.21e-17
* device instance cc_UP_XED_DN_d2 r0 *1 0,0
Ccc_UP_XED_DN_d2 UP XED_DN_d2 1.21e-17
* device instance cc_UP_XED_DN_d3 r0 *1 0,0
Ccc_UP_XED_DN_d3 UP XED_DN_d3 1.21e-17
* device instance cc_UP_XED_DN_d4 r0 *1 0,0
Ccc_UP_XED_DN_d4 UP XED_DN_d4 1.21e-17
* device instance cc_UP_XED_DN_ntmp r0 *1 0,0
Ccc_UP_XED_DN_ntmp UP XED_DN_ntmp 1.8151e-17
* device instance cc_UP_XED_UP_XD5 r0 *1 0,0
Ccc_UP_XED_UP_XD5 UP XED_UP_XD5 1.21e-17
* device instance cc_UP_XED_UP_d1 r0 *1 0,0
Ccc_UP_XED_UP_d1 UP XED_UP_d1 1.21e-17
* device instance cc_UP_XED_UP_d2 r0 *1 0,0
Ccc_UP_XED_UP_d2 UP XED_UP_d2 1.21e-17
* device instance cc_UP_XED_UP_d3 r0 *1 0,0
Ccc_UP_XED_UP_d3 UP XED_UP_d3 1.21e-17
* device instance cc_UP_XED_UP_d4 r0 *1 0,0
Ccc_UP_XED_UP_d4 UP XED_UP_d4 1.21e-17
* device instance cc_UP_XED_UP_ntmp r0 *1 0,0
Ccc_UP_XED_UP_ntmp UP XED_UP_ntmp 1.8151e-17
* device instance cc_UP_XLD_RB r0 *1 0,0
Ccc_UP_XLD_RB UP XLD_RB 2.4201e-17
* device instance cc_UP_XLD_SB r0 *1 0,0
Ccc_UP_XLD_SB UP XLD_SB 2.4201e-17
* device instance cc_UP_XLD_XNQB_mid1 r0 *1 0,0
Ccc_UP_XLD_XNQB_mid1 UP XLD_XNQB_mid1 1.21e-17
* device instance cc_UP_XLD_XNQ_mid1 r0 *1 0,0
Ccc_UP_XLD_XNQ_mid1 UP XLD_XNQ_mid1 1.21e-17
* device instance cc_UP_XLU_RB r0 *1 0,0
Ccc_UP_XLU_RB UP XLU_RB 1.8151e-17
* device instance cc_UP_XLU_SB r0 *1 0,0
Ccc_UP_XLU_SB UP XLU_SB 1.21e-17
* device instance cc_UP_XLU_XNQB_mid1 r0 *1 0,0
Ccc_UP_XLU_XNQB_mid1 UP XLU_XNQB_mid1 1.21e-17
* device instance cc_UP_XLU_XNQ_mid1 r0 *1 0,0
Ccc_UP_XLU_XNQ_mid1 UP XLU_XNQ_mid1 1.1294e-17
* device instance cc_UP_XNR_mid1 r0 *1 0,0
Ccc_UP_XNR_mid1 UP XNR_mid1 1.21e-17
* device instance cc_UP_net1 r0 *1 0,0
Ccc_UP_net1 UP net1 3.0251e-17
* device instance cc_UP_net2 r0 *1 0,0
Ccc_UP_net2 UP net2 3.0251e-17
* device instance cc_UP_reset r0 *1 0,0
Ccc_UP_reset UP reset 2.4201e-17
* device instance cc_UP_reset_d1 r0 *1 0,0
Ccc_UP_reset_d1 UP reset_d1 1.21e-17
* device instance cc_UP_reset_d2 r0 *1 0,0
Ccc_UP_reset_d2 UP reset_d2 1.21e-17
* device instance cc_UP_reset_raw r0 *1 0,0
Ccc_UP_reset_raw UP reset_raw 1.21e-17
* device instance cc_UP_set_dn r0 *1 0,0
Ccc_UP_set_dn UP set_dn 1.8151e-17
* device instance cc_UP_set_up r0 *1 0,0
Ccc_UP_set_up UP set_up 1.21e-17
* device instance cc_VDD_XED_DN_XD5 r0 *1 0,0
Ccc_VDD_XED_DN_XD5 VDD XED_DN_XD5 1.7344e-17
* device instance cc_VDD_XED_DN_d1 r0 *1 0,0
Ccc_VDD_XED_DN_d1 VDD XED_DN_d1 1.7344e-17
* device instance cc_VDD_XED_DN_d2 r0 *1 0,0
Ccc_VDD_XED_DN_d2 VDD XED_DN_d2 1.7344e-17
* device instance cc_VDD_XED_DN_d3 r0 *1 0,0
Ccc_VDD_XED_DN_d3 VDD XED_DN_d3 1.7344e-17
* device instance cc_VDD_XED_DN_d4 r0 *1 0,0
Ccc_VDD_XED_DN_d4 VDD XED_DN_d4 1.7344e-17
* device instance cc_VDD_XED_DN_ntmp r0 *1 0,0
Ccc_VDD_XED_DN_ntmp VDD XED_DN_ntmp 2.8638e-17
* device instance cc_VDD_XED_UP_XD5 r0 *1 0,0
Ccc_VDD_XED_UP_XD5 VDD XED_UP_XD5 1.7344e-17
* device instance cc_VDD_XED_UP_d1 r0 *1 0,0
Ccc_VDD_XED_UP_d1 VDD XED_UP_d1 1.7344e-17
* device instance cc_VDD_XED_UP_d2 r0 *1 0,0
Ccc_VDD_XED_UP_d2 VDD XED_UP_d2 1.7344e-17
* device instance cc_VDD_XED_UP_d3 r0 *1 0,0
Ccc_VDD_XED_UP_d3 VDD XED_UP_d3 1.7344e-17
* device instance cc_VDD_XED_UP_d4 r0 *1 0,0
Ccc_VDD_XED_UP_d4 VDD XED_UP_d4 1.7344e-17
* device instance cc_VDD_XED_UP_ntmp r0 *1 0,0
Ccc_VDD_XED_UP_ntmp VDD XED_UP_ntmp 2.8638e-17
* device instance cc_VDD_XLD_RB r0 *1 0,0
Ccc_VDD_XLD_RB VDD XLD_RB 1.7344e-17
* device instance cc_VDD_XLD_SB r0 *1 0,0
Ccc_VDD_XLD_SB VDD XLD_SB 1.7344e-17
* device instance cc_VDD_XLU_RB r0 *1 0,0
Ccc_VDD_XLU_RB VDD XLU_RB 1.7344e-17
* device instance cc_VDD_XLU_SB r0 *1 0,0
Ccc_VDD_XLU_SB VDD XLU_SB 1.7344e-17
* device instance cc_VDD_net1 r0 *1 0,0
Ccc_VDD_net1 VDD net1 2.8638e-17
* device instance cc_VDD_net2 r0 *1 0,0
Ccc_VDD_net2 VDD net2 2.8638e-17
* device instance cc_VDD_reset r0 *1 0,0
Ccc_VDD_reset VDD reset 1.7344e-17
* device instance cc_VDD_reset_d1 r0 *1 0,0
Ccc_VDD_reset_d1 VDD reset_d1 1.7344e-17
* device instance cc_VDD_reset_d2 r0 *1 0,0
Ccc_VDD_reset_d2 VDD reset_d2 1.7344e-17
* device instance cc_VDD_reset_raw r0 *1 0,0
Ccc_VDD_reset_raw VDD reset_raw 2.8638e-17
* device instance cc_VDD_set_dn r0 *1 0,0
Ccc_VDD_set_dn VDD set_dn 1.7344e-17
* device instance cc_VDD_set_up r0 *1 0,0
Ccc_VDD_set_up VDD set_up 1.7344e-17
* device instance cc_VSS_XED_DN_XD5 r0 *1 0,0
Ccc_VSS_XED_DN_XD5 VSS XED_DN_XD5 1.7344e-17
* device instance cc_VSS_XED_DN_XN1_mid1 r0 *1 0,0
Ccc_VSS_XED_DN_XN1_mid1 VSS XED_DN_XN1_mid1 1.7344e-17
* device instance cc_VSS_XED_DN_d1 r0 *1 0,0
Ccc_VSS_XED_DN_d1 VSS XED_DN_d1 1.7344e-17
* device instance cc_VSS_XED_DN_d2 r0 *1 0,0
Ccc_VSS_XED_DN_d2 VSS XED_DN_d2 1.7344e-17
* device instance cc_VSS_XED_DN_d3 r0 *1 0,0
Ccc_VSS_XED_DN_d3 VSS XED_DN_d3 1.7344e-17
* device instance cc_VSS_XED_DN_d4 r0 *1 0,0
Ccc_VSS_XED_DN_d4 VSS XED_DN_d4 1.7344e-17
* device instance cc_VSS_XED_DN_ntmp r0 *1 0,0
Ccc_VSS_XED_DN_ntmp VSS XED_DN_ntmp 1.21e-17
* device instance cc_VSS_XED_UP_XD5 r0 *1 0,0
Ccc_VSS_XED_UP_XD5 VSS XED_UP_XD5 1.7344e-17
* device instance cc_VSS_XED_UP_XN1_mid1 r0 *1 0,0
Ccc_VSS_XED_UP_XN1_mid1 VSS XED_UP_XN1_mid1 1.7344e-17
* device instance cc_VSS_XED_UP_d1 r0 *1 0,0
Ccc_VSS_XED_UP_d1 VSS XED_UP_d1 1.7344e-17
* device instance cc_VSS_XED_UP_d2 r0 *1 0,0
Ccc_VSS_XED_UP_d2 VSS XED_UP_d2 1.7344e-17
* device instance cc_VSS_XED_UP_d3 r0 *1 0,0
Ccc_VSS_XED_UP_d3 VSS XED_UP_d3 1.7344e-17
* device instance cc_VSS_XED_UP_d4 r0 *1 0,0
Ccc_VSS_XED_UP_d4 VSS XED_UP_d4 1.7344e-17
* device instance cc_VSS_XED_UP_ntmp r0 *1 0,0
Ccc_VSS_XED_UP_ntmp VSS XED_UP_ntmp 1.21e-17
* device instance cc_VSS_XLD_RB r0 *1 0,0
Ccc_VSS_XLD_RB VSS XLD_RB 1.7344e-17
* device instance cc_VSS_XLD_SB r0 *1 0,0
Ccc_VSS_XLD_SB VSS XLD_SB 1.7344e-17
* device instance cc_VSS_XLD_XNQB_mid1 r0 *1 0,0
Ccc_VSS_XLD_XNQB_mid1 VSS XLD_XNQB_mid1 1.7344e-17
* device instance cc_VSS_XLD_XNQ_mid1 r0 *1 0,0
Ccc_VSS_XLD_XNQ_mid1 VSS XLD_XNQ_mid1 1.7344e-17
* device instance cc_VSS_XLU_RB r0 *1 0,0
Ccc_VSS_XLU_RB VSS XLU_RB 1.7344e-17
* device instance cc_VSS_XLU_SB r0 *1 0,0
Ccc_VSS_XLU_SB VSS XLU_SB 1.7344e-17
* device instance cc_VSS_XLU_XNQB_mid1 r0 *1 0,0
Ccc_VSS_XLU_XNQB_mid1 VSS XLU_XNQB_mid1 1.7344e-17
* device instance cc_VSS_XLU_XNQ_mid1 r0 *1 0,0
Ccc_VSS_XLU_XNQ_mid1 VSS XLU_XNQ_mid1 1.7344e-17
* device instance cc_VSS_XNR_mid1 r0 *1 0,0
Ccc_VSS_XNR_mid1 VSS XNR_mid1 1.7344e-17
* device instance cc_VSS_net1 r0 *1 0,0
Ccc_VSS_net1 VSS net1 1.21e-17
* device instance cc_VSS_net2 r0 *1 0,0
Ccc_VSS_net2 VSS net2 1.21e-17
* device instance cc_VSS_reset r0 *1 0,0
Ccc_VSS_reset VSS reset 1.7344e-17
* device instance cc_VSS_reset_d1 r0 *1 0,0
Ccc_VSS_reset_d1 VSS reset_d1 1.7344e-17
* device instance cc_VSS_reset_d2 r0 *1 0,0
Ccc_VSS_reset_d2 VSS reset_d2 1.7344e-17
* device instance cc_VSS_reset_raw r0 *1 0,0
Ccc_VSS_reset_raw VSS reset_raw 1.21e-17
* device instance cc_VSS_set_dn r0 *1 0,0
Ccc_VSS_set_dn VSS set_dn 1.7344e-17
* device instance cc_VSS_set_up r0 *1 0,0
Ccc_VSS_set_up VSS set_up 1.7344e-17
* device instance cc_XED_DN_XD5_XED_DN_XN1_mid1 r0 *1 0,0
Ccc_XED_DN_XD5_XED_DN_XN1_mid1 XED_DN_XD5 XED_DN_XN1_mid1 1.21e-17
* device instance cc_XED_DN_XD5_XED_DN_d1 r0 *1 0,0
Ccc_XED_DN_XD5_XED_DN_d1 XED_DN_XD5 XED_DN_d1 1.21e-17
* device instance cc_XED_DN_XD5_XED_DN_d2 r0 *1 0,0
Ccc_XED_DN_XD5_XED_DN_d2 XED_DN_XD5 XED_DN_d2 1.21e-17
* device instance cc_XED_DN_XD5_XED_DN_d3 r0 *1 0,0
Ccc_XED_DN_XD5_XED_DN_d3 XED_DN_XD5 XED_DN_d3 1.21e-17
* device instance cc_XED_DN_XD5_XED_DN_d4 r0 *1 0,0
Ccc_XED_DN_XD5_XED_DN_d4 XED_DN_XD5 XED_DN_d4 1.21e-17
* device instance cc_XED_DN_XD5_XED_DN_ntmp r0 *1 0,0
Ccc_XED_DN_XD5_XED_DN_ntmp XED_DN_XD5 XED_DN_ntmp 1.8151e-17
* device instance cc_XED_DN_XD5_XED_UP_XD5 r0 *1 0,0
Ccc_XED_DN_XD5_XED_UP_XD5 XED_DN_XD5 XED_UP_XD5 1.21e-17
* device instance cc_XED_DN_XD5_XED_UP_d1 r0 *1 0,0
Ccc_XED_DN_XD5_XED_UP_d1 XED_DN_XD5 XED_UP_d1 1.21e-17
* device instance cc_XED_DN_XD5_XED_UP_d2 r0 *1 0,0
Ccc_XED_DN_XD5_XED_UP_d2 XED_DN_XD5 XED_UP_d2 1.21e-17
* device instance cc_XED_DN_XD5_XED_UP_d3 r0 *1 0,0
Ccc_XED_DN_XD5_XED_UP_d3 XED_DN_XD5 XED_UP_d3 1.21e-17
* device instance cc_XED_DN_XD5_XED_UP_d4 r0 *1 0,0
Ccc_XED_DN_XD5_XED_UP_d4 XED_DN_XD5 XED_UP_d4 1.21e-17
* device instance cc_XED_DN_XD5_XED_UP_ntmp r0 *1 0,0
Ccc_XED_DN_XD5_XED_UP_ntmp XED_DN_XD5 XED_UP_ntmp 1.8151e-17
* device instance cc_XED_DN_XD5_XLD_RB r0 *1 0,0
Ccc_XED_DN_XD5_XLD_RB XED_DN_XD5 XLD_RB 1.21e-17
* device instance cc_XED_DN_XD5_XLD_SB r0 *1 0,0
Ccc_XED_DN_XD5_XLD_SB XED_DN_XD5 XLD_SB 1.21e-17
* device instance cc_XED_DN_XD5_XLD_XNQB_mid1 r0 *1 0,0
Ccc_XED_DN_XD5_XLD_XNQB_mid1 XED_DN_XD5 XLD_XNQB_mid1 1.21e-17
* device instance cc_XED_DN_XD5_XLD_XNQ_mid1 r0 *1 0,0
Ccc_XED_DN_XD5_XLD_XNQ_mid1 XED_DN_XD5 XLD_XNQ_mid1 1.21e-17
* device instance cc_XED_DN_XD5_XLU_RB r0 *1 0,0
Ccc_XED_DN_XD5_XLU_RB XED_DN_XD5 XLU_RB 1.21e-17
* device instance cc_XED_DN_XD5_XLU_SB r0 *1 0,0
Ccc_XED_DN_XD5_XLU_SB XED_DN_XD5 XLU_SB 1.21e-17
* device instance cc_XED_DN_XD5_XLU_XNQB_mid1 r0 *1 0,0
Ccc_XED_DN_XD5_XLU_XNQB_mid1 XED_DN_XD5 XLU_XNQB_mid1 1.21e-17
* device instance cc_XED_DN_XD5_XLU_XNQ_mid1 r0 *1 0,0
Ccc_XED_DN_XD5_XLU_XNQ_mid1 XED_DN_XD5 XLU_XNQ_mid1 1.21e-17
* device instance cc_XED_DN_XD5_XNR_mid1 r0 *1 0,0
Ccc_XED_DN_XD5_XNR_mid1 XED_DN_XD5 XNR_mid1 1.21e-17
* device instance cc_XED_DN_XD5_net1 r0 *1 0,0
Ccc_XED_DN_XD5_net1 XED_DN_XD5 net1 1.21e-17
* device instance cc_XED_DN_XD5_net2 r0 *1 0,0
Ccc_XED_DN_XD5_net2 XED_DN_XD5 net2 1.21e-17
* device instance cc_XED_DN_XD5_reset r0 *1 0,0
Ccc_XED_DN_XD5_reset XED_DN_XD5 reset 1.8151e-17
* device instance cc_XED_DN_XD5_reset_d1 r0 *1 0,0
Ccc_XED_DN_XD5_reset_d1 XED_DN_XD5 reset_d1 1.21e-17
* device instance cc_XED_DN_XD5_reset_d2 r0 *1 0,0
Ccc_XED_DN_XD5_reset_d2 XED_DN_XD5 reset_d2 1.21e-17
* device instance cc_XED_DN_XD5_reset_raw r0 *1 0,0
Ccc_XED_DN_XD5_reset_raw XED_DN_XD5 reset_raw 1.21e-17
* device instance cc_XED_DN_XD5_set_dn r0 *1 0,0
Ccc_XED_DN_XD5_set_dn XED_DN_XD5 set_dn 1.21e-17
* device instance cc_XED_DN_XD5_set_up r0 *1 0,0
Ccc_XED_DN_XD5_set_up XED_DN_XD5 set_up 1.21e-17
* device instance cc_XED_DN_XN1_mid1_XED_DN_ntmp r0 *1 0,0
Ccc_XED_DN_XN1_mid1_XED_DN_ntmp XED_DN_XN1_mid1 XED_DN_ntmp 1.1294e-17
* device instance cc_XED_DN_d1_XED_DN_d2 r0 *1 0,0
Ccc_XED_DN_d1_XED_DN_d2 XED_DN_d1 XED_DN_d2 1.21e-17
* device instance cc_XED_DN_d1_XED_DN_d3 r0 *1 0,0
Ccc_XED_DN_d1_XED_DN_d3 XED_DN_d1 XED_DN_d3 1.21e-17
* device instance cc_XED_DN_d1_XED_DN_d4 r0 *1 0,0
Ccc_XED_DN_d1_XED_DN_d4 XED_DN_d1 XED_DN_d4 1.21e-17
* device instance cc_XED_DN_d1_XED_DN_ntmp r0 *1 0,0
Ccc_XED_DN_d1_XED_DN_ntmp XED_DN_d1 XED_DN_ntmp 1.21e-17
* device instance cc_XED_DN_d1_XED_UP_XD5 r0 *1 0,0
Ccc_XED_DN_d1_XED_UP_XD5 XED_DN_d1 XED_UP_XD5 1.21e-17
* device instance cc_XED_DN_d1_XED_UP_d1 r0 *1 0,0
Ccc_XED_DN_d1_XED_UP_d1 XED_DN_d1 XED_UP_d1 1.21e-17
* device instance cc_XED_DN_d1_XED_UP_d2 r0 *1 0,0
Ccc_XED_DN_d1_XED_UP_d2 XED_DN_d1 XED_UP_d2 1.21e-17
* device instance cc_XED_DN_d1_XED_UP_d3 r0 *1 0,0
Ccc_XED_DN_d1_XED_UP_d3 XED_DN_d1 XED_UP_d3 1.21e-17
* device instance cc_XED_DN_d1_XED_UP_d4 r0 *1 0,0
Ccc_XED_DN_d1_XED_UP_d4 XED_DN_d1 XED_UP_d4 1.21e-17
* device instance cc_XED_DN_d1_XED_UP_ntmp r0 *1 0,0
Ccc_XED_DN_d1_XED_UP_ntmp XED_DN_d1 XED_UP_ntmp 1.8151e-17
* device instance cc_XED_DN_d1_XLD_RB r0 *1 0,0
Ccc_XED_DN_d1_XLD_RB XED_DN_d1 XLD_RB 1.21e-17
* device instance cc_XED_DN_d1_XLD_SB r0 *1 0,0
Ccc_XED_DN_d1_XLD_SB XED_DN_d1 XLD_SB 1.21e-17
* device instance cc_XED_DN_d1_XLD_XNQB_mid1 r0 *1 0,0
Ccc_XED_DN_d1_XLD_XNQB_mid1 XED_DN_d1 XLD_XNQB_mid1 1.21e-17
* device instance cc_XED_DN_d1_XLD_XNQ_mid1 r0 *1 0,0
Ccc_XED_DN_d1_XLD_XNQ_mid1 XED_DN_d1 XLD_XNQ_mid1 1.21e-17
* device instance cc_XED_DN_d1_XLU_RB r0 *1 0,0
Ccc_XED_DN_d1_XLU_RB XED_DN_d1 XLU_RB 1.21e-17
* device instance cc_XED_DN_d1_XLU_SB r0 *1 0,0
Ccc_XED_DN_d1_XLU_SB XED_DN_d1 XLU_SB 1.21e-17
* device instance cc_XED_DN_d1_XLU_XNQB_mid1 r0 *1 0,0
Ccc_XED_DN_d1_XLU_XNQB_mid1 XED_DN_d1 XLU_XNQB_mid1 1.21e-17
* device instance cc_XED_DN_d1_XLU_XNQ_mid1 r0 *1 0,0
Ccc_XED_DN_d1_XLU_XNQ_mid1 XED_DN_d1 XLU_XNQ_mid1 1.21e-17
* device instance cc_XED_DN_d1_XNR_mid1 r0 *1 0,0
Ccc_XED_DN_d1_XNR_mid1 XED_DN_d1 XNR_mid1 1.21e-17
* device instance cc_XED_DN_d1_net1 r0 *1 0,0
Ccc_XED_DN_d1_net1 XED_DN_d1 net1 1.21e-17
* device instance cc_XED_DN_d1_net2 r0 *1 0,0
Ccc_XED_DN_d1_net2 XED_DN_d1 net2 1.21e-17
* device instance cc_XED_DN_d1_reset r0 *1 0,0
Ccc_XED_DN_d1_reset XED_DN_d1 reset 1.8151e-17
* device instance cc_XED_DN_d1_reset_d1 r0 *1 0,0
Ccc_XED_DN_d1_reset_d1 XED_DN_d1 reset_d1 1.21e-17
* device instance cc_XED_DN_d1_reset_d2 r0 *1 0,0
Ccc_XED_DN_d1_reset_d2 XED_DN_d1 reset_d2 1.21e-17
* device instance cc_XED_DN_d1_reset_raw r0 *1 0,0
Ccc_XED_DN_d1_reset_raw XED_DN_d1 reset_raw 1.21e-17
* device instance cc_XED_DN_d1_set_dn r0 *1 0,0
Ccc_XED_DN_d1_set_dn XED_DN_d1 set_dn 1.21e-17
* device instance cc_XED_DN_d1_set_up r0 *1 0,0
Ccc_XED_DN_d1_set_up XED_DN_d1 set_up 1.21e-17
* device instance cc_XED_DN_d2_XED_DN_d3 r0 *1 0,0
Ccc_XED_DN_d2_XED_DN_d3 XED_DN_d2 XED_DN_d3 1.21e-17
* device instance cc_XED_DN_d2_XED_DN_d4 r0 *1 0,0
Ccc_XED_DN_d2_XED_DN_d4 XED_DN_d2 XED_DN_d4 1.21e-17
* device instance cc_XED_DN_d2_XED_DN_ntmp r0 *1 0,0
Ccc_XED_DN_d2_XED_DN_ntmp XED_DN_d2 XED_DN_ntmp 1.21e-17
* device instance cc_XED_DN_d2_XED_UP_XD5 r0 *1 0,0
Ccc_XED_DN_d2_XED_UP_XD5 XED_DN_d2 XED_UP_XD5 1.21e-17
* device instance cc_XED_DN_d2_XED_UP_d1 r0 *1 0,0
Ccc_XED_DN_d2_XED_UP_d1 XED_DN_d2 XED_UP_d1 1.21e-17
* device instance cc_XED_DN_d2_XED_UP_d2 r0 *1 0,0
Ccc_XED_DN_d2_XED_UP_d2 XED_DN_d2 XED_UP_d2 1.21e-17
* device instance cc_XED_DN_d2_XED_UP_d3 r0 *1 0,0
Ccc_XED_DN_d2_XED_UP_d3 XED_DN_d2 XED_UP_d3 1.21e-17
* device instance cc_XED_DN_d2_XED_UP_d4 r0 *1 0,0
Ccc_XED_DN_d2_XED_UP_d4 XED_DN_d2 XED_UP_d4 1.21e-17
* device instance cc_XED_DN_d2_XED_UP_ntmp r0 *1 0,0
Ccc_XED_DN_d2_XED_UP_ntmp XED_DN_d2 XED_UP_ntmp 1.8151e-17
* device instance cc_XED_DN_d2_XLD_RB r0 *1 0,0
Ccc_XED_DN_d2_XLD_RB XED_DN_d2 XLD_RB 1.21e-17
* device instance cc_XED_DN_d2_XLD_SB r0 *1 0,0
Ccc_XED_DN_d2_XLD_SB XED_DN_d2 XLD_SB 1.21e-17
* device instance cc_XED_DN_d2_XLD_XNQB_mid1 r0 *1 0,0
Ccc_XED_DN_d2_XLD_XNQB_mid1 XED_DN_d2 XLD_XNQB_mid1 1.21e-17
* device instance cc_XED_DN_d2_XLD_XNQ_mid1 r0 *1 0,0
Ccc_XED_DN_d2_XLD_XNQ_mid1 XED_DN_d2 XLD_XNQ_mid1 1.21e-17
* device instance cc_XED_DN_d2_XLU_RB r0 *1 0,0
Ccc_XED_DN_d2_XLU_RB XED_DN_d2 XLU_RB 1.21e-17
* device instance cc_XED_DN_d2_XLU_SB r0 *1 0,0
Ccc_XED_DN_d2_XLU_SB XED_DN_d2 XLU_SB 1.21e-17
* device instance cc_XED_DN_d2_XLU_XNQB_mid1 r0 *1 0,0
Ccc_XED_DN_d2_XLU_XNQB_mid1 XED_DN_d2 XLU_XNQB_mid1 1.21e-17
* device instance cc_XED_DN_d2_XLU_XNQ_mid1 r0 *1 0,0
Ccc_XED_DN_d2_XLU_XNQ_mid1 XED_DN_d2 XLU_XNQ_mid1 1.21e-17
* device instance cc_XED_DN_d2_XNR_mid1 r0 *1 0,0
Ccc_XED_DN_d2_XNR_mid1 XED_DN_d2 XNR_mid1 1.21e-17
* device instance cc_XED_DN_d2_net1 r0 *1 0,0
Ccc_XED_DN_d2_net1 XED_DN_d2 net1 1.21e-17
* device instance cc_XED_DN_d2_net2 r0 *1 0,0
Ccc_XED_DN_d2_net2 XED_DN_d2 net2 1.21e-17
* device instance cc_XED_DN_d2_reset r0 *1 0,0
Ccc_XED_DN_d2_reset XED_DN_d2 reset 1.8151e-17
* device instance cc_XED_DN_d2_reset_d1 r0 *1 0,0
Ccc_XED_DN_d2_reset_d1 XED_DN_d2 reset_d1 1.21e-17
* device instance cc_XED_DN_d2_reset_d2 r0 *1 0,0
Ccc_XED_DN_d2_reset_d2 XED_DN_d2 reset_d2 1.21e-17
* device instance cc_XED_DN_d2_reset_raw r0 *1 0,0
Ccc_XED_DN_d2_reset_raw XED_DN_d2 reset_raw 1.21e-17
* device instance cc_XED_DN_d2_set_dn r0 *1 0,0
Ccc_XED_DN_d2_set_dn XED_DN_d2 set_dn 1.21e-17
* device instance cc_XED_DN_d2_set_up r0 *1 0,0
Ccc_XED_DN_d2_set_up XED_DN_d2 set_up 1.21e-17
* device instance cc_XED_DN_d3_XED_DN_d4 r0 *1 0,0
Ccc_XED_DN_d3_XED_DN_d4 XED_DN_d3 XED_DN_d4 1.21e-17
* device instance cc_XED_DN_d3_XED_DN_ntmp r0 *1 0,0
Ccc_XED_DN_d3_XED_DN_ntmp XED_DN_d3 XED_DN_ntmp 1.21e-17
* device instance cc_XED_DN_d3_XED_UP_XD5 r0 *1 0,0
Ccc_XED_DN_d3_XED_UP_XD5 XED_DN_d3 XED_UP_XD5 1.21e-17
* device instance cc_XED_DN_d3_XED_UP_d1 r0 *1 0,0
Ccc_XED_DN_d3_XED_UP_d1 XED_DN_d3 XED_UP_d1 1.21e-17
* device instance cc_XED_DN_d3_XED_UP_d2 r0 *1 0,0
Ccc_XED_DN_d3_XED_UP_d2 XED_DN_d3 XED_UP_d2 1.21e-17
* device instance cc_XED_DN_d3_XED_UP_d3 r0 *1 0,0
Ccc_XED_DN_d3_XED_UP_d3 XED_DN_d3 XED_UP_d3 1.21e-17
* device instance cc_XED_DN_d3_XED_UP_d4 r0 *1 0,0
Ccc_XED_DN_d3_XED_UP_d4 XED_DN_d3 XED_UP_d4 1.21e-17
* device instance cc_XED_DN_d3_XED_UP_ntmp r0 *1 0,0
Ccc_XED_DN_d3_XED_UP_ntmp XED_DN_d3 XED_UP_ntmp 1.8151e-17
* device instance cc_XED_DN_d3_XLD_RB r0 *1 0,0
Ccc_XED_DN_d3_XLD_RB XED_DN_d3 XLD_RB 1.21e-17
* device instance cc_XED_DN_d3_XLD_SB r0 *1 0,0
Ccc_XED_DN_d3_XLD_SB XED_DN_d3 XLD_SB 1.21e-17
* device instance cc_XED_DN_d3_XLD_XNQB_mid1 r0 *1 0,0
Ccc_XED_DN_d3_XLD_XNQB_mid1 XED_DN_d3 XLD_XNQB_mid1 1.21e-17
* device instance cc_XED_DN_d3_XLD_XNQ_mid1 r0 *1 0,0
Ccc_XED_DN_d3_XLD_XNQ_mid1 XED_DN_d3 XLD_XNQ_mid1 1.21e-17
* device instance cc_XED_DN_d3_XLU_RB r0 *1 0,0
Ccc_XED_DN_d3_XLU_RB XED_DN_d3 XLU_RB 1.21e-17
* device instance cc_XED_DN_d3_XLU_SB r0 *1 0,0
Ccc_XED_DN_d3_XLU_SB XED_DN_d3 XLU_SB 1.21e-17
* device instance cc_XED_DN_d3_XLU_XNQB_mid1 r0 *1 0,0
Ccc_XED_DN_d3_XLU_XNQB_mid1 XED_DN_d3 XLU_XNQB_mid1 1.21e-17
* device instance cc_XED_DN_d3_XLU_XNQ_mid1 r0 *1 0,0
Ccc_XED_DN_d3_XLU_XNQ_mid1 XED_DN_d3 XLU_XNQ_mid1 1.21e-17
* device instance cc_XED_DN_d3_XNR_mid1 r0 *1 0,0
Ccc_XED_DN_d3_XNR_mid1 XED_DN_d3 XNR_mid1 1.21e-17
* device instance cc_XED_DN_d3_net1 r0 *1 0,0
Ccc_XED_DN_d3_net1 XED_DN_d3 net1 1.21e-17
* device instance cc_XED_DN_d3_net2 r0 *1 0,0
Ccc_XED_DN_d3_net2 XED_DN_d3 net2 1.21e-17
* device instance cc_XED_DN_d3_reset r0 *1 0,0
Ccc_XED_DN_d3_reset XED_DN_d3 reset 1.8151e-17
* device instance cc_XED_DN_d3_reset_d1 r0 *1 0,0
Ccc_XED_DN_d3_reset_d1 XED_DN_d3 reset_d1 1.21e-17
* device instance cc_XED_DN_d3_reset_d2 r0 *1 0,0
Ccc_XED_DN_d3_reset_d2 XED_DN_d3 reset_d2 1.21e-17
* device instance cc_XED_DN_d3_reset_raw r0 *1 0,0
Ccc_XED_DN_d3_reset_raw XED_DN_d3 reset_raw 1.21e-17
* device instance cc_XED_DN_d3_set_dn r0 *1 0,0
Ccc_XED_DN_d3_set_dn XED_DN_d3 set_dn 1.21e-17
* device instance cc_XED_DN_d3_set_up r0 *1 0,0
Ccc_XED_DN_d3_set_up XED_DN_d3 set_up 1.21e-17
* device instance cc_XED_DN_d4_XED_DN_ntmp r0 *1 0,0
Ccc_XED_DN_d4_XED_DN_ntmp XED_DN_d4 XED_DN_ntmp 1.21e-17
* device instance cc_XED_DN_d4_XED_UP_XD5 r0 *1 0,0
Ccc_XED_DN_d4_XED_UP_XD5 XED_DN_d4 XED_UP_XD5 1.21e-17
* device instance cc_XED_DN_d4_XED_UP_d1 r0 *1 0,0
Ccc_XED_DN_d4_XED_UP_d1 XED_DN_d4 XED_UP_d1 1.21e-17
* device instance cc_XED_DN_d4_XED_UP_d2 r0 *1 0,0
Ccc_XED_DN_d4_XED_UP_d2 XED_DN_d4 XED_UP_d2 1.21e-17
* device instance cc_XED_DN_d4_XED_UP_d3 r0 *1 0,0
Ccc_XED_DN_d4_XED_UP_d3 XED_DN_d4 XED_UP_d3 1.21e-17
* device instance cc_XED_DN_d4_XED_UP_d4 r0 *1 0,0
Ccc_XED_DN_d4_XED_UP_d4 XED_DN_d4 XED_UP_d4 1.21e-17
* device instance cc_XED_DN_d4_XED_UP_ntmp r0 *1 0,0
Ccc_XED_DN_d4_XED_UP_ntmp XED_DN_d4 XED_UP_ntmp 1.8151e-17
* device instance cc_XED_DN_d4_XLD_RB r0 *1 0,0
Ccc_XED_DN_d4_XLD_RB XED_DN_d4 XLD_RB 1.21e-17
* device instance cc_XED_DN_d4_XLD_SB r0 *1 0,0
Ccc_XED_DN_d4_XLD_SB XED_DN_d4 XLD_SB 1.21e-17
* device instance cc_XED_DN_d4_XLD_XNQB_mid1 r0 *1 0,0
Ccc_XED_DN_d4_XLD_XNQB_mid1 XED_DN_d4 XLD_XNQB_mid1 1.21e-17
* device instance cc_XED_DN_d4_XLD_XNQ_mid1 r0 *1 0,0
Ccc_XED_DN_d4_XLD_XNQ_mid1 XED_DN_d4 XLD_XNQ_mid1 1.21e-17
* device instance cc_XED_DN_d4_XLU_RB r0 *1 0,0
Ccc_XED_DN_d4_XLU_RB XED_DN_d4 XLU_RB 1.21e-17
* device instance cc_XED_DN_d4_XLU_SB r0 *1 0,0
Ccc_XED_DN_d4_XLU_SB XED_DN_d4 XLU_SB 1.21e-17
* device instance cc_XED_DN_d4_XLU_XNQB_mid1 r0 *1 0,0
Ccc_XED_DN_d4_XLU_XNQB_mid1 XED_DN_d4 XLU_XNQB_mid1 1.21e-17
* device instance cc_XED_DN_d4_XLU_XNQ_mid1 r0 *1 0,0
Ccc_XED_DN_d4_XLU_XNQ_mid1 XED_DN_d4 XLU_XNQ_mid1 1.21e-17
* device instance cc_XED_DN_d4_XNR_mid1 r0 *1 0,0
Ccc_XED_DN_d4_XNR_mid1 XED_DN_d4 XNR_mid1 1.21e-17
* device instance cc_XED_DN_d4_net1 r0 *1 0,0
Ccc_XED_DN_d4_net1 XED_DN_d4 net1 1.21e-17
* device instance cc_XED_DN_d4_net2 r0 *1 0,0
Ccc_XED_DN_d4_net2 XED_DN_d4 net2 1.21e-17
* device instance cc_XED_DN_d4_reset r0 *1 0,0
Ccc_XED_DN_d4_reset XED_DN_d4 reset 1.8151e-17
* device instance cc_XED_DN_d4_reset_d1 r0 *1 0,0
Ccc_XED_DN_d4_reset_d1 XED_DN_d4 reset_d1 1.21e-17
* device instance cc_XED_DN_d4_reset_d2 r0 *1 0,0
Ccc_XED_DN_d4_reset_d2 XED_DN_d4 reset_d2 1.21e-17
* device instance cc_XED_DN_d4_reset_raw r0 *1 0,0
Ccc_XED_DN_d4_reset_raw XED_DN_d4 reset_raw 1.21e-17
* device instance cc_XED_DN_d4_set_dn r0 *1 0,0
Ccc_XED_DN_d4_set_dn XED_DN_d4 set_dn 1.21e-17
* device instance cc_XED_DN_d4_set_up r0 *1 0,0
Ccc_XED_DN_d4_set_up XED_DN_d4 set_up 1.21e-17
* device instance cc_XED_DN_ntmp_XED_UP_XD5 r0 *1 0,0
Ccc_XED_DN_ntmp_XED_UP_XD5 XED_DN_ntmp XED_UP_XD5 1.21e-17
* device instance cc_XED_DN_ntmp_XED_UP_d1 r0 *1 0,0
Ccc_XED_DN_ntmp_XED_UP_d1 XED_DN_ntmp XED_UP_d1 1.21e-17
* device instance cc_XED_DN_ntmp_XED_UP_d2 r0 *1 0,0
Ccc_XED_DN_ntmp_XED_UP_d2 XED_DN_ntmp XED_UP_d2 1.21e-17
* device instance cc_XED_DN_ntmp_XED_UP_d3 r0 *1 0,0
Ccc_XED_DN_ntmp_XED_UP_d3 XED_DN_ntmp XED_UP_d3 1.21e-17
* device instance cc_XED_DN_ntmp_XED_UP_d4 r0 *1 0,0
Ccc_XED_DN_ntmp_XED_UP_d4 XED_DN_ntmp XED_UP_d4 1.21e-17
* device instance cc_XED_DN_ntmp_XED_UP_ntmp r0 *1 0,0
Ccc_XED_DN_ntmp_XED_UP_ntmp XED_DN_ntmp XED_UP_ntmp 1.8151e-17
* device instance cc_XED_DN_ntmp_XLD_RB r0 *1 0,0
Ccc_XED_DN_ntmp_XLD_RB XED_DN_ntmp XLD_RB 1.21e-17
* device instance cc_XED_DN_ntmp_XLD_SB r0 *1 0,0
Ccc_XED_DN_ntmp_XLD_SB XED_DN_ntmp XLD_SB 1.21e-17
* device instance cc_XED_DN_ntmp_XLD_XNQB_mid1 r0 *1 0,0
Ccc_XED_DN_ntmp_XLD_XNQB_mid1 XED_DN_ntmp XLD_XNQB_mid1 1.21e-17
* device instance cc_XED_DN_ntmp_XLD_XNQ_mid1 r0 *1 0,0
Ccc_XED_DN_ntmp_XLD_XNQ_mid1 XED_DN_ntmp XLD_XNQ_mid1 1.21e-17
* device instance cc_XED_DN_ntmp_XLU_RB r0 *1 0,0
Ccc_XED_DN_ntmp_XLU_RB XED_DN_ntmp XLU_RB 1.21e-17
* device instance cc_XED_DN_ntmp_XLU_SB r0 *1 0,0
Ccc_XED_DN_ntmp_XLU_SB XED_DN_ntmp XLU_SB 1.21e-17
* device instance cc_XED_DN_ntmp_XLU_XNQB_mid1 r0 *1 0,0
Ccc_XED_DN_ntmp_XLU_XNQB_mid1 XED_DN_ntmp XLU_XNQB_mid1 1.21e-17
* device instance cc_XED_DN_ntmp_XLU_XNQ_mid1 r0 *1 0,0
Ccc_XED_DN_ntmp_XLU_XNQ_mid1 XED_DN_ntmp XLU_XNQ_mid1 1.21e-17
* device instance cc_XED_DN_ntmp_XNR_mid1 r0 *1 0,0
Ccc_XED_DN_ntmp_XNR_mid1 XED_DN_ntmp XNR_mid1 1.21e-17
* device instance cc_XED_DN_ntmp_net1 r0 *1 0,0
Ccc_XED_DN_ntmp_net1 XED_DN_ntmp net1 1.21e-17
* device instance cc_XED_DN_ntmp_net2 r0 *1 0,0
Ccc_XED_DN_ntmp_net2 XED_DN_ntmp net2 1.21e-17
* device instance cc_XED_DN_ntmp_reset r0 *1 0,0
Ccc_XED_DN_ntmp_reset XED_DN_ntmp reset 1.8151e-17
* device instance cc_XED_DN_ntmp_reset_d1 r0 *1 0,0
Ccc_XED_DN_ntmp_reset_d1 XED_DN_ntmp reset_d1 1.21e-17
* device instance cc_XED_DN_ntmp_reset_d2 r0 *1 0,0
Ccc_XED_DN_ntmp_reset_d2 XED_DN_ntmp reset_d2 1.21e-17
* device instance cc_XED_DN_ntmp_reset_raw r0 *1 0,0
Ccc_XED_DN_ntmp_reset_raw XED_DN_ntmp reset_raw 1.21e-17
* device instance cc_XED_DN_ntmp_set_dn r0 *1 0,0
Ccc_XED_DN_ntmp_set_dn XED_DN_ntmp set_dn 1.21e-17
* device instance cc_XED_DN_ntmp_set_up r0 *1 0,0
Ccc_XED_DN_ntmp_set_up XED_DN_ntmp set_up 1.21e-17
* device instance cc_XED_UP_XD5_XED_UP_XN1_mid1 r0 *1 0,0
Ccc_XED_UP_XD5_XED_UP_XN1_mid1 XED_UP_XD5 XED_UP_XN1_mid1 1.21e-17
* device instance cc_XED_UP_XD5_XED_UP_d1 r0 *1 0,0
Ccc_XED_UP_XD5_XED_UP_d1 XED_UP_XD5 XED_UP_d1 1.21e-17
* device instance cc_XED_UP_XD5_XED_UP_d2 r0 *1 0,0
Ccc_XED_UP_XD5_XED_UP_d2 XED_UP_XD5 XED_UP_d2 1.21e-17
* device instance cc_XED_UP_XD5_XED_UP_d3 r0 *1 0,0
Ccc_XED_UP_XD5_XED_UP_d3 XED_UP_XD5 XED_UP_d3 1.21e-17
* device instance cc_XED_UP_XD5_XED_UP_d4 r0 *1 0,0
Ccc_XED_UP_XD5_XED_UP_d4 XED_UP_XD5 XED_UP_d4 1.21e-17
* device instance cc_XED_UP_XD5_XED_UP_ntmp r0 *1 0,0
Ccc_XED_UP_XD5_XED_UP_ntmp XED_UP_XD5 XED_UP_ntmp 1.8151e-17
* device instance cc_XED_UP_XD5_XLD_RB r0 *1 0,0
Ccc_XED_UP_XD5_XLD_RB XED_UP_XD5 XLD_RB 1.21e-17
* device instance cc_XED_UP_XD5_XLD_SB r0 *1 0,0
Ccc_XED_UP_XD5_XLD_SB XED_UP_XD5 XLD_SB 1.21e-17
* device instance cc_XED_UP_XD5_XLD_XNQB_mid1 r0 *1 0,0
Ccc_XED_UP_XD5_XLD_XNQB_mid1 XED_UP_XD5 XLD_XNQB_mid1 1.21e-17
* device instance cc_XED_UP_XD5_XLD_XNQ_mid1 r0 *1 0,0
Ccc_XED_UP_XD5_XLD_XNQ_mid1 XED_UP_XD5 XLD_XNQ_mid1 1.21e-17
* device instance cc_XED_UP_XD5_XLU_RB r0 *1 0,0
Ccc_XED_UP_XD5_XLU_RB XED_UP_XD5 XLU_RB 1.21e-17
* device instance cc_XED_UP_XD5_XLU_SB r0 *1 0,0
Ccc_XED_UP_XD5_XLU_SB XED_UP_XD5 XLU_SB 1.21e-17
* device instance cc_XED_UP_XD5_XLU_XNQB_mid1 r0 *1 0,0
Ccc_XED_UP_XD5_XLU_XNQB_mid1 XED_UP_XD5 XLU_XNQB_mid1 1.21e-17
* device instance cc_XED_UP_XD5_XLU_XNQ_mid1 r0 *1 0,0
Ccc_XED_UP_XD5_XLU_XNQ_mid1 XED_UP_XD5 XLU_XNQ_mid1 1.21e-17
* device instance cc_XED_UP_XD5_XNR_mid1 r0 *1 0,0
Ccc_XED_UP_XD5_XNR_mid1 XED_UP_XD5 XNR_mid1 1.21e-17
* device instance cc_XED_UP_XD5_net1 r0 *1 0,0
Ccc_XED_UP_XD5_net1 XED_UP_XD5 net1 1.21e-17
* device instance cc_XED_UP_XD5_net2 r0 *1 0,0
Ccc_XED_UP_XD5_net2 XED_UP_XD5 net2 1.21e-17
* device instance cc_XED_UP_XD5_reset r0 *1 0,0
Ccc_XED_UP_XD5_reset XED_UP_XD5 reset 1.8151e-17
* device instance cc_XED_UP_XD5_reset_d1 r0 *1 0,0
Ccc_XED_UP_XD5_reset_d1 XED_UP_XD5 reset_d1 1.21e-17
* device instance cc_XED_UP_XD5_reset_d2 r0 *1 0,0
Ccc_XED_UP_XD5_reset_d2 XED_UP_XD5 reset_d2 1.21e-17
* device instance cc_XED_UP_XD5_reset_raw r0 *1 0,0
Ccc_XED_UP_XD5_reset_raw XED_UP_XD5 reset_raw 1.21e-17
* device instance cc_XED_UP_XD5_set_dn r0 *1 0,0
Ccc_XED_UP_XD5_set_dn XED_UP_XD5 set_dn 1.21e-17
* device instance cc_XED_UP_XD5_set_up r0 *1 0,0
Ccc_XED_UP_XD5_set_up XED_UP_XD5 set_up 1.21e-17
* device instance cc_XED_UP_XN1_mid1_XED_UP_ntmp r0 *1 0,0
Ccc_XED_UP_XN1_mid1_XED_UP_ntmp XED_UP_XN1_mid1 XED_UP_ntmp 1.1294e-17
* device instance cc_XED_UP_d1_XED_UP_d2 r0 *1 0,0
Ccc_XED_UP_d1_XED_UP_d2 XED_UP_d1 XED_UP_d2 1.21e-17
* device instance cc_XED_UP_d1_XED_UP_d3 r0 *1 0,0
Ccc_XED_UP_d1_XED_UP_d3 XED_UP_d1 XED_UP_d3 1.21e-17
* device instance cc_XED_UP_d1_XED_UP_d4 r0 *1 0,0
Ccc_XED_UP_d1_XED_UP_d4 XED_UP_d1 XED_UP_d4 1.21e-17
* device instance cc_XED_UP_d1_XED_UP_ntmp r0 *1 0,0
Ccc_XED_UP_d1_XED_UP_ntmp XED_UP_d1 XED_UP_ntmp 1.21e-17
* device instance cc_XED_UP_d1_XLD_RB r0 *1 0,0
Ccc_XED_UP_d1_XLD_RB XED_UP_d1 XLD_RB 1.21e-17
* device instance cc_XED_UP_d1_XLD_SB r0 *1 0,0
Ccc_XED_UP_d1_XLD_SB XED_UP_d1 XLD_SB 1.21e-17
* device instance cc_XED_UP_d1_XLD_XNQB_mid1 r0 *1 0,0
Ccc_XED_UP_d1_XLD_XNQB_mid1 XED_UP_d1 XLD_XNQB_mid1 1.21e-17
* device instance cc_XED_UP_d1_XLD_XNQ_mid1 r0 *1 0,0
Ccc_XED_UP_d1_XLD_XNQ_mid1 XED_UP_d1 XLD_XNQ_mid1 1.21e-17
* device instance cc_XED_UP_d1_XLU_RB r0 *1 0,0
Ccc_XED_UP_d1_XLU_RB XED_UP_d1 XLU_RB 1.21e-17
* device instance cc_XED_UP_d1_XLU_SB r0 *1 0,0
Ccc_XED_UP_d1_XLU_SB XED_UP_d1 XLU_SB 1.21e-17
* device instance cc_XED_UP_d1_XLU_XNQB_mid1 r0 *1 0,0
Ccc_XED_UP_d1_XLU_XNQB_mid1 XED_UP_d1 XLU_XNQB_mid1 1.21e-17
* device instance cc_XED_UP_d1_XLU_XNQ_mid1 r0 *1 0,0
Ccc_XED_UP_d1_XLU_XNQ_mid1 XED_UP_d1 XLU_XNQ_mid1 1.21e-17
* device instance cc_XED_UP_d1_XNR_mid1 r0 *1 0,0
Ccc_XED_UP_d1_XNR_mid1 XED_UP_d1 XNR_mid1 1.21e-17
* device instance cc_XED_UP_d1_net1 r0 *1 0,0
Ccc_XED_UP_d1_net1 XED_UP_d1 net1 1.21e-17
* device instance cc_XED_UP_d1_net2 r0 *1 0,0
Ccc_XED_UP_d1_net2 XED_UP_d1 net2 1.21e-17
* device instance cc_XED_UP_d1_reset r0 *1 0,0
Ccc_XED_UP_d1_reset XED_UP_d1 reset 1.8151e-17
* device instance cc_XED_UP_d1_reset_d1 r0 *1 0,0
Ccc_XED_UP_d1_reset_d1 XED_UP_d1 reset_d1 1.21e-17
* device instance cc_XED_UP_d1_reset_d2 r0 *1 0,0
Ccc_XED_UP_d1_reset_d2 XED_UP_d1 reset_d2 1.21e-17
* device instance cc_XED_UP_d1_reset_raw r0 *1 0,0
Ccc_XED_UP_d1_reset_raw XED_UP_d1 reset_raw 1.21e-17
* device instance cc_XED_UP_d1_set_dn r0 *1 0,0
Ccc_XED_UP_d1_set_dn XED_UP_d1 set_dn 1.21e-17
* device instance cc_XED_UP_d1_set_up r0 *1 0,0
Ccc_XED_UP_d1_set_up XED_UP_d1 set_up 1.21e-17
* device instance cc_XED_UP_d2_XED_UP_d3 r0 *1 0,0
Ccc_XED_UP_d2_XED_UP_d3 XED_UP_d2 XED_UP_d3 1.21e-17
* device instance cc_XED_UP_d2_XED_UP_d4 r0 *1 0,0
Ccc_XED_UP_d2_XED_UP_d4 XED_UP_d2 XED_UP_d4 1.21e-17
* device instance cc_XED_UP_d2_XED_UP_ntmp r0 *1 0,0
Ccc_XED_UP_d2_XED_UP_ntmp XED_UP_d2 XED_UP_ntmp 1.21e-17
* device instance cc_XED_UP_d2_XLD_RB r0 *1 0,0
Ccc_XED_UP_d2_XLD_RB XED_UP_d2 XLD_RB 1.21e-17
* device instance cc_XED_UP_d2_XLD_SB r0 *1 0,0
Ccc_XED_UP_d2_XLD_SB XED_UP_d2 XLD_SB 1.21e-17
* device instance cc_XED_UP_d2_XLD_XNQB_mid1 r0 *1 0,0
Ccc_XED_UP_d2_XLD_XNQB_mid1 XED_UP_d2 XLD_XNQB_mid1 1.21e-17
* device instance cc_XED_UP_d2_XLD_XNQ_mid1 r0 *1 0,0
Ccc_XED_UP_d2_XLD_XNQ_mid1 XED_UP_d2 XLD_XNQ_mid1 1.21e-17
* device instance cc_XED_UP_d2_XLU_RB r0 *1 0,0
Ccc_XED_UP_d2_XLU_RB XED_UP_d2 XLU_RB 1.21e-17
* device instance cc_XED_UP_d2_XLU_SB r0 *1 0,0
Ccc_XED_UP_d2_XLU_SB XED_UP_d2 XLU_SB 1.21e-17
* device instance cc_XED_UP_d2_XLU_XNQB_mid1 r0 *1 0,0
Ccc_XED_UP_d2_XLU_XNQB_mid1 XED_UP_d2 XLU_XNQB_mid1 1.21e-17
* device instance cc_XED_UP_d2_XLU_XNQ_mid1 r0 *1 0,0
Ccc_XED_UP_d2_XLU_XNQ_mid1 XED_UP_d2 XLU_XNQ_mid1 1.21e-17
* device instance cc_XED_UP_d2_XNR_mid1 r0 *1 0,0
Ccc_XED_UP_d2_XNR_mid1 XED_UP_d2 XNR_mid1 1.21e-17
* device instance cc_XED_UP_d2_net1 r0 *1 0,0
Ccc_XED_UP_d2_net1 XED_UP_d2 net1 1.21e-17
* device instance cc_XED_UP_d2_net2 r0 *1 0,0
Ccc_XED_UP_d2_net2 XED_UP_d2 net2 1.21e-17
* device instance cc_XED_UP_d2_reset r0 *1 0,0
Ccc_XED_UP_d2_reset XED_UP_d2 reset 1.8151e-17
* device instance cc_XED_UP_d2_reset_d1 r0 *1 0,0
Ccc_XED_UP_d2_reset_d1 XED_UP_d2 reset_d1 1.21e-17
* device instance cc_XED_UP_d2_reset_d2 r0 *1 0,0
Ccc_XED_UP_d2_reset_d2 XED_UP_d2 reset_d2 1.21e-17
* device instance cc_XED_UP_d2_reset_raw r0 *1 0,0
Ccc_XED_UP_d2_reset_raw XED_UP_d2 reset_raw 1.21e-17
* device instance cc_XED_UP_d2_set_dn r0 *1 0,0
Ccc_XED_UP_d2_set_dn XED_UP_d2 set_dn 1.21e-17
* device instance cc_XED_UP_d2_set_up r0 *1 0,0
Ccc_XED_UP_d2_set_up XED_UP_d2 set_up 1.21e-17
* device instance cc_XED_UP_d3_XED_UP_d4 r0 *1 0,0
Ccc_XED_UP_d3_XED_UP_d4 XED_UP_d3 XED_UP_d4 1.21e-17
* device instance cc_XED_UP_d3_XED_UP_ntmp r0 *1 0,0
Ccc_XED_UP_d3_XED_UP_ntmp XED_UP_d3 XED_UP_ntmp 1.21e-17
* device instance cc_XED_UP_d3_XLD_RB r0 *1 0,0
Ccc_XED_UP_d3_XLD_RB XED_UP_d3 XLD_RB 1.21e-17
* device instance cc_XED_UP_d3_XLD_SB r0 *1 0,0
Ccc_XED_UP_d3_XLD_SB XED_UP_d3 XLD_SB 1.21e-17
* device instance cc_XED_UP_d3_XLD_XNQB_mid1 r0 *1 0,0
Ccc_XED_UP_d3_XLD_XNQB_mid1 XED_UP_d3 XLD_XNQB_mid1 1.21e-17
* device instance cc_XED_UP_d3_XLD_XNQ_mid1 r0 *1 0,0
Ccc_XED_UP_d3_XLD_XNQ_mid1 XED_UP_d3 XLD_XNQ_mid1 1.21e-17
* device instance cc_XED_UP_d3_XLU_RB r0 *1 0,0
Ccc_XED_UP_d3_XLU_RB XED_UP_d3 XLU_RB 1.21e-17
* device instance cc_XED_UP_d3_XLU_SB r0 *1 0,0
Ccc_XED_UP_d3_XLU_SB XED_UP_d3 XLU_SB 1.21e-17
* device instance cc_XED_UP_d3_XLU_XNQB_mid1 r0 *1 0,0
Ccc_XED_UP_d3_XLU_XNQB_mid1 XED_UP_d3 XLU_XNQB_mid1 1.21e-17
* device instance cc_XED_UP_d3_XLU_XNQ_mid1 r0 *1 0,0
Ccc_XED_UP_d3_XLU_XNQ_mid1 XED_UP_d3 XLU_XNQ_mid1 1.21e-17
* device instance cc_XED_UP_d3_XNR_mid1 r0 *1 0,0
Ccc_XED_UP_d3_XNR_mid1 XED_UP_d3 XNR_mid1 1.21e-17
* device instance cc_XED_UP_d3_net1 r0 *1 0,0
Ccc_XED_UP_d3_net1 XED_UP_d3 net1 1.21e-17
* device instance cc_XED_UP_d3_net2 r0 *1 0,0
Ccc_XED_UP_d3_net2 XED_UP_d3 net2 1.21e-17
* device instance cc_XED_UP_d3_reset r0 *1 0,0
Ccc_XED_UP_d3_reset XED_UP_d3 reset 1.8151e-17
* device instance cc_XED_UP_d3_reset_d1 r0 *1 0,0
Ccc_XED_UP_d3_reset_d1 XED_UP_d3 reset_d1 1.21e-17
* device instance cc_XED_UP_d3_reset_d2 r0 *1 0,0
Ccc_XED_UP_d3_reset_d2 XED_UP_d3 reset_d2 1.21e-17
* device instance cc_XED_UP_d3_reset_raw r0 *1 0,0
Ccc_XED_UP_d3_reset_raw XED_UP_d3 reset_raw 1.21e-17
* device instance cc_XED_UP_d3_set_dn r0 *1 0,0
Ccc_XED_UP_d3_set_dn XED_UP_d3 set_dn 1.21e-17
* device instance cc_XED_UP_d3_set_up r0 *1 0,0
Ccc_XED_UP_d3_set_up XED_UP_d3 set_up 1.21e-17
* device instance cc_XED_UP_d4_XED_UP_ntmp r0 *1 0,0
Ccc_XED_UP_d4_XED_UP_ntmp XED_UP_d4 XED_UP_ntmp 1.21e-17
* device instance cc_XED_UP_d4_XLD_RB r0 *1 0,0
Ccc_XED_UP_d4_XLD_RB XED_UP_d4 XLD_RB 1.21e-17
* device instance cc_XED_UP_d4_XLD_SB r0 *1 0,0
Ccc_XED_UP_d4_XLD_SB XED_UP_d4 XLD_SB 1.21e-17
* device instance cc_XED_UP_d4_XLD_XNQB_mid1 r0 *1 0,0
Ccc_XED_UP_d4_XLD_XNQB_mid1 XED_UP_d4 XLD_XNQB_mid1 1.21e-17
* device instance cc_XED_UP_d4_XLD_XNQ_mid1 r0 *1 0,0
Ccc_XED_UP_d4_XLD_XNQ_mid1 XED_UP_d4 XLD_XNQ_mid1 1.21e-17
* device instance cc_XED_UP_d4_XLU_RB r0 *1 0,0
Ccc_XED_UP_d4_XLU_RB XED_UP_d4 XLU_RB 1.21e-17
* device instance cc_XED_UP_d4_XLU_SB r0 *1 0,0
Ccc_XED_UP_d4_XLU_SB XED_UP_d4 XLU_SB 1.21e-17
* device instance cc_XED_UP_d4_XLU_XNQB_mid1 r0 *1 0,0
Ccc_XED_UP_d4_XLU_XNQB_mid1 XED_UP_d4 XLU_XNQB_mid1 1.21e-17
* device instance cc_XED_UP_d4_XLU_XNQ_mid1 r0 *1 0,0
Ccc_XED_UP_d4_XLU_XNQ_mid1 XED_UP_d4 XLU_XNQ_mid1 1.21e-17
* device instance cc_XED_UP_d4_XNR_mid1 r0 *1 0,0
Ccc_XED_UP_d4_XNR_mid1 XED_UP_d4 XNR_mid1 1.21e-17
* device instance cc_XED_UP_d4_net1 r0 *1 0,0
Ccc_XED_UP_d4_net1 XED_UP_d4 net1 1.21e-17
* device instance cc_XED_UP_d4_net2 r0 *1 0,0
Ccc_XED_UP_d4_net2 XED_UP_d4 net2 1.21e-17
* device instance cc_XED_UP_d4_reset r0 *1 0,0
Ccc_XED_UP_d4_reset XED_UP_d4 reset 1.8151e-17
* device instance cc_XED_UP_d4_reset_d1 r0 *1 0,0
Ccc_XED_UP_d4_reset_d1 XED_UP_d4 reset_d1 1.21e-17
* device instance cc_XED_UP_d4_reset_d2 r0 *1 0,0
Ccc_XED_UP_d4_reset_d2 XED_UP_d4 reset_d2 1.21e-17
* device instance cc_XED_UP_d4_reset_raw r0 *1 0,0
Ccc_XED_UP_d4_reset_raw XED_UP_d4 reset_raw 1.21e-17
* device instance cc_XED_UP_d4_set_dn r0 *1 0,0
Ccc_XED_UP_d4_set_dn XED_UP_d4 set_dn 1.21e-17
* device instance cc_XED_UP_d4_set_up r0 *1 0,0
Ccc_XED_UP_d4_set_up XED_UP_d4 set_up 1.21e-17
* device instance cc_XED_UP_ntmp_XLD_RB r0 *1 0,0
Ccc_XED_UP_ntmp_XLD_RB XED_UP_ntmp XLD_RB 1.21e-17
* device instance cc_XED_UP_ntmp_XLD_SB r0 *1 0,0
Ccc_XED_UP_ntmp_XLD_SB XED_UP_ntmp XLD_SB 1.21e-17
* device instance cc_XED_UP_ntmp_XLD_XNQB_mid1 r0 *1 0,0
Ccc_XED_UP_ntmp_XLD_XNQB_mid1 XED_UP_ntmp XLD_XNQB_mid1 1.21e-17
* device instance cc_XED_UP_ntmp_XLD_XNQ_mid1 r0 *1 0,0
Ccc_XED_UP_ntmp_XLD_XNQ_mid1 XED_UP_ntmp XLD_XNQ_mid1 1.21e-17
* device instance cc_XED_UP_ntmp_XLU_RB r0 *1 0,0
Ccc_XED_UP_ntmp_XLU_RB XED_UP_ntmp XLU_RB 1.21e-17
* device instance cc_XED_UP_ntmp_XLU_SB r0 *1 0,0
Ccc_XED_UP_ntmp_XLU_SB XED_UP_ntmp XLU_SB 1.21e-17
* device instance cc_XED_UP_ntmp_XLU_XNQB_mid1 r0 *1 0,0
Ccc_XED_UP_ntmp_XLU_XNQB_mid1 XED_UP_ntmp XLU_XNQB_mid1 1.21e-17
* device instance cc_XED_UP_ntmp_XLU_XNQ_mid1 r0 *1 0,0
Ccc_XED_UP_ntmp_XLU_XNQ_mid1 XED_UP_ntmp XLU_XNQ_mid1 1.21e-17
* device instance cc_XED_UP_ntmp_XNR_mid1 r0 *1 0,0
Ccc_XED_UP_ntmp_XNR_mid1 XED_UP_ntmp XNR_mid1 1.21e-17
* device instance cc_XED_UP_ntmp_net1 r0 *1 0,0
Ccc_XED_UP_ntmp_net1 XED_UP_ntmp net1 1.21e-17
* device instance cc_XED_UP_ntmp_net2 r0 *1 0,0
Ccc_XED_UP_ntmp_net2 XED_UP_ntmp net2 1.21e-17
* device instance cc_XED_UP_ntmp_reset r0 *1 0,0
Ccc_XED_UP_ntmp_reset XED_UP_ntmp reset 1.8151e-17
* device instance cc_XED_UP_ntmp_reset_d1 r0 *1 0,0
Ccc_XED_UP_ntmp_reset_d1 XED_UP_ntmp reset_d1 1.21e-17
* device instance cc_XED_UP_ntmp_reset_d2 r0 *1 0,0
Ccc_XED_UP_ntmp_reset_d2 XED_UP_ntmp reset_d2 1.21e-17
* device instance cc_XED_UP_ntmp_reset_raw r0 *1 0,0
Ccc_XED_UP_ntmp_reset_raw XED_UP_ntmp reset_raw 1.21e-17
* device instance cc_XED_UP_ntmp_set_dn r0 *1 0,0
Ccc_XED_UP_ntmp_set_dn XED_UP_ntmp set_dn 1.21e-17
* device instance cc_XED_UP_ntmp_set_up r0 *1 0,0
Ccc_XED_UP_ntmp_set_up XED_UP_ntmp set_up 1.21e-17
* device instance cc_XLD_RB_XLD_SB r0 *1 0,0
Ccc_XLD_RB_XLD_SB XLD_RB XLD_SB 1.8151e-17
* device instance cc_XLD_RB_XLD_XNQB_mid1 r0 *1 0,0
Ccc_XLD_RB_XLD_XNQB_mid1 XLD_RB XLD_XNQB_mid1 1.21e-17
* device instance cc_XLD_RB_XLD_XNQ_mid1 r0 *1 0,0
Ccc_XLD_RB_XLD_XNQ_mid1 XLD_RB XLD_XNQ_mid1 1.21e-17
* device instance cc_XLD_RB_XLU_RB r0 *1 0,0
Ccc_XLD_RB_XLU_RB XLD_RB XLU_RB 1.21e-17
* device instance cc_XLD_RB_XLU_SB r0 *1 0,0
Ccc_XLD_RB_XLU_SB XLD_RB XLU_SB 1.21e-17
* device instance cc_XLD_RB_XNR_mid1 r0 *1 0,0
Ccc_XLD_RB_XNR_mid1 XLD_RB XNR_mid1 1.21e-17
* device instance cc_XLD_RB_net1 r0 *1 0,0
Ccc_XLD_RB_net1 XLD_RB net1 1.8151e-17
* device instance cc_XLD_RB_net2 r0 *1 0,0
Ccc_XLD_RB_net2 XLD_RB net2 1.8151e-17
* device instance cc_XLD_RB_reset r0 *1 0,0
Ccc_XLD_RB_reset XLD_RB reset 1.8151e-17
* device instance cc_XLD_RB_reset_d1 r0 *1 0,0
Ccc_XLD_RB_reset_d1 XLD_RB reset_d1 1.21e-17
* device instance cc_XLD_RB_reset_d2 r0 *1 0,0
Ccc_XLD_RB_reset_d2 XLD_RB reset_d2 1.21e-17
* device instance cc_XLD_RB_reset_raw r0 *1 0,0
Ccc_XLD_RB_reset_raw XLD_RB reset_raw 1.21e-17
* device instance cc_XLD_RB_set_dn r0 *1 0,0
Ccc_XLD_RB_set_dn XLD_RB set_dn 1.21e-17
* device instance cc_XLD_RB_set_up r0 *1 0,0
Ccc_XLD_RB_set_up XLD_RB set_up 1.21e-17
* device instance cc_XLD_SB_XLD_XNQB_mid1 r0 *1 0,0
Ccc_XLD_SB_XLD_XNQB_mid1 XLD_SB XLD_XNQB_mid1 1.21e-17
* device instance cc_XLD_SB_XLD_XNQ_mid1 r0 *1 0,0
Ccc_XLD_SB_XLD_XNQ_mid1 XLD_SB XLD_XNQ_mid1 1.21e-17
* device instance cc_XLD_SB_XLU_RB r0 *1 0,0
Ccc_XLD_SB_XLU_RB XLD_SB XLU_RB 1.21e-17
* device instance cc_XLD_SB_XLU_SB r0 *1 0,0
Ccc_XLD_SB_XLU_SB XLD_SB XLU_SB 1.21e-17
* device instance cc_XLD_SB_XNR_mid1 r0 *1 0,0
Ccc_XLD_SB_XNR_mid1 XLD_SB XNR_mid1 1.21e-17
* device instance cc_XLD_SB_net1 r0 *1 0,0
Ccc_XLD_SB_net1 XLD_SB net1 1.8151e-17
* device instance cc_XLD_SB_net2 r0 *1 0,0
Ccc_XLD_SB_net2 XLD_SB net2 1.21e-17
* device instance cc_XLD_SB_reset r0 *1 0,0
Ccc_XLD_SB_reset XLD_SB reset 2.4201e-17
* device instance cc_XLD_SB_reset_d1 r0 *1 0,0
Ccc_XLD_SB_reset_d1 XLD_SB reset_d1 1.21e-17
* device instance cc_XLD_SB_reset_d2 r0 *1 0,0
Ccc_XLD_SB_reset_d2 XLD_SB reset_d2 1.21e-17
* device instance cc_XLD_SB_reset_raw r0 *1 0,0
Ccc_XLD_SB_reset_raw XLD_SB reset_raw 1.21e-17
* device instance cc_XLD_SB_set_dn r0 *1 0,0
Ccc_XLD_SB_set_dn XLD_SB set_dn 1.21e-17
* device instance cc_XLD_SB_set_up r0 *1 0,0
Ccc_XLD_SB_set_up XLD_SB set_up 1.21e-17
* device instance cc_XLD_XNQB_mid1_net2 r0 *1 0,0
Ccc_XLD_XNQB_mid1_net2 XLD_XNQB_mid1 net2 1.1294e-17
* device instance cc_XLD_XNQ_mid1_net2 r0 *1 0,0
Ccc_XLD_XNQ_mid1_net2 XLD_XNQ_mid1 net2 6.05e-18
* device instance cc_XLU_RB_XLU_SB r0 *1 0,0
Ccc_XLU_RB_XLU_SB XLU_RB XLU_SB 1.8151e-17
* device instance cc_XLU_RB_XLU_XNQB_mid1 r0 *1 0,0
Ccc_XLU_RB_XLU_XNQB_mid1 XLU_RB XLU_XNQB_mid1 1.21e-17
* device instance cc_XLU_RB_XLU_XNQ_mid1 r0 *1 0,0
Ccc_XLU_RB_XLU_XNQ_mid1 XLU_RB XLU_XNQ_mid1 1.21e-17
* device instance cc_XLU_RB_XNR_mid1 r0 *1 0,0
Ccc_XLU_RB_XNR_mid1 XLU_RB XNR_mid1 1.21e-17
* device instance cc_XLU_RB_net1 r0 *1 0,0
Ccc_XLU_RB_net1 XLU_RB net1 1.8151e-17
* device instance cc_XLU_RB_net2 r0 *1 0,0
Ccc_XLU_RB_net2 XLU_RB net2 1.21e-17
* device instance cc_XLU_RB_reset r0 *1 0,0
Ccc_XLU_RB_reset XLU_RB reset 1.8151e-17
* device instance cc_XLU_RB_reset_d1 r0 *1 0,0
Ccc_XLU_RB_reset_d1 XLU_RB reset_d1 1.21e-17
* device instance cc_XLU_RB_reset_d2 r0 *1 0,0
Ccc_XLU_RB_reset_d2 XLU_RB reset_d2 1.21e-17
* device instance cc_XLU_RB_reset_raw r0 *1 0,0
Ccc_XLU_RB_reset_raw XLU_RB reset_raw 1.21e-17
* device instance cc_XLU_RB_set_dn r0 *1 0,0
Ccc_XLU_RB_set_dn XLU_RB set_dn 1.21e-17
* device instance cc_XLU_RB_set_up r0 *1 0,0
Ccc_XLU_RB_set_up XLU_RB set_up 1.21e-17
* device instance cc_XLU_SB_XLU_XNQB_mid1 r0 *1 0,0
Ccc_XLU_SB_XLU_XNQB_mid1 XLU_SB XLU_XNQB_mid1 1.21e-17
* device instance cc_XLU_SB_XLU_XNQ_mid1 r0 *1 0,0
Ccc_XLU_SB_XLU_XNQ_mid1 XLU_SB XLU_XNQ_mid1 1.21e-17
* device instance cc_XLU_SB_XNR_mid1 r0 *1 0,0
Ccc_XLU_SB_XNR_mid1 XLU_SB XNR_mid1 1.21e-17
* device instance cc_XLU_SB_net1 r0 *1 0,0
Ccc_XLU_SB_net1 XLU_SB net1 1.21e-17
* device instance cc_XLU_SB_net2 r0 *1 0,0
Ccc_XLU_SB_net2 XLU_SB net2 1.21e-17
* device instance cc_XLU_SB_reset r0 *1 0,0
Ccc_XLU_SB_reset XLU_SB reset 2.4201e-17
* device instance cc_XLU_SB_reset_d1 r0 *1 0,0
Ccc_XLU_SB_reset_d1 XLU_SB reset_d1 1.21e-17
* device instance cc_XLU_SB_reset_d2 r0 *1 0,0
Ccc_XLU_SB_reset_d2 XLU_SB reset_d2 1.21e-17
* device instance cc_XLU_SB_reset_raw r0 *1 0,0
Ccc_XLU_SB_reset_raw XLU_SB reset_raw 1.21e-17
* device instance cc_XLU_SB_set_dn r0 *1 0,0
Ccc_XLU_SB_set_dn XLU_SB set_dn 1.21e-17
* device instance cc_XLU_SB_set_up r0 *1 0,0
Ccc_XLU_SB_set_up XLU_SB set_up 1.21e-17
* device instance cc_XLU_XNQB_mid1_net1 r0 *1 0,0
Ccc_XLU_XNQB_mid1_net1 XLU_XNQB_mid1 net1 1.1294e-17
* device instance cc_XLU_XNQ_mid1_net1 r0 *1 0,0
Ccc_XLU_XNQ_mid1_net1 XLU_XNQ_mid1 net1 6.05e-18
* device instance cc_XNR_mid1_reset_raw r0 *1 0,0
Ccc_XNR_mid1_reset_raw XNR_mid1 reset_raw 1.1294e-17
* device instance cc_net1_net2 r0 *1 0,0
Ccc_net1_net2 net1 net2 1.21e-17
* device instance cc_net1_reset r0 *1 0,0
Ccc_net1_reset net1 reset 1.8151e-17
* device instance cc_net1_reset_d1 r0 *1 0,0
Ccc_net1_reset_d1 net1 reset_d1 1.21e-17
* device instance cc_net1_reset_d2 r0 *1 0,0
Ccc_net1_reset_d2 net1 reset_d2 1.21e-17
* device instance cc_net1_reset_raw r0 *1 0,0
Ccc_net1_reset_raw net1 reset_raw 1.21e-17
* device instance cc_net1_set_dn r0 *1 0,0
Ccc_net1_set_dn net1 set_dn 1.21e-17
* device instance cc_net1_set_up r0 *1 0,0
Ccc_net1_set_up net1 set_up 1.21e-17
* device instance cc_net2_reset r0 *1 0,0
Ccc_net2_reset net2 reset 1.8151e-17
* device instance cc_net2_reset_d1 r0 *1 0,0
Ccc_net2_reset_d1 net2 reset_d1 1.21e-17
* device instance cc_net2_reset_d2 r0 *1 0,0
Ccc_net2_reset_d2 net2 reset_d2 1.21e-17
* device instance cc_net2_reset_raw r0 *1 0,0
Ccc_net2_reset_raw net2 reset_raw 1.21e-17
* device instance cc_net2_set_dn r0 *1 0,0
Ccc_net2_set_dn net2 set_dn 1.21e-17
* device instance cc_net2_set_up r0 *1 0,0
Ccc_net2_set_up net2 set_up 1.21e-17
* device instance cc_reset_reset_d1 r0 *1 0,0
Ccc_reset_reset_d1 reset reset_d1 2.4201e-17
* device instance cc_reset_reset_d2 r0 *1 0,0
Ccc_reset_reset_d2 reset reset_d2 2.4201e-17
* device instance cc_reset_reset_raw r0 *1 0,0
Ccc_reset_reset_raw reset reset_raw 3.0251e-17
* device instance cc_reset_set_dn r0 *1 0,0
Ccc_reset_set_dn reset set_dn 1.8151e-17
* device instance cc_reset_set_up r0 *1 0,0
Ccc_reset_set_up reset set_up 1.21e-17
* device instance cc_reset_d1_reset_d2 r0 *1 0,0
Ccc_reset_d1_reset_d2 reset_d1 reset_d2 1.21e-17
* device instance cc_reset_d1_reset_raw r0 *1 0,0
Ccc_reset_d1_reset_raw reset_d1 reset_raw 1.8151e-17
* device instance cc_reset_d1_set_dn r0 *1 0,0
Ccc_reset_d1_set_dn reset_d1 set_dn 1.21e-17
* device instance cc_reset_d1_set_up r0 *1 0,0
Ccc_reset_d1_set_up reset_d1 set_up 1.21e-17
* device instance cc_reset_d2_reset_raw r0 *1 0,0
Ccc_reset_d2_reset_raw reset_d2 reset_raw 1.8151e-17
* device instance cc_reset_d2_set_dn r0 *1 0,0
Ccc_reset_d2_set_dn reset_d2 set_dn 1.21e-17
* device instance cc_reset_d2_set_up r0 *1 0,0
Ccc_reset_d2_set_up reset_d2 set_up 1.21e-17
* device instance cc_reset_raw_set_dn r0 *1 0,0
Ccc_reset_raw_set_dn reset_raw set_dn 1.21e-17
* device instance cc_reset_raw_set_up r0 *1 0,0
Ccc_reset_raw_set_up reset_raw set_up 1.21e-17
* device instance cc_set_dn_set_up r0 *1 0,0
Ccc_set_dn_set_up set_dn set_up 1.8151e-17
* device instance vsubs_dctie r0 *1 0,0
Rvsubs_dctie vsubs 0 1e+12
.ENDS pll_pfd
