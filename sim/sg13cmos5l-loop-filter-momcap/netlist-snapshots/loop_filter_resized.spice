* Netlist provenance snapshot -- sim/README.md convention
* Frozen from design/sg13cmos5l/netlist/loop_filter.spice at this record's own
* branch (parent commit 15de40cbb38392c5b38b758e263d60a42f60776d), after
* issue #41's R1 resize (DR-006): XR1 w=4u l=120u -> w=0.6u l=810u (the
* full-amended-f_ref-range-verified ~x44.2 scale factor -- see DR-006 for
* why the initially-proposed x20 scale was superseded).
* Simulated by sim/sg13cmos5l-loop-filter-momcap/ RECORD-002 (issue #41, Part
* of #16). Differs from ../netlist-snapshots/loop_filter.spice (RECORD-001's
* own, unedited, pre-resize snapshot) in exactly XR1's w/l -- XC1/XC2
* untouched. Independent of whatever design/sg13cmos5l/netlist/loop_filter.spice
* says today.
*
* sg13g2-pll :: loop_filter (SG13CMOS5L) -- generated by design/sg13cmos5l/netlist.sh from loop_filter.sch
* xschem XSCHEM V3.4.7; do not edit by hand.
** sch_path: design/sg13cmos5l/loop_filter.sch
.subckt loop_filter VCTRL VSS
*.iopin VCTRL
*.iopin VSS
XR1 VCTRL NZ sub! rppd w=0.6u l=810u m=1 b=0
XC1 NZ VSS cap_cmomi w=40u l=40u mmin=1 mmax=4 feed=double subblock=0 m=1 mm_ok=1
XC2 VCTRL VSS cap_cmomi w=10u l=10u mmin=1 mmax=4 feed=double subblock=0 m=1 mm_ok=1
.ends
