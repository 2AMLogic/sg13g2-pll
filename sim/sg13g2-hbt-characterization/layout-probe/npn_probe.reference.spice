* Reference netlist for the minimal npn13G2 probe cell (one device, Nx=1).
.subckt npn_probe c b e sub
XQ1 c b e sub npn13G2 Nx=1
.ends npn_probe
