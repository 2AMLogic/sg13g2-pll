* extracted by klt extract --deck sg13g2

* cell npn_probe
* pin vsubs
.SUBCKT npn_probe vsubs
.ENDS npn_probe
