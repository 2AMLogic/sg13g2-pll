* Netlist provenance snapshot -- sim/README.md convention
* Frozen from design/sg13cmos5l/netlist/pfd.spice at commit fbebbdbdd57637b8dae0c1dabaf75d3be5411edb
* (main, after PR #39 -- the SG13CMOS5L device-level layout/LVS series;
*  no schematic content changed since PR #26 ported the blocks).
* Simulated by sim/sg13cmos5l-closed-loop-lock/ (issue #37, Part of #16).
* Independent of whatever design/sg13cmos5l/netlist/pfd.spice says today.
*
* sg13g2-pll :: pfd (SG13CMOS5L) -- generated by design/sg13cmos5l/netlist.sh from pfd.sch
* xschem XSCHEM V3.4.7; do not edit by hand.
** sch_path: design/sg13cmos5l/pfd.sch
.subckt pfd REF FB UP DN VDD VSS
*.ipin REF
*.ipin FB
*.opin UP
*.opin DN
*.iopin VDD
*.iopin VSS
XED_UP REF set_up VDD VSS edgedet
XED_DN FB set_dn VDD VSS edgedet
XLU set_up reset UP net1 VDD VSS srlatch
XLD set_dn reset DN net2 VDD VSS srlatch
XNR UP DN reset_raw VDD VSS nand2_hv
XI1 reset_raw reset_d1 VDD VSS inv_hv
XI2 reset_d1 reset VDD VSS inv2x_hv
.ends

* expanding   symbol:  edgedet.sym # of pins=4
** sym_path: design/sg13cmos5l/edgedet.sym
** sch_path: design/sg13cmos5l/edgedet.sch
.subckt edgedet X OUT VDD VSS
*.ipin X
*.opin OUT
*.iopin VDD
*.iopin VSS
XD1 X d1 VDD VSS inv_hv
XD2 d1 d2 VDD VSS inv_hv
XD3 d2 d3 VDD VSS inv_hv
XD4 d3 d4 VDD VSS inv_hv
XD5 d4 XD5 VDD VSS inv_hv
XN1 X XD5 ntmp VDD VSS nand2_hv
XOUT ntmp OUT VDD VSS inv_hv
.ends

* expanding   symbol:  srlatch.sym # of pins=6
** sym_path: design/sg13cmos5l/srlatch.sym
** sch_path: design/sg13cmos5l/srlatch.sch
.subckt srlatch S R Q QB VDD VSS
*.ipin S
*.ipin R
*.opin Q
*.opin QB
*.iopin VDD
*.iopin VSS
XIS S SB VDD VSS inv_hv
XIR R RB VDD VSS inv_hv
XNQ SB QB Q VDD VSS nand2_hv
XNQB RB Q QB VDD VSS nand2_hv
.ends

* expanding   symbol:  nand2_hv.sym # of pins=5
** sym_path: design/sg13cmos5l/nand2_hv.sym
** sch_path: design/sg13cmos5l/nand2_hv.sch
.subckt nand2_hv A1 A2 Y VDD VSS
*.opin Y
*.ipin A1
*.ipin A2
*.iopin VDD
*.iopin VSS
XMP1 Y A1 VDD VDD sg13_hv_pmos w=5u l=0.5u ng=1 m=1
XMP2 Y A2 VDD VDD sg13_hv_pmos w=5u l=0.5u ng=1 m=1
XMN1 Y A1 mid1 VSS sg13_hv_nmos w=2u l=0.5u ng=1 m=1
XMN2 mid1 A2 VSS VSS sg13_hv_nmos w=2u l=0.5u ng=1 m=1
.ends

* expanding   symbol:  inv_hv.sym # of pins=4
** sym_path: design/sg13cmos5l/inv_hv.sym
** sch_path: design/sg13cmos5l/inv_hv.sch
.subckt inv_hv A Y VDD VSS
*.ipin A
*.opin Y
*.iopin VDD
*.iopin VSS
XMP Y A VDD VDD sg13_hv_pmos w=5u l=0.5u ng=1 m=1
XMN Y A VSS VSS sg13_hv_nmos w=2u l=0.5u ng=1 m=1
.ends

* expanding   symbol:  inv2x_hv.sym # of pins=4
** sym_path: design/sg13cmos5l/inv2x_hv.sym
** sch_path: design/sg13cmos5l/inv2x_hv.sch
.subckt inv2x_hv A Y VDD VSS
*.ipin A
*.opin Y
*.iopin VDD
*.iopin VSS
XMP Y A VDD VDD sg13_hv_pmos w=10u l=0.5u ng=1 m=1
XMN Y A VSS VSS sg13_hv_nmos w=4u l=0.5u ng=1 m=1
.ends
