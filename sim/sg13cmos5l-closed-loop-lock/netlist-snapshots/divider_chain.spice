* Netlist provenance snapshot -- sim/README.md convention
* Frozen from design/sg13cmos5l/netlist/divider_chain.spice at commit fbebbdbdd57637b8dae0c1dabaf75d3be5411edb
* (main, after PR #39 -- the SG13CMOS5L device-level layout/LVS series;
*  no schematic content changed since PR #26 ported the blocks).
* Simulated by sim/sg13cmos5l-closed-loop-lock/ (issue #37, Part of #16).
* Independent of whatever design/sg13cmos5l/netlist/divider_chain.spice says today.
*
* sg13g2-pll :: divider_chain (SG13CMOS5L) -- generated by design/sg13cmos5l/netlist.sh from divider_chain.sch
* xschem XSCHEM V3.4.7; do not edit by hand.
** sch_path: design/sg13cmos5l/divider_chain.sch
.subckt divider_chain CKIN CKIN_VCO P0 P1 P2 P3 P4 P5 FB DIVOUT VDD_DIV VSS
*.ipin CKIN
*.ipin CKIN_VCO
*.ipin P0
*.ipin P1
*.ipin P2
*.ipin P3
*.ipin P4
*.ipin P5
*.opin FB
*.opin DIVOUT
*.iopin VDD_DIV
*.iopin VSS
XD0 mod0 P0 CKIN ck1 net1 VDD_DIV VSS div23_cell
XD1 mod1 P1 ck1 ck2 mod0 VDD_DIV VSS div23_cell
XD2 mod2 P2 ck2 ck3 mod1 VDD_DIV VSS div23_cell
XD3 mod3 P3 ck3 ck4 mod2 VDD_DIV VSS div23_cell
XD4 mod4 P4 ck4 ck5 mod3 VDD_DIV VSS div23_cell
XD5 VDD_DIV P5 ck5 DIVOUT mod4 VDD_DIV VSS div23_cell
XFRT DIVOUT CKIN_VCO FB VDD_DIV VSS dff_tg_hv
.ends

* expanding   symbol:  div23_cell.sym # of pins=7
** sym_path: design/sg13cmos5l/div23_cell.sym
** sch_path: design/sg13cmos5l/div23_cell.sch
.subckt div23_cell MODIN P CKIN Q MODOUT VDD VSS
*.ipin MODIN
*.ipin P
*.ipin CKIN
*.opin Q
*.opin MODOUT
*.iopin VDD
*.iopin VSS
XN3 MODIN P MODOUT nt VDD VSS nand3_hv
XI1 nt t1 VDD VSS inv_hv
XNOR Q t1 dq VDD VSS nor2_hv
XDFFQ dq CKIN Q VDD VSS dff_tg_hv
XN2 MODIN Q nm VDD VSS nand2_hv
XI2 nm dmodout VDD VSS inv_hv
XDFFM dmodout CKIN MODOUT VDD VSS dff_tg_hv
.ends

* expanding   symbol:  dff_tg_hv.sym # of pins=5
** sym_path: design/sg13cmos5l/dff_tg_hv.sym
** sch_path: design/sg13cmos5l/dff_tg_hv.sch
.subckt dff_tg_hv D CLK Q VDD VSS
*.ipin D
*.ipin CLK
*.opin Q
*.iopin VDD
*.iopin VSS
XICLK CLK CLKB VDD VSS inv_hv
XTG1 D CLKB CLK M VDD VSS tgate_hv
XIM M MB VDD VSS inv_hv
XTGFBM MB CLK CLKB M VDD VSS tgate_hv
XTG2 M CLK CLKB S VDD VSS tgate_hv
XIS S SB VDD VSS inv_hv
XTGFBS SB CLKB CLK S VDD VSS tgate_hv
XBQ SB Q VDD VSS inv_hv
.ends

* expanding   symbol:  nand3_hv.sym # of pins=6
** sym_path: design/sg13cmos5l/nand3_hv.sym
** sch_path: design/sg13cmos5l/nand3_hv.sch
.subckt nand3_hv A1 A2 A3 Y VDD VSS
*.opin Y
*.ipin A1
*.ipin A2
*.ipin A3
*.iopin VDD
*.iopin VSS
XMP1 Y A1 VDD VDD sg13_hv_pmos w=5u l=0.5u ng=1 m=1
XMP2 Y A2 VDD VDD sg13_hv_pmos w=5u l=0.5u ng=1 m=1
XMP3 Y A3 VDD VDD sg13_hv_pmos w=5u l=0.5u ng=1 m=1
XMN1 Y A1 mid1 VSS sg13_hv_nmos w=2u l=0.5u ng=1 m=1
XMN2 mid1 A2 mid2 VSS sg13_hv_nmos w=2u l=0.5u ng=1 m=1
XMN3 mid2 A3 VSS VSS sg13_hv_nmos w=2u l=0.5u ng=1 m=1
.ends

* expanding   symbol:  inv_hv.sym # of pins=4
** sym_path: design/sg13cmos5l/inv_hv.sym
** sch_path: design/sg13cmos5l/inv_hv.sch
.subckt inv_hv A Y VDD VSS
*.ipin A
*.opin Y
*.iopin VDD
*.iopin VSS
XMP Y A VDD VDD sg13_hv_pmos w=5u l=0.5u ng=1 m=1
XMN Y A VSS VSS sg13_hv_nmos w=2u l=0.5u ng=1 m=1
.ends

* expanding   symbol:  nor2_hv.sym # of pins=5
** sym_path: design/sg13cmos5l/nor2_hv.sym
** sch_path: design/sg13cmos5l/nor2_hv.sch
.subckt nor2_hv A B Y VDD VSS
*.ipin A
*.ipin B
*.opin Y
*.iopin VDD
*.iopin VSS
XMP1 midp A VDD VDD sg13_hv_pmos w=5u l=0.5u ng=1 m=1
XMP2 Y B midp VDD sg13_hv_pmos w=5u l=0.5u ng=1 m=1
XMN1 Y A VSS VSS sg13_hv_nmos w=2u l=0.5u ng=1 m=1
XMN2 Y B VSS VSS sg13_hv_nmos w=2u l=0.5u ng=1 m=1
.ends

* expanding   symbol:  nand2_hv.sym # of pins=5
** sym_path: design/sg13cmos5l/nand2_hv.sym
** sch_path: design/sg13cmos5l/nand2_hv.sch
.subckt nand2_hv A1 A2 Y VDD VSS
*.opin Y
*.ipin A1
*.ipin A2
*.iopin VDD
*.iopin VSS
XMP1 Y A1 VDD VDD sg13_hv_pmos w=5u l=0.5u ng=1 m=1
XMP2 Y A2 VDD VDD sg13_hv_pmos w=5u l=0.5u ng=1 m=1
XMN1 Y A1 mid1 VSS sg13_hv_nmos w=2u l=0.5u ng=1 m=1
XMN2 mid1 A2 VSS VSS sg13_hv_nmos w=2u l=0.5u ng=1 m=1
.ends

* expanding   symbol:  tgate_hv.sym # of pins=6
** sym_path: design/sg13cmos5l/tgate_hv.sym
** sch_path: design/sg13cmos5l/tgate_hv.sch
.subckt tgate_hv A NG PG Y VDD VSS
*.ipin A
*.opin Y
*.ipin NG
*.ipin PG
*.iopin VDD
*.iopin VSS
XMN A NG Y VSS sg13_hv_nmos w=2u l=0.5u ng=1 m=1
XMP Y PG A VDD sg13_hv_pmos w=5u l=0.5u ng=1 m=1
.ends
