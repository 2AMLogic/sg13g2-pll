* sg13g2-pll :: sim/sg13g2-lock-detector-window (issue #82, Part of #16 via #78)
* Frozen snapshot of design/netlist/lock_detector.spice at the END of this
* issue's two-stage re-derivation, taken on this issue's own branch with
* parent commit 6c4351b30b58b5de8a25430936317dc440908930.  Independent of whatever
* design/netlist/lock_detector.spice says by the time this record is read
* later -- see sim/README.md's own "Netlist provenance" convention.
*
* This is the block ../records/RECORD-001 draws its spec/porting-plan.md
* row 16 verdicts against.  It differs from ./lock_detector.spice (the
* PRE-resize snapshot issue #81 froze, which stands unedited) in EXACTLY FOUR
* instance values and is byte-identical everywhere else:
*
*   Instance             was              now             evidence
*   XRPU (rhigh)         w=0.5u l=6u      w=0.5u l=500u   ../corners/rc_sizing.csv + rc_pairing.csv (R*C >> T_ref)
*   XCW (cap_cmim)       w=6u l=6u m=1    w=45u l=45u m=1 same
*   XDW.XC1 (cap_cmim)   w=4u l=4u m=1    w=45u l=45u m=1 ../corners/window_sizing.csv (row 16's >= 2.5 ns floor)
*   XMPD (sg13_hv_nmos)  w=2u l=0.5u      w=0.25u l=12u   ../corners/xmpd_sizing.csv (two-sided bound)
*
* schmitt_hv, xor2_hv, nand2_hv, inv_hv and the four-inverter chain's own
* drive are UNTOUCHED.  schmitt_hv in particular already carries the classic
* cross-coupled feedback connection (issue #66) on this PDK -- see XMP3/XMN3
* below -- which is why this record needs no rewired-Schmitt control the way
* the SG13CMOS5L sibling's RECORD-002/RECORD-003 did.
*
* ./lock_detector_rc_resized.spice is the INTERMEDIATE snapshot (stage 1:
* XRPU/XCW/XDW.XC1 only, XMPD still as drawn) that ./testbench/run_xmpd_sizing.sh
* was run against; it is frozen separately so stage 2's input is citable.
*
* xschem XSCHEM V3.4.7; do not edit by hand.
** sch_path: design/lock_detector.sch
.subckt lock_detector UP DN LOCK VDD VSS
*.ipin UP
*.ipin DN
*.opin LOCK
*.iopin VDD
*.iopin VSS
XXOR UP DN ERR VDD VSS xor2_hv
XDW ERR ERRD VDD VSS delaywin_hv
XNW ERR ERRD nwide VDD VSS nand2_hv
XIW nwide WIDE VDD VSS inv_hv
XRPU VDD VWIN sub! rhigh w=0.5u l=500u m=1 b=0
XMPD VWIN WIDE VSS VSS sg13_hv_nmos w=0.25u l=12u ng=1 m=1
XCW VWIN VSS cap_cmim w=45u l=45u m=1
XSCH VWIN LOCK VDD VSS schmitt_hv
.ends

* expanding   symbol:  xor2_hv.sym # of pins=5
** sym_path: design/xor2_hv.sym
** sch_path: design/xor2_hv.sch
.subckt xor2_hv A B Y VDD VSS
*.ipin A
*.ipin B
*.opin Y
*.iopin VDD
*.iopin VSS
XN1 A B n1 VDD VSS nand2_hv
XN2 A n1 n2 VDD VSS nand2_hv
XN3 B n1 n3 VDD VSS nand2_hv
XN4 n2 n3 Y VDD VSS nand2_hv
.ends

* expanding   symbol:  delaywin_hv.sym # of pins=4
** sym_path: design/delaywin_hv.sym
** sch_path: design/delaywin_hv.sch
.subckt delaywin_hv IN OUT VDD VSS
*.ipin IN
*.opin OUT
*.iopin VDD
*.iopin VSS
XI1 IN d1 VDD VSS inv_hv
XI2 d1 d2 VDD VSS inv_hv
XI3 d2 d3 VDD VSS inv_hv
XI4 d3 OUT VDD VSS inv_hv
XC1 OUT VSS cap_cmim w=45u l=45u m=1
.ends

* expanding   symbol:  nand2_hv.sym # of pins=5
** sym_path: design/nand2_hv.sym
** sch_path: design/nand2_hv.sch
.subckt nand2_hv A1 A2 Y VDD VSS
*.opin Y
*.ipin A1
*.ipin A2
*.iopin VDD
*.iopin VSS
XMP1 Y A1 VDD VDD sg13_hv_pmos w=5u l=0.5u ng=1 m=1
XMP2 Y A2 VDD VDD sg13_hv_pmos w=5u l=0.5u ng=1 m=1
XMN1 Y A1 mid1 VSS sg13_hv_nmos w=2u l=0.5u ng=1 m=1
XMN2 mid1 A2 VSS VSS sg13_hv_nmos w=2u l=0.5u ng=1 m=1
.ends

* expanding   symbol:  inv_hv.sym # of pins=4
** sym_path: design/inv_hv.sym
** sch_path: design/inv_hv.sch
.subckt inv_hv A Y VDD VSS
*.ipin A
*.opin Y
*.iopin VDD
*.iopin VSS
XMP Y A VDD VDD sg13_hv_pmos w=5u l=0.5u ng=1 m=1
XMN Y A VSS VSS sg13_hv_nmos w=2u l=0.5u ng=1 m=1
.ends

* expanding   symbol:  schmitt_hv.sym # of pins=4
** sym_path: design/schmitt_hv.sym
** sch_path: design/schmitt_hv.sch
.subckt schmitt_hv IN OUT VDD VSS
*.ipin IN
*.opin OUT
*.iopin VDD
*.iopin VSS
XMP1 np IN VDD VDD sg13_hv_pmos w=5u l=2u ng=1 m=1
XMP2 OUT IN np VDD sg13_hv_pmos w=5u l=2u ng=1 m=1
XMP3 VSS OUT np VDD sg13_hv_pmos w=5u l=2u ng=1 m=1
XMN1 OUT IN nn VSS sg13_hv_nmos w=2u l=2u ng=1 m=1
XMN2 nn IN VSS VSS sg13_hv_nmos w=2u l=2u ng=1 m=1
XMN3 VDD OUT nn VSS sg13_hv_nmos w=2u l=2u ng=1 m=1
.ends
