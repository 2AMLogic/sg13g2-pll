* sg13g2-pll :: sim/sg13cmos5l-loop-bandwidth-pm (issue #196, RECORD-005)
* GENERATED by gen_issue196_ccp_requests.py -- do not edit by hand.
* Circuit body for `klt sim` (AC, 400 kHz / 700 kHz / 1 MHz). Total idle-state (UP =
* DN = 0) capacitance the cp presents on VOUT: each instance is alone on its
* own 0 V ammeter Vm_<inst> from the shared source Vs_<k> (no baseline is
* subtracted), so imag(i(Vm))/omega is the whole cp ("real cp vs no cp").
.include ../netlist-snapshots/cp_otabuf.spice

* buffer-less baseline: the snapshot's cp top-level subckt with XBUF -> EDUMP
.subckt cp_idealdump UP DN IBP ICP IBN ICN VOUT VDD VSS
*.ipin UP
*.ipin DN
*.iopin IBP
*.iopin ICP
*.iopin IBN
*.iopin ICN
*.opin VOUT
*.iopin VDD
*.iopin VSS
XIUP UP UPB VDD VSS inv_hv
XIDN DN DNB VDD VSS inv_hv
XLEGP IBP ICP UP UPB VOUT VDUMP VDD cp_leg_p
XLEGN IBN ICN DN DNB VOUT VDUMP VSS cp_leg_n
EDUMP VDUMP VSS VOUT VSS 1
XMBP nxp IBP VDD VDD sg13_hv_pmos w=24u l=1u ng=1 m=1
XMBPC IBP ICP nxp VDD sg13_hv_pmos w=24u l=1u ng=1 m=1
XMCP ICP ICP VDD VDD sg13_hv_pmos w=6u l=3u ng=1 m=1
XMBN nxn IBN VSS VSS sg13_hv_nmos w=8u l=1u ng=1 m=1
XMBNC IBN ICN nxn VSS sg13_hv_nmos w=8u l=1u ng=1 m=1
XMCN ICN ICN VSS VSS sg13_hv_nmos w=2u l=3u ng=1 m=1
.ends

Vdd VDD 0 dc 3.3
Xc375_0 0 0 ibp_c375_0 icp_c375_0 ibn_c375_0 icn_c375_0 vo_c375_0 VDD 0 cp
Irbp_c375_0 ibp_c375_0 0 dc 3.75u
Ircp_c375_0 icp_c375_0 0 dc 3.75u
Irbn_c375_0 0 ibn_c375_0 dc 3.75u
Ircn_c375_0 0 icn_c375_0 dc 3.75u
Vm_c375_0 vs_0 vo_c375_0 dc 0
Xc10_0 0 0 ibp_c10_0 icp_c10_0 ibn_c10_0 icn_c10_0 vo_c10_0 VDD 0 cp
Irbp_c10_0 ibp_c10_0 0 dc 10u
Ircp_c10_0 icp_c10_0 0 dc 10u
Irbn_c10_0 0 ibn_c10_0 dc 10u
Ircn_c10_0 0 icn_c10_0 dc 10u
Vm_c10_0 vs_0 vo_c10_0 dc 0
Xc11_0 0 0 ibp_c11_0 icp_c11_0 ibn_c11_0 icn_c11_0 vo_c11_0 VDD 0 cp
Irbp_c11_0 ibp_c11_0 0 dc 11u
Ircp_c11_0 icp_c11_0 0 dc 11u
Irbn_c11_0 0 ibn_c11_0 dc 11u
Ircn_c11_0 0 icn_c11_0 dc 11u
Vm_c11_0 vs_0 vo_c11_0 dc 0
Xb10_0 0 0 ibp_b10_0 icp_b10_0 ibn_b10_0 icn_b10_0 vo_b10_0 VDD 0 cp_idealdump
Irbp_b10_0 ibp_b10_0 0 dc 10u
Ircp_b10_0 icp_b10_0 0 dc 10u
Irbn_b10_0 0 ibn_b10_0 dc 10u
Ircn_b10_0 0 icn_b10_0 dc 10u
Vm_b10_0 vs_0 vo_b10_0 dc 0
Vs_0 vs_0 0 dc 0.3 ac 1
Xc375_1 0 0 ibp_c375_1 icp_c375_1 ibn_c375_1 icn_c375_1 vo_c375_1 VDD 0 cp
Irbp_c375_1 ibp_c375_1 0 dc 3.75u
Ircp_c375_1 icp_c375_1 0 dc 3.75u
Irbn_c375_1 0 ibn_c375_1 dc 3.75u
Ircn_c375_1 0 icn_c375_1 dc 3.75u
Vm_c375_1 vs_1 vo_c375_1 dc 0
Xc10_1 0 0 ibp_c10_1 icp_c10_1 ibn_c10_1 icn_c10_1 vo_c10_1 VDD 0 cp
Irbp_c10_1 ibp_c10_1 0 dc 10u
Ircp_c10_1 icp_c10_1 0 dc 10u
Irbn_c10_1 0 ibn_c10_1 dc 10u
Ircn_c10_1 0 icn_c10_1 dc 10u
Vm_c10_1 vs_1 vo_c10_1 dc 0
Xc11_1 0 0 ibp_c11_1 icp_c11_1 ibn_c11_1 icn_c11_1 vo_c11_1 VDD 0 cp
Irbp_c11_1 ibp_c11_1 0 dc 11u
Ircp_c11_1 icp_c11_1 0 dc 11u
Irbn_c11_1 0 ibn_c11_1 dc 11u
Ircn_c11_1 0 icn_c11_1 dc 11u
Vm_c11_1 vs_1 vo_c11_1 dc 0
Xb10_1 0 0 ibp_b10_1 icp_b10_1 ibn_b10_1 icn_b10_1 vo_b10_1 VDD 0 cp_idealdump
Irbp_b10_1 ibp_b10_1 0 dc 10u
Ircp_b10_1 icp_b10_1 0 dc 10u
Irbn_b10_1 0 ibn_b10_1 dc 10u
Ircn_b10_1 0 icn_b10_1 dc 10u
Vm_b10_1 vs_1 vo_b10_1 dc 0
Vs_1 vs_1 0 dc 0.5 ac 1
Xc375_2 0 0 ibp_c375_2 icp_c375_2 ibn_c375_2 icn_c375_2 vo_c375_2 VDD 0 cp
Irbp_c375_2 ibp_c375_2 0 dc 3.75u
Ircp_c375_2 icp_c375_2 0 dc 3.75u
Irbn_c375_2 0 ibn_c375_2 dc 3.75u
Ircn_c375_2 0 icn_c375_2 dc 3.75u
Vm_c375_2 vs_2 vo_c375_2 dc 0
Xc10_2 0 0 ibp_c10_2 icp_c10_2 ibn_c10_2 icn_c10_2 vo_c10_2 VDD 0 cp
Irbp_c10_2 ibp_c10_2 0 dc 10u
Ircp_c10_2 icp_c10_2 0 dc 10u
Irbn_c10_2 0 ibn_c10_2 dc 10u
Ircn_c10_2 0 icn_c10_2 dc 10u
Vm_c10_2 vs_2 vo_c10_2 dc 0
Xc11_2 0 0 ibp_c11_2 icp_c11_2 ibn_c11_2 icn_c11_2 vo_c11_2 VDD 0 cp
Irbp_c11_2 ibp_c11_2 0 dc 11u
Ircp_c11_2 icp_c11_2 0 dc 11u
Irbn_c11_2 0 ibn_c11_2 dc 11u
Ircn_c11_2 0 icn_c11_2 dc 11u
Vm_c11_2 vs_2 vo_c11_2 dc 0
Xb10_2 0 0 ibp_b10_2 icp_b10_2 ibn_b10_2 icn_b10_2 vo_b10_2 VDD 0 cp_idealdump
Irbp_b10_2 ibp_b10_2 0 dc 10u
Ircp_b10_2 icp_b10_2 0 dc 10u
Irbn_b10_2 0 ibn_b10_2 dc 10u
Ircn_b10_2 0 icn_b10_2 dc 10u
Vm_b10_2 vs_2 vo_b10_2 dc 0
Vs_2 vs_2 0 dc 0.7 ac 1
Xc375_3 0 0 ibp_c375_3 icp_c375_3 ibn_c375_3 icn_c375_3 vo_c375_3 VDD 0 cp
Irbp_c375_3 ibp_c375_3 0 dc 3.75u
Ircp_c375_3 icp_c375_3 0 dc 3.75u
Irbn_c375_3 0 ibn_c375_3 dc 3.75u
Ircn_c375_3 0 icn_c375_3 dc 3.75u
Vm_c375_3 vs_3 vo_c375_3 dc 0
Xc10_3 0 0 ibp_c10_3 icp_c10_3 ibn_c10_3 icn_c10_3 vo_c10_3 VDD 0 cp
Irbp_c10_3 ibp_c10_3 0 dc 10u
Ircp_c10_3 icp_c10_3 0 dc 10u
Irbn_c10_3 0 ibn_c10_3 dc 10u
Ircn_c10_3 0 icn_c10_3 dc 10u
Vm_c10_3 vs_3 vo_c10_3 dc 0
Xc11_3 0 0 ibp_c11_3 icp_c11_3 ibn_c11_3 icn_c11_3 vo_c11_3 VDD 0 cp
Irbp_c11_3 ibp_c11_3 0 dc 11u
Ircp_c11_3 icp_c11_3 0 dc 11u
Irbn_c11_3 0 ibn_c11_3 dc 11u
Ircn_c11_3 0 icn_c11_3 dc 11u
Vm_c11_3 vs_3 vo_c11_3 dc 0
Xb10_3 0 0 ibp_b10_3 icp_b10_3 ibn_b10_3 icn_b10_3 vo_b10_3 VDD 0 cp_idealdump
Irbp_b10_3 ibp_b10_3 0 dc 10u
Ircp_b10_3 icp_b10_3 0 dc 10u
Irbn_b10_3 0 ibn_b10_3 dc 10u
Ircn_b10_3 0 icn_b10_3 dc 10u
Vm_b10_3 vs_3 vo_b10_3 dc 0
Vs_3 vs_3 0 dc 0.9 ac 1
Xc375_4 0 0 ibp_c375_4 icp_c375_4 ibn_c375_4 icn_c375_4 vo_c375_4 VDD 0 cp
Irbp_c375_4 ibp_c375_4 0 dc 3.75u
Ircp_c375_4 icp_c375_4 0 dc 3.75u
Irbn_c375_4 0 ibn_c375_4 dc 3.75u
Ircn_c375_4 0 icn_c375_4 dc 3.75u
Vm_c375_4 vs_4 vo_c375_4 dc 0
Xc10_4 0 0 ibp_c10_4 icp_c10_4 ibn_c10_4 icn_c10_4 vo_c10_4 VDD 0 cp
Irbp_c10_4 ibp_c10_4 0 dc 10u
Ircp_c10_4 icp_c10_4 0 dc 10u
Irbn_c10_4 0 ibn_c10_4 dc 10u
Ircn_c10_4 0 icn_c10_4 dc 10u
Vm_c10_4 vs_4 vo_c10_4 dc 0
Xc11_4 0 0 ibp_c11_4 icp_c11_4 ibn_c11_4 icn_c11_4 vo_c11_4 VDD 0 cp
Irbp_c11_4 ibp_c11_4 0 dc 11u
Ircp_c11_4 icp_c11_4 0 dc 11u
Irbn_c11_4 0 ibn_c11_4 dc 11u
Ircn_c11_4 0 icn_c11_4 dc 11u
Vm_c11_4 vs_4 vo_c11_4 dc 0
Xb10_4 0 0 ibp_b10_4 icp_b10_4 ibn_b10_4 icn_b10_4 vo_b10_4 VDD 0 cp_idealdump
Irbp_b10_4 ibp_b10_4 0 dc 10u
Ircp_b10_4 icp_b10_4 0 dc 10u
Irbn_b10_4 0 ibn_b10_4 dc 10u
Ircn_b10_4 0 icn_b10_4 dc 10u
Vm_b10_4 vs_4 vo_b10_4 dc 0
Vs_4 vs_4 0 dc 1.1 ac 1
Xc375_5 0 0 ibp_c375_5 icp_c375_5 ibn_c375_5 icn_c375_5 vo_c375_5 VDD 0 cp
Irbp_c375_5 ibp_c375_5 0 dc 3.75u
Ircp_c375_5 icp_c375_5 0 dc 3.75u
Irbn_c375_5 0 ibn_c375_5 dc 3.75u
Ircn_c375_5 0 icn_c375_5 dc 3.75u
Vm_c375_5 vs_5 vo_c375_5 dc 0
Xc10_5 0 0 ibp_c10_5 icp_c10_5 ibn_c10_5 icn_c10_5 vo_c10_5 VDD 0 cp
Irbp_c10_5 ibp_c10_5 0 dc 10u
Ircp_c10_5 icp_c10_5 0 dc 10u
Irbn_c10_5 0 ibn_c10_5 dc 10u
Ircn_c10_5 0 icn_c10_5 dc 10u
Vm_c10_5 vs_5 vo_c10_5 dc 0
Xc11_5 0 0 ibp_c11_5 icp_c11_5 ibn_c11_5 icn_c11_5 vo_c11_5 VDD 0 cp
Irbp_c11_5 ibp_c11_5 0 dc 11u
Ircp_c11_5 icp_c11_5 0 dc 11u
Irbn_c11_5 0 ibn_c11_5 dc 11u
Ircn_c11_5 0 icn_c11_5 dc 11u
Vm_c11_5 vs_5 vo_c11_5 dc 0
Xb10_5 0 0 ibp_b10_5 icp_b10_5 ibn_b10_5 icn_b10_5 vo_b10_5 VDD 0 cp_idealdump
Irbp_b10_5 ibp_b10_5 0 dc 10u
Ircp_b10_5 icp_b10_5 0 dc 10u
Irbn_b10_5 0 ibn_b10_5 dc 10u
Ircn_b10_5 0 icn_b10_5 dc 10u
Vm_b10_5 vs_5 vo_b10_5 dc 0
Vs_5 vs_5 0 dc 1.3 ac 1
Xc375_6 0 0 ibp_c375_6 icp_c375_6 ibn_c375_6 icn_c375_6 vo_c375_6 VDD 0 cp
Irbp_c375_6 ibp_c375_6 0 dc 3.75u
Ircp_c375_6 icp_c375_6 0 dc 3.75u
Irbn_c375_6 0 ibn_c375_6 dc 3.75u
Ircn_c375_6 0 icn_c375_6 dc 3.75u
Vm_c375_6 vs_6 vo_c375_6 dc 0
Xc10_6 0 0 ibp_c10_6 icp_c10_6 ibn_c10_6 icn_c10_6 vo_c10_6 VDD 0 cp
Irbp_c10_6 ibp_c10_6 0 dc 10u
Ircp_c10_6 icp_c10_6 0 dc 10u
Irbn_c10_6 0 ibn_c10_6 dc 10u
Ircn_c10_6 0 icn_c10_6 dc 10u
Vm_c10_6 vs_6 vo_c10_6 dc 0
Xc11_6 0 0 ibp_c11_6 icp_c11_6 ibn_c11_6 icn_c11_6 vo_c11_6 VDD 0 cp
Irbp_c11_6 ibp_c11_6 0 dc 11u
Ircp_c11_6 icp_c11_6 0 dc 11u
Irbn_c11_6 0 ibn_c11_6 dc 11u
Ircn_c11_6 0 icn_c11_6 dc 11u
Vm_c11_6 vs_6 vo_c11_6 dc 0
Xb10_6 0 0 ibp_b10_6 icp_b10_6 ibn_b10_6 icn_b10_6 vo_b10_6 VDD 0 cp_idealdump
Irbp_b10_6 ibp_b10_6 0 dc 10u
Ircp_b10_6 icp_b10_6 0 dc 10u
Irbn_b10_6 0 ibn_b10_6 dc 10u
Ircn_b10_6 0 icn_b10_6 dc 10u
Vm_b10_6 vs_6 vo_b10_6 dc 0
Vs_6 vs_6 0 dc 1.5 ac 1
Xc375_7 0 0 ibp_c375_7 icp_c375_7 ibn_c375_7 icn_c375_7 vo_c375_7 VDD 0 cp
Irbp_c375_7 ibp_c375_7 0 dc 3.75u
Ircp_c375_7 icp_c375_7 0 dc 3.75u
Irbn_c375_7 0 ibn_c375_7 dc 3.75u
Ircn_c375_7 0 icn_c375_7 dc 3.75u
Vm_c375_7 vs_7 vo_c375_7 dc 0
Xc10_7 0 0 ibp_c10_7 icp_c10_7 ibn_c10_7 icn_c10_7 vo_c10_7 VDD 0 cp
Irbp_c10_7 ibp_c10_7 0 dc 10u
Ircp_c10_7 icp_c10_7 0 dc 10u
Irbn_c10_7 0 ibn_c10_7 dc 10u
Ircn_c10_7 0 icn_c10_7 dc 10u
Vm_c10_7 vs_7 vo_c10_7 dc 0
Xc11_7 0 0 ibp_c11_7 icp_c11_7 ibn_c11_7 icn_c11_7 vo_c11_7 VDD 0 cp
Irbp_c11_7 ibp_c11_7 0 dc 11u
Ircp_c11_7 icp_c11_7 0 dc 11u
Irbn_c11_7 0 ibn_c11_7 dc 11u
Ircn_c11_7 0 icn_c11_7 dc 11u
Vm_c11_7 vs_7 vo_c11_7 dc 0
Xb10_7 0 0 ibp_b10_7 icp_b10_7 ibn_b10_7 icn_b10_7 vo_b10_7 VDD 0 cp_idealdump
Irbp_b10_7 ibp_b10_7 0 dc 10u
Ircp_b10_7 icp_b10_7 0 dc 10u
Irbn_b10_7 0 ibn_b10_7 dc 10u
Ircn_b10_7 0 icn_b10_7 dc 10u
Vm_b10_7 vs_7 vo_b10_7 dc 0
Vs_7 vs_7 0 dc 1.7 ac 1
Xc375_8 0 0 ibp_c375_8 icp_c375_8 ibn_c375_8 icn_c375_8 vo_c375_8 VDD 0 cp
Irbp_c375_8 ibp_c375_8 0 dc 3.75u
Ircp_c375_8 icp_c375_8 0 dc 3.75u
Irbn_c375_8 0 ibn_c375_8 dc 3.75u
Ircn_c375_8 0 icn_c375_8 dc 3.75u
Vm_c375_8 vs_8 vo_c375_8 dc 0
Xc10_8 0 0 ibp_c10_8 icp_c10_8 ibn_c10_8 icn_c10_8 vo_c10_8 VDD 0 cp
Irbp_c10_8 ibp_c10_8 0 dc 10u
Ircp_c10_8 icp_c10_8 0 dc 10u
Irbn_c10_8 0 ibn_c10_8 dc 10u
Ircn_c10_8 0 icn_c10_8 dc 10u
Vm_c10_8 vs_8 vo_c10_8 dc 0
Xc11_8 0 0 ibp_c11_8 icp_c11_8 ibn_c11_8 icn_c11_8 vo_c11_8 VDD 0 cp
Irbp_c11_8 ibp_c11_8 0 dc 11u
Ircp_c11_8 icp_c11_8 0 dc 11u
Irbn_c11_8 0 ibn_c11_8 dc 11u
Ircn_c11_8 0 icn_c11_8 dc 11u
Vm_c11_8 vs_8 vo_c11_8 dc 0
Xb10_8 0 0 ibp_b10_8 icp_b10_8 ibn_b10_8 icn_b10_8 vo_b10_8 VDD 0 cp_idealdump
Irbp_b10_8 ibp_b10_8 0 dc 10u
Ircp_b10_8 icp_b10_8 0 dc 10u
Irbn_b10_8 0 ibn_b10_8 dc 10u
Ircn_b10_8 0 icn_b10_8 dc 10u
Vm_b10_8 vs_8 vo_b10_8 dc 0
Vs_8 vs_8 0 dc 1.9 ac 1
Xc375_9 0 0 ibp_c375_9 icp_c375_9 ibn_c375_9 icn_c375_9 vo_c375_9 VDD 0 cp
Irbp_c375_9 ibp_c375_9 0 dc 3.75u
Ircp_c375_9 icp_c375_9 0 dc 3.75u
Irbn_c375_9 0 ibn_c375_9 dc 3.75u
Ircn_c375_9 0 icn_c375_9 dc 3.75u
Vm_c375_9 vs_9 vo_c375_9 dc 0
Xc10_9 0 0 ibp_c10_9 icp_c10_9 ibn_c10_9 icn_c10_9 vo_c10_9 VDD 0 cp
Irbp_c10_9 ibp_c10_9 0 dc 10u
Ircp_c10_9 icp_c10_9 0 dc 10u
Irbn_c10_9 0 ibn_c10_9 dc 10u
Ircn_c10_9 0 icn_c10_9 dc 10u
Vm_c10_9 vs_9 vo_c10_9 dc 0
Xc11_9 0 0 ibp_c11_9 icp_c11_9 ibn_c11_9 icn_c11_9 vo_c11_9 VDD 0 cp
Irbp_c11_9 ibp_c11_9 0 dc 11u
Ircp_c11_9 icp_c11_9 0 dc 11u
Irbn_c11_9 0 ibn_c11_9 dc 11u
Ircn_c11_9 0 icn_c11_9 dc 11u
Vm_c11_9 vs_9 vo_c11_9 dc 0
Xb10_9 0 0 ibp_b10_9 icp_b10_9 ibn_b10_9 icn_b10_9 vo_b10_9 VDD 0 cp_idealdump
Irbp_b10_9 ibp_b10_9 0 dc 10u
Ircp_b10_9 icp_b10_9 0 dc 10u
Irbn_b10_9 0 ibn_b10_9 dc 10u
Ircn_b10_9 0 icn_b10_9 dc 10u
Vm_b10_9 vs_9 vo_b10_9 dc 0
Vs_9 vs_9 0 dc 2.1 ac 1
Xc375_10 0 0 ibp_c375_10 icp_c375_10 ibn_c375_10 icn_c375_10 vo_c375_10 VDD 0 cp
Irbp_c375_10 ibp_c375_10 0 dc 3.75u
Ircp_c375_10 icp_c375_10 0 dc 3.75u
Irbn_c375_10 0 ibn_c375_10 dc 3.75u
Ircn_c375_10 0 icn_c375_10 dc 3.75u
Vm_c375_10 vs_10 vo_c375_10 dc 0
Xc10_10 0 0 ibp_c10_10 icp_c10_10 ibn_c10_10 icn_c10_10 vo_c10_10 VDD 0 cp
Irbp_c10_10 ibp_c10_10 0 dc 10u
Ircp_c10_10 icp_c10_10 0 dc 10u
Irbn_c10_10 0 ibn_c10_10 dc 10u
Ircn_c10_10 0 icn_c10_10 dc 10u
Vm_c10_10 vs_10 vo_c10_10 dc 0
Xc11_10 0 0 ibp_c11_10 icp_c11_10 ibn_c11_10 icn_c11_10 vo_c11_10 VDD 0 cp
Irbp_c11_10 ibp_c11_10 0 dc 11u
Ircp_c11_10 icp_c11_10 0 dc 11u
Irbn_c11_10 0 ibn_c11_10 dc 11u
Ircn_c11_10 0 icn_c11_10 dc 11u
Vm_c11_10 vs_10 vo_c11_10 dc 0
Xb10_10 0 0 ibp_b10_10 icp_b10_10 ibn_b10_10 icn_b10_10 vo_b10_10 VDD 0 cp_idealdump
Irbp_b10_10 ibp_b10_10 0 dc 10u
Ircp_b10_10 icp_b10_10 0 dc 10u
Irbn_b10_10 0 ibn_b10_10 dc 10u
Ircn_b10_10 0 icn_b10_10 dc 10u
Vm_b10_10 vs_10 vo_b10_10 dc 0
Vs_10 vs_10 0 dc 2.3 ac 1
Xc375_11 0 0 ibp_c375_11 icp_c375_11 ibn_c375_11 icn_c375_11 vo_c375_11 VDD 0 cp
Irbp_c375_11 ibp_c375_11 0 dc 3.75u
Ircp_c375_11 icp_c375_11 0 dc 3.75u
Irbn_c375_11 0 ibn_c375_11 dc 3.75u
Ircn_c375_11 0 icn_c375_11 dc 3.75u
Vm_c375_11 vs_11 vo_c375_11 dc 0
Xc10_11 0 0 ibp_c10_11 icp_c10_11 ibn_c10_11 icn_c10_11 vo_c10_11 VDD 0 cp
Irbp_c10_11 ibp_c10_11 0 dc 10u
Ircp_c10_11 icp_c10_11 0 dc 10u
Irbn_c10_11 0 ibn_c10_11 dc 10u
Ircn_c10_11 0 icn_c10_11 dc 10u
Vm_c10_11 vs_11 vo_c10_11 dc 0
Xc11_11 0 0 ibp_c11_11 icp_c11_11 ibn_c11_11 icn_c11_11 vo_c11_11 VDD 0 cp
Irbp_c11_11 ibp_c11_11 0 dc 11u
Ircp_c11_11 icp_c11_11 0 dc 11u
Irbn_c11_11 0 ibn_c11_11 dc 11u
Ircn_c11_11 0 icn_c11_11 dc 11u
Vm_c11_11 vs_11 vo_c11_11 dc 0
Xb10_11 0 0 ibp_b10_11 icp_b10_11 ibn_b10_11 icn_b10_11 vo_b10_11 VDD 0 cp_idealdump
Irbp_b10_11 ibp_b10_11 0 dc 10u
Ircp_b10_11 icp_b10_11 0 dc 10u
Irbn_b10_11 0 ibn_b10_11 dc 10u
Ircn_b10_11 0 icn_b10_11 dc 10u
Vm_b10_11 vs_11 vo_b10_11 dc 0
Vs_11 vs_11 0 dc 2.5 ac 1
Xc375_12 0 0 ibp_c375_12 icp_c375_12 ibn_c375_12 icn_c375_12 vo_c375_12 VDD 0 cp
Irbp_c375_12 ibp_c375_12 0 dc 3.75u
Ircp_c375_12 icp_c375_12 0 dc 3.75u
Irbn_c375_12 0 ibn_c375_12 dc 3.75u
Ircn_c375_12 0 icn_c375_12 dc 3.75u
Vm_c375_12 vs_12 vo_c375_12 dc 0
Xc10_12 0 0 ibp_c10_12 icp_c10_12 ibn_c10_12 icn_c10_12 vo_c10_12 VDD 0 cp
Irbp_c10_12 ibp_c10_12 0 dc 10u
Ircp_c10_12 icp_c10_12 0 dc 10u
Irbn_c10_12 0 ibn_c10_12 dc 10u
Ircn_c10_12 0 icn_c10_12 dc 10u
Vm_c10_12 vs_12 vo_c10_12 dc 0
Xc11_12 0 0 ibp_c11_12 icp_c11_12 ibn_c11_12 icn_c11_12 vo_c11_12 VDD 0 cp
Irbp_c11_12 ibp_c11_12 0 dc 11u
Ircp_c11_12 icp_c11_12 0 dc 11u
Irbn_c11_12 0 ibn_c11_12 dc 11u
Ircn_c11_12 0 icn_c11_12 dc 11u
Vm_c11_12 vs_12 vo_c11_12 dc 0
Xb10_12 0 0 ibp_b10_12 icp_b10_12 ibn_b10_12 icn_b10_12 vo_b10_12 VDD 0 cp_idealdump
Irbp_b10_12 ibp_b10_12 0 dc 10u
Ircp_b10_12 icp_b10_12 0 dc 10u
Irbn_b10_12 0 ibn_b10_12 dc 10u
Ircn_b10_12 0 icn_b10_12 dc 10u
Vm_b10_12 vs_12 vo_b10_12 dc 0
Vs_12 vs_12 0 dc 2.7 ac 1
Xc375_13 0 0 ibp_c375_13 icp_c375_13 ibn_c375_13 icn_c375_13 vo_c375_13 VDD 0 cp
Irbp_c375_13 ibp_c375_13 0 dc 3.75u
Ircp_c375_13 icp_c375_13 0 dc 3.75u
Irbn_c375_13 0 ibn_c375_13 dc 3.75u
Ircn_c375_13 0 icn_c375_13 dc 3.75u
Vm_c375_13 vs_13 vo_c375_13 dc 0
Xc10_13 0 0 ibp_c10_13 icp_c10_13 ibn_c10_13 icn_c10_13 vo_c10_13 VDD 0 cp
Irbp_c10_13 ibp_c10_13 0 dc 10u
Ircp_c10_13 icp_c10_13 0 dc 10u
Irbn_c10_13 0 ibn_c10_13 dc 10u
Ircn_c10_13 0 icn_c10_13 dc 10u
Vm_c10_13 vs_13 vo_c10_13 dc 0
Xc11_13 0 0 ibp_c11_13 icp_c11_13 ibn_c11_13 icn_c11_13 vo_c11_13 VDD 0 cp
Irbp_c11_13 ibp_c11_13 0 dc 11u
Ircp_c11_13 icp_c11_13 0 dc 11u
Irbn_c11_13 0 ibn_c11_13 dc 11u
Ircn_c11_13 0 icn_c11_13 dc 11u
Vm_c11_13 vs_13 vo_c11_13 dc 0
Xb10_13 0 0 ibp_b10_13 icp_b10_13 ibn_b10_13 icn_b10_13 vo_b10_13 VDD 0 cp_idealdump
Irbp_b10_13 ibp_b10_13 0 dc 10u
Ircp_b10_13 icp_b10_13 0 dc 10u
Irbn_b10_13 0 ibn_b10_13 dc 10u
Ircn_b10_13 0 icn_b10_13 dc 10u
Vm_b10_13 vs_13 vo_b10_13 dc 0
Vs_13 vs_13 0 dc 2.9 ac 1
