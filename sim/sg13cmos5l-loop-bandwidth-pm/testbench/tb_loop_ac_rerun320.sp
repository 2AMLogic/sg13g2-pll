* sg13g2-pll :: sim/sg13cmos5l-loop-bandwidth-pm (issue #320, RECORD-006)
* GENERATED by gen_rerun320_requests.py -- do not edit by hand.
* Circuit body for `klt sim` (AC, dec 200 10 1e9 as RECORD-002..004). Each loop
* is tb_loop_ac_real_resized.sp.tmpl's scenario verbatim (ideal Gcp, ideal VCO
* integrator, memoryless 1/N, REAL resized loop filter), Kd/Kv/N from the
* committed RECORD-003/004 CSVs and Icp from their cp-icp-trim inputs.
.include /home/ubuntu/share/pdk/ihp-sg13cmos5l/libs.tech/ngspice/models/cap_cmomi.lib
.include ../netlist-snapshots/loop_filter_resized.spice
.option scale=1
.global sub!

Vsub sub! 0 dc 0
Vpe pe 0 dc 0 ac 1
* --- loop dr008_fast: fast bundle, trim 11u, n_div 127
Gcp_dr008_fast 0 vc_dr008_fast pe 0 1.750782359932964e-06
XLF_dr008_fast vc_dr008_fast 0 loop_filter
Gvco_dr008_fast 0 vph_dr008_fast vc_dr008_fast 0 461985148.381761
Cint_dr008_fast vph_dr008_fast 0 1
Rleak_dr008_fast vph_dr008_fast 0 1e15
Ediv_dr008_fast fb_dr008_fast 0 vph_dr008_fast 0 0.007874015748031496
* --- loop dr008_typ: typ bundle, trim 11u, n_div 114
Gcp_dr008_typ 0 vc_dr008_typ pe 0 1.7507839514823947e-06
XLF_dr008_typ vc_dr008_typ 0 loop_filter
Gvco_dr008_typ 0 vph_dr008_typ vc_dr008_typ 0 409652497.95826226
Cint_dr008_typ vph_dr008_typ 0 1
Rleak_dr008_typ vph_dr008_typ 0 1e15
Ediv_dr008_typ fb_dr008_typ 0 vph_dr008_typ 0 0.008771929824561403
* --- loop dr008_slow: slow bundle, trim 11u, n_div 103
Gcp_dr008_slow 0 vc_dr008_slow pe 0 1.7508269233170294e-06
XLF_dr008_slow vc_dr008_slow 0 loop_filter
Gvco_dr008_slow 0 vph_dr008_slow vc_dr008_slow 0 399248171.4081036
Cint_dr008_slow vph_dr008_slow 0 1
Rleak_dr008_slow vph_dr008_slow 0 1e15
Ediv_dr008_slow fb_dr008_slow 0 vph_dr008_slow 0 0.009708737864077669
* --- loop dr007_slow: slow bundle, trim 3.75u, n_div 119
Gcp_dr007_slow 0 vc_dr007_slow pe 0 5.969071126574055e-07
XLF_dr007_slow vc_dr007_slow 0 loop_filter
Gvco_dr007_slow 0 vph_dr007_slow vc_dr007_slow 0 1057966511.934083
Cint_dr007_slow vph_dr007_slow 0 1
Rleak_dr007_slow vph_dr007_slow 0 1e15
Ediv_dr007_slow fb_dr007_slow 0 vph_dr007_slow 0 0.008403361344537815
