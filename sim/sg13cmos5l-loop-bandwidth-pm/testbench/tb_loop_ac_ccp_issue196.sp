* sg13g2-pll :: sim/sg13cmos5l-loop-bandwidth-pm (issue #196, RECORD-005)
* GENERATED by gen_issue196_ccp_requests.py -- do not edit by hand.
* Circuit body for `klt sim` (AC, dec 200 10 1e9 as RECORD-001..004).
* Open-loop gain v(fb_<loop>) per 1 rad of phase error on `pe`. Each <t>_nocp
* loop is tb_loop_ac_real_resized.sp.tmpl verbatim (ideal Gcp, no cp); each
* <t>_v<v> loop adds the real idle cp (VOUT pin on vc_<loop>, VCTRL = v).
* Kd/Kv/N per tuple are read from the committed RECORD-003/004 CSVs.
.include /home/ubuntu/share/pdk/ihp-sg13cmos5l/libs.tech/ngspice/models/cap_cmomi.lib
.include ../netlist-snapshots/loop_filter_resized.spice
.include ../netlist-snapshots/cp_otabuf.spice
.option scale=1
.global sub!

Vsub sub! 0 dc 0
Vdd VDD 0 dc 3.3
Vpe pe 0 dc 0 ac 1
* --- loop dr008_fast_nocp
Gcp_dr008_fast_nocp 0 vc_dr008_fast_nocp pe 0 1.750782359932964e-06
XLF_dr008_fast_nocp vc_dr008_fast_nocp 0 loop_filter
Gvco_dr008_fast_nocp 0 vph_dr008_fast_nocp vc_dr008_fast_nocp 0 461985148.381761
Cint_dr008_fast_nocp vph_dr008_fast_nocp 0 1
Rleak_dr008_fast_nocp vph_dr008_fast_nocp 0 1e15
Ediv_dr008_fast_nocp fb_dr008_fast_nocp 0 vph_dr008_fast_nocp 0 0.007874015748031496
* --- loop dr008_fast_lonly
Gcp_dr008_fast_lonly 0 vc_dr008_fast_lonly pe 0 1.750782359932964e-06
XLF_dr008_fast_lonly vc_dr008_fast_lonly 0 loop_filter
Gvco_dr008_fast_lonly 0 vph_dr008_fast_lonly vc_dr008_fast_lonly vb_dr008_fast_lonly 461985148.381761
Cint_dr008_fast_lonly vph_dr008_fast_lonly 0 1
Rleak_dr008_fast_lonly vph_dr008_fast_lonly 0 1e15
Ediv_dr008_fast_lonly fb_dr008_fast_lonly 0 vph_dr008_fast_lonly 0 0.007874015748031496
Lb_dr008_fast_lonly vc_dr008_fast_lonly vb_dr008_fast_lonly 1e12
Vb_dr008_fast_lonly vb_dr008_fast_lonly 0 dc 1.5
* --- loop dr008_fast_v0p3
Gcp_dr008_fast_v0p3 0 vc_dr008_fast_v0p3 pe 0 1.750782359932964e-06
XLF_dr008_fast_v0p3 vc_dr008_fast_v0p3 0 loop_filter
Gvco_dr008_fast_v0p3 0 vph_dr008_fast_v0p3 vc_dr008_fast_v0p3 vb_dr008_fast_v0p3 461985148.381761
Cint_dr008_fast_v0p3 vph_dr008_fast_v0p3 0 1
Rleak_dr008_fast_v0p3 vph_dr008_fast_v0p3 0 1e15
Ediv_dr008_fast_v0p3 fb_dr008_fast_v0p3 0 vph_dr008_fast_v0p3 0 0.007874015748031496
Lb_dr008_fast_v0p3 vc_dr008_fast_v0p3 vb_dr008_fast_v0p3 1e12
Vb_dr008_fast_v0p3 vb_dr008_fast_v0p3 0 dc 0.3
Xcp_dr008_fast_v0p3 0 0 ibp_dr008_fast_v0p3 icp_dr008_fast_v0p3 ibn_dr008_fast_v0p3 icn_dr008_fast_v0p3 vc_dr008_fast_v0p3 VDD 0 cp
Irbp_dr008_fast_v0p3 ibp_dr008_fast_v0p3 0 dc 11u
Ircp_dr008_fast_v0p3 icp_dr008_fast_v0p3 0 dc 11u
Irbn_dr008_fast_v0p3 0 ibn_dr008_fast_v0p3 dc 11u
Ircn_dr008_fast_v0p3 0 icn_dr008_fast_v0p3 dc 11u
* --- loop dr008_fast_v0p5
Gcp_dr008_fast_v0p5 0 vc_dr008_fast_v0p5 pe 0 1.750782359932964e-06
XLF_dr008_fast_v0p5 vc_dr008_fast_v0p5 0 loop_filter
Gvco_dr008_fast_v0p5 0 vph_dr008_fast_v0p5 vc_dr008_fast_v0p5 vb_dr008_fast_v0p5 461985148.381761
Cint_dr008_fast_v0p5 vph_dr008_fast_v0p5 0 1
Rleak_dr008_fast_v0p5 vph_dr008_fast_v0p5 0 1e15
Ediv_dr008_fast_v0p5 fb_dr008_fast_v0p5 0 vph_dr008_fast_v0p5 0 0.007874015748031496
Lb_dr008_fast_v0p5 vc_dr008_fast_v0p5 vb_dr008_fast_v0p5 1e12
Vb_dr008_fast_v0p5 vb_dr008_fast_v0p5 0 dc 0.5
Xcp_dr008_fast_v0p5 0 0 ibp_dr008_fast_v0p5 icp_dr008_fast_v0p5 ibn_dr008_fast_v0p5 icn_dr008_fast_v0p5 vc_dr008_fast_v0p5 VDD 0 cp
Irbp_dr008_fast_v0p5 ibp_dr008_fast_v0p5 0 dc 11u
Ircp_dr008_fast_v0p5 icp_dr008_fast_v0p5 0 dc 11u
Irbn_dr008_fast_v0p5 0 ibn_dr008_fast_v0p5 dc 11u
Ircn_dr008_fast_v0p5 0 icn_dr008_fast_v0p5 dc 11u
* --- loop dr008_fast_v0p7
Gcp_dr008_fast_v0p7 0 vc_dr008_fast_v0p7 pe 0 1.750782359932964e-06
XLF_dr008_fast_v0p7 vc_dr008_fast_v0p7 0 loop_filter
Gvco_dr008_fast_v0p7 0 vph_dr008_fast_v0p7 vc_dr008_fast_v0p7 vb_dr008_fast_v0p7 461985148.381761
Cint_dr008_fast_v0p7 vph_dr008_fast_v0p7 0 1
Rleak_dr008_fast_v0p7 vph_dr008_fast_v0p7 0 1e15
Ediv_dr008_fast_v0p7 fb_dr008_fast_v0p7 0 vph_dr008_fast_v0p7 0 0.007874015748031496
Lb_dr008_fast_v0p7 vc_dr008_fast_v0p7 vb_dr008_fast_v0p7 1e12
Vb_dr008_fast_v0p7 vb_dr008_fast_v0p7 0 dc 0.7
Xcp_dr008_fast_v0p7 0 0 ibp_dr008_fast_v0p7 icp_dr008_fast_v0p7 ibn_dr008_fast_v0p7 icn_dr008_fast_v0p7 vc_dr008_fast_v0p7 VDD 0 cp
Irbp_dr008_fast_v0p7 ibp_dr008_fast_v0p7 0 dc 11u
Ircp_dr008_fast_v0p7 icp_dr008_fast_v0p7 0 dc 11u
Irbn_dr008_fast_v0p7 0 ibn_dr008_fast_v0p7 dc 11u
Ircn_dr008_fast_v0p7 0 icn_dr008_fast_v0p7 dc 11u
* --- loop dr008_fast_v0p9
Gcp_dr008_fast_v0p9 0 vc_dr008_fast_v0p9 pe 0 1.750782359932964e-06
XLF_dr008_fast_v0p9 vc_dr008_fast_v0p9 0 loop_filter
Gvco_dr008_fast_v0p9 0 vph_dr008_fast_v0p9 vc_dr008_fast_v0p9 vb_dr008_fast_v0p9 461985148.381761
Cint_dr008_fast_v0p9 vph_dr008_fast_v0p9 0 1
Rleak_dr008_fast_v0p9 vph_dr008_fast_v0p9 0 1e15
Ediv_dr008_fast_v0p9 fb_dr008_fast_v0p9 0 vph_dr008_fast_v0p9 0 0.007874015748031496
Lb_dr008_fast_v0p9 vc_dr008_fast_v0p9 vb_dr008_fast_v0p9 1e12
Vb_dr008_fast_v0p9 vb_dr008_fast_v0p9 0 dc 0.9
Xcp_dr008_fast_v0p9 0 0 ibp_dr008_fast_v0p9 icp_dr008_fast_v0p9 ibn_dr008_fast_v0p9 icn_dr008_fast_v0p9 vc_dr008_fast_v0p9 VDD 0 cp
Irbp_dr008_fast_v0p9 ibp_dr008_fast_v0p9 0 dc 11u
Ircp_dr008_fast_v0p9 icp_dr008_fast_v0p9 0 dc 11u
Irbn_dr008_fast_v0p9 0 ibn_dr008_fast_v0p9 dc 11u
Ircn_dr008_fast_v0p9 0 icn_dr008_fast_v0p9 dc 11u
* --- loop dr008_fast_v1p1
Gcp_dr008_fast_v1p1 0 vc_dr008_fast_v1p1 pe 0 1.750782359932964e-06
XLF_dr008_fast_v1p1 vc_dr008_fast_v1p1 0 loop_filter
Gvco_dr008_fast_v1p1 0 vph_dr008_fast_v1p1 vc_dr008_fast_v1p1 vb_dr008_fast_v1p1 461985148.381761
Cint_dr008_fast_v1p1 vph_dr008_fast_v1p1 0 1
Rleak_dr008_fast_v1p1 vph_dr008_fast_v1p1 0 1e15
Ediv_dr008_fast_v1p1 fb_dr008_fast_v1p1 0 vph_dr008_fast_v1p1 0 0.007874015748031496
Lb_dr008_fast_v1p1 vc_dr008_fast_v1p1 vb_dr008_fast_v1p1 1e12
Vb_dr008_fast_v1p1 vb_dr008_fast_v1p1 0 dc 1.1
Xcp_dr008_fast_v1p1 0 0 ibp_dr008_fast_v1p1 icp_dr008_fast_v1p1 ibn_dr008_fast_v1p1 icn_dr008_fast_v1p1 vc_dr008_fast_v1p1 VDD 0 cp
Irbp_dr008_fast_v1p1 ibp_dr008_fast_v1p1 0 dc 11u
Ircp_dr008_fast_v1p1 icp_dr008_fast_v1p1 0 dc 11u
Irbn_dr008_fast_v1p1 0 ibn_dr008_fast_v1p1 dc 11u
Ircn_dr008_fast_v1p1 0 icn_dr008_fast_v1p1 dc 11u
* --- loop dr008_fast_v1p3
Gcp_dr008_fast_v1p3 0 vc_dr008_fast_v1p3 pe 0 1.750782359932964e-06
XLF_dr008_fast_v1p3 vc_dr008_fast_v1p3 0 loop_filter
Gvco_dr008_fast_v1p3 0 vph_dr008_fast_v1p3 vc_dr008_fast_v1p3 vb_dr008_fast_v1p3 461985148.381761
Cint_dr008_fast_v1p3 vph_dr008_fast_v1p3 0 1
Rleak_dr008_fast_v1p3 vph_dr008_fast_v1p3 0 1e15
Ediv_dr008_fast_v1p3 fb_dr008_fast_v1p3 0 vph_dr008_fast_v1p3 0 0.007874015748031496
Lb_dr008_fast_v1p3 vc_dr008_fast_v1p3 vb_dr008_fast_v1p3 1e12
Vb_dr008_fast_v1p3 vb_dr008_fast_v1p3 0 dc 1.3
Xcp_dr008_fast_v1p3 0 0 ibp_dr008_fast_v1p3 icp_dr008_fast_v1p3 ibn_dr008_fast_v1p3 icn_dr008_fast_v1p3 vc_dr008_fast_v1p3 VDD 0 cp
Irbp_dr008_fast_v1p3 ibp_dr008_fast_v1p3 0 dc 11u
Ircp_dr008_fast_v1p3 icp_dr008_fast_v1p3 0 dc 11u
Irbn_dr008_fast_v1p3 0 ibn_dr008_fast_v1p3 dc 11u
Ircn_dr008_fast_v1p3 0 icn_dr008_fast_v1p3 dc 11u
* --- loop dr008_fast_v1p5
Gcp_dr008_fast_v1p5 0 vc_dr008_fast_v1p5 pe 0 1.750782359932964e-06
XLF_dr008_fast_v1p5 vc_dr008_fast_v1p5 0 loop_filter
Gvco_dr008_fast_v1p5 0 vph_dr008_fast_v1p5 vc_dr008_fast_v1p5 vb_dr008_fast_v1p5 461985148.381761
Cint_dr008_fast_v1p5 vph_dr008_fast_v1p5 0 1
Rleak_dr008_fast_v1p5 vph_dr008_fast_v1p5 0 1e15
Ediv_dr008_fast_v1p5 fb_dr008_fast_v1p5 0 vph_dr008_fast_v1p5 0 0.007874015748031496
Lb_dr008_fast_v1p5 vc_dr008_fast_v1p5 vb_dr008_fast_v1p5 1e12
Vb_dr008_fast_v1p5 vb_dr008_fast_v1p5 0 dc 1.5
Xcp_dr008_fast_v1p5 0 0 ibp_dr008_fast_v1p5 icp_dr008_fast_v1p5 ibn_dr008_fast_v1p5 icn_dr008_fast_v1p5 vc_dr008_fast_v1p5 VDD 0 cp
Irbp_dr008_fast_v1p5 ibp_dr008_fast_v1p5 0 dc 11u
Ircp_dr008_fast_v1p5 icp_dr008_fast_v1p5 0 dc 11u
Irbn_dr008_fast_v1p5 0 ibn_dr008_fast_v1p5 dc 11u
Ircn_dr008_fast_v1p5 0 icn_dr008_fast_v1p5 dc 11u
* --- loop dr008_fast_v1p7
Gcp_dr008_fast_v1p7 0 vc_dr008_fast_v1p7 pe 0 1.750782359932964e-06
XLF_dr008_fast_v1p7 vc_dr008_fast_v1p7 0 loop_filter
Gvco_dr008_fast_v1p7 0 vph_dr008_fast_v1p7 vc_dr008_fast_v1p7 vb_dr008_fast_v1p7 461985148.381761
Cint_dr008_fast_v1p7 vph_dr008_fast_v1p7 0 1
Rleak_dr008_fast_v1p7 vph_dr008_fast_v1p7 0 1e15
Ediv_dr008_fast_v1p7 fb_dr008_fast_v1p7 0 vph_dr008_fast_v1p7 0 0.007874015748031496
Lb_dr008_fast_v1p7 vc_dr008_fast_v1p7 vb_dr008_fast_v1p7 1e12
Vb_dr008_fast_v1p7 vb_dr008_fast_v1p7 0 dc 1.7
Xcp_dr008_fast_v1p7 0 0 ibp_dr008_fast_v1p7 icp_dr008_fast_v1p7 ibn_dr008_fast_v1p7 icn_dr008_fast_v1p7 vc_dr008_fast_v1p7 VDD 0 cp
Irbp_dr008_fast_v1p7 ibp_dr008_fast_v1p7 0 dc 11u
Ircp_dr008_fast_v1p7 icp_dr008_fast_v1p7 0 dc 11u
Irbn_dr008_fast_v1p7 0 ibn_dr008_fast_v1p7 dc 11u
Ircn_dr008_fast_v1p7 0 icn_dr008_fast_v1p7 dc 11u
* --- loop dr008_fast_v1p9
Gcp_dr008_fast_v1p9 0 vc_dr008_fast_v1p9 pe 0 1.750782359932964e-06
XLF_dr008_fast_v1p9 vc_dr008_fast_v1p9 0 loop_filter
Gvco_dr008_fast_v1p9 0 vph_dr008_fast_v1p9 vc_dr008_fast_v1p9 vb_dr008_fast_v1p9 461985148.381761
Cint_dr008_fast_v1p9 vph_dr008_fast_v1p9 0 1
Rleak_dr008_fast_v1p9 vph_dr008_fast_v1p9 0 1e15
Ediv_dr008_fast_v1p9 fb_dr008_fast_v1p9 0 vph_dr008_fast_v1p9 0 0.007874015748031496
Lb_dr008_fast_v1p9 vc_dr008_fast_v1p9 vb_dr008_fast_v1p9 1e12
Vb_dr008_fast_v1p9 vb_dr008_fast_v1p9 0 dc 1.9
Xcp_dr008_fast_v1p9 0 0 ibp_dr008_fast_v1p9 icp_dr008_fast_v1p9 ibn_dr008_fast_v1p9 icn_dr008_fast_v1p9 vc_dr008_fast_v1p9 VDD 0 cp
Irbp_dr008_fast_v1p9 ibp_dr008_fast_v1p9 0 dc 11u
Ircp_dr008_fast_v1p9 icp_dr008_fast_v1p9 0 dc 11u
Irbn_dr008_fast_v1p9 0 ibn_dr008_fast_v1p9 dc 11u
Ircn_dr008_fast_v1p9 0 icn_dr008_fast_v1p9 dc 11u
* --- loop dr008_fast_v2p1
Gcp_dr008_fast_v2p1 0 vc_dr008_fast_v2p1 pe 0 1.750782359932964e-06
XLF_dr008_fast_v2p1 vc_dr008_fast_v2p1 0 loop_filter
Gvco_dr008_fast_v2p1 0 vph_dr008_fast_v2p1 vc_dr008_fast_v2p1 vb_dr008_fast_v2p1 461985148.381761
Cint_dr008_fast_v2p1 vph_dr008_fast_v2p1 0 1
Rleak_dr008_fast_v2p1 vph_dr008_fast_v2p1 0 1e15
Ediv_dr008_fast_v2p1 fb_dr008_fast_v2p1 0 vph_dr008_fast_v2p1 0 0.007874015748031496
Lb_dr008_fast_v2p1 vc_dr008_fast_v2p1 vb_dr008_fast_v2p1 1e12
Vb_dr008_fast_v2p1 vb_dr008_fast_v2p1 0 dc 2.1
Xcp_dr008_fast_v2p1 0 0 ibp_dr008_fast_v2p1 icp_dr008_fast_v2p1 ibn_dr008_fast_v2p1 icn_dr008_fast_v2p1 vc_dr008_fast_v2p1 VDD 0 cp
Irbp_dr008_fast_v2p1 ibp_dr008_fast_v2p1 0 dc 11u
Ircp_dr008_fast_v2p1 icp_dr008_fast_v2p1 0 dc 11u
Irbn_dr008_fast_v2p1 0 ibn_dr008_fast_v2p1 dc 11u
Ircn_dr008_fast_v2p1 0 icn_dr008_fast_v2p1 dc 11u
* --- loop dr008_fast_v2p3
Gcp_dr008_fast_v2p3 0 vc_dr008_fast_v2p3 pe 0 1.750782359932964e-06
XLF_dr008_fast_v2p3 vc_dr008_fast_v2p3 0 loop_filter
Gvco_dr008_fast_v2p3 0 vph_dr008_fast_v2p3 vc_dr008_fast_v2p3 vb_dr008_fast_v2p3 461985148.381761
Cint_dr008_fast_v2p3 vph_dr008_fast_v2p3 0 1
Rleak_dr008_fast_v2p3 vph_dr008_fast_v2p3 0 1e15
Ediv_dr008_fast_v2p3 fb_dr008_fast_v2p3 0 vph_dr008_fast_v2p3 0 0.007874015748031496
Lb_dr008_fast_v2p3 vc_dr008_fast_v2p3 vb_dr008_fast_v2p3 1e12
Vb_dr008_fast_v2p3 vb_dr008_fast_v2p3 0 dc 2.3
Xcp_dr008_fast_v2p3 0 0 ibp_dr008_fast_v2p3 icp_dr008_fast_v2p3 ibn_dr008_fast_v2p3 icn_dr008_fast_v2p3 vc_dr008_fast_v2p3 VDD 0 cp
Irbp_dr008_fast_v2p3 ibp_dr008_fast_v2p3 0 dc 11u
Ircp_dr008_fast_v2p3 icp_dr008_fast_v2p3 0 dc 11u
Irbn_dr008_fast_v2p3 0 ibn_dr008_fast_v2p3 dc 11u
Ircn_dr008_fast_v2p3 0 icn_dr008_fast_v2p3 dc 11u
* --- loop dr008_fast_v2p5
Gcp_dr008_fast_v2p5 0 vc_dr008_fast_v2p5 pe 0 1.750782359932964e-06
XLF_dr008_fast_v2p5 vc_dr008_fast_v2p5 0 loop_filter
Gvco_dr008_fast_v2p5 0 vph_dr008_fast_v2p5 vc_dr008_fast_v2p5 vb_dr008_fast_v2p5 461985148.381761
Cint_dr008_fast_v2p5 vph_dr008_fast_v2p5 0 1
Rleak_dr008_fast_v2p5 vph_dr008_fast_v2p5 0 1e15
Ediv_dr008_fast_v2p5 fb_dr008_fast_v2p5 0 vph_dr008_fast_v2p5 0 0.007874015748031496
Lb_dr008_fast_v2p5 vc_dr008_fast_v2p5 vb_dr008_fast_v2p5 1e12
Vb_dr008_fast_v2p5 vb_dr008_fast_v2p5 0 dc 2.5
Xcp_dr008_fast_v2p5 0 0 ibp_dr008_fast_v2p5 icp_dr008_fast_v2p5 ibn_dr008_fast_v2p5 icn_dr008_fast_v2p5 vc_dr008_fast_v2p5 VDD 0 cp
Irbp_dr008_fast_v2p5 ibp_dr008_fast_v2p5 0 dc 11u
Ircp_dr008_fast_v2p5 icp_dr008_fast_v2p5 0 dc 11u
Irbn_dr008_fast_v2p5 0 ibn_dr008_fast_v2p5 dc 11u
Ircn_dr008_fast_v2p5 0 icn_dr008_fast_v2p5 dc 11u
* --- loop dr008_fast_v2p7
Gcp_dr008_fast_v2p7 0 vc_dr008_fast_v2p7 pe 0 1.750782359932964e-06
XLF_dr008_fast_v2p7 vc_dr008_fast_v2p7 0 loop_filter
Gvco_dr008_fast_v2p7 0 vph_dr008_fast_v2p7 vc_dr008_fast_v2p7 vb_dr008_fast_v2p7 461985148.381761
Cint_dr008_fast_v2p7 vph_dr008_fast_v2p7 0 1
Rleak_dr008_fast_v2p7 vph_dr008_fast_v2p7 0 1e15
Ediv_dr008_fast_v2p7 fb_dr008_fast_v2p7 0 vph_dr008_fast_v2p7 0 0.007874015748031496
Lb_dr008_fast_v2p7 vc_dr008_fast_v2p7 vb_dr008_fast_v2p7 1e12
Vb_dr008_fast_v2p7 vb_dr008_fast_v2p7 0 dc 2.7
Xcp_dr008_fast_v2p7 0 0 ibp_dr008_fast_v2p7 icp_dr008_fast_v2p7 ibn_dr008_fast_v2p7 icn_dr008_fast_v2p7 vc_dr008_fast_v2p7 VDD 0 cp
Irbp_dr008_fast_v2p7 ibp_dr008_fast_v2p7 0 dc 11u
Ircp_dr008_fast_v2p7 icp_dr008_fast_v2p7 0 dc 11u
Irbn_dr008_fast_v2p7 0 ibn_dr008_fast_v2p7 dc 11u
Ircn_dr008_fast_v2p7 0 icn_dr008_fast_v2p7 dc 11u
* --- loop dr008_fast_v2p9
Gcp_dr008_fast_v2p9 0 vc_dr008_fast_v2p9 pe 0 1.750782359932964e-06
XLF_dr008_fast_v2p9 vc_dr008_fast_v2p9 0 loop_filter
Gvco_dr008_fast_v2p9 0 vph_dr008_fast_v2p9 vc_dr008_fast_v2p9 vb_dr008_fast_v2p9 461985148.381761
Cint_dr008_fast_v2p9 vph_dr008_fast_v2p9 0 1
Rleak_dr008_fast_v2p9 vph_dr008_fast_v2p9 0 1e15
Ediv_dr008_fast_v2p9 fb_dr008_fast_v2p9 0 vph_dr008_fast_v2p9 0 0.007874015748031496
Lb_dr008_fast_v2p9 vc_dr008_fast_v2p9 vb_dr008_fast_v2p9 1e12
Vb_dr008_fast_v2p9 vb_dr008_fast_v2p9 0 dc 2.9
Xcp_dr008_fast_v2p9 0 0 ibp_dr008_fast_v2p9 icp_dr008_fast_v2p9 ibn_dr008_fast_v2p9 icn_dr008_fast_v2p9 vc_dr008_fast_v2p9 VDD 0 cp
Irbp_dr008_fast_v2p9 ibp_dr008_fast_v2p9 0 dc 11u
Ircp_dr008_fast_v2p9 icp_dr008_fast_v2p9 0 dc 11u
Irbn_dr008_fast_v2p9 0 ibn_dr008_fast_v2p9 dc 11u
Ircn_dr008_fast_v2p9 0 icn_dr008_fast_v2p9 dc 11u
* --- loop dr008_typ_nocp
Gcp_dr008_typ_nocp 0 vc_dr008_typ_nocp pe 0 1.7507839514823947e-06
XLF_dr008_typ_nocp vc_dr008_typ_nocp 0 loop_filter
Gvco_dr008_typ_nocp 0 vph_dr008_typ_nocp vc_dr008_typ_nocp 0 409652497.95826226
Cint_dr008_typ_nocp vph_dr008_typ_nocp 0 1
Rleak_dr008_typ_nocp vph_dr008_typ_nocp 0 1e15
Ediv_dr008_typ_nocp fb_dr008_typ_nocp 0 vph_dr008_typ_nocp 0 0.008771929824561403
* --- loop dr008_typ_lonly
Gcp_dr008_typ_lonly 0 vc_dr008_typ_lonly pe 0 1.7507839514823947e-06
XLF_dr008_typ_lonly vc_dr008_typ_lonly 0 loop_filter
Gvco_dr008_typ_lonly 0 vph_dr008_typ_lonly vc_dr008_typ_lonly vb_dr008_typ_lonly 409652497.95826226
Cint_dr008_typ_lonly vph_dr008_typ_lonly 0 1
Rleak_dr008_typ_lonly vph_dr008_typ_lonly 0 1e15
Ediv_dr008_typ_lonly fb_dr008_typ_lonly 0 vph_dr008_typ_lonly 0 0.008771929824561403
Lb_dr008_typ_lonly vc_dr008_typ_lonly vb_dr008_typ_lonly 1e12
Vb_dr008_typ_lonly vb_dr008_typ_lonly 0 dc 1.5
* --- loop dr008_typ_v0p3
Gcp_dr008_typ_v0p3 0 vc_dr008_typ_v0p3 pe 0 1.7507839514823947e-06
XLF_dr008_typ_v0p3 vc_dr008_typ_v0p3 0 loop_filter
Gvco_dr008_typ_v0p3 0 vph_dr008_typ_v0p3 vc_dr008_typ_v0p3 vb_dr008_typ_v0p3 409652497.95826226
Cint_dr008_typ_v0p3 vph_dr008_typ_v0p3 0 1
Rleak_dr008_typ_v0p3 vph_dr008_typ_v0p3 0 1e15
Ediv_dr008_typ_v0p3 fb_dr008_typ_v0p3 0 vph_dr008_typ_v0p3 0 0.008771929824561403
Lb_dr008_typ_v0p3 vc_dr008_typ_v0p3 vb_dr008_typ_v0p3 1e12
Vb_dr008_typ_v0p3 vb_dr008_typ_v0p3 0 dc 0.3
Xcp_dr008_typ_v0p3 0 0 ibp_dr008_typ_v0p3 icp_dr008_typ_v0p3 ibn_dr008_typ_v0p3 icn_dr008_typ_v0p3 vc_dr008_typ_v0p3 VDD 0 cp
Irbp_dr008_typ_v0p3 ibp_dr008_typ_v0p3 0 dc 11u
Ircp_dr008_typ_v0p3 icp_dr008_typ_v0p3 0 dc 11u
Irbn_dr008_typ_v0p3 0 ibn_dr008_typ_v0p3 dc 11u
Ircn_dr008_typ_v0p3 0 icn_dr008_typ_v0p3 dc 11u
* --- loop dr008_typ_v0p5
Gcp_dr008_typ_v0p5 0 vc_dr008_typ_v0p5 pe 0 1.7507839514823947e-06
XLF_dr008_typ_v0p5 vc_dr008_typ_v0p5 0 loop_filter
Gvco_dr008_typ_v0p5 0 vph_dr008_typ_v0p5 vc_dr008_typ_v0p5 vb_dr008_typ_v0p5 409652497.95826226
Cint_dr008_typ_v0p5 vph_dr008_typ_v0p5 0 1
Rleak_dr008_typ_v0p5 vph_dr008_typ_v0p5 0 1e15
Ediv_dr008_typ_v0p5 fb_dr008_typ_v0p5 0 vph_dr008_typ_v0p5 0 0.008771929824561403
Lb_dr008_typ_v0p5 vc_dr008_typ_v0p5 vb_dr008_typ_v0p5 1e12
Vb_dr008_typ_v0p5 vb_dr008_typ_v0p5 0 dc 0.5
Xcp_dr008_typ_v0p5 0 0 ibp_dr008_typ_v0p5 icp_dr008_typ_v0p5 ibn_dr008_typ_v0p5 icn_dr008_typ_v0p5 vc_dr008_typ_v0p5 VDD 0 cp
Irbp_dr008_typ_v0p5 ibp_dr008_typ_v0p5 0 dc 11u
Ircp_dr008_typ_v0p5 icp_dr008_typ_v0p5 0 dc 11u
Irbn_dr008_typ_v0p5 0 ibn_dr008_typ_v0p5 dc 11u
Ircn_dr008_typ_v0p5 0 icn_dr008_typ_v0p5 dc 11u
* --- loop dr008_typ_v0p7
Gcp_dr008_typ_v0p7 0 vc_dr008_typ_v0p7 pe 0 1.7507839514823947e-06
XLF_dr008_typ_v0p7 vc_dr008_typ_v0p7 0 loop_filter
Gvco_dr008_typ_v0p7 0 vph_dr008_typ_v0p7 vc_dr008_typ_v0p7 vb_dr008_typ_v0p7 409652497.95826226
Cint_dr008_typ_v0p7 vph_dr008_typ_v0p7 0 1
Rleak_dr008_typ_v0p7 vph_dr008_typ_v0p7 0 1e15
Ediv_dr008_typ_v0p7 fb_dr008_typ_v0p7 0 vph_dr008_typ_v0p7 0 0.008771929824561403
Lb_dr008_typ_v0p7 vc_dr008_typ_v0p7 vb_dr008_typ_v0p7 1e12
Vb_dr008_typ_v0p7 vb_dr008_typ_v0p7 0 dc 0.7
Xcp_dr008_typ_v0p7 0 0 ibp_dr008_typ_v0p7 icp_dr008_typ_v0p7 ibn_dr008_typ_v0p7 icn_dr008_typ_v0p7 vc_dr008_typ_v0p7 VDD 0 cp
Irbp_dr008_typ_v0p7 ibp_dr008_typ_v0p7 0 dc 11u
Ircp_dr008_typ_v0p7 icp_dr008_typ_v0p7 0 dc 11u
Irbn_dr008_typ_v0p7 0 ibn_dr008_typ_v0p7 dc 11u
Ircn_dr008_typ_v0p7 0 icn_dr008_typ_v0p7 dc 11u
* --- loop dr008_typ_v0p9
Gcp_dr008_typ_v0p9 0 vc_dr008_typ_v0p9 pe 0 1.7507839514823947e-06
XLF_dr008_typ_v0p9 vc_dr008_typ_v0p9 0 loop_filter
Gvco_dr008_typ_v0p9 0 vph_dr008_typ_v0p9 vc_dr008_typ_v0p9 vb_dr008_typ_v0p9 409652497.95826226
Cint_dr008_typ_v0p9 vph_dr008_typ_v0p9 0 1
Rleak_dr008_typ_v0p9 vph_dr008_typ_v0p9 0 1e15
Ediv_dr008_typ_v0p9 fb_dr008_typ_v0p9 0 vph_dr008_typ_v0p9 0 0.008771929824561403
Lb_dr008_typ_v0p9 vc_dr008_typ_v0p9 vb_dr008_typ_v0p9 1e12
Vb_dr008_typ_v0p9 vb_dr008_typ_v0p9 0 dc 0.9
Xcp_dr008_typ_v0p9 0 0 ibp_dr008_typ_v0p9 icp_dr008_typ_v0p9 ibn_dr008_typ_v0p9 icn_dr008_typ_v0p9 vc_dr008_typ_v0p9 VDD 0 cp
Irbp_dr008_typ_v0p9 ibp_dr008_typ_v0p9 0 dc 11u
Ircp_dr008_typ_v0p9 icp_dr008_typ_v0p9 0 dc 11u
Irbn_dr008_typ_v0p9 0 ibn_dr008_typ_v0p9 dc 11u
Ircn_dr008_typ_v0p9 0 icn_dr008_typ_v0p9 dc 11u
* --- loop dr008_typ_v1p1
Gcp_dr008_typ_v1p1 0 vc_dr008_typ_v1p1 pe 0 1.7507839514823947e-06
XLF_dr008_typ_v1p1 vc_dr008_typ_v1p1 0 loop_filter
Gvco_dr008_typ_v1p1 0 vph_dr008_typ_v1p1 vc_dr008_typ_v1p1 vb_dr008_typ_v1p1 409652497.95826226
Cint_dr008_typ_v1p1 vph_dr008_typ_v1p1 0 1
Rleak_dr008_typ_v1p1 vph_dr008_typ_v1p1 0 1e15
Ediv_dr008_typ_v1p1 fb_dr008_typ_v1p1 0 vph_dr008_typ_v1p1 0 0.008771929824561403
Lb_dr008_typ_v1p1 vc_dr008_typ_v1p1 vb_dr008_typ_v1p1 1e12
Vb_dr008_typ_v1p1 vb_dr008_typ_v1p1 0 dc 1.1
Xcp_dr008_typ_v1p1 0 0 ibp_dr008_typ_v1p1 icp_dr008_typ_v1p1 ibn_dr008_typ_v1p1 icn_dr008_typ_v1p1 vc_dr008_typ_v1p1 VDD 0 cp
Irbp_dr008_typ_v1p1 ibp_dr008_typ_v1p1 0 dc 11u
Ircp_dr008_typ_v1p1 icp_dr008_typ_v1p1 0 dc 11u
Irbn_dr008_typ_v1p1 0 ibn_dr008_typ_v1p1 dc 11u
Ircn_dr008_typ_v1p1 0 icn_dr008_typ_v1p1 dc 11u
* --- loop dr008_typ_v1p3
Gcp_dr008_typ_v1p3 0 vc_dr008_typ_v1p3 pe 0 1.7507839514823947e-06
XLF_dr008_typ_v1p3 vc_dr008_typ_v1p3 0 loop_filter
Gvco_dr008_typ_v1p3 0 vph_dr008_typ_v1p3 vc_dr008_typ_v1p3 vb_dr008_typ_v1p3 409652497.95826226
Cint_dr008_typ_v1p3 vph_dr008_typ_v1p3 0 1
Rleak_dr008_typ_v1p3 vph_dr008_typ_v1p3 0 1e15
Ediv_dr008_typ_v1p3 fb_dr008_typ_v1p3 0 vph_dr008_typ_v1p3 0 0.008771929824561403
Lb_dr008_typ_v1p3 vc_dr008_typ_v1p3 vb_dr008_typ_v1p3 1e12
Vb_dr008_typ_v1p3 vb_dr008_typ_v1p3 0 dc 1.3
Xcp_dr008_typ_v1p3 0 0 ibp_dr008_typ_v1p3 icp_dr008_typ_v1p3 ibn_dr008_typ_v1p3 icn_dr008_typ_v1p3 vc_dr008_typ_v1p3 VDD 0 cp
Irbp_dr008_typ_v1p3 ibp_dr008_typ_v1p3 0 dc 11u
Ircp_dr008_typ_v1p3 icp_dr008_typ_v1p3 0 dc 11u
Irbn_dr008_typ_v1p3 0 ibn_dr008_typ_v1p3 dc 11u
Ircn_dr008_typ_v1p3 0 icn_dr008_typ_v1p3 dc 11u
* --- loop dr008_typ_v1p5
Gcp_dr008_typ_v1p5 0 vc_dr008_typ_v1p5 pe 0 1.7507839514823947e-06
XLF_dr008_typ_v1p5 vc_dr008_typ_v1p5 0 loop_filter
Gvco_dr008_typ_v1p5 0 vph_dr008_typ_v1p5 vc_dr008_typ_v1p5 vb_dr008_typ_v1p5 409652497.95826226
Cint_dr008_typ_v1p5 vph_dr008_typ_v1p5 0 1
Rleak_dr008_typ_v1p5 vph_dr008_typ_v1p5 0 1e15
Ediv_dr008_typ_v1p5 fb_dr008_typ_v1p5 0 vph_dr008_typ_v1p5 0 0.008771929824561403
Lb_dr008_typ_v1p5 vc_dr008_typ_v1p5 vb_dr008_typ_v1p5 1e12
Vb_dr008_typ_v1p5 vb_dr008_typ_v1p5 0 dc 1.5
Xcp_dr008_typ_v1p5 0 0 ibp_dr008_typ_v1p5 icp_dr008_typ_v1p5 ibn_dr008_typ_v1p5 icn_dr008_typ_v1p5 vc_dr008_typ_v1p5 VDD 0 cp
Irbp_dr008_typ_v1p5 ibp_dr008_typ_v1p5 0 dc 11u
Ircp_dr008_typ_v1p5 icp_dr008_typ_v1p5 0 dc 11u
Irbn_dr008_typ_v1p5 0 ibn_dr008_typ_v1p5 dc 11u
Ircn_dr008_typ_v1p5 0 icn_dr008_typ_v1p5 dc 11u
* --- loop dr008_typ_v1p7
Gcp_dr008_typ_v1p7 0 vc_dr008_typ_v1p7 pe 0 1.7507839514823947e-06
XLF_dr008_typ_v1p7 vc_dr008_typ_v1p7 0 loop_filter
Gvco_dr008_typ_v1p7 0 vph_dr008_typ_v1p7 vc_dr008_typ_v1p7 vb_dr008_typ_v1p7 409652497.95826226
Cint_dr008_typ_v1p7 vph_dr008_typ_v1p7 0 1
Rleak_dr008_typ_v1p7 vph_dr008_typ_v1p7 0 1e15
Ediv_dr008_typ_v1p7 fb_dr008_typ_v1p7 0 vph_dr008_typ_v1p7 0 0.008771929824561403
Lb_dr008_typ_v1p7 vc_dr008_typ_v1p7 vb_dr008_typ_v1p7 1e12
Vb_dr008_typ_v1p7 vb_dr008_typ_v1p7 0 dc 1.7
Xcp_dr008_typ_v1p7 0 0 ibp_dr008_typ_v1p7 icp_dr008_typ_v1p7 ibn_dr008_typ_v1p7 icn_dr008_typ_v1p7 vc_dr008_typ_v1p7 VDD 0 cp
Irbp_dr008_typ_v1p7 ibp_dr008_typ_v1p7 0 dc 11u
Ircp_dr008_typ_v1p7 icp_dr008_typ_v1p7 0 dc 11u
Irbn_dr008_typ_v1p7 0 ibn_dr008_typ_v1p7 dc 11u
Ircn_dr008_typ_v1p7 0 icn_dr008_typ_v1p7 dc 11u
* --- loop dr008_typ_v1p9
Gcp_dr008_typ_v1p9 0 vc_dr008_typ_v1p9 pe 0 1.7507839514823947e-06
XLF_dr008_typ_v1p9 vc_dr008_typ_v1p9 0 loop_filter
Gvco_dr008_typ_v1p9 0 vph_dr008_typ_v1p9 vc_dr008_typ_v1p9 vb_dr008_typ_v1p9 409652497.95826226
Cint_dr008_typ_v1p9 vph_dr008_typ_v1p9 0 1
Rleak_dr008_typ_v1p9 vph_dr008_typ_v1p9 0 1e15
Ediv_dr008_typ_v1p9 fb_dr008_typ_v1p9 0 vph_dr008_typ_v1p9 0 0.008771929824561403
Lb_dr008_typ_v1p9 vc_dr008_typ_v1p9 vb_dr008_typ_v1p9 1e12
Vb_dr008_typ_v1p9 vb_dr008_typ_v1p9 0 dc 1.9
Xcp_dr008_typ_v1p9 0 0 ibp_dr008_typ_v1p9 icp_dr008_typ_v1p9 ibn_dr008_typ_v1p9 icn_dr008_typ_v1p9 vc_dr008_typ_v1p9 VDD 0 cp
Irbp_dr008_typ_v1p9 ibp_dr008_typ_v1p9 0 dc 11u
Ircp_dr008_typ_v1p9 icp_dr008_typ_v1p9 0 dc 11u
Irbn_dr008_typ_v1p9 0 ibn_dr008_typ_v1p9 dc 11u
Ircn_dr008_typ_v1p9 0 icn_dr008_typ_v1p9 dc 11u
* --- loop dr008_typ_v2p1
Gcp_dr008_typ_v2p1 0 vc_dr008_typ_v2p1 pe 0 1.7507839514823947e-06
XLF_dr008_typ_v2p1 vc_dr008_typ_v2p1 0 loop_filter
Gvco_dr008_typ_v2p1 0 vph_dr008_typ_v2p1 vc_dr008_typ_v2p1 vb_dr008_typ_v2p1 409652497.95826226
Cint_dr008_typ_v2p1 vph_dr008_typ_v2p1 0 1
Rleak_dr008_typ_v2p1 vph_dr008_typ_v2p1 0 1e15
Ediv_dr008_typ_v2p1 fb_dr008_typ_v2p1 0 vph_dr008_typ_v2p1 0 0.008771929824561403
Lb_dr008_typ_v2p1 vc_dr008_typ_v2p1 vb_dr008_typ_v2p1 1e12
Vb_dr008_typ_v2p1 vb_dr008_typ_v2p1 0 dc 2.1
Xcp_dr008_typ_v2p1 0 0 ibp_dr008_typ_v2p1 icp_dr008_typ_v2p1 ibn_dr008_typ_v2p1 icn_dr008_typ_v2p1 vc_dr008_typ_v2p1 VDD 0 cp
Irbp_dr008_typ_v2p1 ibp_dr008_typ_v2p1 0 dc 11u
Ircp_dr008_typ_v2p1 icp_dr008_typ_v2p1 0 dc 11u
Irbn_dr008_typ_v2p1 0 ibn_dr008_typ_v2p1 dc 11u
Ircn_dr008_typ_v2p1 0 icn_dr008_typ_v2p1 dc 11u
* --- loop dr008_typ_v2p3
Gcp_dr008_typ_v2p3 0 vc_dr008_typ_v2p3 pe 0 1.7507839514823947e-06
XLF_dr008_typ_v2p3 vc_dr008_typ_v2p3 0 loop_filter
Gvco_dr008_typ_v2p3 0 vph_dr008_typ_v2p3 vc_dr008_typ_v2p3 vb_dr008_typ_v2p3 409652497.95826226
Cint_dr008_typ_v2p3 vph_dr008_typ_v2p3 0 1
Rleak_dr008_typ_v2p3 vph_dr008_typ_v2p3 0 1e15
Ediv_dr008_typ_v2p3 fb_dr008_typ_v2p3 0 vph_dr008_typ_v2p3 0 0.008771929824561403
Lb_dr008_typ_v2p3 vc_dr008_typ_v2p3 vb_dr008_typ_v2p3 1e12
Vb_dr008_typ_v2p3 vb_dr008_typ_v2p3 0 dc 2.3
Xcp_dr008_typ_v2p3 0 0 ibp_dr008_typ_v2p3 icp_dr008_typ_v2p3 ibn_dr008_typ_v2p3 icn_dr008_typ_v2p3 vc_dr008_typ_v2p3 VDD 0 cp
Irbp_dr008_typ_v2p3 ibp_dr008_typ_v2p3 0 dc 11u
Ircp_dr008_typ_v2p3 icp_dr008_typ_v2p3 0 dc 11u
Irbn_dr008_typ_v2p3 0 ibn_dr008_typ_v2p3 dc 11u
Ircn_dr008_typ_v2p3 0 icn_dr008_typ_v2p3 dc 11u
* --- loop dr008_typ_v2p5
Gcp_dr008_typ_v2p5 0 vc_dr008_typ_v2p5 pe 0 1.7507839514823947e-06
XLF_dr008_typ_v2p5 vc_dr008_typ_v2p5 0 loop_filter
Gvco_dr008_typ_v2p5 0 vph_dr008_typ_v2p5 vc_dr008_typ_v2p5 vb_dr008_typ_v2p5 409652497.95826226
Cint_dr008_typ_v2p5 vph_dr008_typ_v2p5 0 1
Rleak_dr008_typ_v2p5 vph_dr008_typ_v2p5 0 1e15
Ediv_dr008_typ_v2p5 fb_dr008_typ_v2p5 0 vph_dr008_typ_v2p5 0 0.008771929824561403
Lb_dr008_typ_v2p5 vc_dr008_typ_v2p5 vb_dr008_typ_v2p5 1e12
Vb_dr008_typ_v2p5 vb_dr008_typ_v2p5 0 dc 2.5
Xcp_dr008_typ_v2p5 0 0 ibp_dr008_typ_v2p5 icp_dr008_typ_v2p5 ibn_dr008_typ_v2p5 icn_dr008_typ_v2p5 vc_dr008_typ_v2p5 VDD 0 cp
Irbp_dr008_typ_v2p5 ibp_dr008_typ_v2p5 0 dc 11u
Ircp_dr008_typ_v2p5 icp_dr008_typ_v2p5 0 dc 11u
Irbn_dr008_typ_v2p5 0 ibn_dr008_typ_v2p5 dc 11u
Ircn_dr008_typ_v2p5 0 icn_dr008_typ_v2p5 dc 11u
* --- loop dr008_typ_v2p7
Gcp_dr008_typ_v2p7 0 vc_dr008_typ_v2p7 pe 0 1.7507839514823947e-06
XLF_dr008_typ_v2p7 vc_dr008_typ_v2p7 0 loop_filter
Gvco_dr008_typ_v2p7 0 vph_dr008_typ_v2p7 vc_dr008_typ_v2p7 vb_dr008_typ_v2p7 409652497.95826226
Cint_dr008_typ_v2p7 vph_dr008_typ_v2p7 0 1
Rleak_dr008_typ_v2p7 vph_dr008_typ_v2p7 0 1e15
Ediv_dr008_typ_v2p7 fb_dr008_typ_v2p7 0 vph_dr008_typ_v2p7 0 0.008771929824561403
Lb_dr008_typ_v2p7 vc_dr008_typ_v2p7 vb_dr008_typ_v2p7 1e12
Vb_dr008_typ_v2p7 vb_dr008_typ_v2p7 0 dc 2.7
Xcp_dr008_typ_v2p7 0 0 ibp_dr008_typ_v2p7 icp_dr008_typ_v2p7 ibn_dr008_typ_v2p7 icn_dr008_typ_v2p7 vc_dr008_typ_v2p7 VDD 0 cp
Irbp_dr008_typ_v2p7 ibp_dr008_typ_v2p7 0 dc 11u
Ircp_dr008_typ_v2p7 icp_dr008_typ_v2p7 0 dc 11u
Irbn_dr008_typ_v2p7 0 ibn_dr008_typ_v2p7 dc 11u
Ircn_dr008_typ_v2p7 0 icn_dr008_typ_v2p7 dc 11u
* --- loop dr008_typ_v2p9
Gcp_dr008_typ_v2p9 0 vc_dr008_typ_v2p9 pe 0 1.7507839514823947e-06
XLF_dr008_typ_v2p9 vc_dr008_typ_v2p9 0 loop_filter
Gvco_dr008_typ_v2p9 0 vph_dr008_typ_v2p9 vc_dr008_typ_v2p9 vb_dr008_typ_v2p9 409652497.95826226
Cint_dr008_typ_v2p9 vph_dr008_typ_v2p9 0 1
Rleak_dr008_typ_v2p9 vph_dr008_typ_v2p9 0 1e15
Ediv_dr008_typ_v2p9 fb_dr008_typ_v2p9 0 vph_dr008_typ_v2p9 0 0.008771929824561403
Lb_dr008_typ_v2p9 vc_dr008_typ_v2p9 vb_dr008_typ_v2p9 1e12
Vb_dr008_typ_v2p9 vb_dr008_typ_v2p9 0 dc 2.9
Xcp_dr008_typ_v2p9 0 0 ibp_dr008_typ_v2p9 icp_dr008_typ_v2p9 ibn_dr008_typ_v2p9 icn_dr008_typ_v2p9 vc_dr008_typ_v2p9 VDD 0 cp
Irbp_dr008_typ_v2p9 ibp_dr008_typ_v2p9 0 dc 11u
Ircp_dr008_typ_v2p9 icp_dr008_typ_v2p9 0 dc 11u
Irbn_dr008_typ_v2p9 0 ibn_dr008_typ_v2p9 dc 11u
Ircn_dr008_typ_v2p9 0 icn_dr008_typ_v2p9 dc 11u
* --- loop dr008_slow_nocp
Gcp_dr008_slow_nocp 0 vc_dr008_slow_nocp pe 0 1.7508269233170294e-06
XLF_dr008_slow_nocp vc_dr008_slow_nocp 0 loop_filter
Gvco_dr008_slow_nocp 0 vph_dr008_slow_nocp vc_dr008_slow_nocp 0 399248171.4081036
Cint_dr008_slow_nocp vph_dr008_slow_nocp 0 1
Rleak_dr008_slow_nocp vph_dr008_slow_nocp 0 1e15
Ediv_dr008_slow_nocp fb_dr008_slow_nocp 0 vph_dr008_slow_nocp 0 0.009708737864077669
* --- loop dr008_slow_lonly
Gcp_dr008_slow_lonly 0 vc_dr008_slow_lonly pe 0 1.7508269233170294e-06
XLF_dr008_slow_lonly vc_dr008_slow_lonly 0 loop_filter
Gvco_dr008_slow_lonly 0 vph_dr008_slow_lonly vc_dr008_slow_lonly vb_dr008_slow_lonly 399248171.4081036
Cint_dr008_slow_lonly vph_dr008_slow_lonly 0 1
Rleak_dr008_slow_lonly vph_dr008_slow_lonly 0 1e15
Ediv_dr008_slow_lonly fb_dr008_slow_lonly 0 vph_dr008_slow_lonly 0 0.009708737864077669
Lb_dr008_slow_lonly vc_dr008_slow_lonly vb_dr008_slow_lonly 1e12
Vb_dr008_slow_lonly vb_dr008_slow_lonly 0 dc 1.5
* --- loop dr008_slow_v0p3
Gcp_dr008_slow_v0p3 0 vc_dr008_slow_v0p3 pe 0 1.7508269233170294e-06
XLF_dr008_slow_v0p3 vc_dr008_slow_v0p3 0 loop_filter
Gvco_dr008_slow_v0p3 0 vph_dr008_slow_v0p3 vc_dr008_slow_v0p3 vb_dr008_slow_v0p3 399248171.4081036
Cint_dr008_slow_v0p3 vph_dr008_slow_v0p3 0 1
Rleak_dr008_slow_v0p3 vph_dr008_slow_v0p3 0 1e15
Ediv_dr008_slow_v0p3 fb_dr008_slow_v0p3 0 vph_dr008_slow_v0p3 0 0.009708737864077669
Lb_dr008_slow_v0p3 vc_dr008_slow_v0p3 vb_dr008_slow_v0p3 1e12
Vb_dr008_slow_v0p3 vb_dr008_slow_v0p3 0 dc 0.3
Xcp_dr008_slow_v0p3 0 0 ibp_dr008_slow_v0p3 icp_dr008_slow_v0p3 ibn_dr008_slow_v0p3 icn_dr008_slow_v0p3 vc_dr008_slow_v0p3 VDD 0 cp
Irbp_dr008_slow_v0p3 ibp_dr008_slow_v0p3 0 dc 11u
Ircp_dr008_slow_v0p3 icp_dr008_slow_v0p3 0 dc 11u
Irbn_dr008_slow_v0p3 0 ibn_dr008_slow_v0p3 dc 11u
Ircn_dr008_slow_v0p3 0 icn_dr008_slow_v0p3 dc 11u
* --- loop dr008_slow_v0p5
Gcp_dr008_slow_v0p5 0 vc_dr008_slow_v0p5 pe 0 1.7508269233170294e-06
XLF_dr008_slow_v0p5 vc_dr008_slow_v0p5 0 loop_filter
Gvco_dr008_slow_v0p5 0 vph_dr008_slow_v0p5 vc_dr008_slow_v0p5 vb_dr008_slow_v0p5 399248171.4081036
Cint_dr008_slow_v0p5 vph_dr008_slow_v0p5 0 1
Rleak_dr008_slow_v0p5 vph_dr008_slow_v0p5 0 1e15
Ediv_dr008_slow_v0p5 fb_dr008_slow_v0p5 0 vph_dr008_slow_v0p5 0 0.009708737864077669
Lb_dr008_slow_v0p5 vc_dr008_slow_v0p5 vb_dr008_slow_v0p5 1e12
Vb_dr008_slow_v0p5 vb_dr008_slow_v0p5 0 dc 0.5
Xcp_dr008_slow_v0p5 0 0 ibp_dr008_slow_v0p5 icp_dr008_slow_v0p5 ibn_dr008_slow_v0p5 icn_dr008_slow_v0p5 vc_dr008_slow_v0p5 VDD 0 cp
Irbp_dr008_slow_v0p5 ibp_dr008_slow_v0p5 0 dc 11u
Ircp_dr008_slow_v0p5 icp_dr008_slow_v0p5 0 dc 11u
Irbn_dr008_slow_v0p5 0 ibn_dr008_slow_v0p5 dc 11u
Ircn_dr008_slow_v0p5 0 icn_dr008_slow_v0p5 dc 11u
* --- loop dr008_slow_v0p7
Gcp_dr008_slow_v0p7 0 vc_dr008_slow_v0p7 pe 0 1.7508269233170294e-06
XLF_dr008_slow_v0p7 vc_dr008_slow_v0p7 0 loop_filter
Gvco_dr008_slow_v0p7 0 vph_dr008_slow_v0p7 vc_dr008_slow_v0p7 vb_dr008_slow_v0p7 399248171.4081036
Cint_dr008_slow_v0p7 vph_dr008_slow_v0p7 0 1
Rleak_dr008_slow_v0p7 vph_dr008_slow_v0p7 0 1e15
Ediv_dr008_slow_v0p7 fb_dr008_slow_v0p7 0 vph_dr008_slow_v0p7 0 0.009708737864077669
Lb_dr008_slow_v0p7 vc_dr008_slow_v0p7 vb_dr008_slow_v0p7 1e12
Vb_dr008_slow_v0p7 vb_dr008_slow_v0p7 0 dc 0.7
Xcp_dr008_slow_v0p7 0 0 ibp_dr008_slow_v0p7 icp_dr008_slow_v0p7 ibn_dr008_slow_v0p7 icn_dr008_slow_v0p7 vc_dr008_slow_v0p7 VDD 0 cp
Irbp_dr008_slow_v0p7 ibp_dr008_slow_v0p7 0 dc 11u
Ircp_dr008_slow_v0p7 icp_dr008_slow_v0p7 0 dc 11u
Irbn_dr008_slow_v0p7 0 ibn_dr008_slow_v0p7 dc 11u
Ircn_dr008_slow_v0p7 0 icn_dr008_slow_v0p7 dc 11u
* --- loop dr008_slow_v0p9
Gcp_dr008_slow_v0p9 0 vc_dr008_slow_v0p9 pe 0 1.7508269233170294e-06
XLF_dr008_slow_v0p9 vc_dr008_slow_v0p9 0 loop_filter
Gvco_dr008_slow_v0p9 0 vph_dr008_slow_v0p9 vc_dr008_slow_v0p9 vb_dr008_slow_v0p9 399248171.4081036
Cint_dr008_slow_v0p9 vph_dr008_slow_v0p9 0 1
Rleak_dr008_slow_v0p9 vph_dr008_slow_v0p9 0 1e15
Ediv_dr008_slow_v0p9 fb_dr008_slow_v0p9 0 vph_dr008_slow_v0p9 0 0.009708737864077669
Lb_dr008_slow_v0p9 vc_dr008_slow_v0p9 vb_dr008_slow_v0p9 1e12
Vb_dr008_slow_v0p9 vb_dr008_slow_v0p9 0 dc 0.9
Xcp_dr008_slow_v0p9 0 0 ibp_dr008_slow_v0p9 icp_dr008_slow_v0p9 ibn_dr008_slow_v0p9 icn_dr008_slow_v0p9 vc_dr008_slow_v0p9 VDD 0 cp
Irbp_dr008_slow_v0p9 ibp_dr008_slow_v0p9 0 dc 11u
Ircp_dr008_slow_v0p9 icp_dr008_slow_v0p9 0 dc 11u
Irbn_dr008_slow_v0p9 0 ibn_dr008_slow_v0p9 dc 11u
Ircn_dr008_slow_v0p9 0 icn_dr008_slow_v0p9 dc 11u
* --- loop dr008_slow_v1p1
Gcp_dr008_slow_v1p1 0 vc_dr008_slow_v1p1 pe 0 1.7508269233170294e-06
XLF_dr008_slow_v1p1 vc_dr008_slow_v1p1 0 loop_filter
Gvco_dr008_slow_v1p1 0 vph_dr008_slow_v1p1 vc_dr008_slow_v1p1 vb_dr008_slow_v1p1 399248171.4081036
Cint_dr008_slow_v1p1 vph_dr008_slow_v1p1 0 1
Rleak_dr008_slow_v1p1 vph_dr008_slow_v1p1 0 1e15
Ediv_dr008_slow_v1p1 fb_dr008_slow_v1p1 0 vph_dr008_slow_v1p1 0 0.009708737864077669
Lb_dr008_slow_v1p1 vc_dr008_slow_v1p1 vb_dr008_slow_v1p1 1e12
Vb_dr008_slow_v1p1 vb_dr008_slow_v1p1 0 dc 1.1
Xcp_dr008_slow_v1p1 0 0 ibp_dr008_slow_v1p1 icp_dr008_slow_v1p1 ibn_dr008_slow_v1p1 icn_dr008_slow_v1p1 vc_dr008_slow_v1p1 VDD 0 cp
Irbp_dr008_slow_v1p1 ibp_dr008_slow_v1p1 0 dc 11u
Ircp_dr008_slow_v1p1 icp_dr008_slow_v1p1 0 dc 11u
Irbn_dr008_slow_v1p1 0 ibn_dr008_slow_v1p1 dc 11u
Ircn_dr008_slow_v1p1 0 icn_dr008_slow_v1p1 dc 11u
* --- loop dr008_slow_v1p3
Gcp_dr008_slow_v1p3 0 vc_dr008_slow_v1p3 pe 0 1.7508269233170294e-06
XLF_dr008_slow_v1p3 vc_dr008_slow_v1p3 0 loop_filter
Gvco_dr008_slow_v1p3 0 vph_dr008_slow_v1p3 vc_dr008_slow_v1p3 vb_dr008_slow_v1p3 399248171.4081036
Cint_dr008_slow_v1p3 vph_dr008_slow_v1p3 0 1
Rleak_dr008_slow_v1p3 vph_dr008_slow_v1p3 0 1e15
Ediv_dr008_slow_v1p3 fb_dr008_slow_v1p3 0 vph_dr008_slow_v1p3 0 0.009708737864077669
Lb_dr008_slow_v1p3 vc_dr008_slow_v1p3 vb_dr008_slow_v1p3 1e12
Vb_dr008_slow_v1p3 vb_dr008_slow_v1p3 0 dc 1.3
Xcp_dr008_slow_v1p3 0 0 ibp_dr008_slow_v1p3 icp_dr008_slow_v1p3 ibn_dr008_slow_v1p3 icn_dr008_slow_v1p3 vc_dr008_slow_v1p3 VDD 0 cp
Irbp_dr008_slow_v1p3 ibp_dr008_slow_v1p3 0 dc 11u
Ircp_dr008_slow_v1p3 icp_dr008_slow_v1p3 0 dc 11u
Irbn_dr008_slow_v1p3 0 ibn_dr008_slow_v1p3 dc 11u
Ircn_dr008_slow_v1p3 0 icn_dr008_slow_v1p3 dc 11u
* --- loop dr008_slow_v1p5
Gcp_dr008_slow_v1p5 0 vc_dr008_slow_v1p5 pe 0 1.7508269233170294e-06
XLF_dr008_slow_v1p5 vc_dr008_slow_v1p5 0 loop_filter
Gvco_dr008_slow_v1p5 0 vph_dr008_slow_v1p5 vc_dr008_slow_v1p5 vb_dr008_slow_v1p5 399248171.4081036
Cint_dr008_slow_v1p5 vph_dr008_slow_v1p5 0 1
Rleak_dr008_slow_v1p5 vph_dr008_slow_v1p5 0 1e15
Ediv_dr008_slow_v1p5 fb_dr008_slow_v1p5 0 vph_dr008_slow_v1p5 0 0.009708737864077669
Lb_dr008_slow_v1p5 vc_dr008_slow_v1p5 vb_dr008_slow_v1p5 1e12
Vb_dr008_slow_v1p5 vb_dr008_slow_v1p5 0 dc 1.5
Xcp_dr008_slow_v1p5 0 0 ibp_dr008_slow_v1p5 icp_dr008_slow_v1p5 ibn_dr008_slow_v1p5 icn_dr008_slow_v1p5 vc_dr008_slow_v1p5 VDD 0 cp
Irbp_dr008_slow_v1p5 ibp_dr008_slow_v1p5 0 dc 11u
Ircp_dr008_slow_v1p5 icp_dr008_slow_v1p5 0 dc 11u
Irbn_dr008_slow_v1p5 0 ibn_dr008_slow_v1p5 dc 11u
Ircn_dr008_slow_v1p5 0 icn_dr008_slow_v1p5 dc 11u
* --- loop dr008_slow_v1p7
Gcp_dr008_slow_v1p7 0 vc_dr008_slow_v1p7 pe 0 1.7508269233170294e-06
XLF_dr008_slow_v1p7 vc_dr008_slow_v1p7 0 loop_filter
Gvco_dr008_slow_v1p7 0 vph_dr008_slow_v1p7 vc_dr008_slow_v1p7 vb_dr008_slow_v1p7 399248171.4081036
Cint_dr008_slow_v1p7 vph_dr008_slow_v1p7 0 1
Rleak_dr008_slow_v1p7 vph_dr008_slow_v1p7 0 1e15
Ediv_dr008_slow_v1p7 fb_dr008_slow_v1p7 0 vph_dr008_slow_v1p7 0 0.009708737864077669
Lb_dr008_slow_v1p7 vc_dr008_slow_v1p7 vb_dr008_slow_v1p7 1e12
Vb_dr008_slow_v1p7 vb_dr008_slow_v1p7 0 dc 1.7
Xcp_dr008_slow_v1p7 0 0 ibp_dr008_slow_v1p7 icp_dr008_slow_v1p7 ibn_dr008_slow_v1p7 icn_dr008_slow_v1p7 vc_dr008_slow_v1p7 VDD 0 cp
Irbp_dr008_slow_v1p7 ibp_dr008_slow_v1p7 0 dc 11u
Ircp_dr008_slow_v1p7 icp_dr008_slow_v1p7 0 dc 11u
Irbn_dr008_slow_v1p7 0 ibn_dr008_slow_v1p7 dc 11u
Ircn_dr008_slow_v1p7 0 icn_dr008_slow_v1p7 dc 11u
* --- loop dr008_slow_v1p9
Gcp_dr008_slow_v1p9 0 vc_dr008_slow_v1p9 pe 0 1.7508269233170294e-06
XLF_dr008_slow_v1p9 vc_dr008_slow_v1p9 0 loop_filter
Gvco_dr008_slow_v1p9 0 vph_dr008_slow_v1p9 vc_dr008_slow_v1p9 vb_dr008_slow_v1p9 399248171.4081036
Cint_dr008_slow_v1p9 vph_dr008_slow_v1p9 0 1
Rleak_dr008_slow_v1p9 vph_dr008_slow_v1p9 0 1e15
Ediv_dr008_slow_v1p9 fb_dr008_slow_v1p9 0 vph_dr008_slow_v1p9 0 0.009708737864077669
Lb_dr008_slow_v1p9 vc_dr008_slow_v1p9 vb_dr008_slow_v1p9 1e12
Vb_dr008_slow_v1p9 vb_dr008_slow_v1p9 0 dc 1.9
Xcp_dr008_slow_v1p9 0 0 ibp_dr008_slow_v1p9 icp_dr008_slow_v1p9 ibn_dr008_slow_v1p9 icn_dr008_slow_v1p9 vc_dr008_slow_v1p9 VDD 0 cp
Irbp_dr008_slow_v1p9 ibp_dr008_slow_v1p9 0 dc 11u
Ircp_dr008_slow_v1p9 icp_dr008_slow_v1p9 0 dc 11u
Irbn_dr008_slow_v1p9 0 ibn_dr008_slow_v1p9 dc 11u
Ircn_dr008_slow_v1p9 0 icn_dr008_slow_v1p9 dc 11u
* --- loop dr008_slow_v2p1
Gcp_dr008_slow_v2p1 0 vc_dr008_slow_v2p1 pe 0 1.7508269233170294e-06
XLF_dr008_slow_v2p1 vc_dr008_slow_v2p1 0 loop_filter
Gvco_dr008_slow_v2p1 0 vph_dr008_slow_v2p1 vc_dr008_slow_v2p1 vb_dr008_slow_v2p1 399248171.4081036
Cint_dr008_slow_v2p1 vph_dr008_slow_v2p1 0 1
Rleak_dr008_slow_v2p1 vph_dr008_slow_v2p1 0 1e15
Ediv_dr008_slow_v2p1 fb_dr008_slow_v2p1 0 vph_dr008_slow_v2p1 0 0.009708737864077669
Lb_dr008_slow_v2p1 vc_dr008_slow_v2p1 vb_dr008_slow_v2p1 1e12
Vb_dr008_slow_v2p1 vb_dr008_slow_v2p1 0 dc 2.1
Xcp_dr008_slow_v2p1 0 0 ibp_dr008_slow_v2p1 icp_dr008_slow_v2p1 ibn_dr008_slow_v2p1 icn_dr008_slow_v2p1 vc_dr008_slow_v2p1 VDD 0 cp
Irbp_dr008_slow_v2p1 ibp_dr008_slow_v2p1 0 dc 11u
Ircp_dr008_slow_v2p1 icp_dr008_slow_v2p1 0 dc 11u
Irbn_dr008_slow_v2p1 0 ibn_dr008_slow_v2p1 dc 11u
Ircn_dr008_slow_v2p1 0 icn_dr008_slow_v2p1 dc 11u
* --- loop dr008_slow_v2p3
Gcp_dr008_slow_v2p3 0 vc_dr008_slow_v2p3 pe 0 1.7508269233170294e-06
XLF_dr008_slow_v2p3 vc_dr008_slow_v2p3 0 loop_filter
Gvco_dr008_slow_v2p3 0 vph_dr008_slow_v2p3 vc_dr008_slow_v2p3 vb_dr008_slow_v2p3 399248171.4081036
Cint_dr008_slow_v2p3 vph_dr008_slow_v2p3 0 1
Rleak_dr008_slow_v2p3 vph_dr008_slow_v2p3 0 1e15
Ediv_dr008_slow_v2p3 fb_dr008_slow_v2p3 0 vph_dr008_slow_v2p3 0 0.009708737864077669
Lb_dr008_slow_v2p3 vc_dr008_slow_v2p3 vb_dr008_slow_v2p3 1e12
Vb_dr008_slow_v2p3 vb_dr008_slow_v2p3 0 dc 2.3
Xcp_dr008_slow_v2p3 0 0 ibp_dr008_slow_v2p3 icp_dr008_slow_v2p3 ibn_dr008_slow_v2p3 icn_dr008_slow_v2p3 vc_dr008_slow_v2p3 VDD 0 cp
Irbp_dr008_slow_v2p3 ibp_dr008_slow_v2p3 0 dc 11u
Ircp_dr008_slow_v2p3 icp_dr008_slow_v2p3 0 dc 11u
Irbn_dr008_slow_v2p3 0 ibn_dr008_slow_v2p3 dc 11u
Ircn_dr008_slow_v2p3 0 icn_dr008_slow_v2p3 dc 11u
* --- loop dr008_slow_v2p5
Gcp_dr008_slow_v2p5 0 vc_dr008_slow_v2p5 pe 0 1.7508269233170294e-06
XLF_dr008_slow_v2p5 vc_dr008_slow_v2p5 0 loop_filter
Gvco_dr008_slow_v2p5 0 vph_dr008_slow_v2p5 vc_dr008_slow_v2p5 vb_dr008_slow_v2p5 399248171.4081036
Cint_dr008_slow_v2p5 vph_dr008_slow_v2p5 0 1
Rleak_dr008_slow_v2p5 vph_dr008_slow_v2p5 0 1e15
Ediv_dr008_slow_v2p5 fb_dr008_slow_v2p5 0 vph_dr008_slow_v2p5 0 0.009708737864077669
Lb_dr008_slow_v2p5 vc_dr008_slow_v2p5 vb_dr008_slow_v2p5 1e12
Vb_dr008_slow_v2p5 vb_dr008_slow_v2p5 0 dc 2.5
Xcp_dr008_slow_v2p5 0 0 ibp_dr008_slow_v2p5 icp_dr008_slow_v2p5 ibn_dr008_slow_v2p5 icn_dr008_slow_v2p5 vc_dr008_slow_v2p5 VDD 0 cp
Irbp_dr008_slow_v2p5 ibp_dr008_slow_v2p5 0 dc 11u
Ircp_dr008_slow_v2p5 icp_dr008_slow_v2p5 0 dc 11u
Irbn_dr008_slow_v2p5 0 ibn_dr008_slow_v2p5 dc 11u
Ircn_dr008_slow_v2p5 0 icn_dr008_slow_v2p5 dc 11u
* --- loop dr008_slow_v2p7
Gcp_dr008_slow_v2p7 0 vc_dr008_slow_v2p7 pe 0 1.7508269233170294e-06
XLF_dr008_slow_v2p7 vc_dr008_slow_v2p7 0 loop_filter
Gvco_dr008_slow_v2p7 0 vph_dr008_slow_v2p7 vc_dr008_slow_v2p7 vb_dr008_slow_v2p7 399248171.4081036
Cint_dr008_slow_v2p7 vph_dr008_slow_v2p7 0 1
Rleak_dr008_slow_v2p7 vph_dr008_slow_v2p7 0 1e15
Ediv_dr008_slow_v2p7 fb_dr008_slow_v2p7 0 vph_dr008_slow_v2p7 0 0.009708737864077669
Lb_dr008_slow_v2p7 vc_dr008_slow_v2p7 vb_dr008_slow_v2p7 1e12
Vb_dr008_slow_v2p7 vb_dr008_slow_v2p7 0 dc 2.7
Xcp_dr008_slow_v2p7 0 0 ibp_dr008_slow_v2p7 icp_dr008_slow_v2p7 ibn_dr008_slow_v2p7 icn_dr008_slow_v2p7 vc_dr008_slow_v2p7 VDD 0 cp
Irbp_dr008_slow_v2p7 ibp_dr008_slow_v2p7 0 dc 11u
Ircp_dr008_slow_v2p7 icp_dr008_slow_v2p7 0 dc 11u
Irbn_dr008_slow_v2p7 0 ibn_dr008_slow_v2p7 dc 11u
Ircn_dr008_slow_v2p7 0 icn_dr008_slow_v2p7 dc 11u
* --- loop dr008_slow_v2p9
Gcp_dr008_slow_v2p9 0 vc_dr008_slow_v2p9 pe 0 1.7508269233170294e-06
XLF_dr008_slow_v2p9 vc_dr008_slow_v2p9 0 loop_filter
Gvco_dr008_slow_v2p9 0 vph_dr008_slow_v2p9 vc_dr008_slow_v2p9 vb_dr008_slow_v2p9 399248171.4081036
Cint_dr008_slow_v2p9 vph_dr008_slow_v2p9 0 1
Rleak_dr008_slow_v2p9 vph_dr008_slow_v2p9 0 1e15
Ediv_dr008_slow_v2p9 fb_dr008_slow_v2p9 0 vph_dr008_slow_v2p9 0 0.009708737864077669
Lb_dr008_slow_v2p9 vc_dr008_slow_v2p9 vb_dr008_slow_v2p9 1e12
Vb_dr008_slow_v2p9 vb_dr008_slow_v2p9 0 dc 2.9
Xcp_dr008_slow_v2p9 0 0 ibp_dr008_slow_v2p9 icp_dr008_slow_v2p9 ibn_dr008_slow_v2p9 icn_dr008_slow_v2p9 vc_dr008_slow_v2p9 VDD 0 cp
Irbp_dr008_slow_v2p9 ibp_dr008_slow_v2p9 0 dc 11u
Ircp_dr008_slow_v2p9 icp_dr008_slow_v2p9 0 dc 11u
Irbn_dr008_slow_v2p9 0 ibn_dr008_slow_v2p9 dc 11u
Ircn_dr008_slow_v2p9 0 icn_dr008_slow_v2p9 dc 11u
* --- loop dr007_slow_nocp
Gcp_dr007_slow_nocp 0 vc_dr007_slow_nocp pe 0 5.969071126574055e-07
XLF_dr007_slow_nocp vc_dr007_slow_nocp 0 loop_filter
Gvco_dr007_slow_nocp 0 vph_dr007_slow_nocp vc_dr007_slow_nocp 0 1057966511.934083
Cint_dr007_slow_nocp vph_dr007_slow_nocp 0 1
Rleak_dr007_slow_nocp vph_dr007_slow_nocp 0 1e15
Ediv_dr007_slow_nocp fb_dr007_slow_nocp 0 vph_dr007_slow_nocp 0 0.008403361344537815
* --- loop dr007_slow_lonly
Gcp_dr007_slow_lonly 0 vc_dr007_slow_lonly pe 0 5.969071126574055e-07
XLF_dr007_slow_lonly vc_dr007_slow_lonly 0 loop_filter
Gvco_dr007_slow_lonly 0 vph_dr007_slow_lonly vc_dr007_slow_lonly vb_dr007_slow_lonly 1057966511.934083
Cint_dr007_slow_lonly vph_dr007_slow_lonly 0 1
Rleak_dr007_slow_lonly vph_dr007_slow_lonly 0 1e15
Ediv_dr007_slow_lonly fb_dr007_slow_lonly 0 vph_dr007_slow_lonly 0 0.008403361344537815
Lb_dr007_slow_lonly vc_dr007_slow_lonly vb_dr007_slow_lonly 1e12
Vb_dr007_slow_lonly vb_dr007_slow_lonly 0 dc 1.5
* --- loop dr007_slow_v0p3
Gcp_dr007_slow_v0p3 0 vc_dr007_slow_v0p3 pe 0 5.969071126574055e-07
XLF_dr007_slow_v0p3 vc_dr007_slow_v0p3 0 loop_filter
Gvco_dr007_slow_v0p3 0 vph_dr007_slow_v0p3 vc_dr007_slow_v0p3 vb_dr007_slow_v0p3 1057966511.934083
Cint_dr007_slow_v0p3 vph_dr007_slow_v0p3 0 1
Rleak_dr007_slow_v0p3 vph_dr007_slow_v0p3 0 1e15
Ediv_dr007_slow_v0p3 fb_dr007_slow_v0p3 0 vph_dr007_slow_v0p3 0 0.008403361344537815
Lb_dr007_slow_v0p3 vc_dr007_slow_v0p3 vb_dr007_slow_v0p3 1e12
Vb_dr007_slow_v0p3 vb_dr007_slow_v0p3 0 dc 0.3
Xcp_dr007_slow_v0p3 0 0 ibp_dr007_slow_v0p3 icp_dr007_slow_v0p3 ibn_dr007_slow_v0p3 icn_dr007_slow_v0p3 vc_dr007_slow_v0p3 VDD 0 cp
Irbp_dr007_slow_v0p3 ibp_dr007_slow_v0p3 0 dc 3.75u
Ircp_dr007_slow_v0p3 icp_dr007_slow_v0p3 0 dc 3.75u
Irbn_dr007_slow_v0p3 0 ibn_dr007_slow_v0p3 dc 3.75u
Ircn_dr007_slow_v0p3 0 icn_dr007_slow_v0p3 dc 3.75u
* --- loop dr007_slow_v0p5
Gcp_dr007_slow_v0p5 0 vc_dr007_slow_v0p5 pe 0 5.969071126574055e-07
XLF_dr007_slow_v0p5 vc_dr007_slow_v0p5 0 loop_filter
Gvco_dr007_slow_v0p5 0 vph_dr007_slow_v0p5 vc_dr007_slow_v0p5 vb_dr007_slow_v0p5 1057966511.934083
Cint_dr007_slow_v0p5 vph_dr007_slow_v0p5 0 1
Rleak_dr007_slow_v0p5 vph_dr007_slow_v0p5 0 1e15
Ediv_dr007_slow_v0p5 fb_dr007_slow_v0p5 0 vph_dr007_slow_v0p5 0 0.008403361344537815
Lb_dr007_slow_v0p5 vc_dr007_slow_v0p5 vb_dr007_slow_v0p5 1e12
Vb_dr007_slow_v0p5 vb_dr007_slow_v0p5 0 dc 0.5
Xcp_dr007_slow_v0p5 0 0 ibp_dr007_slow_v0p5 icp_dr007_slow_v0p5 ibn_dr007_slow_v0p5 icn_dr007_slow_v0p5 vc_dr007_slow_v0p5 VDD 0 cp
Irbp_dr007_slow_v0p5 ibp_dr007_slow_v0p5 0 dc 3.75u
Ircp_dr007_slow_v0p5 icp_dr007_slow_v0p5 0 dc 3.75u
Irbn_dr007_slow_v0p5 0 ibn_dr007_slow_v0p5 dc 3.75u
Ircn_dr007_slow_v0p5 0 icn_dr007_slow_v0p5 dc 3.75u
* --- loop dr007_slow_v0p7
Gcp_dr007_slow_v0p7 0 vc_dr007_slow_v0p7 pe 0 5.969071126574055e-07
XLF_dr007_slow_v0p7 vc_dr007_slow_v0p7 0 loop_filter
Gvco_dr007_slow_v0p7 0 vph_dr007_slow_v0p7 vc_dr007_slow_v0p7 vb_dr007_slow_v0p7 1057966511.934083
Cint_dr007_slow_v0p7 vph_dr007_slow_v0p7 0 1
Rleak_dr007_slow_v0p7 vph_dr007_slow_v0p7 0 1e15
Ediv_dr007_slow_v0p7 fb_dr007_slow_v0p7 0 vph_dr007_slow_v0p7 0 0.008403361344537815
Lb_dr007_slow_v0p7 vc_dr007_slow_v0p7 vb_dr007_slow_v0p7 1e12
Vb_dr007_slow_v0p7 vb_dr007_slow_v0p7 0 dc 0.7
Xcp_dr007_slow_v0p7 0 0 ibp_dr007_slow_v0p7 icp_dr007_slow_v0p7 ibn_dr007_slow_v0p7 icn_dr007_slow_v0p7 vc_dr007_slow_v0p7 VDD 0 cp
Irbp_dr007_slow_v0p7 ibp_dr007_slow_v0p7 0 dc 3.75u
Ircp_dr007_slow_v0p7 icp_dr007_slow_v0p7 0 dc 3.75u
Irbn_dr007_slow_v0p7 0 ibn_dr007_slow_v0p7 dc 3.75u
Ircn_dr007_slow_v0p7 0 icn_dr007_slow_v0p7 dc 3.75u
* --- loop dr007_slow_v0p9
Gcp_dr007_slow_v0p9 0 vc_dr007_slow_v0p9 pe 0 5.969071126574055e-07
XLF_dr007_slow_v0p9 vc_dr007_slow_v0p9 0 loop_filter
Gvco_dr007_slow_v0p9 0 vph_dr007_slow_v0p9 vc_dr007_slow_v0p9 vb_dr007_slow_v0p9 1057966511.934083
Cint_dr007_slow_v0p9 vph_dr007_slow_v0p9 0 1
Rleak_dr007_slow_v0p9 vph_dr007_slow_v0p9 0 1e15
Ediv_dr007_slow_v0p9 fb_dr007_slow_v0p9 0 vph_dr007_slow_v0p9 0 0.008403361344537815
Lb_dr007_slow_v0p9 vc_dr007_slow_v0p9 vb_dr007_slow_v0p9 1e12
Vb_dr007_slow_v0p9 vb_dr007_slow_v0p9 0 dc 0.9
Xcp_dr007_slow_v0p9 0 0 ibp_dr007_slow_v0p9 icp_dr007_slow_v0p9 ibn_dr007_slow_v0p9 icn_dr007_slow_v0p9 vc_dr007_slow_v0p9 VDD 0 cp
Irbp_dr007_slow_v0p9 ibp_dr007_slow_v0p9 0 dc 3.75u
Ircp_dr007_slow_v0p9 icp_dr007_slow_v0p9 0 dc 3.75u
Irbn_dr007_slow_v0p9 0 ibn_dr007_slow_v0p9 dc 3.75u
Ircn_dr007_slow_v0p9 0 icn_dr007_slow_v0p9 dc 3.75u
* --- loop dr007_slow_v1p1
Gcp_dr007_slow_v1p1 0 vc_dr007_slow_v1p1 pe 0 5.969071126574055e-07
XLF_dr007_slow_v1p1 vc_dr007_slow_v1p1 0 loop_filter
Gvco_dr007_slow_v1p1 0 vph_dr007_slow_v1p1 vc_dr007_slow_v1p1 vb_dr007_slow_v1p1 1057966511.934083
Cint_dr007_slow_v1p1 vph_dr007_slow_v1p1 0 1
Rleak_dr007_slow_v1p1 vph_dr007_slow_v1p1 0 1e15
Ediv_dr007_slow_v1p1 fb_dr007_slow_v1p1 0 vph_dr007_slow_v1p1 0 0.008403361344537815
Lb_dr007_slow_v1p1 vc_dr007_slow_v1p1 vb_dr007_slow_v1p1 1e12
Vb_dr007_slow_v1p1 vb_dr007_slow_v1p1 0 dc 1.1
Xcp_dr007_slow_v1p1 0 0 ibp_dr007_slow_v1p1 icp_dr007_slow_v1p1 ibn_dr007_slow_v1p1 icn_dr007_slow_v1p1 vc_dr007_slow_v1p1 VDD 0 cp
Irbp_dr007_slow_v1p1 ibp_dr007_slow_v1p1 0 dc 3.75u
Ircp_dr007_slow_v1p1 icp_dr007_slow_v1p1 0 dc 3.75u
Irbn_dr007_slow_v1p1 0 ibn_dr007_slow_v1p1 dc 3.75u
Ircn_dr007_slow_v1p1 0 icn_dr007_slow_v1p1 dc 3.75u
* --- loop dr007_slow_v1p3
Gcp_dr007_slow_v1p3 0 vc_dr007_slow_v1p3 pe 0 5.969071126574055e-07
XLF_dr007_slow_v1p3 vc_dr007_slow_v1p3 0 loop_filter
Gvco_dr007_slow_v1p3 0 vph_dr007_slow_v1p3 vc_dr007_slow_v1p3 vb_dr007_slow_v1p3 1057966511.934083
Cint_dr007_slow_v1p3 vph_dr007_slow_v1p3 0 1
Rleak_dr007_slow_v1p3 vph_dr007_slow_v1p3 0 1e15
Ediv_dr007_slow_v1p3 fb_dr007_slow_v1p3 0 vph_dr007_slow_v1p3 0 0.008403361344537815
Lb_dr007_slow_v1p3 vc_dr007_slow_v1p3 vb_dr007_slow_v1p3 1e12
Vb_dr007_slow_v1p3 vb_dr007_slow_v1p3 0 dc 1.3
Xcp_dr007_slow_v1p3 0 0 ibp_dr007_slow_v1p3 icp_dr007_slow_v1p3 ibn_dr007_slow_v1p3 icn_dr007_slow_v1p3 vc_dr007_slow_v1p3 VDD 0 cp
Irbp_dr007_slow_v1p3 ibp_dr007_slow_v1p3 0 dc 3.75u
Ircp_dr007_slow_v1p3 icp_dr007_slow_v1p3 0 dc 3.75u
Irbn_dr007_slow_v1p3 0 ibn_dr007_slow_v1p3 dc 3.75u
Ircn_dr007_slow_v1p3 0 icn_dr007_slow_v1p3 dc 3.75u
* --- loop dr007_slow_v1p5
Gcp_dr007_slow_v1p5 0 vc_dr007_slow_v1p5 pe 0 5.969071126574055e-07
XLF_dr007_slow_v1p5 vc_dr007_slow_v1p5 0 loop_filter
Gvco_dr007_slow_v1p5 0 vph_dr007_slow_v1p5 vc_dr007_slow_v1p5 vb_dr007_slow_v1p5 1057966511.934083
Cint_dr007_slow_v1p5 vph_dr007_slow_v1p5 0 1
Rleak_dr007_slow_v1p5 vph_dr007_slow_v1p5 0 1e15
Ediv_dr007_slow_v1p5 fb_dr007_slow_v1p5 0 vph_dr007_slow_v1p5 0 0.008403361344537815
Lb_dr007_slow_v1p5 vc_dr007_slow_v1p5 vb_dr007_slow_v1p5 1e12
Vb_dr007_slow_v1p5 vb_dr007_slow_v1p5 0 dc 1.5
Xcp_dr007_slow_v1p5 0 0 ibp_dr007_slow_v1p5 icp_dr007_slow_v1p5 ibn_dr007_slow_v1p5 icn_dr007_slow_v1p5 vc_dr007_slow_v1p5 VDD 0 cp
Irbp_dr007_slow_v1p5 ibp_dr007_slow_v1p5 0 dc 3.75u
Ircp_dr007_slow_v1p5 icp_dr007_slow_v1p5 0 dc 3.75u
Irbn_dr007_slow_v1p5 0 ibn_dr007_slow_v1p5 dc 3.75u
Ircn_dr007_slow_v1p5 0 icn_dr007_slow_v1p5 dc 3.75u
* --- loop dr007_slow_v1p7
Gcp_dr007_slow_v1p7 0 vc_dr007_slow_v1p7 pe 0 5.969071126574055e-07
XLF_dr007_slow_v1p7 vc_dr007_slow_v1p7 0 loop_filter
Gvco_dr007_slow_v1p7 0 vph_dr007_slow_v1p7 vc_dr007_slow_v1p7 vb_dr007_slow_v1p7 1057966511.934083
Cint_dr007_slow_v1p7 vph_dr007_slow_v1p7 0 1
Rleak_dr007_slow_v1p7 vph_dr007_slow_v1p7 0 1e15
Ediv_dr007_slow_v1p7 fb_dr007_slow_v1p7 0 vph_dr007_slow_v1p7 0 0.008403361344537815
Lb_dr007_slow_v1p7 vc_dr007_slow_v1p7 vb_dr007_slow_v1p7 1e12
Vb_dr007_slow_v1p7 vb_dr007_slow_v1p7 0 dc 1.7
Xcp_dr007_slow_v1p7 0 0 ibp_dr007_slow_v1p7 icp_dr007_slow_v1p7 ibn_dr007_slow_v1p7 icn_dr007_slow_v1p7 vc_dr007_slow_v1p7 VDD 0 cp
Irbp_dr007_slow_v1p7 ibp_dr007_slow_v1p7 0 dc 3.75u
Ircp_dr007_slow_v1p7 icp_dr007_slow_v1p7 0 dc 3.75u
Irbn_dr007_slow_v1p7 0 ibn_dr007_slow_v1p7 dc 3.75u
Ircn_dr007_slow_v1p7 0 icn_dr007_slow_v1p7 dc 3.75u
* --- loop dr007_slow_v1p9
Gcp_dr007_slow_v1p9 0 vc_dr007_slow_v1p9 pe 0 5.969071126574055e-07
XLF_dr007_slow_v1p9 vc_dr007_slow_v1p9 0 loop_filter
Gvco_dr007_slow_v1p9 0 vph_dr007_slow_v1p9 vc_dr007_slow_v1p9 vb_dr007_slow_v1p9 1057966511.934083
Cint_dr007_slow_v1p9 vph_dr007_slow_v1p9 0 1
Rleak_dr007_slow_v1p9 vph_dr007_slow_v1p9 0 1e15
Ediv_dr007_slow_v1p9 fb_dr007_slow_v1p9 0 vph_dr007_slow_v1p9 0 0.008403361344537815
Lb_dr007_slow_v1p9 vc_dr007_slow_v1p9 vb_dr007_slow_v1p9 1e12
Vb_dr007_slow_v1p9 vb_dr007_slow_v1p9 0 dc 1.9
Xcp_dr007_slow_v1p9 0 0 ibp_dr007_slow_v1p9 icp_dr007_slow_v1p9 ibn_dr007_slow_v1p9 icn_dr007_slow_v1p9 vc_dr007_slow_v1p9 VDD 0 cp
Irbp_dr007_slow_v1p9 ibp_dr007_slow_v1p9 0 dc 3.75u
Ircp_dr007_slow_v1p9 icp_dr007_slow_v1p9 0 dc 3.75u
Irbn_dr007_slow_v1p9 0 ibn_dr007_slow_v1p9 dc 3.75u
Ircn_dr007_slow_v1p9 0 icn_dr007_slow_v1p9 dc 3.75u
* --- loop dr007_slow_v2p1
Gcp_dr007_slow_v2p1 0 vc_dr007_slow_v2p1 pe 0 5.969071126574055e-07
XLF_dr007_slow_v2p1 vc_dr007_slow_v2p1 0 loop_filter
Gvco_dr007_slow_v2p1 0 vph_dr007_slow_v2p1 vc_dr007_slow_v2p1 vb_dr007_slow_v2p1 1057966511.934083
Cint_dr007_slow_v2p1 vph_dr007_slow_v2p1 0 1
Rleak_dr007_slow_v2p1 vph_dr007_slow_v2p1 0 1e15
Ediv_dr007_slow_v2p1 fb_dr007_slow_v2p1 0 vph_dr007_slow_v2p1 0 0.008403361344537815
Lb_dr007_slow_v2p1 vc_dr007_slow_v2p1 vb_dr007_slow_v2p1 1e12
Vb_dr007_slow_v2p1 vb_dr007_slow_v2p1 0 dc 2.1
Xcp_dr007_slow_v2p1 0 0 ibp_dr007_slow_v2p1 icp_dr007_slow_v2p1 ibn_dr007_slow_v2p1 icn_dr007_slow_v2p1 vc_dr007_slow_v2p1 VDD 0 cp
Irbp_dr007_slow_v2p1 ibp_dr007_slow_v2p1 0 dc 3.75u
Ircp_dr007_slow_v2p1 icp_dr007_slow_v2p1 0 dc 3.75u
Irbn_dr007_slow_v2p1 0 ibn_dr007_slow_v2p1 dc 3.75u
Ircn_dr007_slow_v2p1 0 icn_dr007_slow_v2p1 dc 3.75u
* --- loop dr007_slow_v2p3
Gcp_dr007_slow_v2p3 0 vc_dr007_slow_v2p3 pe 0 5.969071126574055e-07
XLF_dr007_slow_v2p3 vc_dr007_slow_v2p3 0 loop_filter
Gvco_dr007_slow_v2p3 0 vph_dr007_slow_v2p3 vc_dr007_slow_v2p3 vb_dr007_slow_v2p3 1057966511.934083
Cint_dr007_slow_v2p3 vph_dr007_slow_v2p3 0 1
Rleak_dr007_slow_v2p3 vph_dr007_slow_v2p3 0 1e15
Ediv_dr007_slow_v2p3 fb_dr007_slow_v2p3 0 vph_dr007_slow_v2p3 0 0.008403361344537815
Lb_dr007_slow_v2p3 vc_dr007_slow_v2p3 vb_dr007_slow_v2p3 1e12
Vb_dr007_slow_v2p3 vb_dr007_slow_v2p3 0 dc 2.3
Xcp_dr007_slow_v2p3 0 0 ibp_dr007_slow_v2p3 icp_dr007_slow_v2p3 ibn_dr007_slow_v2p3 icn_dr007_slow_v2p3 vc_dr007_slow_v2p3 VDD 0 cp
Irbp_dr007_slow_v2p3 ibp_dr007_slow_v2p3 0 dc 3.75u
Ircp_dr007_slow_v2p3 icp_dr007_slow_v2p3 0 dc 3.75u
Irbn_dr007_slow_v2p3 0 ibn_dr007_slow_v2p3 dc 3.75u
Ircn_dr007_slow_v2p3 0 icn_dr007_slow_v2p3 dc 3.75u
* --- loop dr007_slow_v2p5
Gcp_dr007_slow_v2p5 0 vc_dr007_slow_v2p5 pe 0 5.969071126574055e-07
XLF_dr007_slow_v2p5 vc_dr007_slow_v2p5 0 loop_filter
Gvco_dr007_slow_v2p5 0 vph_dr007_slow_v2p5 vc_dr007_slow_v2p5 vb_dr007_slow_v2p5 1057966511.934083
Cint_dr007_slow_v2p5 vph_dr007_slow_v2p5 0 1
Rleak_dr007_slow_v2p5 vph_dr007_slow_v2p5 0 1e15
Ediv_dr007_slow_v2p5 fb_dr007_slow_v2p5 0 vph_dr007_slow_v2p5 0 0.008403361344537815
Lb_dr007_slow_v2p5 vc_dr007_slow_v2p5 vb_dr007_slow_v2p5 1e12
Vb_dr007_slow_v2p5 vb_dr007_slow_v2p5 0 dc 2.5
Xcp_dr007_slow_v2p5 0 0 ibp_dr007_slow_v2p5 icp_dr007_slow_v2p5 ibn_dr007_slow_v2p5 icn_dr007_slow_v2p5 vc_dr007_slow_v2p5 VDD 0 cp
Irbp_dr007_slow_v2p5 ibp_dr007_slow_v2p5 0 dc 3.75u
Ircp_dr007_slow_v2p5 icp_dr007_slow_v2p5 0 dc 3.75u
Irbn_dr007_slow_v2p5 0 ibn_dr007_slow_v2p5 dc 3.75u
Ircn_dr007_slow_v2p5 0 icn_dr007_slow_v2p5 dc 3.75u
* --- loop dr007_slow_v2p7
Gcp_dr007_slow_v2p7 0 vc_dr007_slow_v2p7 pe 0 5.969071126574055e-07
XLF_dr007_slow_v2p7 vc_dr007_slow_v2p7 0 loop_filter
Gvco_dr007_slow_v2p7 0 vph_dr007_slow_v2p7 vc_dr007_slow_v2p7 vb_dr007_slow_v2p7 1057966511.934083
Cint_dr007_slow_v2p7 vph_dr007_slow_v2p7 0 1
Rleak_dr007_slow_v2p7 vph_dr007_slow_v2p7 0 1e15
Ediv_dr007_slow_v2p7 fb_dr007_slow_v2p7 0 vph_dr007_slow_v2p7 0 0.008403361344537815
Lb_dr007_slow_v2p7 vc_dr007_slow_v2p7 vb_dr007_slow_v2p7 1e12
Vb_dr007_slow_v2p7 vb_dr007_slow_v2p7 0 dc 2.7
Xcp_dr007_slow_v2p7 0 0 ibp_dr007_slow_v2p7 icp_dr007_slow_v2p7 ibn_dr007_slow_v2p7 icn_dr007_slow_v2p7 vc_dr007_slow_v2p7 VDD 0 cp
Irbp_dr007_slow_v2p7 ibp_dr007_slow_v2p7 0 dc 3.75u
Ircp_dr007_slow_v2p7 icp_dr007_slow_v2p7 0 dc 3.75u
Irbn_dr007_slow_v2p7 0 ibn_dr007_slow_v2p7 dc 3.75u
Ircn_dr007_slow_v2p7 0 icn_dr007_slow_v2p7 dc 3.75u
* --- loop dr007_slow_v2p9
Gcp_dr007_slow_v2p9 0 vc_dr007_slow_v2p9 pe 0 5.969071126574055e-07
XLF_dr007_slow_v2p9 vc_dr007_slow_v2p9 0 loop_filter
Gvco_dr007_slow_v2p9 0 vph_dr007_slow_v2p9 vc_dr007_slow_v2p9 vb_dr007_slow_v2p9 1057966511.934083
Cint_dr007_slow_v2p9 vph_dr007_slow_v2p9 0 1
Rleak_dr007_slow_v2p9 vph_dr007_slow_v2p9 0 1e15
Ediv_dr007_slow_v2p9 fb_dr007_slow_v2p9 0 vph_dr007_slow_v2p9 0 0.008403361344537815
Lb_dr007_slow_v2p9 vc_dr007_slow_v2p9 vb_dr007_slow_v2p9 1e12
Vb_dr007_slow_v2p9 vb_dr007_slow_v2p9 0 dc 2.9
Xcp_dr007_slow_v2p9 0 0 ibp_dr007_slow_v2p9 icp_dr007_slow_v2p9 ibn_dr007_slow_v2p9 icn_dr007_slow_v2p9 vc_dr007_slow_v2p9 VDD 0 cp
Irbp_dr007_slow_v2p9 ibp_dr007_slow_v2p9 0 dc 3.75u
Ircp_dr007_slow_v2p9 icp_dr007_slow_v2p9 0 dc 3.75u
Irbn_dr007_slow_v2p9 0 ibn_dr007_slow_v2p9 dc 3.75u
Ircn_dr007_slow_v2p9 0 icn_dr007_slow_v2p9 dc 3.75u
