* Netlist provenance snapshot -- sim/README.md convention
* Frozen from design/sg13cmos5l/netlist/loop_filter.spice at commit db5ec6afaf79a04aeb13b9a43a4b5905472ff37a
* (main, after PR #33 -- loop_filter.spice content unchanged since PR #26)
* Simulated by sim/sg13cmos5l-loop-bandwidth-pm/ (issue #27, Part of #16).
* Independent of whatever design/sg13cmos5l/netlist/loop_filter.spice says today.
*
* sg13g2-pll :: loop_filter (SG13CMOS5L) -- generated by design/sg13cmos5l/netlist.sh from loop_filter.sch
* xschem XSCHEM V3.4.7; do not edit by hand.
** sch_path: design/sg13cmos5l/loop_filter.sch
.subckt loop_filter VCTRL VSS
*.iopin VCTRL
*.iopin VSS
XR1 VCTRL NZ sub! rppd w=4u l=120u m=1 b=0
XC1 NZ VSS cap_cmomi w=40u l=40u mmin=1 mmax=4 feed=double subblock=0 m=1 mm_ok=1
XC2 VCTRL VSS cap_cmomi w=10u l=10u mmin=1 mmax=4 feed=double subblock=0 m=1 mm_ok=1
.ends
