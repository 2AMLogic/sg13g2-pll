* RECORD-002 (#316): vco.XCDECAP AC extraction
.include /home/ubuntu/share/pdk/ihp-sg13cmos5l/libs.tech/ngspice/models/cap_cmomi.lib
.option scale=1
Xcap n1 0 cap_cmomi w=70u l=70u mmin=1 mmax=4 feed=double subblock=0 m=1 mm_ok=1
Rbleed n1 0 1e14
Iac n1 0 dc 0 ac 1
.end
