* generated by gen_rerun331_requests.py (variant long2u) -- do not edit
.global sub!
.subckt schmitt_hv IN OUT VDD VSS
*.ipin IN
*.opin OUT
*.iopin VDD
*.iopin VSS
XMP1 np IN VDD VDD sg13_hv_pmos w=5u l=2u ng=1 m=1
XMP2 OUT IN np VDD sg13_hv_pmos w=5u l=2u ng=1 m=1
XMP3 VSS OUT np VDD sg13_hv_pmos w=5u l=2u ng=1 m=1
XMN1 OUT IN nn VSS sg13_hv_nmos w=2u l=2u ng=1 m=1
XMN2 nn IN VSS VSS sg13_hv_nmos w=2u l=2u ng=1 m=1
XMN3 VDD OUT nn VSS sg13_hv_nmos w=2u l=2u ng=1 m=1
.ends

Vsub sub! 0 0
Vdd vdd 0 dc 3.3
Bmid vmid 0 v=v(vdd)/2
Bin vin 0 v='v(vdd)*(time<2u ? time/2u : (time<4u ? (4u-time)/2u : 0))'
Xsch vin sout vdd 0 schmitt_hv
.options reltol=1e-3 abstol=1e-10 vntol=1e-5 chgtol=1e-13
