* issue #329 rerun deck generated by gen_rerun329.py from tb_schmitt_rewire.sp.tmpl
.option scale=1
.global sub!

.include "../../netlist-snapshots/rerun329/cmos5l_as_drawn.spice"

Vsub sub! 0 0
Vdd vdd 0 dc 2.97

Vin vin 0 pwl(0 0 2u 2.97 4u 0)
Xsch vin sout vdd 0 schmitt_hv

.options reltol=1e-3 abstol=1e-10 vntol=1e-5 chgtol=1e-13
.end
