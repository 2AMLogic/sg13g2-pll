* Netlist provenance snapshot -- sim/README.md convention
* Frozen from design/sg13cmos5l/netlist/lock_detector.spice at issue #76's own
* branch HEAD, i.e. AFTER schmitt_hv's six channel lengths were taken from
* l=0.5u to l=2u to cut the in-band crowbar current this record measures.
*
* This is a FOURTH, separate snapshot.  lock_detector.spice stays frozen at
* RECORD-001's pre-resize netlist, lock_detector_resized.spice at RECORD-002's
* post-XRPU/XCW/XDW.XC1-resize netlist, and lock_detector_hystfix.spice at
* RECORD-003's post-schmitt-rewire/post-XMPD-resize netlist; sim/README.md's
* records are append-only and each must keep describing the netlist it actually
* simulated.  This file differs from lock_detector_hystfix.spice in exactly SIX
* lines and is byte-identical everywhere else:
*     schmitt_hv.XMP1/XMP2/XMP3  w=5u l=0.5u  ->  w=5u l=2u
*     schmitt_hv.XMN1/XMN2/XMN3  w=2u l=0.5u  ->  w=2u l=2u
* Every W is UNCHANGED, so every W/L ratio inside the cell scales by the same
* factor and the trip points that set row 16's hysteresis are preserved to
* within +-4% (measured -- ../corners/schmitt_crowbar.csv).  XRPU, XMPD, XCW
* and XDW.XC1 are untouched, so neither #52's R*C margin nor #66's XMPD
* two-sided bound is spent here -- and both are re-measured anyway.
*
* Simulated by sim/sg13cmos5l-lock-detector-window/ (issue #76, Part of #16).
* Independent of whatever design/sg13cmos5l/netlist/lock_detector.spice says today.
*
* sg13g2-pll :: lock_detector (SG13CMOS5L) -- generated by design/sg13cmos5l/netlist.sh from lock_detector.sch
* xschem XSCHEM V3.4.7; do not edit by hand.
** sch_path: design/sg13cmos5l/lock_detector.sch
.subckt lock_detector UP DN LOCK VDD VSS
*.ipin UP
*.ipin DN
*.opin LOCK
*.iopin VDD
*.iopin VSS
XXOR UP DN ERR VDD VSS xor2_hv
XDW ERR ERRD VDD VSS delaywin_hv
XNW ERR ERRD nwide VDD VSS nand2_hv
XIW nwide WIDE VDD VSS inv_hv
XRPU VDD VWIN sub! rhigh w=0.5u l=700u m=1 b=0
XMPD VWIN WIDE VSS VSS sg13_hv_nmos w=0.25u l=16u ng=1 m=1
XCW VWIN VSS cap_cmomi w=40u l=40u mmin=1 mmax=4 feed=double subblock=0 m=1 mm_ok=1
XSCH VWIN LOCK VDD VSS schmitt_hv
.ends

* expanding   symbol:  xor2_hv.sym # of pins=5
** sym_path: design/sg13cmos5l/xor2_hv.sym
** sch_path: design/sg13cmos5l/xor2_hv.sch
.subckt xor2_hv A B Y VDD VSS
*.ipin A
*.ipin B
*.opin Y
*.iopin VDD
*.iopin VSS
XN1 A B n1 VDD VSS nand2_hv
XN2 A n1 n2 VDD VSS nand2_hv
XN3 B n1 n3 VDD VSS nand2_hv
XN4 n2 n3 Y VDD VSS nand2_hv
.ends

* expanding   symbol:  delaywin_hv.sym # of pins=4
** sym_path: design/sg13cmos5l/delaywin_hv.sym
** sch_path: design/sg13cmos5l/delaywin_hv.sch
.subckt delaywin_hv IN OUT VDD VSS
*.ipin IN
*.opin OUT
*.iopin VDD
*.iopin VSS
XI1 IN d1 VDD VSS inv_hv
XI2 d1 d2 VDD VSS inv_hv
XI3 d2 d3 VDD VSS inv_hv
XI4 d3 OUT VDD VSS inv_hv
XC1 OUT VSS cap_cmomi w=40u l=40u mmin=1 mmax=4 feed=double subblock=0 m=2 mm_ok=1
.ends

* expanding   symbol:  nand2_hv.sym # of pins=5
** sym_path: design/sg13cmos5l/nand2_hv.sym
** sch_path: design/sg13cmos5l/nand2_hv.sch
.subckt nand2_hv A1 A2 Y VDD VSS
*.opin Y
*.ipin A1
*.ipin A2
*.iopin VDD
*.iopin VSS
XMP1 Y A1 VDD VDD sg13_hv_pmos w=5u l=0.5u ng=1 m=1
XMP2 Y A2 VDD VDD sg13_hv_pmos w=5u l=0.5u ng=1 m=1
XMN1 Y A1 mid1 VSS sg13_hv_nmos w=2u l=0.5u ng=1 m=1
XMN2 mid1 A2 VSS VSS sg13_hv_nmos w=2u l=0.5u ng=1 m=1
.ends

* expanding   symbol:  inv_hv.sym # of pins=4
** sym_path: design/sg13cmos5l/inv_hv.sym
** sch_path: design/sg13cmos5l/inv_hv.sch
.subckt inv_hv A Y VDD VSS
*.ipin A
*.opin Y
*.iopin VDD
*.iopin VSS
XMP Y A VDD VDD sg13_hv_pmos w=5u l=0.5u ng=1 m=1
XMN Y A VSS VSS sg13_hv_nmos w=2u l=0.5u ng=1 m=1
.ends

* expanding   symbol:  schmitt_hv.sym # of pins=4
** sym_path: design/sg13cmos5l/schmitt_hv.sym
** sch_path: design/sg13cmos5l/schmitt_hv.sch
.subckt schmitt_hv IN OUT VDD VSS
*.ipin IN
*.opin OUT
*.iopin VDD
*.iopin VSS
XMP1 np IN VDD VDD sg13_hv_pmos w=5u l=2u ng=1 m=1
XMP2 OUT IN np VDD sg13_hv_pmos w=5u l=2u ng=1 m=1
XMP3 VSS OUT np VDD sg13_hv_pmos w=5u l=2u ng=1 m=1
XMN1 OUT IN nn VSS sg13_hv_nmos w=2u l=2u ng=1 m=1
XMN2 nn IN VSS VSS sg13_hv_nmos w=2u l=2u ng=1 m=1
XMN3 VDD OUT nn VSS sg13_hv_nmos w=2u l=2u ng=1 m=1
.ends
