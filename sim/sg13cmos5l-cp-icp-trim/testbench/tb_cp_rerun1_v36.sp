* sg13g2-pll :: sim/sg13cmos5l-cp-icp-trim (issue #230, rerun of RECORD-001)
* GENERATED by gen_rerun_requests.py -- do not edit by hand.
* Circuit body for `klt sim` (no .control/.end; klt owns those).
* DUT: ../netlist-snapshots/cp-b37918d.spice (historical cp, NOT today's cp).
* 18 instances (6 trim codes x states up/dn/both) share ONE swept output
* voltage VS (0.15 -> 3.45 V, 50 mV, 67 points; index k <-> 0.15 + 0.05 k V).
* Each instance has its own 0 V ammeter Vm_<inst> (i > 0 = cp sources INTO the
* output). Switch levels follow VDD through B-sources.
.option scale=1
.include ../netlist-snapshots/cp-b37918d.spice

Vdd VDD 0 dc 3.6
Vs vs 0 dc 1.8000

* --- up2p5: UP=1 DN=0 Iref=2.5u
XMREFP1_up2p5 nrp1_up2p5 nbp_up2p5 VDD VDD sg13_hv_pmos w=24u l=1u ng=1 m=1
XMREFP2_up2p5 nbp_up2p5 nbp_up2p5 nrp1_up2p5 VDD sg13_hv_pmos w=24u l=1u ng=1 m=1
Irefp_up2p5 nbp_up2p5 0 dc 2.5u
XMREFN1_up2p5 nrn1_up2p5 nbn_up2p5 0 0 sg13_hv_nmos w=8u l=1u ng=1 m=1
XMREFN2_up2p5 nbn_up2p5 nbn_up2p5 nrn1_up2p5 0 sg13_hv_nmos w=8u l=1u ng=1 m=1
Irefn_up2p5 0 nbn_up2p5 dc 2.5u
Xup2p5 up_up2p5 dn_up2p5 nbp_up2p5 nbp_up2p5 nbn_up2p5 nbn_up2p5 vo_up2p5 VDD 0 cp
Bup_up2p5 up_up2p5 0 V=v(VDD)
Bdn_up2p5 dn_up2p5 0 V=0
Vm_up2p5 vo_up2p5 vs dc 0
* --- dn2p5: UP=0 DN=1 Iref=2.5u
XMREFP1_dn2p5 nrp1_dn2p5 nbp_dn2p5 VDD VDD sg13_hv_pmos w=24u l=1u ng=1 m=1
XMREFP2_dn2p5 nbp_dn2p5 nbp_dn2p5 nrp1_dn2p5 VDD sg13_hv_pmos w=24u l=1u ng=1 m=1
Irefp_dn2p5 nbp_dn2p5 0 dc 2.5u
XMREFN1_dn2p5 nrn1_dn2p5 nbn_dn2p5 0 0 sg13_hv_nmos w=8u l=1u ng=1 m=1
XMREFN2_dn2p5 nbn_dn2p5 nbn_dn2p5 nrn1_dn2p5 0 sg13_hv_nmos w=8u l=1u ng=1 m=1
Irefn_dn2p5 0 nbn_dn2p5 dc 2.5u
Xdn2p5 up_dn2p5 dn_dn2p5 nbp_dn2p5 nbp_dn2p5 nbn_dn2p5 nbn_dn2p5 vo_dn2p5 VDD 0 cp
Bup_dn2p5 up_dn2p5 0 V=0
Bdn_dn2p5 dn_dn2p5 0 V=v(VDD)
Vm_dn2p5 vo_dn2p5 vs dc 0
* --- both2p5: UP=1 DN=1 Iref=2.5u
XMREFP1_both2p5 nrp1_both2p5 nbp_both2p5 VDD VDD sg13_hv_pmos w=24u l=1u ng=1 m=1
XMREFP2_both2p5 nbp_both2p5 nbp_both2p5 nrp1_both2p5 VDD sg13_hv_pmos w=24u l=1u ng=1 m=1
Irefp_both2p5 nbp_both2p5 0 dc 2.5u
XMREFN1_both2p5 nrn1_both2p5 nbn_both2p5 0 0 sg13_hv_nmos w=8u l=1u ng=1 m=1
XMREFN2_both2p5 nbn_both2p5 nbn_both2p5 nrn1_both2p5 0 sg13_hv_nmos w=8u l=1u ng=1 m=1
Irefn_both2p5 0 nbn_both2p5 dc 2.5u
Xboth2p5 up_both2p5 dn_both2p5 nbp_both2p5 nbp_both2p5 nbn_both2p5 nbn_both2p5 vo_both2p5 VDD 0 cp
Bup_both2p5 up_both2p5 0 V=v(VDD)
Bdn_both2p5 dn_both2p5 0 V=v(VDD)
Vm_both2p5 vo_both2p5 vs dc 0
* --- up5: UP=1 DN=0 Iref=5u
XMREFP1_up5 nrp1_up5 nbp_up5 VDD VDD sg13_hv_pmos w=24u l=1u ng=1 m=1
XMREFP2_up5 nbp_up5 nbp_up5 nrp1_up5 VDD sg13_hv_pmos w=24u l=1u ng=1 m=1
Irefp_up5 nbp_up5 0 dc 5u
XMREFN1_up5 nrn1_up5 nbn_up5 0 0 sg13_hv_nmos w=8u l=1u ng=1 m=1
XMREFN2_up5 nbn_up5 nbn_up5 nrn1_up5 0 sg13_hv_nmos w=8u l=1u ng=1 m=1
Irefn_up5 0 nbn_up5 dc 5u
Xup5 up_up5 dn_up5 nbp_up5 nbp_up5 nbn_up5 nbn_up5 vo_up5 VDD 0 cp
Bup_up5 up_up5 0 V=v(VDD)
Bdn_up5 dn_up5 0 V=0
Vm_up5 vo_up5 vs dc 0
* --- dn5: UP=0 DN=1 Iref=5u
XMREFP1_dn5 nrp1_dn5 nbp_dn5 VDD VDD sg13_hv_pmos w=24u l=1u ng=1 m=1
XMREFP2_dn5 nbp_dn5 nbp_dn5 nrp1_dn5 VDD sg13_hv_pmos w=24u l=1u ng=1 m=1
Irefp_dn5 nbp_dn5 0 dc 5u
XMREFN1_dn5 nrn1_dn5 nbn_dn5 0 0 sg13_hv_nmos w=8u l=1u ng=1 m=1
XMREFN2_dn5 nbn_dn5 nbn_dn5 nrn1_dn5 0 sg13_hv_nmos w=8u l=1u ng=1 m=1
Irefn_dn5 0 nbn_dn5 dc 5u
Xdn5 up_dn5 dn_dn5 nbp_dn5 nbp_dn5 nbn_dn5 nbn_dn5 vo_dn5 VDD 0 cp
Bup_dn5 up_dn5 0 V=0
Bdn_dn5 dn_dn5 0 V=v(VDD)
Vm_dn5 vo_dn5 vs dc 0
* --- both5: UP=1 DN=1 Iref=5u
XMREFP1_both5 nrp1_both5 nbp_both5 VDD VDD sg13_hv_pmos w=24u l=1u ng=1 m=1
XMREFP2_both5 nbp_both5 nbp_both5 nrp1_both5 VDD sg13_hv_pmos w=24u l=1u ng=1 m=1
Irefp_both5 nbp_both5 0 dc 5u
XMREFN1_both5 nrn1_both5 nbn_both5 0 0 sg13_hv_nmos w=8u l=1u ng=1 m=1
XMREFN2_both5 nbn_both5 nbn_both5 nrn1_both5 0 sg13_hv_nmos w=8u l=1u ng=1 m=1
Irefn_both5 0 nbn_both5 dc 5u
Xboth5 up_both5 dn_both5 nbp_both5 nbp_both5 nbn_both5 nbn_both5 vo_both5 VDD 0 cp
Bup_both5 up_both5 0 V=v(VDD)
Bdn_both5 dn_both5 0 V=v(VDD)
Vm_both5 vo_both5 vs dc 0
* --- up10: UP=1 DN=0 Iref=10u
XMREFP1_up10 nrp1_up10 nbp_up10 VDD VDD sg13_hv_pmos w=24u l=1u ng=1 m=1
XMREFP2_up10 nbp_up10 nbp_up10 nrp1_up10 VDD sg13_hv_pmos w=24u l=1u ng=1 m=1
Irefp_up10 nbp_up10 0 dc 10u
XMREFN1_up10 nrn1_up10 nbn_up10 0 0 sg13_hv_nmos w=8u l=1u ng=1 m=1
XMREFN2_up10 nbn_up10 nbn_up10 nrn1_up10 0 sg13_hv_nmos w=8u l=1u ng=1 m=1
Irefn_up10 0 nbn_up10 dc 10u
Xup10 up_up10 dn_up10 nbp_up10 nbp_up10 nbn_up10 nbn_up10 vo_up10 VDD 0 cp
Bup_up10 up_up10 0 V=v(VDD)
Bdn_up10 dn_up10 0 V=0
Vm_up10 vo_up10 vs dc 0
* --- dn10: UP=0 DN=1 Iref=10u
XMREFP1_dn10 nrp1_dn10 nbp_dn10 VDD VDD sg13_hv_pmos w=24u l=1u ng=1 m=1
XMREFP2_dn10 nbp_dn10 nbp_dn10 nrp1_dn10 VDD sg13_hv_pmos w=24u l=1u ng=1 m=1
Irefp_dn10 nbp_dn10 0 dc 10u
XMREFN1_dn10 nrn1_dn10 nbn_dn10 0 0 sg13_hv_nmos w=8u l=1u ng=1 m=1
XMREFN2_dn10 nbn_dn10 nbn_dn10 nrn1_dn10 0 sg13_hv_nmos w=8u l=1u ng=1 m=1
Irefn_dn10 0 nbn_dn10 dc 10u
Xdn10 up_dn10 dn_dn10 nbp_dn10 nbp_dn10 nbn_dn10 nbn_dn10 vo_dn10 VDD 0 cp
Bup_dn10 up_dn10 0 V=0
Bdn_dn10 dn_dn10 0 V=v(VDD)
Vm_dn10 vo_dn10 vs dc 0
* --- both10: UP=1 DN=1 Iref=10u
XMREFP1_both10 nrp1_both10 nbp_both10 VDD VDD sg13_hv_pmos w=24u l=1u ng=1 m=1
XMREFP2_both10 nbp_both10 nbp_both10 nrp1_both10 VDD sg13_hv_pmos w=24u l=1u ng=1 m=1
Irefp_both10 nbp_both10 0 dc 10u
XMREFN1_both10 nrn1_both10 nbn_both10 0 0 sg13_hv_nmos w=8u l=1u ng=1 m=1
XMREFN2_both10 nbn_both10 nbn_both10 nrn1_both10 0 sg13_hv_nmos w=8u l=1u ng=1 m=1
Irefn_both10 0 nbn_both10 dc 10u
Xboth10 up_both10 dn_both10 nbp_both10 nbp_both10 nbn_both10 nbn_both10 vo_both10 VDD 0 cp
Bup_both10 up_both10 0 V=v(VDD)
Bdn_both10 dn_both10 0 V=v(VDD)
Vm_both10 vo_both10 vs dc 0
* --- up20: UP=1 DN=0 Iref=20u
XMREFP1_up20 nrp1_up20 nbp_up20 VDD VDD sg13_hv_pmos w=24u l=1u ng=1 m=1
XMREFP2_up20 nbp_up20 nbp_up20 nrp1_up20 VDD sg13_hv_pmos w=24u l=1u ng=1 m=1
Irefp_up20 nbp_up20 0 dc 20u
XMREFN1_up20 nrn1_up20 nbn_up20 0 0 sg13_hv_nmos w=8u l=1u ng=1 m=1
XMREFN2_up20 nbn_up20 nbn_up20 nrn1_up20 0 sg13_hv_nmos w=8u l=1u ng=1 m=1
Irefn_up20 0 nbn_up20 dc 20u
Xup20 up_up20 dn_up20 nbp_up20 nbp_up20 nbn_up20 nbn_up20 vo_up20 VDD 0 cp
Bup_up20 up_up20 0 V=v(VDD)
Bdn_up20 dn_up20 0 V=0
Vm_up20 vo_up20 vs dc 0
* --- dn20: UP=0 DN=1 Iref=20u
XMREFP1_dn20 nrp1_dn20 nbp_dn20 VDD VDD sg13_hv_pmos w=24u l=1u ng=1 m=1
XMREFP2_dn20 nbp_dn20 nbp_dn20 nrp1_dn20 VDD sg13_hv_pmos w=24u l=1u ng=1 m=1
Irefp_dn20 nbp_dn20 0 dc 20u
XMREFN1_dn20 nrn1_dn20 nbn_dn20 0 0 sg13_hv_nmos w=8u l=1u ng=1 m=1
XMREFN2_dn20 nbn_dn20 nbn_dn20 nrn1_dn20 0 sg13_hv_nmos w=8u l=1u ng=1 m=1
Irefn_dn20 0 nbn_dn20 dc 20u
Xdn20 up_dn20 dn_dn20 nbp_dn20 nbp_dn20 nbn_dn20 nbn_dn20 vo_dn20 VDD 0 cp
Bup_dn20 up_dn20 0 V=0
Bdn_dn20 dn_dn20 0 V=v(VDD)
Vm_dn20 vo_dn20 vs dc 0
* --- both20: UP=1 DN=1 Iref=20u
XMREFP1_both20 nrp1_both20 nbp_both20 VDD VDD sg13_hv_pmos w=24u l=1u ng=1 m=1
XMREFP2_both20 nbp_both20 nbp_both20 nrp1_both20 VDD sg13_hv_pmos w=24u l=1u ng=1 m=1
Irefp_both20 nbp_both20 0 dc 20u
XMREFN1_both20 nrn1_both20 nbn_both20 0 0 sg13_hv_nmos w=8u l=1u ng=1 m=1
XMREFN2_both20 nbn_both20 nbn_both20 nrn1_both20 0 sg13_hv_nmos w=8u l=1u ng=1 m=1
Irefn_both20 0 nbn_both20 dc 20u
Xboth20 up_both20 dn_both20 nbp_both20 nbp_both20 nbn_both20 nbn_both20 vo_both20 VDD 0 cp
Bup_both20 up_both20 0 V=v(VDD)
Bdn_both20 dn_both20 0 V=v(VDD)
Vm_both20 vo_both20 vs dc 0
* --- up40: UP=1 DN=0 Iref=40u
XMREFP1_up40 nrp1_up40 nbp_up40 VDD VDD sg13_hv_pmos w=24u l=1u ng=1 m=1
XMREFP2_up40 nbp_up40 nbp_up40 nrp1_up40 VDD sg13_hv_pmos w=24u l=1u ng=1 m=1
Irefp_up40 nbp_up40 0 dc 40u
XMREFN1_up40 nrn1_up40 nbn_up40 0 0 sg13_hv_nmos w=8u l=1u ng=1 m=1
XMREFN2_up40 nbn_up40 nbn_up40 nrn1_up40 0 sg13_hv_nmos w=8u l=1u ng=1 m=1
Irefn_up40 0 nbn_up40 dc 40u
Xup40 up_up40 dn_up40 nbp_up40 nbp_up40 nbn_up40 nbn_up40 vo_up40 VDD 0 cp
Bup_up40 up_up40 0 V=v(VDD)
Bdn_up40 dn_up40 0 V=0
Vm_up40 vo_up40 vs dc 0
* --- dn40: UP=0 DN=1 Iref=40u
XMREFP1_dn40 nrp1_dn40 nbp_dn40 VDD VDD sg13_hv_pmos w=24u l=1u ng=1 m=1
XMREFP2_dn40 nbp_dn40 nbp_dn40 nrp1_dn40 VDD sg13_hv_pmos w=24u l=1u ng=1 m=1
Irefp_dn40 nbp_dn40 0 dc 40u
XMREFN1_dn40 nrn1_dn40 nbn_dn40 0 0 sg13_hv_nmos w=8u l=1u ng=1 m=1
XMREFN2_dn40 nbn_dn40 nbn_dn40 nrn1_dn40 0 sg13_hv_nmos w=8u l=1u ng=1 m=1
Irefn_dn40 0 nbn_dn40 dc 40u
Xdn40 up_dn40 dn_dn40 nbp_dn40 nbp_dn40 nbn_dn40 nbn_dn40 vo_dn40 VDD 0 cp
Bup_dn40 up_dn40 0 V=0
Bdn_dn40 dn_dn40 0 V=v(VDD)
Vm_dn40 vo_dn40 vs dc 0
* --- both40: UP=1 DN=1 Iref=40u
XMREFP1_both40 nrp1_both40 nbp_both40 VDD VDD sg13_hv_pmos w=24u l=1u ng=1 m=1
XMREFP2_both40 nbp_both40 nbp_both40 nrp1_both40 VDD sg13_hv_pmos w=24u l=1u ng=1 m=1
Irefp_both40 nbp_both40 0 dc 40u
XMREFN1_both40 nrn1_both40 nbn_both40 0 0 sg13_hv_nmos w=8u l=1u ng=1 m=1
XMREFN2_both40 nbn_both40 nbn_both40 nrn1_both40 0 sg13_hv_nmos w=8u l=1u ng=1 m=1
Irefn_both40 0 nbn_both40 dc 40u
Xboth40 up_both40 dn_both40 nbp_both40 nbp_both40 nbn_both40 nbn_both40 vo_both40 VDD 0 cp
Bup_both40 up_both40 0 V=v(VDD)
Bdn_both40 dn_both40 0 V=v(VDD)
Vm_both40 vo_both40 vs dc 0
* --- up80: UP=1 DN=0 Iref=80u
XMREFP1_up80 nrp1_up80 nbp_up80 VDD VDD sg13_hv_pmos w=24u l=1u ng=1 m=1
XMREFP2_up80 nbp_up80 nbp_up80 nrp1_up80 VDD sg13_hv_pmos w=24u l=1u ng=1 m=1
Irefp_up80 nbp_up80 0 dc 80u
XMREFN1_up80 nrn1_up80 nbn_up80 0 0 sg13_hv_nmos w=8u l=1u ng=1 m=1
XMREFN2_up80 nbn_up80 nbn_up80 nrn1_up80 0 sg13_hv_nmos w=8u l=1u ng=1 m=1
Irefn_up80 0 nbn_up80 dc 80u
Xup80 up_up80 dn_up80 nbp_up80 nbp_up80 nbn_up80 nbn_up80 vo_up80 VDD 0 cp
Bup_up80 up_up80 0 V=v(VDD)
Bdn_up80 dn_up80 0 V=0
Vm_up80 vo_up80 vs dc 0
* --- dn80: UP=0 DN=1 Iref=80u
XMREFP1_dn80 nrp1_dn80 nbp_dn80 VDD VDD sg13_hv_pmos w=24u l=1u ng=1 m=1
XMREFP2_dn80 nbp_dn80 nbp_dn80 nrp1_dn80 VDD sg13_hv_pmos w=24u l=1u ng=1 m=1
Irefp_dn80 nbp_dn80 0 dc 80u
XMREFN1_dn80 nrn1_dn80 nbn_dn80 0 0 sg13_hv_nmos w=8u l=1u ng=1 m=1
XMREFN2_dn80 nbn_dn80 nbn_dn80 nrn1_dn80 0 sg13_hv_nmos w=8u l=1u ng=1 m=1
Irefn_dn80 0 nbn_dn80 dc 80u
Xdn80 up_dn80 dn_dn80 nbp_dn80 nbp_dn80 nbn_dn80 nbn_dn80 vo_dn80 VDD 0 cp
Bup_dn80 up_dn80 0 V=0
Bdn_dn80 dn_dn80 0 V=v(VDD)
Vm_dn80 vo_dn80 vs dc 0
* --- both80: UP=1 DN=1 Iref=80u
XMREFP1_both80 nrp1_both80 nbp_both80 VDD VDD sg13_hv_pmos w=24u l=1u ng=1 m=1
XMREFP2_both80 nbp_both80 nbp_both80 nrp1_both80 VDD sg13_hv_pmos w=24u l=1u ng=1 m=1
Irefp_both80 nbp_both80 0 dc 80u
XMREFN1_both80 nrn1_both80 nbn_both80 0 0 sg13_hv_nmos w=8u l=1u ng=1 m=1
XMREFN2_both80 nbn_both80 nbn_both80 nrn1_both80 0 sg13_hv_nmos w=8u l=1u ng=1 m=1
Irefn_both80 0 nbn_both80 dc 80u
Xboth80 up_both80 dn_both80 nbp_both80 nbp_both80 nbn_both80 nbn_both80 vo_both80 VDD 0 cp
Bup_both80 up_both80 0 V=v(VDD)
Bdn_both80 dn_both80 0 V=v(VDD)
Vm_both80 vo_both80 vs dc 0
