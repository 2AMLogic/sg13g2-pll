* sg13g2-pll :: #231 rerun deck, Iref=11u (generated by gen_finetrim_rerun231.py)
* Circuit body for `klt sim` (no .control/.end; klt owns those).
.option scale=1
.include ../netlist-snapshots/cp.spice
Vdd VDD 0 dc 3.3
XCP_up up_up dn_up ibp_up icp_up ibn_up icn_up vout_up VDD 0 cp
Irefbp_up ibp_up 0 dc 11u
Irefcp_up icp_up 0 dc 11u
Irefbn_up 0 ibn_up dc 11u
Irefcn_up 0 icn_up dc 11u
Vup_up up_up 0 dc 3.3
Vdn_up dn_up 0 dc 0.0
Vout_up vout_up 0 dc 1.65
XCP_dn up_dn dn_dn ibp_dn icp_dn ibn_dn icn_dn vout_dn VDD 0 cp
Irefbp_dn ibp_dn 0 dc 11u
Irefcp_dn icp_dn 0 dc 11u
Irefbn_dn 0 ibn_dn dc 11u
Irefcn_dn 0 icn_dn dc 11u
Vup_dn up_dn 0 dc 0.0
Vdn_dn dn_dn 0 dc 3.3
Vout_dn vout_dn 0 dc 1.65
XCP_both up_both dn_both ibp_both icp_both ibn_both icn_both vout_both VDD 0 cp
Irefbp_both ibp_both 0 dc 11u
Irefcp_both icp_both 0 dc 11u
Irefbn_both 0 ibn_both dc 11u
Irefcn_both 0 icn_both dc 11u
Vup_both up_both 0 dc 3.3
Vdn_both dn_both 0 dc 3.3
Vout_both vout_both 0 dc 1.65
