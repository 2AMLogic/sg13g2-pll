* sg13g2-pll :: sim/sg13cmos5l-cp-icp-trim (issue #165, RECORD-005)
* GENERATED by gen_otabuf_requests.py -- do not edit by hand.
* Circuit body for `klt sim` (AC): cp_dumpbuf unity-feedback loop gain, loop
* broken at the MN2/MP2 gates (see the generator for the method).
.include ../netlist-snapshots/cp_otabuf.spice

.subckt cp_dumpbuf_lb VOUT IBN IBP VDUMP VDD VSS INJ
*.ipin VOUT
*.ipin IBN
*.ipin IBP
*.opin VDUMP
*.iopin VDD
*.iopin VSS
XMTN NSRC IBN VSS VSS sg13_hv_nmos w=12u l=1u ng=1 m=1
XMN1 NDA VOUT NSRC VSS sg13_hv_nmos w=2u l=1u ng=1 m=1
XMN2 VDUMP FB NSRC VSS sg13_hv_nmos w=2u l=1u ng=1 m=1
XMN3 NDA NDA VDD VDD sg13_hv_pmos w=24u l=1u ng=1 m=1
XMN4 VDUMP NDA VDD VDD sg13_hv_pmos w=24u l=1u ng=1 m=1
XMTP PSRC IBP VDD VDD sg13_hv_pmos w=36u l=1u ng=1 m=1
XMP1 PDA VOUT PSRC PSRC sg13_hv_pmos w=6u l=0.5u ng=1 m=1
XMP2 VDUMP FB PSRC PSRC sg13_hv_pmos w=6u l=0.5u ng=1 m=1
XMP3 PDA PDA VSS VSS sg13_hv_nmos w=16u l=1u ng=1 m=1
XMP4 VDUMP PDA VSS VSS sg13_hv_nmos w=16u l=1u ng=1 m=1
Lbrk VDUMP FB 1G
Cinj FB INJ 1
.ends

.subckt cp_lb UP DN IBP ICP IBN ICN VOUT VDD VSS INJ
*.ipin UP
*.ipin DN
*.iopin IBP
*.iopin ICP
*.iopin IBN
*.iopin ICN
*.opin VOUT
*.iopin VDD
*.iopin VSS
XIUP UP UPB VDD VSS inv_hv
XIDN DN DNB VDD VSS inv_hv
XLEGP IBP ICP UP UPB VOUT VDUMP VDD cp_leg_p
XLEGN IBN ICN DN DNB VOUT VDUMP VSS cp_leg_n
XBUF VOUT IBN IBP VDUMP VDD VSS INJ cp_dumpbuf_lb
XMBP nxp IBP VDD VDD sg13_hv_pmos w=24u l=1u ng=1 m=1
XMBPC IBP ICP nxp VDD sg13_hv_pmos w=24u l=1u ng=1 m=1
XMCP ICP ICP VDD VDD sg13_hv_pmos w=6u l=3u ng=1 m=1
XMBN nxn IBN VSS VSS sg13_hv_nmos w=8u l=1u ng=1 m=1
XMBNC IBN ICN nxn VSS sg13_hv_nmos w=8u l=1u ng=1 m=1
XMCN ICN ICN VSS VSS sg13_hv_nmos w=2u l=3u ng=1 m=1
.ends

Vdd VDD 0 dc 3.3
X0 0 0 ibp0 icp0 ibn0 icn0 vo0 VDD 0 inj0 cp_lb
Irbp0 ibp0 0 dc 10u
Ircp0 icp0 0 dc 10u
Irbn0 0 ibn0 dc 10u
Ircn0 0 icn0 dc 10u
Vo0 vo0 0 dc 0.5
Vinj0 inj0 0 dc 0 ac 1
X1 0 0 ibp1 icp1 ibn1 icn1 vo1 VDD 0 inj1 cp_lb
Irbp1 ibp1 0 dc 10u
Ircp1 icp1 0 dc 10u
Irbn1 0 ibn1 dc 10u
Ircn1 0 icn1 dc 10u
Vo1 vo1 0 dc 1.0
Vinj1 inj1 0 dc 0 ac 1
X2 0 0 ibp2 icp2 ibn2 icn2 vo2 VDD 0 inj2 cp_lb
Irbp2 ibp2 0 dc 10u
Ircp2 icp2 0 dc 10u
Irbn2 0 ibn2 dc 10u
Ircn2 0 icn2 dc 10u
Vo2 vo2 0 dc 1.65
Vinj2 inj2 0 dc 0 ac 1
X3 0 0 ibp3 icp3 ibn3 icn3 vo3 VDD 0 inj3 cp_lb
Irbp3 ibp3 0 dc 10u
Ircp3 icp3 0 dc 10u
Irbn3 0 ibn3 dc 10u
Ircn3 0 icn3 dc 10u
Vo3 vo3 0 dc 2.4
Vinj3 inj3 0 dc 0 ac 1
X4 0 0 ibp4 icp4 ibn4 icn4 vo4 VDD 0 inj4 cp_lb
Irbp4 ibp4 0 dc 10u
Ircp4 icp4 0 dc 10u
Irbn4 0 ibn4 dc 10u
Ircn4 0 icn4 dc 10u
Vo4 vo4 0 dc 2.7
Vinj4 inj4 0 dc 0 ac 1
