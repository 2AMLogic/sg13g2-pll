* sg13g2-pll :: sim/sg13cmos5l-cp-icp-trim (issue #230, rerun of RECORD-002)
* GENERATED by gen_rerun_requests.py -- do not edit by hand.
* Circuit body for `klt sim` (no .control/.end; klt owns those).
* DUT: ../netlist-snapshots/cp-f54b9ef.spice (historical cp, NOT today's cp).
* 18 instances (6 trim codes x states up/dn/both) share ONE swept output
* voltage VS (0.15 -> 2.85 V, 50 mV, 55 points; index k <-> 0.15 + 0.05 k V).
* Each instance has its own 0 V ammeter Vm_<inst> (i > 0 = cp sources INTO the
* output). Switch levels follow VDD through B-sources.
.option scale=1
.include ../netlist-snapshots/cp-f54b9ef.spice

Vdd VDD 0 dc 3.0
Vs vs 0 dc 1.5000

* --- up2p5: UP=1 DN=0 Iref=2.5u
Xup2p5 up_up2p5 dn_up2p5 ibp_up2p5 icp_up2p5 ibn_up2p5 icn_up2p5 vo_up2p5 VDD 0 cp
Irbp_up2p5 ibp_up2p5 0 dc 2.5u
Ircp_up2p5 icp_up2p5 0 dc 2.5u
Irbn_up2p5 0 ibn_up2p5 dc 2.5u
Ircn_up2p5 0 icn_up2p5 dc 2.5u
Bup_up2p5 up_up2p5 0 V=v(VDD)
Bdn_up2p5 dn_up2p5 0 V=0
Vm_up2p5 vo_up2p5 vs dc 0
* --- dn2p5: UP=0 DN=1 Iref=2.5u
Xdn2p5 up_dn2p5 dn_dn2p5 ibp_dn2p5 icp_dn2p5 ibn_dn2p5 icn_dn2p5 vo_dn2p5 VDD 0 cp
Irbp_dn2p5 ibp_dn2p5 0 dc 2.5u
Ircp_dn2p5 icp_dn2p5 0 dc 2.5u
Irbn_dn2p5 0 ibn_dn2p5 dc 2.5u
Ircn_dn2p5 0 icn_dn2p5 dc 2.5u
Bup_dn2p5 up_dn2p5 0 V=0
Bdn_dn2p5 dn_dn2p5 0 V=v(VDD)
Vm_dn2p5 vo_dn2p5 vs dc 0
* --- both2p5: UP=1 DN=1 Iref=2.5u
Xboth2p5 up_both2p5 dn_both2p5 ibp_both2p5 icp_both2p5 ibn_both2p5 icn_both2p5 vo_both2p5 VDD 0 cp
Irbp_both2p5 ibp_both2p5 0 dc 2.5u
Ircp_both2p5 icp_both2p5 0 dc 2.5u
Irbn_both2p5 0 ibn_both2p5 dc 2.5u
Ircn_both2p5 0 icn_both2p5 dc 2.5u
Bup_both2p5 up_both2p5 0 V=v(VDD)
Bdn_both2p5 dn_both2p5 0 V=v(VDD)
Vm_both2p5 vo_both2p5 vs dc 0
* --- up5: UP=1 DN=0 Iref=5u
Xup5 up_up5 dn_up5 ibp_up5 icp_up5 ibn_up5 icn_up5 vo_up5 VDD 0 cp
Irbp_up5 ibp_up5 0 dc 5u
Ircp_up5 icp_up5 0 dc 5u
Irbn_up5 0 ibn_up5 dc 5u
Ircn_up5 0 icn_up5 dc 5u
Bup_up5 up_up5 0 V=v(VDD)
Bdn_up5 dn_up5 0 V=0
Vm_up5 vo_up5 vs dc 0
* --- dn5: UP=0 DN=1 Iref=5u
Xdn5 up_dn5 dn_dn5 ibp_dn5 icp_dn5 ibn_dn5 icn_dn5 vo_dn5 VDD 0 cp
Irbp_dn5 ibp_dn5 0 dc 5u
Ircp_dn5 icp_dn5 0 dc 5u
Irbn_dn5 0 ibn_dn5 dc 5u
Ircn_dn5 0 icn_dn5 dc 5u
Bup_dn5 up_dn5 0 V=0
Bdn_dn5 dn_dn5 0 V=v(VDD)
Vm_dn5 vo_dn5 vs dc 0
* --- both5: UP=1 DN=1 Iref=5u
Xboth5 up_both5 dn_both5 ibp_both5 icp_both5 ibn_both5 icn_both5 vo_both5 VDD 0 cp
Irbp_both5 ibp_both5 0 dc 5u
Ircp_both5 icp_both5 0 dc 5u
Irbn_both5 0 ibn_both5 dc 5u
Ircn_both5 0 icn_both5 dc 5u
Bup_both5 up_both5 0 V=v(VDD)
Bdn_both5 dn_both5 0 V=v(VDD)
Vm_both5 vo_both5 vs dc 0
* --- up10: UP=1 DN=0 Iref=10u
Xup10 up_up10 dn_up10 ibp_up10 icp_up10 ibn_up10 icn_up10 vo_up10 VDD 0 cp
Irbp_up10 ibp_up10 0 dc 10u
Ircp_up10 icp_up10 0 dc 10u
Irbn_up10 0 ibn_up10 dc 10u
Ircn_up10 0 icn_up10 dc 10u
Bup_up10 up_up10 0 V=v(VDD)
Bdn_up10 dn_up10 0 V=0
Vm_up10 vo_up10 vs dc 0
* --- dn10: UP=0 DN=1 Iref=10u
Xdn10 up_dn10 dn_dn10 ibp_dn10 icp_dn10 ibn_dn10 icn_dn10 vo_dn10 VDD 0 cp
Irbp_dn10 ibp_dn10 0 dc 10u
Ircp_dn10 icp_dn10 0 dc 10u
Irbn_dn10 0 ibn_dn10 dc 10u
Ircn_dn10 0 icn_dn10 dc 10u
Bup_dn10 up_dn10 0 V=0
Bdn_dn10 dn_dn10 0 V=v(VDD)
Vm_dn10 vo_dn10 vs dc 0
* --- both10: UP=1 DN=1 Iref=10u
Xboth10 up_both10 dn_both10 ibp_both10 icp_both10 ibn_both10 icn_both10 vo_both10 VDD 0 cp
Irbp_both10 ibp_both10 0 dc 10u
Ircp_both10 icp_both10 0 dc 10u
Irbn_both10 0 ibn_both10 dc 10u
Ircn_both10 0 icn_both10 dc 10u
Bup_both10 up_both10 0 V=v(VDD)
Bdn_both10 dn_both10 0 V=v(VDD)
Vm_both10 vo_both10 vs dc 0
* --- up20: UP=1 DN=0 Iref=20u
Xup20 up_up20 dn_up20 ibp_up20 icp_up20 ibn_up20 icn_up20 vo_up20 VDD 0 cp
Irbp_up20 ibp_up20 0 dc 20u
Ircp_up20 icp_up20 0 dc 20u
Irbn_up20 0 ibn_up20 dc 20u
Ircn_up20 0 icn_up20 dc 20u
Bup_up20 up_up20 0 V=v(VDD)
Bdn_up20 dn_up20 0 V=0
Vm_up20 vo_up20 vs dc 0
* --- dn20: UP=0 DN=1 Iref=20u
Xdn20 up_dn20 dn_dn20 ibp_dn20 icp_dn20 ibn_dn20 icn_dn20 vo_dn20 VDD 0 cp
Irbp_dn20 ibp_dn20 0 dc 20u
Ircp_dn20 icp_dn20 0 dc 20u
Irbn_dn20 0 ibn_dn20 dc 20u
Ircn_dn20 0 icn_dn20 dc 20u
Bup_dn20 up_dn20 0 V=0
Bdn_dn20 dn_dn20 0 V=v(VDD)
Vm_dn20 vo_dn20 vs dc 0
* --- both20: UP=1 DN=1 Iref=20u
Xboth20 up_both20 dn_both20 ibp_both20 icp_both20 ibn_both20 icn_both20 vo_both20 VDD 0 cp
Irbp_both20 ibp_both20 0 dc 20u
Ircp_both20 icp_both20 0 dc 20u
Irbn_both20 0 ibn_both20 dc 20u
Ircn_both20 0 icn_both20 dc 20u
Bup_both20 up_both20 0 V=v(VDD)
Bdn_both20 dn_both20 0 V=v(VDD)
Vm_both20 vo_both20 vs dc 0
* --- up40: UP=1 DN=0 Iref=40u
Xup40 up_up40 dn_up40 ibp_up40 icp_up40 ibn_up40 icn_up40 vo_up40 VDD 0 cp
Irbp_up40 ibp_up40 0 dc 40u
Ircp_up40 icp_up40 0 dc 40u
Irbn_up40 0 ibn_up40 dc 40u
Ircn_up40 0 icn_up40 dc 40u
Bup_up40 up_up40 0 V=v(VDD)
Bdn_up40 dn_up40 0 V=0
Vm_up40 vo_up40 vs dc 0
* --- dn40: UP=0 DN=1 Iref=40u
Xdn40 up_dn40 dn_dn40 ibp_dn40 icp_dn40 ibn_dn40 icn_dn40 vo_dn40 VDD 0 cp
Irbp_dn40 ibp_dn40 0 dc 40u
Ircp_dn40 icp_dn40 0 dc 40u
Irbn_dn40 0 ibn_dn40 dc 40u
Ircn_dn40 0 icn_dn40 dc 40u
Bup_dn40 up_dn40 0 V=0
Bdn_dn40 dn_dn40 0 V=v(VDD)
Vm_dn40 vo_dn40 vs dc 0
* --- both40: UP=1 DN=1 Iref=40u
Xboth40 up_both40 dn_both40 ibp_both40 icp_both40 ibn_both40 icn_both40 vo_both40 VDD 0 cp
Irbp_both40 ibp_both40 0 dc 40u
Ircp_both40 icp_both40 0 dc 40u
Irbn_both40 0 ibn_both40 dc 40u
Ircn_both40 0 icn_both40 dc 40u
Bup_both40 up_both40 0 V=v(VDD)
Bdn_both40 dn_both40 0 V=v(VDD)
Vm_both40 vo_both40 vs dc 0
* --- up80: UP=1 DN=0 Iref=80u
Xup80 up_up80 dn_up80 ibp_up80 icp_up80 ibn_up80 icn_up80 vo_up80 VDD 0 cp
Irbp_up80 ibp_up80 0 dc 80u
Ircp_up80 icp_up80 0 dc 80u
Irbn_up80 0 ibn_up80 dc 80u
Ircn_up80 0 icn_up80 dc 80u
Bup_up80 up_up80 0 V=v(VDD)
Bdn_up80 dn_up80 0 V=0
Vm_up80 vo_up80 vs dc 0
* --- dn80: UP=0 DN=1 Iref=80u
Xdn80 up_dn80 dn_dn80 ibp_dn80 icp_dn80 ibn_dn80 icn_dn80 vo_dn80 VDD 0 cp
Irbp_dn80 ibp_dn80 0 dc 80u
Ircp_dn80 icp_dn80 0 dc 80u
Irbn_dn80 0 ibn_dn80 dc 80u
Ircn_dn80 0 icn_dn80 dc 80u
Bup_dn80 up_dn80 0 V=0
Bdn_dn80 dn_dn80 0 V=v(VDD)
Vm_dn80 vo_dn80 vs dc 0
* --- both80: UP=1 DN=1 Iref=80u
Xboth80 up_both80 dn_both80 ibp_both80 icp_both80 ibn_both80 icn_both80 vo_both80 VDD 0 cp
Irbp_both80 ibp_both80 0 dc 80u
Ircp_both80 icp_both80 0 dc 80u
Irbn_both80 0 ibn_both80 dc 80u
Ircn_both80 0 icn_both80 dc 80u
Bup_both80 up_both80 0 V=v(VDD)
Bdn_both80 dn_both80 0 V=v(VDD)
Vm_both80 vo_both80 vs dc 0
