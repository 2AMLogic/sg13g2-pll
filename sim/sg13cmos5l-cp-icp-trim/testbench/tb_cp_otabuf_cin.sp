* sg13g2-pll :: sim/sg13cmos5l-cp-icp-trim (issue #165, RECORD-005)
* GENERATED by gen_otabuf_requests.py -- do not edit by hand.
* Circuit body for `klt sim` (AC). Buffer input capacitance on VOUT: for each
* VOUT point a real cp (Xr_<k>) and a baseline cp_idealdump (Xb_<k>, XBUF ->
* ideal unity VCVS, derived below from the frozen snapshot's own cp subckt)
* share one AC source Vs_<k>; each has its own 0 V ammeter. Idle state
* (UP = DN = 0), 10 uA trim code.
.include ../netlist-snapshots/cp_otabuf.spice

* baseline: the snapshot's cp top-level subckt with XBUF -> EDUMP
.subckt cp_idealdump UP DN IBP ICP IBN ICN VOUT VDD VSS
*.ipin UP
*.ipin DN
*.iopin IBP
*.iopin ICP
*.iopin IBN
*.iopin ICN
*.opin VOUT
*.iopin VDD
*.iopin VSS
XIUP UP UPB VDD VSS inv_hv
XIDN DN DNB VDD VSS inv_hv
XLEGP IBP ICP UP UPB VOUT VDUMP VDD cp_leg_p
XLEGN IBN ICN DN DNB VOUT VDUMP VSS cp_leg_n
EDUMP VDUMP VSS VOUT VSS 1
XMBP nxp IBP VDD VDD sg13_hv_pmos w=24u l=1u ng=1 m=1
XMBPC IBP ICP nxp VDD sg13_hv_pmos w=24u l=1u ng=1 m=1
XMCP ICP ICP VDD VDD sg13_hv_pmos w=6u l=3u ng=1 m=1
XMBN nxn IBN VSS VSS sg13_hv_nmos w=8u l=1u ng=1 m=1
XMBNC IBN ICN nxn VSS sg13_hv_nmos w=8u l=1u ng=1 m=1
XMCN ICN ICN VSS VSS sg13_hv_nmos w=2u l=3u ng=1 m=1
.ends

Vdd VDD 0 dc 3.3
Xr0 0 0 ibp_r0 icp_r0 ibn_r0 icn_r0 vo_r0 VDD 0 cp
Irbp_r0 ibp_r0 0 dc 10u
Ircp_r0 icp_r0 0 dc 10u
Irbn_r0 0 ibn_r0 dc 10u
Ircn_r0 0 icn_r0 dc 10u
Vm_r0 vs_0 vo_r0 dc 0
Xb0 0 0 ibp_b0 icp_b0 ibn_b0 icn_b0 vo_b0 VDD 0 cp_idealdump
Irbp_b0 ibp_b0 0 dc 10u
Ircp_b0 icp_b0 0 dc 10u
Irbn_b0 0 ibn_b0 dc 10u
Ircn_b0 0 icn_b0 dc 10u
Vm_b0 vs_0 vo_b0 dc 0
Vs_0 vs_0 0 dc 0.3 ac 1
Xr1 0 0 ibp_r1 icp_r1 ibn_r1 icn_r1 vo_r1 VDD 0 cp
Irbp_r1 ibp_r1 0 dc 10u
Ircp_r1 icp_r1 0 dc 10u
Irbn_r1 0 ibn_r1 dc 10u
Ircn_r1 0 icn_r1 dc 10u
Vm_r1 vs_1 vo_r1 dc 0
Xb1 0 0 ibp_b1 icp_b1 ibn_b1 icn_b1 vo_b1 VDD 0 cp_idealdump
Irbp_b1 ibp_b1 0 dc 10u
Ircp_b1 icp_b1 0 dc 10u
Irbn_b1 0 ibn_b1 dc 10u
Ircn_b1 0 icn_b1 dc 10u
Vm_b1 vs_1 vo_b1 dc 0
Vs_1 vs_1 0 dc 0.5 ac 1
Xr2 0 0 ibp_r2 icp_r2 ibn_r2 icn_r2 vo_r2 VDD 0 cp
Irbp_r2 ibp_r2 0 dc 10u
Ircp_r2 icp_r2 0 dc 10u
Irbn_r2 0 ibn_r2 dc 10u
Ircn_r2 0 icn_r2 dc 10u
Vm_r2 vs_2 vo_r2 dc 0
Xb2 0 0 ibp_b2 icp_b2 ibn_b2 icn_b2 vo_b2 VDD 0 cp_idealdump
Irbp_b2 ibp_b2 0 dc 10u
Ircp_b2 icp_b2 0 dc 10u
Irbn_b2 0 ibn_b2 dc 10u
Ircn_b2 0 icn_b2 dc 10u
Vm_b2 vs_2 vo_b2 dc 0
Vs_2 vs_2 0 dc 0.7 ac 1
Xr3 0 0 ibp_r3 icp_r3 ibn_r3 icn_r3 vo_r3 VDD 0 cp
Irbp_r3 ibp_r3 0 dc 10u
Ircp_r3 icp_r3 0 dc 10u
Irbn_r3 0 ibn_r3 dc 10u
Ircn_r3 0 icn_r3 dc 10u
Vm_r3 vs_3 vo_r3 dc 0
Xb3 0 0 ibp_b3 icp_b3 ibn_b3 icn_b3 vo_b3 VDD 0 cp_idealdump
Irbp_b3 ibp_b3 0 dc 10u
Ircp_b3 icp_b3 0 dc 10u
Irbn_b3 0 ibn_b3 dc 10u
Ircn_b3 0 icn_b3 dc 10u
Vm_b3 vs_3 vo_b3 dc 0
Vs_3 vs_3 0 dc 0.9 ac 1
Xr4 0 0 ibp_r4 icp_r4 ibn_r4 icn_r4 vo_r4 VDD 0 cp
Irbp_r4 ibp_r4 0 dc 10u
Ircp_r4 icp_r4 0 dc 10u
Irbn_r4 0 ibn_r4 dc 10u
Ircn_r4 0 icn_r4 dc 10u
Vm_r4 vs_4 vo_r4 dc 0
Xb4 0 0 ibp_b4 icp_b4 ibn_b4 icn_b4 vo_b4 VDD 0 cp_idealdump
Irbp_b4 ibp_b4 0 dc 10u
Ircp_b4 icp_b4 0 dc 10u
Irbn_b4 0 ibn_b4 dc 10u
Ircn_b4 0 icn_b4 dc 10u
Vm_b4 vs_4 vo_b4 dc 0
Vs_4 vs_4 0 dc 1.1 ac 1
Xr5 0 0 ibp_r5 icp_r5 ibn_r5 icn_r5 vo_r5 VDD 0 cp
Irbp_r5 ibp_r5 0 dc 10u
Ircp_r5 icp_r5 0 dc 10u
Irbn_r5 0 ibn_r5 dc 10u
Ircn_r5 0 icn_r5 dc 10u
Vm_r5 vs_5 vo_r5 dc 0
Xb5 0 0 ibp_b5 icp_b5 ibn_b5 icn_b5 vo_b5 VDD 0 cp_idealdump
Irbp_b5 ibp_b5 0 dc 10u
Ircp_b5 icp_b5 0 dc 10u
Irbn_b5 0 ibn_b5 dc 10u
Ircn_b5 0 icn_b5 dc 10u
Vm_b5 vs_5 vo_b5 dc 0
Vs_5 vs_5 0 dc 1.3 ac 1
Xr6 0 0 ibp_r6 icp_r6 ibn_r6 icn_r6 vo_r6 VDD 0 cp
Irbp_r6 ibp_r6 0 dc 10u
Ircp_r6 icp_r6 0 dc 10u
Irbn_r6 0 ibn_r6 dc 10u
Ircn_r6 0 icn_r6 dc 10u
Vm_r6 vs_6 vo_r6 dc 0
Xb6 0 0 ibp_b6 icp_b6 ibn_b6 icn_b6 vo_b6 VDD 0 cp_idealdump
Irbp_b6 ibp_b6 0 dc 10u
Ircp_b6 icp_b6 0 dc 10u
Irbn_b6 0 ibn_b6 dc 10u
Ircn_b6 0 icn_b6 dc 10u
Vm_b6 vs_6 vo_b6 dc 0
Vs_6 vs_6 0 dc 1.5 ac 1
Xr7 0 0 ibp_r7 icp_r7 ibn_r7 icn_r7 vo_r7 VDD 0 cp
Irbp_r7 ibp_r7 0 dc 10u
Ircp_r7 icp_r7 0 dc 10u
Irbn_r7 0 ibn_r7 dc 10u
Ircn_r7 0 icn_r7 dc 10u
Vm_r7 vs_7 vo_r7 dc 0
Xb7 0 0 ibp_b7 icp_b7 ibn_b7 icn_b7 vo_b7 VDD 0 cp_idealdump
Irbp_b7 ibp_b7 0 dc 10u
Ircp_b7 icp_b7 0 dc 10u
Irbn_b7 0 ibn_b7 dc 10u
Ircn_b7 0 icn_b7 dc 10u
Vm_b7 vs_7 vo_b7 dc 0
Vs_7 vs_7 0 dc 1.7 ac 1
Xr8 0 0 ibp_r8 icp_r8 ibn_r8 icn_r8 vo_r8 VDD 0 cp
Irbp_r8 ibp_r8 0 dc 10u
Ircp_r8 icp_r8 0 dc 10u
Irbn_r8 0 ibn_r8 dc 10u
Ircn_r8 0 icn_r8 dc 10u
Vm_r8 vs_8 vo_r8 dc 0
Xb8 0 0 ibp_b8 icp_b8 ibn_b8 icn_b8 vo_b8 VDD 0 cp_idealdump
Irbp_b8 ibp_b8 0 dc 10u
Ircp_b8 icp_b8 0 dc 10u
Irbn_b8 0 ibn_b8 dc 10u
Ircn_b8 0 icn_b8 dc 10u
Vm_b8 vs_8 vo_b8 dc 0
Vs_8 vs_8 0 dc 1.9 ac 1
Xr9 0 0 ibp_r9 icp_r9 ibn_r9 icn_r9 vo_r9 VDD 0 cp
Irbp_r9 ibp_r9 0 dc 10u
Ircp_r9 icp_r9 0 dc 10u
Irbn_r9 0 ibn_r9 dc 10u
Ircn_r9 0 icn_r9 dc 10u
Vm_r9 vs_9 vo_r9 dc 0
Xb9 0 0 ibp_b9 icp_b9 ibn_b9 icn_b9 vo_b9 VDD 0 cp_idealdump
Irbp_b9 ibp_b9 0 dc 10u
Ircp_b9 icp_b9 0 dc 10u
Irbn_b9 0 ibn_b9 dc 10u
Ircn_b9 0 icn_b9 dc 10u
Vm_b9 vs_9 vo_b9 dc 0
Vs_9 vs_9 0 dc 2.1 ac 1
Xr10 0 0 ibp_r10 icp_r10 ibn_r10 icn_r10 vo_r10 VDD 0 cp
Irbp_r10 ibp_r10 0 dc 10u
Ircp_r10 icp_r10 0 dc 10u
Irbn_r10 0 ibn_r10 dc 10u
Ircn_r10 0 icn_r10 dc 10u
Vm_r10 vs_10 vo_r10 dc 0
Xb10 0 0 ibp_b10 icp_b10 ibn_b10 icn_b10 vo_b10 VDD 0 cp_idealdump
Irbp_b10 ibp_b10 0 dc 10u
Ircp_b10 icp_b10 0 dc 10u
Irbn_b10 0 ibn_b10 dc 10u
Ircn_b10 0 icn_b10 dc 10u
Vm_b10 vs_10 vo_b10 dc 0
Vs_10 vs_10 0 dc 2.3 ac 1
Xr11 0 0 ibp_r11 icp_r11 ibn_r11 icn_r11 vo_r11 VDD 0 cp
Irbp_r11 ibp_r11 0 dc 10u
Ircp_r11 icp_r11 0 dc 10u
Irbn_r11 0 ibn_r11 dc 10u
Ircn_r11 0 icn_r11 dc 10u
Vm_r11 vs_11 vo_r11 dc 0
Xb11 0 0 ibp_b11 icp_b11 ibn_b11 icn_b11 vo_b11 VDD 0 cp_idealdump
Irbp_b11 ibp_b11 0 dc 10u
Ircp_b11 icp_b11 0 dc 10u
Irbn_b11 0 ibn_b11 dc 10u
Ircn_b11 0 icn_b11 dc 10u
Vm_b11 vs_11 vo_b11 dc 0
Vs_11 vs_11 0 dc 2.5 ac 1
Xr12 0 0 ibp_r12 icp_r12 ibn_r12 icn_r12 vo_r12 VDD 0 cp
Irbp_r12 ibp_r12 0 dc 10u
Ircp_r12 icp_r12 0 dc 10u
Irbn_r12 0 ibn_r12 dc 10u
Ircn_r12 0 icn_r12 dc 10u
Vm_r12 vs_12 vo_r12 dc 0
Xb12 0 0 ibp_b12 icp_b12 ibn_b12 icn_b12 vo_b12 VDD 0 cp_idealdump
Irbp_b12 ibp_b12 0 dc 10u
Ircp_b12 icp_b12 0 dc 10u
Irbn_b12 0 ibn_b12 dc 10u
Ircn_b12 0 icn_b12 dc 10u
Vm_b12 vs_12 vo_b12 dc 0
Vs_12 vs_12 0 dc 2.7 ac 1
Xr13 0 0 ibp_r13 icp_r13 ibn_r13 icn_r13 vo_r13 VDD 0 cp
Irbp_r13 ibp_r13 0 dc 10u
Ircp_r13 icp_r13 0 dc 10u
Irbn_r13 0 ibn_r13 dc 10u
Ircn_r13 0 icn_r13 dc 10u
Vm_r13 vs_13 vo_r13 dc 0
Xb13 0 0 ibp_b13 icp_b13 ibn_b13 icn_b13 vo_b13 VDD 0 cp_idealdump
Irbp_b13 ibp_b13 0 dc 10u
Ircp_b13 icp_b13 0 dc 10u
Irbn_b13 0 ibn_b13 dc 10u
Ircn_b13 0 icn_b13 dc 10u
Vm_b13 vs_13 vo_b13 dc 0
Vs_13 vs_13 0 dc 2.9 ac 1
